* Extracted by KLayout with GF180MCU LVS runset on : 31/10/2026 11:46

* cell PLL_RING_DCO_PHYS
* pin A,MID_MUX[14]
* pin A,MID_MUX[8]
* pin A,MID_MUX[11]
* pin A,COARSE_MUX[14]
* pin A,COARSE_MUX[13]
* pin A,COARSE_MUX[12]
* pin A,COARSE_MUX[11]
* pin A,COARSE_MUX[10]
* pin A,Y
* pin A,Y
* pin A,Y
* pin A,Y
* pin A,Y
* pin A,Y
* pin VDD
* pin A,MID_MUX[6]
* pin A,B,Y
* pin C,Y
* pin Y
* pin C,Y
* pin Y
* pin Y
* pin A,Y
* pin B,Y
* pin B,Y
* pin A,Y
* pin C,Y
* pin A,Y
* pin B,Y
* pin B,Y
* pin B,Y
* pin B,Y
* pin A,Y
* pin A,Y
* pin Y
* pin B,Y
* pin A,Y
* pin A,Y
* pin A,Y
* pin B,Y
* pin C,Y
* pin A,Y
* pin A,Y
* pin B,Y
* pin B,Y
* pin B,Y
* pin B,Y
* pin B,Y
* pin A,Y
* pin A,Y
* pin B,Y
* pin A,Y
* pin A,COARSE_MUX[8]
* pin B,Y
* pin A,COARSE_MUX[9]
* pin B,Y
* pin A,Y
* pin B,Y
* pin A,Y
* pin A,Y
* pin A,Y
* pin A,Y
* pin A,COARSE_MUX[7]
* pin A,Y
* pin A,Y
* pin A,Y
* pin A,Y
* pin A,Y
* pin A,Y
* pin A,Y
* pin A,Y
* pin A,Y
* pin A,Y
* pin A,Y
* pin A,Y
* pin A,Y
* pin A,Y
* pin A,Y
* pin A,Y
* pin A,Y
* pin A,Y
* pin A,Y
* pin B,Y
* pin A,Y
* pin B,Y
* pin A,Y
* pin A,COARSE_MUX[6]
* pin A,Y
* pin A,Y
* pin A,Y
* pin A,Y
* pin A,Y
* pin A,Y
* pin A,Y
* pin A,Y
* pin A,Y
* pin A,Y
* pin A,Y
* pin A,Y
* pin A,Y
* pin A,Y
* pin A,Y
* pin A,Y
* pin A,Y
* pin A,Y
* pin A,Y
* pin A,Y
* pin B,Y
* pin A,Y
* pin A,Y
* pin A,Y
* pin B,Y
* pin A,Y
* pin A,Y
* pin A,Y
* pin A,Y
* pin A,Y
* pin A,Y
* pin A,Y
* pin A,Y
* pin A,Y
* pin A,Y
* pin A,Y
* pin A,Y
* pin A,Y
* pin A,Y
* pin A,Y
* pin A,COARSE_MUX[5]
* pin A,COARSE_MUX[4]
* pin B,Y
* pin A,Y
* pin A,Y
* pin A,Y
* pin A,Y
* pin A,Y
* pin A,Y
* pin Y
* pin A,Y
* pin A,Y
* pin B,Y
* pin C,Y
* pin A,Y
* pin A,Y
* pin A,Y
* pin A,Y
* pin A,Y
* pin A,Y
* pin A,Y
* pin A,Y
* pin B,Y
* pin Y
* pin A,MID_MUX[9]
* pin A,Y
* pin B,Y
* pin A,Y
* pin A,Y
* pin A,Y
* pin C,Y
* pin A,Y
* pin A,Y
* pin A,Y
* pin A,Y
* pin A,Y
* pin A,Y
* pin C,Y
* pin Y
* pin A,Y
* pin A,Q
* pin A,CLK,REF
* pin D,Y
* pin A,Q
* pin A,Y
* pin A,Y
* pin A,Y
* pin A,Y
* pin A,Y
* pin A,Y
* pin A,Y
* pin A,Y
* pin A,Y
* pin A,Y
* pin A,Y
* pin A,COARSE_MUX[3]
* pin A,Y
* pin C,Y
* pin A,MID_MUX[2]
* pin A,MID_MUX[3]
* pin A,Y
* pin A,Y
* pin A,Y
* pin A,Y
* pin A,Y
* pin A,Y
* pin A,Y
* pin A,Y
* pin A,Y
* pin A,Y
* pin A,Y
* pin B,Y
* pin B,Y
* pin Y
* pin A,Y
* pin A,COARSE_MUX[1]
* pin D,Y
* pin A,Y
* pin SS_BBPD[1],Y
* pin A,Y
* pin A,B,Y
* pin A,Y
* pin A,Y
* pin A,Y
* pin A,Y
* pin A,Y
* pin A,Y
* pin A,Y
* pin B,Y
* pin A,MID_MUX[0]
* pin A,COARSE_MUX[2]
* pin A,Y
* pin A,MID_MUX[7]
* pin A,MID_MUX[1]
* pin A,B,Y
* pin A,Y
* pin SS_BBPD[0],Y
* pin INJ_EDGE,Y
* pin A,Y
* pin A,Y
* pin A,Y
* pin A,Y
* pin A,Y
* pin A,Y
* pin A,Y
* pin A,Y
* pin A,Y
* pin A,Y
* pin A,Y
* pin A,Y
* pin A,Y
* pin B,Y
* pin A,Y
* pin C,Y
* pin C,Y
* pin Y
* pin A,COARSE_MUX[0]
* pin Y
* pin Y
* pin A,Y
* pin A,Y
* pin A,Y
* pin A,Y
* pin A,Y
* pin A,Y
* pin Y
* pin A,Y
* pin A,Y
* pin A,Y
* pin A,Y
* pin A,Y
* pin A,Y
* pin A,Y
* pin A,Y
* pin A,Y
* pin A,Y
* pin A,Y
* pin A,MID_MUX[12]
* pin C,Y
* pin A,Y
* pin A,MID_MUX[13]
* pin A,DCO_EN
* pin A,Y
* pin OUT,Y
* pin A,Y
* pin B,ZERO
* pin A,Y
* pin A,Y
* pin A,Y
* pin A,Y
* pin A,Y
* pin A,Y
* pin A,Y
* pin A,Y
* pin A,Y
* pin B,Y
* pin A,Y
* pin A,MID_MUX[5]
* pin A,Y
* pin Y
* pin A,Y
* pin B,ZERO
* pin B,Y
* pin B,Y
* pin A,Y
* pin A,Y
* pin A,Y
* pin A,Y
* pin A,Y
* pin A,Y
* pin A,Y
* pin A,Y
* pin C,Y
* pin Y
* pin C,Y
* pin A,MID_MUX[4]
* pin A,FINE_MUX[8]
* pin A,Y
* pin A,MID_MUX[10]
* pin C,Y
* pin A,B,Y
* pin A,Y
* pin A,Y
* pin A,Y
* pin A,Y
* pin A,Y
* pin A,Y
* pin C,Y
* pin Y
* pin A,Y
* pin Y
* pin Y
* pin A,Y
* pin A,Y
* pin Y
* pin MID_OUT,Y
* pin C,Y
* pin A,Y
* pin A,Y
* pin A,Y
* pin A,Y
* pin A,Y
* pin A,Y
* pin C,Y
* pin A,Y
* pin A,Y
* pin A,Y
* pin A,FINE_MUX[19]
* pin A,Y
* pin A,Y
* pin C,Y
* pin A,Y
* pin A,Y
* pin A,Y
* pin Y
* pin A,FINE_MUX[22]
* pin Y
* pin A,FINE_MUX[26]
* pin A,FINE_MUX[0]
* pin Y
* pin Y
* pin A,Y
* pin A,Y
* pin A,Y
* pin A,Y
* pin A,Y
* pin A,Y
* pin A,Y
* pin A,Y
* pin A,Y
* pin A,Y
* pin A,Y
* pin C,Y
* pin A,Y
* pin C,Y
* pin A,Y
* pin A,Y
* pin A,Y
* pin A,Y
* pin A,Y
* pin A,Y
* pin A,Y
* pin A,Y
* pin A,Y
* pin C,Y
* pin A,Y
* pin A,Y
* pin A,Y
* pin A,Y
* pin A,Y
* pin A,Y
* pin A,Y
* pin C,Y
* pin Y
* pin C,Y
* pin A,Y
* pin A,Y
* pin A,Y
* pin A,FINE_MUX[28]
* pin A,Y
* pin A,Y
* pin A,Y
* pin A,FINE_MUX[7]
* pin A,FINE_MUX[4]
* pin A,Y
* pin A,Y
* pin A,Y
* pin A,Y
* pin Y
* pin Y
* pin Y
* pin A,Y
* pin A,Y
* pin A,Y
* pin A,Y
* pin A,Y
* pin A,Y
* pin C,Y
* pin A,Y
* pin A,Y
* pin A,Y
* pin A,Y
* pin A,FINE_MUX[3]
* pin A,FINE_MUX[1]
* pin A,FINE_MUX[15]
* pin A,Y
* pin C,Y
* pin A,Y
* pin C,Y
* pin A,Y
* pin A,Y
* pin A,Y
* pin A,Y
* pin A,Y
* pin A,Y
* pin A,Y
* pin A,Y
* pin A,Y
* pin A,Y
* pin A,FINE_MUX[25]
* pin Y
* pin Y
* pin C,Y
* pin Y
* pin A,Y
* pin A,Y
* pin A,Y
* pin A,Y
* pin A,Y
* pin A,Y
* pin A,Y
* pin C,Y
* pin A,Y
* pin A,Y
* pin A,Y
* pin A,Y
* pin A,FINE_MUX[10]
* pin A,FINE_MUX[24]
* pin A,FINE_MUX[20]
* pin A,Y
* pin Y
* pin C,Y
* pin A,Y
* pin A,Y
* pin A,Y
* pin A,Y
* pin A,Y
* pin A,Y
* pin A,Y
* pin A,Y
* pin A,Y
* pin A,Y
* pin A,Y
* pin A,Y
* pin A,Y
* pin A,FINE_MUX[18]
* pin A,Y
* pin C,Y
* pin C,Y
* pin C,Y
* pin A,Y
* pin A,Y
* pin A,Y
* pin A,Y
* pin A,Y
* pin A,Y
* pin A,Y
* pin A,Y
* pin A,Y
* pin A,Y
* pin A,Y
* pin A,Y
* pin A,Y
* pin A,Y
* pin A,Y
* pin A,Y
* pin A,Y
* pin Y
* pin A,Y
* pin Y
* pin Y
* pin Y
* pin A,Y
* pin A,Y
* pin A,Y
* pin C,Y
* pin C,Y
* pin Y
* pin A,Y
* pin Y
* pin Y
* pin C,Y
* pin C,Y
* pin C,Y
* pin C,Y
* pin A,Y
* pin A,FINE_MUX[9]
* pin A,Y
* pin A,Y
* pin A,FINE_MUX[17]
* pin C,Y
* pin Y
* pin A,Y
* pin C,Y
* pin A,Y
* pin C,Y
* pin A,FINE_MUX[29]
* pin A,FINE_MUX[2]
* pin C,Y
* pin A,Y
* pin C,Y
* pin Y
* pin Y
* pin Y
* pin A,Y
* pin C,Y
* pin A,Y
* pin C,Y
* pin Y
* pin A,Y
* pin A,FINE_MUX[27]
* pin Y
* pin Y
* pin A,Y
* pin Y
* pin A,Y
* pin Y
* pin A,Y
* pin Y
* pin C,Y
* pin A,FINE_MUX[23]
* pin A,FINE_MUX[30]
* pin A,FINE_MUX[6]
* pin A,FINE_MUX[13]
* pin A,FINE_MUX[12]
* pin A,FINE_MUX[14]
* pin A,FINE_MUX[16]
* pin A,FINE_MUX[21]
* pin A,FINE_MUX[11]
* pin A,FINE_MUX[5]
* pin Y
* pin VSS
.SUBCKT PLL_RING_DCO_PHYS A|MID_MUX[14] A|MID_MUX[8] A|MID_MUX[11]
+ A|COARSE_MUX[14] A|COARSE_MUX[13] A|COARSE_MUX[12] A|COARSE_MUX[11]
+ A|COARSE_MUX[10] A|Y A|Y$1 A|Y$2 A|Y$3 A|Y$4 A|Y$5 VDD A|MID_MUX[6] A|B|Y C|Y
+ Y C|Y$1 Y$1 Y$2 A|Y$6 B|Y B|Y$1 A|Y$7 C|Y$2 A|Y$8 B|Y$2 B|Y$3 B|Y$4 B|Y$5
+ A|Y$9 A|Y$10 Y$3 B|Y$6 A|Y$11 A|Y$12 A|Y$13 B|Y$7 C|Y$3 A|Y$14 A|Y$15 B|Y$8
+ B|Y$9 B|Y$10 B|Y$11 B|Y$12 A|Y$16 A|Y$17 B|Y$13 A|Y$18 A|COARSE_MUX[8] B|Y$14
+ A|COARSE_MUX[9] B|Y$15 A|Y$19 B|Y$16 A|Y$20 A|Y$21 A|Y$22 A|Y$23
+ A|COARSE_MUX[7] A|Y$24 A|Y$25 A|Y$26 A|Y$27 A|Y$28 A|Y$29 A|Y$30 A|Y$31
+ A|Y$32 A|Y$33 A|Y$34 A|Y$35 A|Y$36 A|Y$37 A|Y$38 A|Y$39 A|Y$40 A|Y$41 A|Y$42
+ B|Y$17 A|Y$43 B|Y$18 A|Y$44 A|COARSE_MUX[6] A|Y$45 A|Y$46 A|Y$47 A|Y$48
+ A|Y$49 A|Y$50 A|Y$51 A|Y$52 A|Y$53 A|Y$54 A|Y$55 A|Y$56 A|Y$57 A|Y$58 A|Y$59
+ A|Y$60 A|Y$61 A|Y$62 A|Y$63 A|Y$64 B|Y$19 A|Y$65 A|Y$66 A|Y$67 B|Y$20 A|Y$68
+ A|Y$69 A|Y$70 A|Y$71 A|Y$72 A|Y$73 A|Y$74 A|Y$75 A|Y$76 A|Y$77 A|Y$78 A|Y$79
+ A|Y$80 A|Y$81 A|Y$82 A|COARSE_MUX[5] A|COARSE_MUX[4] B|Y$21 A|Y$83 A|Y$84
+ A|Y$85 A|Y$86 A|Y$87 A|Y$88 Y$4 A|Y$89 A|Y$90 B|Y$22 C|Y$4 A|Y$91 A|Y$92
+ A|Y$93 A|Y$94 A|Y$95 A|Y$96 A|Y$97 A|Y$98 B|Y$23 Y$5 A|MID_MUX[9] A|Y$99
+ B|Y$24 A|Y$100 A|Y$101 A|Y$102 C|Y$5 A|Y$103 A|Y$104 A|Y$105 A|Y$106 A|Y$107
+ A|Y$108 C|Y$6 Y$6 A|Y$109 A|Q A|CLK|REF D|Y A|Q$1 A|Y$110 A|Y$111 A|Y$112
+ A|Y$113 A|Y$114 A|Y$115 A|Y$116 A|Y$117 A|Y$118 A|Y$119 A|Y$120
+ A|COARSE_MUX[3] A|Y$121 C|Y$7 A|MID_MUX[2] A|MID_MUX[3] A|Y$122 A|Y$123
+ A|Y$124 A|Y$125 A|Y$126 A|Y$127 A|Y$128 A|Y$129 A|Y$130 A|Y$131 A|Y$132
+ B|Y$25 B|Y$26 Y$7 A|Y$133 A|COARSE_MUX[1] D|Y$1 A|Y$134 SS_BBPD[1]|Y A|Y$135
+ A|B|Y$1 A|Y$136 A|Y$137 A|Y$138 A|Y$139 A|Y$140 A|Y$141 A|Y$142 B|Y$27
+ A|MID_MUX[0] A|COARSE_MUX[2] A|Y$143 A|MID_MUX[7] A|MID_MUX[1] A|B|Y$2
+ A|Y$144 SS_BBPD[0]|Y INJ_EDGE|Y A|Y$145 A|Y$146 A|Y$147 A|Y$148 A|Y$149
+ A|Y$150 A|Y$151 A|Y$152 A|Y$153 A|Y$154 A|Y$155 A|Y$156 A|Y$157 B|Y$28
+ A|Y$158 C|Y$8 C|Y$9 Y$8 A|COARSE_MUX[0] Y$9 Y$10 A|Y$159 A|Y$160 A|Y$161
+ A|Y$162 A|Y$163 A|Y$164 Y$11 A|Y$165 A|Y$166 A|Y$167 A|Y$168 A|Y$169 A|Y$170
+ A|Y$171 A|Y$172 A|Y$173 A|Y$174 A|Y$175 A|MID_MUX[12] C|Y$10 A|Y$176
+ A|MID_MUX[13] A|DCO_EN A|Y$177 OUT|Y A|Y$178 B|ZERO A|Y$179 A|Y$180 A|Y$181
+ A|Y$182 A|Y$183 A|Y$184 A|Y$185 A|Y$186 A|Y$187 B|Y$29 A|Y$188 A|MID_MUX[5]
+ A|Y$189 Y$12 A|Y$190 B|ZERO$1 B|Y$30 B|Y$31 A|Y$191 A|Y$192 A|Y$193 A|Y$194
+ A|Y$195 A|Y$196 A|Y$197 A|Y$198 C|Y$11 Y$13 C|Y$12 A|MID_MUX[4] A|FINE_MUX[8]
+ A|Y$199 A|MID_MUX[10] C|Y$13 A|B|Y$3 A|Y$200 A|Y$201 A|Y$202 A|Y$203 A|Y$204
+ A|Y$205 C|Y$14 Y$14 A|Y$206 Y$15 Y$16 A|Y$207 A|Y$208 Y$17 MID_OUT|Y C|Y$15
+ A|Y$209 A|Y$210 A|Y$211 A|Y$212 A|Y$213 A|Y$214 C|Y$16 A|Y$215 A|Y$216
+ A|Y$217 A|FINE_MUX[19] A|Y$218 A|Y$219 C|Y$17 A|Y$220 A|Y$221 A|Y$222 Y$18
+ A|FINE_MUX[22] Y$19 A|FINE_MUX[26] A|FINE_MUX[0] Y$20 Y$21 A|Y$223 A|Y$224
+ A|Y$225 A|Y$226 A|Y$227 A|Y$228 A|Y$229 A|Y$230 A|Y$231 A|Y$232 A|Y$233
+ C|Y$18 A|Y$234 C|Y$19 A|Y$235 A|Y$236 A|Y$237 A|Y$238 A|Y$239 A|Y$240 A|Y$241
+ A|Y$242 A|Y$243 C|Y$20 A|Y$244 A|Y$245 A|Y$246 A|Y$247 A|Y$248 A|Y$249
+ A|Y$250 C|Y$21 Y$22 C|Y$22 A|Y$251 A|Y$252 A|Y$253 A|FINE_MUX[28] A|Y$254
+ A|Y$255 A|Y$256 A|FINE_MUX[7] A|FINE_MUX[4] A|Y$257 A|Y$258 A|Y$259 A|Y$260
+ Y$23 Y$24 Y$25 A|Y$261 A|Y$262 A|Y$263 A|Y$264 A|Y$265 A|Y$266 C|Y$23 A|Y$267
+ A|Y$268 A|Y$269 A|Y$270 A|FINE_MUX[3] A|FINE_MUX[1] A|FINE_MUX[15] A|Y$271
+ C|Y$24 A|Y$272 C|Y$25 A|Y$273 A|Y$274 A|Y$275 A|Y$276 A|Y$277 A|Y$278 A|Y$279
+ A|Y$280 A|Y$281 A|Y$282 A|FINE_MUX[25] Y$26 Y$27 C|Y$26 Y$28 A|Y$283 A|Y$284
+ A|Y$285 A|Y$286 A|Y$287 A|Y$288 A|Y$289 C|Y$27 A|Y$290 A|Y$291 A|Y$292
+ A|Y$293 A|FINE_MUX[10] A|FINE_MUX[24] A|FINE_MUX[20] A|Y$294 Y$29 C|Y$28
+ A|Y$295 A|Y$296 A|Y$297 A|Y$298 A|Y$299 A|Y$300 A|Y$301 A|Y$302 A|Y$303
+ A|Y$304 A|Y$305 A|Y$306 A|Y$307 A|FINE_MUX[18] A|Y$308 C|Y$29 C|Y$30 C|Y$31
+ A|Y$309 A|Y$310 A|Y$311 A|Y$312 A|Y$313 A|Y$314 A|Y$315 A|Y$316 A|Y$317
+ A|Y$318 A|Y$319 A|Y$320 A|Y$321 A|Y$322 A|Y$323 A|Y$324 A|Y$325 Y$30 A|Y$326
+ Y$31 Y$32 Y$33 A|Y$327 A|Y$328 A|Y$329 C|Y$32 C|Y$33 Y$34 A|Y$330 Y$35 Y$36
+ C|Y$34 C|Y$35 C|Y$36 C|Y$37 A|Y$331 A|FINE_MUX[9] A|Y$332 A|Y$333
+ A|FINE_MUX[17] C|Y$38 Y$37 A|Y$334 C|Y$39 A|Y$335 C|Y$40 A|FINE_MUX[29]
+ A|FINE_MUX[2] C|Y$41 A|Y$336 C|Y$42 Y$38 Y$39 Y$40 A|Y$337 C|Y$43 A|Y$338
+ C|Y$44 Y$41 A|Y$339 A|FINE_MUX[27] Y$42 Y$43 A|Y$340 Y$44 A|Y$341 Y$45
+ A|Y$342 Y$46 C|Y$45 A|FINE_MUX[23] A|FINE_MUX[30] A|FINE_MUX[6]
+ A|FINE_MUX[13] A|FINE_MUX[12] A|FINE_MUX[14] A|FINE_MUX[16] A|FINE_MUX[21]
+ A|FINE_MUX[11] A|FINE_MUX[5] Y$47 VSS
* device instance $1 r0 *1 87.28,18.57 pfet_03v3
M$1 A|Y \$47 VDD VDD pfet_03v3 L=0.28U W=2.76U AS=1.4076P AD=0.7176P PS=6.18U
+ PD=3.8U
* device instance $3 r0 *1 88.88,18.57 pfet_03v3
M$3 \$47 A|MID_MUX[6] VDD VDD pfet_03v3 L=0.28U W=1.38U AS=0.3588P AD=0.6072P
+ PS=1.9U PD=3.64U
* device instance $4 r0 *1 90.64,18.57 pfet_03v3
M$4 A|Y$7 \$49 VDD VDD pfet_03v3 L=0.28U W=2.76U AS=1.4076P AD=0.7176P PS=6.18U
+ PD=3.8U
* device instance $6 r0 *1 92.24,18.57 pfet_03v3
M$6 \$49 A|MID_MUX[14] VDD VDD pfet_03v3 L=0.28U W=1.38U AS=0.3588P AD=0.6072P
+ PS=1.9U PD=3.64U
* device instance $7 r0 *1 93.68,18.57 pfet_03v3
M$7 Y A|Y VDD VDD pfet_03v3 L=0.28U W=2.76U AS=0.966P AD=0.7176P PS=5.54U
+ PD=3.8U
* device instance $9 r0 *1 95.28,18.57 pfet_03v3
M$9 Y A|B|Y VDD VDD pfet_03v3 L=0.28U W=2.76U AS=0.7176P AD=1.1592P PS=3.8U
+ PD=4.44U
* device instance $11 r0 *1 97.52,18.57 pfet_03v3
M$11 Y C|Y VDD VDD pfet_03v3 L=0.28U W=2.76U AS=1.1592P AD=0.9798P PS=4.44U
+ PD=5.56U
* device instance $13 r0 *1 103.76,18.57 pfet_03v3
M$13 VDD A|MID_MUX[8] \$16 VDD pfet_03v3 L=0.28U W=1.38U AS=0.6072P AD=0.3588P
+ PS=3.64U PD=1.9U
* device instance $14 r0 *1 104.56,18.57 pfet_03v3
M$14 A|Y$14 \$16 VDD VDD pfet_03v3 L=0.28U W=2.76U AS=0.7176P AD=1.4076P
+ PS=3.8U PD=6.18U
* device instance $16 r0 *1 107.12,18.57 pfet_03v3
M$16 VDD A|MID_MUX[11] \$17 VDD pfet_03v3 L=0.28U W=1.38U AS=0.6072P AD=0.3588P
+ PS=3.64U PD=1.9U
* device instance $17 r0 *1 107.92,18.57 pfet_03v3
M$17 A|Y$8 \$17 VDD VDD pfet_03v3 L=0.28U W=2.76U AS=0.7176P AD=1.4076P PS=3.8U
+ PD=6.18U
* device instance $19 r0 *1 122.8,18.57 pfet_03v3
M$19 VDD A|COARSE_MUX[14] \$19 VDD pfet_03v3 L=0.28U W=1.38U AS=0.6072P
+ AD=0.3588P PS=3.64U PD=1.9U
* device instance $20 r0 *1 123.6,18.57 pfet_03v3
M$20 A|Y$1 \$19 VDD VDD pfet_03v3 L=0.28U W=2.76U AS=0.7176P AD=1.4076P PS=3.8U
+ PD=6.18U
* device instance $22 r0 *1 126.16,18.57 pfet_03v3
M$22 VDD A|COARSE_MUX[13] \$21 VDD pfet_03v3 L=0.28U W=1.38U AS=0.6072P
+ AD=0.3588P PS=3.64U PD=1.9U
* device instance $23 r0 *1 126.96,18.57 pfet_03v3
M$23 A|Y$2 \$21 VDD VDD pfet_03v3 L=0.28U W=2.76U AS=0.7176P AD=1.4076P PS=3.8U
+ PD=6.18U
* device instance $25 r0 *1 129.52,18.57 pfet_03v3
M$25 VDD A|COARSE_MUX[12] \$23 VDD pfet_03v3 L=0.28U W=1.38U AS=0.6072P
+ AD=0.3588P PS=3.64U PD=1.9U
* device instance $26 r0 *1 130.32,18.57 pfet_03v3
M$26 A|Y$3 \$23 VDD VDD pfet_03v3 L=0.28U W=2.76U AS=0.7176P AD=1.4076P PS=3.8U
+ PD=6.18U
* device instance $28 r0 *1 133.44,18.57 pfet_03v3
M$28 VDD A|COARSE_MUX[11] \$25 VDD pfet_03v3 L=0.28U W=1.38U AS=0.6072P
+ AD=0.3588P PS=3.64U PD=1.9U
* device instance $29 r0 *1 134.24,18.57 pfet_03v3
M$29 A|Y$4 \$25 VDD VDD pfet_03v3 L=0.28U W=2.76U AS=0.7176P AD=1.4076P PS=3.8U
+ PD=6.18U
* device instance $31 r0 *1 136.8,18.57 pfet_03v3
M$31 VDD A|COARSE_MUX[10] \$27 VDD pfet_03v3 L=0.28U W=1.38U AS=0.6072P
+ AD=0.3588P PS=3.64U PD=1.9U
* device instance $32 r0 *1 137.6,18.57 pfet_03v3
M$32 A|Y$5 \$27 VDD VDD pfet_03v3 L=0.28U W=2.76U AS=0.7176P AD=1.4076P PS=3.8U
+ PD=6.18U
* device instance $34 r0 *1 12.345,20.485 pfet_03v3
M$34 VDD \$84 \$61 VDD pfet_03v3 L=7.75U W=1.09U AS=0.5341P AD=0.4796P PS=3.16U
+ PD=3.06U
* device instance $35 r0 *1 12.345,18.715 pfet_03v3
M$35 VDD \$31 \$30 VDD pfet_03v3 L=7.75U W=1.09U AS=0.5341P AD=0.4796P PS=3.16U
+ PD=3.06U
* device instance $36 r0 *1 21.305,20.485 pfet_03v3
M$36 VDD \$85 \$62 VDD pfet_03v3 L=7.75U W=1.09U AS=0.5341P AD=0.4796P PS=3.16U
+ PD=3.06U
* device instance $37 r0 *1 21.305,18.715 pfet_03v3
M$37 VDD \$33 \$32 VDD pfet_03v3 L=7.75U W=1.09U AS=0.5341P AD=0.4796P PS=3.16U
+ PD=3.06U
* device instance $38 r0 *1 30.265,20.485 pfet_03v3
M$38 VDD \$86 \$63 VDD pfet_03v3 L=7.75U W=1.09U AS=0.5341P AD=0.4796P PS=3.16U
+ PD=3.06U
* device instance $39 r0 *1 31.385,18.715 pfet_03v3
M$39 VDD \$35 \$34 VDD pfet_03v3 L=7.75U W=1.09U AS=0.5341P AD=0.4796P PS=3.16U
+ PD=3.06U
* device instance $40 r0 *1 39.225,20.485 pfet_03v3
M$40 VDD \$87 \$64 VDD pfet_03v3 L=7.75U W=1.09U AS=0.5341P AD=0.4796P PS=3.16U
+ PD=3.06U
* device instance $41 r0 *1 40.345,18.715 pfet_03v3
M$41 VDD \$37 \$36 VDD pfet_03v3 L=7.75U W=1.09U AS=0.5341P AD=0.4796P PS=3.16U
+ PD=3.06U
* device instance $42 r0 *1 44.825,20.48 pfet_03v3
M$42 VDD \$88 \$65 VDD pfet_03v3 L=1.03U W=1.08U AS=0.5292P AD=0.4752P PS=3.14U
+ PD=3.04U
* device instance $43 r0 *1 50.425,18.715 pfet_03v3
M$43 VDD \$39 \$38 VDD pfet_03v3 L=7.75U W=1.09U AS=0.5341P AD=0.4796P PS=3.16U
+ PD=3.06U
* device instance $44 r0 *1 51.545,20.485 pfet_03v3
M$44 VDD \$89 \$66 VDD pfet_03v3 L=7.75U W=1.09U AS=0.5341P AD=0.4796P PS=3.16U
+ PD=3.06U
* device instance $45 r0 *1 59.385,18.715 pfet_03v3
M$45 VDD \$41 \$40 VDD pfet_03v3 L=7.75U W=1.09U AS=0.5341P AD=0.4796P PS=3.16U
+ PD=3.06U
* device instance $46 r0 *1 60.505,20.485 pfet_03v3
M$46 VDD \$90 \$67 VDD pfet_03v3 L=7.75U W=1.09U AS=0.5341P AD=0.4796P PS=3.16U
+ PD=3.06U
* device instance $47 r0 *1 69.465,20.485 pfet_03v3
M$47 VDD \$91 \$68 VDD pfet_03v3 L=7.75U W=1.09U AS=0.5341P AD=0.4796P PS=3.16U
+ PD=3.06U
* device instance $48 r0 *1 69.465,18.715 pfet_03v3
M$48 VDD \$43 \$42 VDD pfet_03v3 L=7.75U W=1.09U AS=0.5341P AD=0.4796P PS=3.16U
+ PD=3.06U
* device instance $49 r0 *1 78.425,20.485 pfet_03v3
M$49 VDD \$92 \$69 VDD pfet_03v3 L=7.75U W=1.09U AS=0.5341P AD=0.4796P PS=3.16U
+ PD=3.06U
* device instance $50 r0 *1 78.425,18.715 pfet_03v3
M$50 VDD \$45 \$44 VDD pfet_03v3 L=7.75U W=1.09U AS=0.5341P AD=0.4796P PS=3.16U
+ PD=3.06U
* device instance $51 r0 *1 84.025,20.48 pfet_03v3
M$51 VDD \$93 \$70 VDD pfet_03v3 L=1.03U W=1.08U AS=0.5292P AD=0.4752P PS=3.14U
+ PD=3.04U
* device instance $52 r0 *1 85.145,18.72 pfet_03v3
M$52 VDD \$11 \$46 VDD pfet_03v3 L=1.03U W=1.08U AS=0.5292P AD=0.4752P PS=3.14U
+ PD=3.04U
* device instance $53 r0 *1 87.385,20.48 pfet_03v3
M$53 VDD \$94 \$71 VDD pfet_03v3 L=1.03U W=1.08U AS=0.5292P AD=0.4752P PS=3.14U
+ PD=3.04U
* device instance $54 r0 *1 90.32,20.63 pfet_03v3
M$54 C|Y$1 A|Y$7 VDD VDD pfet_03v3 L=0.28U W=2.76U AS=0.966P AD=0.966P PS=5.54U
+ PD=5.54U
* device instance $56 r0 *1 92.56,20.63 pfet_03v3
M$56 Y$1 A|Y$7 VDD VDD pfet_03v3 L=0.28U W=2.76U AS=0.966P AD=0.7176P PS=5.54U
+ PD=3.8U
* device instance $58 r0 *1 94.16,20.63 pfet_03v3
M$58 Y$1 A|B|Y VDD VDD pfet_03v3 L=0.28U W=2.76U AS=0.7176P AD=1.1592P PS=3.8U
+ PD=4.44U
* device instance $60 r0 *1 96.4,20.63 pfet_03v3
M$60 Y$1 C|Y$1 VDD VDD pfet_03v3 L=0.28U W=2.76U AS=1.1592P AD=0.9798P PS=4.44U
+ PD=5.56U
* device instance $62 r0 *1 99.36,20.63 pfet_03v3
M$62 Y$2 C|Y$2 VDD VDD pfet_03v3 L=0.28U W=2.76U AS=0.9798P AD=1.1592P PS=5.56U
+ PD=4.44U
* device instance $64 r0 *1 101.6,20.63 pfet_03v3
M$64 Y$2 A|B|Y VDD VDD pfet_03v3 L=0.28U W=2.76U AS=1.1592P AD=0.7176P PS=4.44U
+ PD=3.8U
* device instance $66 r0 *1 103.2,20.63 pfet_03v3
M$66 Y$2 A|Y$8 VDD VDD pfet_03v3 L=0.28U W=2.76U AS=0.7176P AD=0.966P PS=3.8U
+ PD=5.54U
* device instance $68 r0 *1 100.265,18.72 pfet_03v3
M$68 VDD \$15 \$52 VDD pfet_03v3 L=1.03U W=1.08U AS=0.5292P AD=0.4752P PS=3.14U
+ PD=3.04U
* device instance $69 r0 *1 109.225,20.485 pfet_03v3
M$69 VDD \$98 \$75 VDD pfet_03v3 L=7.75U W=1.09U AS=0.5341P AD=0.4796P PS=3.16U
+ PD=3.06U
* device instance $70 r0 *1 114.265,18.715 pfet_03v3
M$70 VDD \$54 \$53 VDD pfet_03v3 L=7.75U W=1.09U AS=0.5341P AD=0.4796P PS=3.16U
+ PD=3.06U
* device instance $71 r0 *1 114.825,20.48 pfet_03v3
M$71 VDD \$99 \$76 VDD pfet_03v3 L=1.03U W=1.08U AS=0.5292P AD=0.4752P PS=3.14U
+ PD=3.04U
* device instance $72 r0 *1 118.4,20.63 pfet_03v3
M$72 A|Y$6 B|Y$2 VDD VDD pfet_03v3 L=0.28U W=2.76U AS=1.0764P AD=0.7176P
+ PS=5.7U PD=3.8U
* device instance $74 r0 *1 120,20.63 pfet_03v3
M$74 A|Y$6 A|Y$1 VDD VDD pfet_03v3 L=0.28U W=2.76U AS=0.7176P AD=0.966P PS=3.8U
+ PD=5.54U
* device instance $76 r0 *1 119.865,18.72 pfet_03v3
M$76 VDD \$18 \$55 VDD pfet_03v3 L=1.03U W=1.08U AS=0.5292P AD=0.4752P PS=3.14U
+ PD=3.04U
* device instance $77 r0 *1 122.665,20.48 pfet_03v3
M$77 VDD \$101 \$78 VDD pfet_03v3 L=1.03U W=1.08U AS=0.5292P AD=0.4752P
+ PS=3.14U PD=3.04U
* device instance $78 r0 *1 126.16,20.63 pfet_03v3
M$78 B|Y$2 A|Y$2 VDD VDD pfet_03v3 L=0.28U W=2.76U AS=0.966P AD=0.7176P
+ PS=5.54U PD=3.8U
* device instance $80 r0 *1 127.76,20.63 pfet_03v3
M$80 B|Y$2 B|Y$3 VDD VDD pfet_03v3 L=0.28U W=2.76U AS=0.7176P AD=1.0764P
+ PS=3.8U PD=5.7U
* device instance $82 r0 *1 130.08,20.63 pfet_03v3
M$82 B|Y$3 A|Y$3 VDD VDD pfet_03v3 L=0.28U W=2.76U AS=0.966P AD=0.7176P
+ PS=5.54U PD=3.8U
* device instance $84 r0 *1 131.68,20.63 pfet_03v3
M$84 B|Y$3 B|Y$4 VDD VDD pfet_03v3 L=0.28U W=2.76U AS=0.7176P AD=1.0764P
+ PS=3.8U PD=5.7U
* device instance $86 r0 *1 135.12,20.63 pfet_03v3
M$86 B|Y$4 A|Y$4 VDD VDD pfet_03v3 L=0.28U W=2.76U AS=0.966P AD=0.7176P
+ PS=5.54U PD=3.8U
* device instance $88 r0 *1 136.72,20.63 pfet_03v3
M$88 B|Y$4 B|Y$5 VDD VDD pfet_03v3 L=0.28U W=2.76U AS=0.7176P AD=1.0764P
+ PS=3.8U PD=5.7U
* device instance $90 r0 *1 140.72,20.63 pfet_03v3
M$90 B|Y A|Y$9 VDD VDD pfet_03v3 L=0.28U W=2.76U AS=0.966P AD=0.7176P PS=5.54U
+ PD=3.8U
* device instance $92 r0 *1 142.32,20.63 pfet_03v3
M$92 B|Y B|Y$10 VDD VDD pfet_03v3 L=0.28U W=2.76U AS=0.7176P AD=1.0764P PS=3.8U
+ PD=5.7U
* device instance $94 r0 *1 145.625,18.715 pfet_03v3
M$94 VDD \$57 \$56 VDD pfet_03v3 L=7.75U W=1.09U AS=0.5341P AD=0.4796P PS=3.16U
+ PD=3.06U
* device instance $95 r0 *1 145.065,20.48 pfet_03v3
M$95 VDD \$106 \$80 VDD pfet_03v3 L=1.03U W=1.08U AS=0.5292P AD=0.4752P
+ PS=3.14U PD=3.04U
* device instance $96 r0 *1 146.96,20.63 pfet_03v3
M$96 B|Y$1 B|Y VDD VDD pfet_03v3 L=0.28U W=2.76U AS=1.0764P AD=0.7176P PS=5.7U
+ PD=3.8U
* device instance $98 r0 *1 148.56,20.63 pfet_03v3
M$98 B|Y$1 A|Y$10 VDD VDD pfet_03v3 L=0.28U W=2.76U AS=0.7176P AD=0.966P
+ PS=3.8U PD=5.54U
* device instance $100 r0 *1 154.585,18.715 pfet_03v3
M$100 VDD \$59 \$58 VDD pfet_03v3 L=7.75U W=1.09U AS=0.5341P AD=0.4796P
+ PS=3.16U PD=3.06U
* device instance $101 r0 *1 154.585,20.485 pfet_03v3
M$101 VDD \$108 \$82 VDD pfet_03v3 L=7.75U W=1.09U AS=0.5341P AD=0.4796P
+ PS=3.16U PD=3.06U
* device instance $102 r0 *1 160.185,20.48 pfet_03v3
M$102 VDD \$109 \$83 VDD pfet_03v3 L=1.03U W=1.08U AS=0.5292P AD=0.4752P
+ PS=3.14U PD=3.04U
* device instance $103 r0 *1 12.345,26.555 pfet_03v3
M$103 VDD \$120 \$155 VDD pfet_03v3 L=7.75U W=1.09U AS=0.5341P AD=0.4796P
+ PS=3.16U PD=3.06U
* device instance $104 r0 *1 21.305,26.555 pfet_03v3
M$104 VDD \$121 \$156 VDD pfet_03v3 L=7.75U W=1.09U AS=0.5341P AD=0.4796P
+ PS=3.16U PD=3.06U
* device instance $105 r0 *1 31.945,26.555 pfet_03v3
M$105 VDD \$122 \$157 VDD pfet_03v3 L=7.75U W=1.09U AS=0.5341P AD=0.4796P
+ PS=3.16U PD=3.06U
* device instance $106 r0 *1 40.905,26.555 pfet_03v3
M$106 VDD \$123 \$158 VDD pfet_03v3 L=7.75U W=1.09U AS=0.5341P AD=0.4796P
+ PS=3.16U PD=3.06U
* device instance $107 r0 *1 49.865,26.555 pfet_03v3
M$107 VDD \$124 \$159 VDD pfet_03v3 L=7.75U W=1.09U AS=0.5341P AD=0.4796P
+ PS=3.16U PD=3.06U
* device instance $108 r0 *1 58.825,26.555 pfet_03v3
M$108 VDD \$125 \$160 VDD pfet_03v3 L=7.75U W=1.09U AS=0.5341P AD=0.4796P
+ PS=3.16U PD=3.06U
* device instance $109 r0 *1 64.425,26.56 pfet_03v3
M$109 VDD \$126 \$161 VDD pfet_03v3 L=1.03U W=1.08U AS=0.5292P AD=0.4752P
+ PS=3.14U PD=3.04U
* device instance $110 r0 *1 71.145,26.555 pfet_03v3
M$110 VDD \$127 \$162 VDD pfet_03v3 L=7.75U W=1.09U AS=0.5341P AD=0.4796P
+ PS=3.16U PD=3.06U
* device instance $111 r0 *1 80.105,26.555 pfet_03v3
M$111 VDD \$128 \$163 VDD pfet_03v3 L=7.75U W=1.09U AS=0.5341P AD=0.4796P
+ PS=3.16U PD=3.06U
* device instance $112 r0 *1 86.825,26.555 pfet_03v3
M$112 VDD \$129 \$164 VDD pfet_03v3 L=3.27U W=1.09U AS=0.5341P AD=0.4796P
+ PS=3.16U PD=3.06U
* device instance $113 r0 *1 90.185,26.56 pfet_03v3
M$113 VDD \$130 \$165 VDD pfet_03v3 L=1.03U W=1.08U AS=0.5292P AD=0.4752P
+ PS=3.14U PD=3.04U
* device instance $114 r0 *1 92,26.41 pfet_03v3
M$114 C|Y A|Y VDD VDD pfet_03v3 L=0.28U W=2.76U AS=0.966P AD=0.966P PS=5.54U
+ PD=5.54U
* device instance $116 r0 *1 94.32,26.41 pfet_03v3
M$116 Y$3 C|Y$3 VDD VDD pfet_03v3 L=0.28U W=2.76U AS=0.9798P AD=1.1592P
+ PS=5.56U PD=4.44U
* device instance $118 r0 *1 96.56,26.41 pfet_03v3
M$118 Y$3 A|B|Y VDD VDD pfet_03v3 L=0.28U W=2.76U AS=1.1592P AD=0.7176P
+ PS=4.44U PD=3.8U
* device instance $120 r0 *1 98.16,26.41 pfet_03v3
M$120 Y$3 A|Y$14 VDD VDD pfet_03v3 L=0.28U W=2.76U AS=0.7176P AD=0.966P PS=3.8U
+ PD=5.54U
* device instance $122 r0 *1 101.52,26.41 pfet_03v3
M$122 C|Y$2 A|Y$8 VDD VDD pfet_03v3 L=0.28U W=2.76U AS=0.966P AD=0.966P
+ PS=5.54U PD=5.54U
* device instance $124 r0 *1 108.105,26.555 pfet_03v3
M$124 VDD \$134 \$168 VDD pfet_03v3 L=3.27U W=1.09U AS=0.5341P AD=0.4796P
+ PS=3.16U PD=3.06U
* device instance $125 r0 *1 111.465,26.56 pfet_03v3
M$125 VDD \$135 \$169 VDD pfet_03v3 L=1.03U W=1.08U AS=0.5292P AD=0.4752P
+ PS=3.14U PD=3.04U
* device instance $126 r0 *1 115.28,26.41 pfet_03v3
M$126 B|Y$6 \$170 VDD VDD pfet_03v3 L=0.28U W=2.76U AS=1.4076P AD=0.7176P
+ PS=6.18U PD=3.8U
* device instance $128 r0 *1 116.88,26.41 pfet_03v3
M$128 \$170 A|Y$6 VDD VDD pfet_03v3 L=0.28U W=1.38U AS=0.3588P AD=0.6072P
+ PS=1.9U PD=3.64U
* device instance $129 r0 *1 118.56,26.41 pfet_03v3
M$129 \$137 A|Y$1 VDD VDD pfet_03v3 L=0.28U W=1.38U AS=0.6348P AD=0.6072P
+ PS=3.68U PD=3.64U
* device instance $130 r0 *1 120,26.41 pfet_03v3
M$130 A|Y$11 \$137 VDD VDD pfet_03v3 L=0.28U W=2.76U AS=0.966P AD=0.7176P
+ PS=5.54U PD=3.8U
* device instance $132 r0 *1 121.6,26.41 pfet_03v3
M$132 A|Y$11 B|Y$2 VDD VDD pfet_03v3 L=0.28U W=2.76U AS=0.7176P AD=1.0764P
+ PS=3.8U PD=5.7U
* device instance $134 r0 *1 124.16,26.41 pfet_03v3
M$134 \$140 A|Y$2 VDD VDD pfet_03v3 L=0.28U W=1.38U AS=0.6348P AD=0.6072P
+ PS=3.68U PD=3.64U
* device instance $135 r0 *1 125.6,26.41 pfet_03v3
M$135 A|Y$12 \$140 VDD VDD pfet_03v3 L=0.28U W=2.76U AS=0.966P AD=0.7176P
+ PS=5.54U PD=3.8U
* device instance $137 r0 *1 127.2,26.41 pfet_03v3
M$137 A|Y$12 B|Y$3 VDD VDD pfet_03v3 L=0.28U W=2.76U AS=0.7176P AD=1.0764P
+ PS=3.8U PD=5.7U
* device instance $139 r0 *1 130.88,26.41 pfet_03v3
M$139 \$143 A|Y$3 VDD VDD pfet_03v3 L=0.28U W=1.38U AS=0.6348P AD=0.6072P
+ PS=3.68U PD=3.64U
* device instance $140 r0 *1 132.32,26.41 pfet_03v3
M$140 A|Y$13 \$143 VDD VDD pfet_03v3 L=0.28U W=2.76U AS=0.966P AD=0.7176P
+ PS=5.54U PD=3.8U
* device instance $142 r0 *1 133.92,26.41 pfet_03v3
M$142 A|Y$13 B|Y$4 VDD VDD pfet_03v3 L=0.28U W=2.76U AS=0.7176P AD=1.0764P
+ PS=3.8U PD=5.7U
* device instance $144 r0 *1 137.04,26.41 pfet_03v3
M$144 \$146 A|Y$4 VDD VDD pfet_03v3 L=0.28U W=1.38U AS=0.6348P AD=0.6072P
+ PS=3.68U PD=3.64U
* device instance $145 r0 *1 138.48,26.41 pfet_03v3
M$145 A|Y$9 \$146 VDD VDD pfet_03v3 L=0.28U W=2.76U AS=0.966P AD=0.7176P
+ PS=5.54U PD=3.8U
* device instance $147 r0 *1 140.08,26.41 pfet_03v3
M$147 A|Y$9 B|Y$5 VDD VDD pfet_03v3 L=0.28U W=2.76U AS=0.7176P AD=1.0764P
+ PS=3.8U PD=5.7U
* device instance $149 r0 *1 142.825,26.56 pfet_03v3
M$149 VDD \$148 \$171 VDD pfet_03v3 L=1.03U W=1.08U AS=0.5292P AD=0.4752P
+ PS=3.14U PD=3.04U
* device instance $150 r0 *1 146,26.41 pfet_03v3
M$150 \$149 A|Y$5 VDD VDD pfet_03v3 L=0.28U W=1.38U AS=0.6348P AD=0.6072P
+ PS=3.68U PD=3.64U
* device instance $151 r0 *1 147.44,26.41 pfet_03v3
M$151 A|Y$10 \$149 VDD VDD pfet_03v3 L=0.28U W=2.76U AS=0.966P AD=0.7176P
+ PS=5.54U PD=3.8U
* device instance $153 r0 *1 149.04,26.41 pfet_03v3
M$153 A|Y$10 B|Y$11 VDD VDD pfet_03v3 L=0.28U W=2.76U AS=0.7176P AD=1.0764P
+ PS=3.8U PD=5.7U
* device instance $155 r0 *1 151.36,26.41 pfet_03v3
M$155 B|Y$7 A|Y$15 VDD VDD pfet_03v3 L=0.28U W=2.76U AS=0.966P AD=0.7176P
+ PS=5.54U PD=3.8U
* device instance $157 r0 *1 152.96,26.41 pfet_03v3
M$157 B|Y$7 B|Y$1 VDD VDD pfet_03v3 L=0.28U W=2.76U AS=0.7176P AD=1.0764P
+ PS=3.8U PD=5.7U
* device instance $159 r0 *1 156.825,26.555 pfet_03v3
M$159 VDD \$153 \$173 VDD pfet_03v3 L=3.27U W=1.09U AS=0.5341P AD=0.4796P
+ PS=3.16U PD=3.06U
* device instance $160 r0 *1 160.185,26.56 pfet_03v3
M$160 VDD \$154 \$174 VDD pfet_03v3 L=1.03U W=1.08U AS=0.5292P AD=0.4752P
+ PS=3.14U PD=3.04U
* device instance $161 r0 *1 12.345,34.395 pfet_03v3
M$161 VDD \$223 \$222 VDD pfet_03v3 L=7.75U W=1.09U AS=0.5341P AD=0.4796P
+ PS=3.16U PD=3.06U
* device instance $162 r0 *1 12.345,28.325 pfet_03v3
M$162 VDD \$176 \$175 VDD pfet_03v3 L=7.75U W=1.09U AS=0.5341P AD=0.4796P
+ PS=3.16U PD=3.06U
* device instance $163 r0 *1 21.305,28.325 pfet_03v3
M$163 VDD \$178 \$177 VDD pfet_03v3 L=7.75U W=1.09U AS=0.5341P AD=0.4796P
+ PS=3.16U PD=3.06U
* device instance $164 r0 *1 21.305,34.395 pfet_03v3
M$164 VDD \$225 \$224 VDD pfet_03v3 L=7.75U W=1.09U AS=0.5341P AD=0.4796P
+ PS=3.16U PD=3.06U
* device instance $165 r0 *1 30.265,28.325 pfet_03v3
M$165 VDD \$180 \$179 VDD pfet_03v3 L=7.75U W=1.09U AS=0.5341P AD=0.4796P
+ PS=3.16U PD=3.06U
* device instance $166 r0 *1 31.945,34.395 pfet_03v3
M$166 VDD \$227 \$226 VDD pfet_03v3 L=7.75U W=1.09U AS=0.5341P AD=0.4796P
+ PS=3.16U PD=3.06U
* device instance $167 r0 *1 39.225,28.325 pfet_03v3
M$167 VDD \$182 \$181 VDD pfet_03v3 L=7.75U W=1.09U AS=0.5341P AD=0.4796P
+ PS=3.16U PD=3.06U
* device instance $168 r0 *1 40.905,34.395 pfet_03v3
M$168 VDD \$229 \$228 VDD pfet_03v3 L=7.75U W=1.09U AS=0.5341P AD=0.4796P
+ PS=3.16U PD=3.06U
* device instance $169 r0 *1 44.825,28.32 pfet_03v3
M$169 VDD \$184 \$183 VDD pfet_03v3 L=1.03U W=1.08U AS=0.5292P AD=0.4752P
+ PS=3.14U PD=3.04U
* device instance $170 r0 *1 49.865,34.395 pfet_03v3
M$170 VDD \$231 \$230 VDD pfet_03v3 L=7.75U W=1.09U AS=0.5341P AD=0.4796P
+ PS=3.16U PD=3.06U
* device instance $171 r0 *1 51.545,28.325 pfet_03v3
M$171 VDD \$186 \$185 VDD pfet_03v3 L=7.75U W=1.09U AS=0.5341P AD=0.4796P
+ PS=3.16U PD=3.06U
* device instance $172 r0 *1 58.825,34.395 pfet_03v3
M$172 VDD \$233 \$232 VDD pfet_03v3 L=7.75U W=1.09U AS=0.5341P AD=0.4796P
+ PS=3.16U PD=3.06U
* device instance $173 r0 *1 60.505,28.325 pfet_03v3
M$173 VDD \$188 \$187 VDD pfet_03v3 L=7.75U W=1.09U AS=0.5341P AD=0.4796P
+ PS=3.16U PD=3.06U
* device instance $174 r0 *1 69.465,28.325 pfet_03v3
M$174 VDD \$190 \$189 VDD pfet_03v3 L=7.75U W=1.09U AS=0.5341P AD=0.4796P
+ PS=3.16U PD=3.06U
* device instance $175 r0 *1 71.145,34.395 pfet_03v3
M$175 VDD \$237 \$236 VDD pfet_03v3 L=7.75U W=1.09U AS=0.5341P AD=0.4796P
+ PS=3.16U PD=3.06U
* device instance $176 r0 *1 78.425,28.325 pfet_03v3
M$176 VDD \$192 \$191 VDD pfet_03v3 L=7.75U W=1.09U AS=0.5341P AD=0.4796P
+ PS=3.16U PD=3.06U
* device instance $177 r0 *1 80.105,34.395 pfet_03v3
M$177 VDD \$239 \$238 VDD pfet_03v3 L=7.75U W=1.09U AS=0.5341P AD=0.4796P
+ PS=3.16U PD=3.06U
* device instance $178 r0 *1 84.025,28.32 pfet_03v3
M$178 VDD \$194 \$193 VDD pfet_03v3 L=1.03U W=1.08U AS=0.5292P AD=0.4752P
+ PS=3.14U PD=3.04U
* device instance $179 r0 *1 89.065,34.395 pfet_03v3
M$179 VDD \$241 \$240 VDD pfet_03v3 L=7.75U W=1.09U AS=0.5341P AD=0.4796P
+ PS=3.16U PD=3.06U
* device instance $180 r0 *1 90.745,28.325 pfet_03v3
M$180 VDD \$196 \$195 VDD pfet_03v3 L=7.75U W=1.09U AS=0.5341P AD=0.4796P
+ PS=3.16U PD=3.06U
* device instance $181 r0 *1 98.025,34.395 pfet_03v3
M$181 VDD \$243 \$242 VDD pfet_03v3 L=7.75U W=1.09U AS=0.5341P AD=0.4796P
+ PS=3.16U PD=3.06U
* device instance $182 r0 *1 95.92,28.47 pfet_03v3
M$182 C|Y$3 A|Y$14 VDD VDD pfet_03v3 L=0.28U W=2.76U AS=0.966P AD=0.966P
+ PS=5.54U PD=5.54U
* device instance $184 r0 *1 101.945,28.325 pfet_03v3
M$184 VDD \$198 \$197 VDD pfet_03v3 L=7.75U W=1.09U AS=0.5341P AD=0.4796P
+ PS=3.16U PD=3.06U
* device instance $185 r0 *1 110.345,34.395 pfet_03v3
M$185 VDD \$247 \$246 VDD pfet_03v3 L=7.75U W=1.09U AS=0.5341P AD=0.4796P
+ PS=3.16U PD=3.06U
* device instance $186 r0 *1 110.905,28.325 pfet_03v3
M$186 VDD \$200 \$199 VDD pfet_03v3 L=7.75U W=1.09U AS=0.5341P AD=0.4796P
+ PS=3.16U PD=3.06U
* device instance $187 r0 *1 119.305,34.395 pfet_03v3
M$187 VDD \$249 \$248 VDD pfet_03v3 L=7.75U W=1.09U AS=0.5341P AD=0.4796P
+ PS=3.16U PD=3.06U
* device instance $188 r0 *1 117.625,28.325 pfet_03v3
M$188 VDD \$202 \$201 VDD pfet_03v3 L=3.27U W=1.09U AS=0.5341P AD=0.4796P
+ PS=3.16U PD=3.06U
* device instance $189 r0 *1 121.12,28.47 pfet_03v3
M$189 B|Y$8 A|Y$11 VDD VDD pfet_03v3 L=0.28U W=2.76U AS=0.966P AD=0.7176P
+ PS=5.54U PD=3.8U
* device instance $191 r0 *1 122.72,28.47 pfet_03v3
M$191 B|Y$8 B|Y$6 VDD VDD pfet_03v3 L=0.28U W=2.76U AS=0.7176P AD=1.0764P
+ PS=3.8U PD=5.7U
* device instance $193 r0 *1 128.265,34.395 pfet_03v3
M$193 VDD \$251 \$250 VDD pfet_03v3 L=7.75U W=1.09U AS=0.5341P AD=0.4796P
+ PS=3.16U PD=3.06U
* device instance $194 r0 *1 126.24,28.47 pfet_03v3
M$194 B|Y$9 B|Y$8 VDD VDD pfet_03v3 L=0.28U W=2.76U AS=1.0764P AD=0.7176P
+ PS=5.7U PD=3.8U
* device instance $196 r0 *1 127.84,28.47 pfet_03v3
M$196 B|Y$9 A|Y$12 VDD VDD pfet_03v3 L=0.28U W=2.76U AS=0.7176P AD=0.966P
+ PS=3.8U PD=5.54U
* device instance $198 r0 *1 130.505,28.32 pfet_03v3
M$198 VDD \$206 \$205 VDD pfet_03v3 L=1.03U W=1.08U AS=0.5292P AD=0.4752P
+ PS=3.14U PD=3.04U
* device instance $199 r0 *1 133.44,28.47 pfet_03v3
M$199 B|Y$10 A|Y$13 VDD VDD pfet_03v3 L=0.28U W=2.76U AS=0.966P AD=0.7176P
+ PS=5.54U PD=3.8U
* device instance $201 r0 *1 135.04,28.47 pfet_03v3
M$201 B|Y$10 B|Y$9 VDD VDD pfet_03v3 L=0.28U W=2.76U AS=0.7176P AD=1.0764P
+ PS=3.8U PD=5.7U
* device instance $203 r0 *1 137.225,34.395 pfet_03v3
M$203 VDD \$253 \$252 VDD pfet_03v3 L=7.75U W=1.09U AS=0.5341P AD=0.4796P
+ PS=3.16U PD=3.06U
* device instance $204 r0 *1 138.905,28.325 pfet_03v3
M$204 VDD \$209 \$208 VDD pfet_03v3 L=3.27U W=1.09U AS=0.5341P AD=0.4796P
+ PS=3.16U PD=3.06U
* device instance $205 r0 *1 141.92,28.47 pfet_03v3
M$205 B|Y$5 B|Y$11 VDD VDD pfet_03v3 L=0.28U W=2.76U AS=1.0764P AD=0.7176P
+ PS=5.7U PD=3.8U
* device instance $207 r0 *1 143.52,28.47 pfet_03v3
M$207 B|Y$5 A|Y$5 VDD VDD pfet_03v3 L=0.28U W=2.76U AS=0.7176P AD=0.966P
+ PS=3.8U PD=5.54U
* device instance $209 r0 *1 147.305,34.395 pfet_03v3
M$209 VDD \$257 \$256 VDD pfet_03v3 L=3.27U W=1.09U AS=0.5341P AD=0.4796P
+ PS=3.16U PD=3.06U
* device instance $210 r0 *1 147.52,28.47 pfet_03v3
M$210 B|Y$11 B|Y$12 VDD VDD pfet_03v3 L=0.28U W=2.76U AS=1.0764P AD=0.7176P
+ PS=5.7U PD=3.8U
* device instance $212 r0 *1 149.12,28.47 pfet_03v3
M$212 B|Y$11 A|Y$16 VDD VDD pfet_03v3 L=0.28U W=2.76U AS=0.7176P AD=0.966P
+ PS=3.8U PD=5.54U
* device instance $214 r0 *1 151.44,28.47 pfet_03v3
M$214 A|Y$15 B|Y$12 VDD VDD pfet_03v3 L=0.28U W=2.76U AS=1.0764P AD=0.7176P
+ PS=5.7U PD=3.8U
* device instance $216 r0 *1 153.04,28.47 pfet_03v3
M$216 A|Y$15 \$215 VDD VDD pfet_03v3 L=0.28U W=2.76U AS=0.7176P AD=0.966P
+ PS=3.8U PD=5.54U
* device instance $218 r0 *1 152.48,34.25 pfet_03v3
M$218 B|Y$13 A|Y$17 VDD VDD pfet_03v3 L=0.28U W=2.76U AS=0.966P AD=0.7176P
+ PS=5.54U PD=3.8U
* device instance $220 r0 *1 154.08,34.25 pfet_03v3
M$220 B|Y$13 B|Y$7 VDD VDD pfet_03v3 L=0.28U W=2.76U AS=0.7176P AD=1.0764P
+ PS=3.8U PD=5.7U
* device instance $222 r0 *1 155.28,28.47 pfet_03v3
M$222 VDD A|Y$16 \$215 VDD pfet_03v3 L=0.28U W=1.38U AS=0.6072P AD=0.6348P
+ PS=3.64U PD=3.68U
* device instance $223 r0 *1 158.505,28.325 pfet_03v3
M$223 VDD \$214 \$213 VDD pfet_03v3 L=3.27U W=1.09U AS=0.5341P AD=0.4796P
+ PS=3.16U PD=3.06U
* device instance $224 r0 *1 159.52,34.25 pfet_03v3
M$224 A|Y$18 \$265 VDD VDD pfet_03v3 L=0.28U W=2.76U AS=1.4076P AD=0.7176P
+ PS=6.18U PD=3.8U
* device instance $226 r0 *1 161.12,34.25 pfet_03v3
M$226 \$265 A|COARSE_MUX[8] VDD VDD pfet_03v3 L=0.28U W=1.38U AS=0.3588P
+ AD=0.6072P PS=1.9U PD=3.64U
* device instance $227 r0 *1 12.345,36.165 pfet_03v3
M$227 VDD \$269 \$268 VDD pfet_03v3 L=7.75U W=1.09U AS=0.5341P AD=0.4796P
+ PS=3.16U PD=3.06U
* device instance $228 r0 *1 21.305,36.165 pfet_03v3
M$228 VDD \$271 \$270 VDD pfet_03v3 L=7.75U W=1.09U AS=0.5341P AD=0.4796P
+ PS=3.16U PD=3.06U
* device instance $229 r0 *1 30.265,36.165 pfet_03v3
M$229 VDD \$273 \$272 VDD pfet_03v3 L=7.75U W=1.09U AS=0.5341P AD=0.4796P
+ PS=3.16U PD=3.06U
* device instance $230 r0 *1 39.225,36.165 pfet_03v3
M$230 VDD \$275 \$274 VDD pfet_03v3 L=7.75U W=1.09U AS=0.5341P AD=0.4796P
+ PS=3.16U PD=3.06U
* device instance $231 r0 *1 44.825,36.16 pfet_03v3
M$231 VDD \$277 \$276 VDD pfet_03v3 L=1.03U W=1.08U AS=0.5292P AD=0.4752P
+ PS=3.14U PD=3.04U
* device instance $232 r0 *1 51.545,36.165 pfet_03v3
M$232 VDD \$279 \$278 VDD pfet_03v3 L=7.75U W=1.09U AS=0.5341P AD=0.4796P
+ PS=3.16U PD=3.06U
* device instance $233 r0 *1 60.505,36.165 pfet_03v3
M$233 VDD \$281 \$280 VDD pfet_03v3 L=7.75U W=1.09U AS=0.5341P AD=0.4796P
+ PS=3.16U PD=3.06U
* device instance $234 r0 *1 64.425,34.4 pfet_03v3
M$234 VDD \$235 \$234 VDD pfet_03v3 L=1.03U W=1.08U AS=0.5292P AD=0.4752P
+ PS=3.14U PD=3.04U
* device instance $235 r0 *1 69.465,36.165 pfet_03v3
M$235 VDD \$283 \$282 VDD pfet_03v3 L=7.75U W=1.09U AS=0.5341P AD=0.4796P
+ PS=3.16U PD=3.06U
* device instance $236 r0 *1 78.425,36.165 pfet_03v3
M$236 VDD \$285 \$284 VDD pfet_03v3 L=7.75U W=1.09U AS=0.5341P AD=0.4796P
+ PS=3.16U PD=3.06U
* device instance $237 r0 *1 84.025,36.16 pfet_03v3
M$237 VDD \$287 \$286 VDD pfet_03v3 L=1.03U W=1.08U AS=0.5292P AD=0.4752P
+ PS=3.14U PD=3.04U
* device instance $238 r0 *1 90.745,36.165 pfet_03v3
M$238 VDD \$289 \$288 VDD pfet_03v3 L=7.75U W=1.09U AS=0.5341P AD=0.4796P
+ PS=3.16U PD=3.06U
* device instance $239 r0 *1 99.705,36.165 pfet_03v3
M$239 VDD \$291 \$290 VDD pfet_03v3 L=7.75U W=1.09U AS=0.5341P AD=0.4796P
+ PS=3.16U PD=3.06U
* device instance $240 r0 *1 103.625,34.4 pfet_03v3
M$240 VDD \$245 \$244 VDD pfet_03v3 L=1.03U W=1.08U AS=0.5292P AD=0.4752P
+ PS=3.14U PD=3.04U
* device instance $241 r0 *1 108.665,36.165 pfet_03v3
M$241 VDD \$293 \$292 VDD pfet_03v3 L=7.75U W=1.09U AS=0.5341P AD=0.4796P
+ PS=3.16U PD=3.06U
* device instance $242 r0 *1 117.625,36.165 pfet_03v3
M$242 VDD \$295 \$294 VDD pfet_03v3 L=7.75U W=1.09U AS=0.5341P AD=0.4796P
+ PS=3.16U PD=3.06U
* device instance $243 r0 *1 123.225,36.16 pfet_03v3
M$243 VDD \$297 \$296 VDD pfet_03v3 L=1.03U W=1.08U AS=0.5292P AD=0.4752P
+ PS=3.14U PD=3.04U
* device instance $244 r0 *1 129.945,36.165 pfet_03v3
M$244 VDD \$299 \$298 VDD pfet_03v3 L=7.75U W=1.09U AS=0.5341P AD=0.4796P
+ PS=3.16U PD=3.06U
* device instance $245 r0 *1 138.905,36.165 pfet_03v3
M$245 VDD \$301 \$300 VDD pfet_03v3 L=7.75U W=1.09U AS=0.5341P AD=0.4796P
+ PS=3.16U PD=3.06U
* device instance $246 r0 *1 142.825,34.4 pfet_03v3
M$246 VDD \$255 \$254 VDD pfet_03v3 L=1.03U W=1.08U AS=0.5292P AD=0.4752P
+ PS=3.14U PD=3.04U
* device instance $247 r0 *1 145.625,36.165 pfet_03v3
M$247 VDD \$303 \$302 VDD pfet_03v3 L=3.27U W=1.09U AS=0.5341P AD=0.4796P
+ PS=3.16U PD=3.06U
* device instance $248 r0 *1 148.985,36.16 pfet_03v3
M$248 VDD \$305 \$304 VDD pfet_03v3 L=1.03U W=1.08U AS=0.5292P AD=0.4752P
+ PS=3.14U PD=3.04U
* device instance $249 r0 *1 150.665,34.4 pfet_03v3
M$249 VDD \$259 \$258 VDD pfet_03v3 L=1.03U W=1.08U AS=0.5292P AD=0.4752P
+ PS=3.14U PD=3.04U
* device instance $250 r0 *1 152,36.31 pfet_03v3
M$250 A|Y$17 B|Y$14 VDD VDD pfet_03v3 L=0.28U W=2.76U AS=1.0764P AD=0.7176P
+ PS=5.7U PD=3.8U
* device instance $252 r0 *1 153.6,36.31 pfet_03v3
M$252 A|Y$17 \$307 VDD VDD pfet_03v3 L=0.28U W=2.76U AS=0.7176P AD=0.966P
+ PS=3.8U PD=5.54U
* device instance $254 r0 *1 155.84,36.31 pfet_03v3
M$254 VDD A|Y$18 \$307 VDD pfet_03v3 L=0.28U W=1.38U AS=0.6072P AD=0.6348P
+ PS=3.64U PD=3.68U
* device instance $255 r0 *1 156.825,34.4 pfet_03v3
M$255 VDD \$264 \$263 VDD pfet_03v3 L=1.03U W=1.08U AS=0.5292P AD=0.4752P
+ PS=3.14U PD=3.04U
* device instance $256 r0 *1 157.6,36.31 pfet_03v3
M$256 B|Y$12 B|Y$14 VDD VDD pfet_03v3 L=0.28U W=2.76U AS=1.0764P AD=0.7176P
+ PS=5.7U PD=3.8U
* device instance $258 r0 *1 159.2,36.31 pfet_03v3
M$258 B|Y$12 A|Y$18 VDD VDD pfet_03v3 L=0.28U W=2.76U AS=0.7176P AD=0.966P
+ PS=3.8U PD=5.54U
* device instance $260 r0 *1 12.345,42.235 pfet_03v3
M$260 VDD \$313 \$311 VDD pfet_03v3 L=7.75U W=1.09U AS=0.5341P AD=0.4796P
+ PS=3.16U PD=3.06U
* device instance $261 r0 *1 12.345,44.005 pfet_03v3
M$261 VDD \$358 \$357 VDD pfet_03v3 L=7.75U W=1.09U AS=0.5341P AD=0.4796P
+ PS=3.16U PD=3.06U
* device instance $262 r0 *1 21.305,42.235 pfet_03v3
M$262 VDD \$315 \$314 VDD pfet_03v3 L=7.75U W=1.09U AS=0.5341P AD=0.4796P
+ PS=3.16U PD=3.06U
* device instance $263 r0 *1 21.305,44.005 pfet_03v3
M$263 VDD \$360 \$359 VDD pfet_03v3 L=7.75U W=1.09U AS=0.5341P AD=0.4796P
+ PS=3.16U PD=3.06U
* device instance $264 r0 *1 26.905,44 pfet_03v3
M$264 VDD \$362 \$361 VDD pfet_03v3 L=1.03U W=1.08U AS=0.5292P AD=0.4752P
+ PS=3.14U PD=3.04U
* device instance $265 r0 *1 31.945,42.235 pfet_03v3
M$265 VDD \$317 \$316 VDD pfet_03v3 L=7.75U W=1.09U AS=0.5341P AD=0.4796P
+ PS=3.16U PD=3.06U
* device instance $266 r0 *1 29.28,44.15 pfet_03v3
M$266 VDD A|Y$45 \$363 VDD pfet_03v3 L=0.28U W=1.38U AS=0.6072P AD=0.3588P
+ PS=3.64U PD=1.9U
* device instance $267 r0 *1 30.08,44.15 pfet_03v3
M$267 A|Y$21 \$363 VDD VDD pfet_03v3 L=0.28U W=2.76U AS=0.7176P AD=1.4076P
+ PS=3.8U PD=6.18U
* device instance $269 r0 *1 32.64,44.15 pfet_03v3
M$269 VDD A|Y$24 \$365 VDD pfet_03v3 L=0.28U W=1.38U AS=0.6072P AD=0.3588P
+ PS=3.64U PD=1.9U
* device instance $270 r0 *1 33.44,44.15 pfet_03v3
M$270 A|Y$22 \$365 VDD VDD pfet_03v3 L=0.28U W=2.76U AS=0.7176P AD=1.4076P
+ PS=3.8U PD=6.18U
* device instance $272 r0 *1 39.785,44.005 pfet_03v3
M$272 VDD \$368 \$367 VDD pfet_03v3 L=7.75U W=1.09U AS=0.5341P AD=0.4796P
+ PS=3.16U PD=3.06U
* device instance $273 r0 *1 40.905,42.235 pfet_03v3
M$273 VDD \$319 \$318 VDD pfet_03v3 L=7.75U W=1.09U AS=0.5341P AD=0.4796P
+ PS=3.16U PD=3.06U
* device instance $274 r0 *1 49.865,42.235 pfet_03v3
M$274 VDD \$321 \$320 VDD pfet_03v3 L=7.75U W=1.09U AS=0.5341P AD=0.4796P
+ PS=3.16U PD=3.06U
* device instance $275 r0 *1 51.545,44.005 pfet_03v3
M$275 VDD \$370 \$369 VDD pfet_03v3 L=7.75U W=1.09U AS=0.5341P AD=0.4796P
+ PS=3.16U PD=3.06U
* device instance $276 r0 *1 58.825,42.235 pfet_03v3
M$276 VDD \$323 \$322 VDD pfet_03v3 L=7.75U W=1.09U AS=0.5341P AD=0.4796P
+ PS=3.16U PD=3.06U
* device instance $277 r0 *1 60.505,44.005 pfet_03v3
M$277 VDD \$372 \$371 VDD pfet_03v3 L=7.75U W=1.09U AS=0.5341P AD=0.4796P
+ PS=3.16U PD=3.06U
* device instance $278 r0 *1 64.425,42.24 pfet_03v3
M$278 VDD \$325 \$324 VDD pfet_03v3 L=1.03U W=1.08U AS=0.5292P AD=0.4752P
+ PS=3.14U PD=3.04U
* device instance $279 r0 *1 69.465,44.005 pfet_03v3
M$279 VDD \$374 \$373 VDD pfet_03v3 L=7.75U W=1.09U AS=0.5341P AD=0.4796P
+ PS=3.16U PD=3.06U
* device instance $280 r0 *1 71.145,42.235 pfet_03v3
M$280 VDD \$327 \$326 VDD pfet_03v3 L=7.75U W=1.09U AS=0.5341P AD=0.4796P
+ PS=3.16U PD=3.06U
* device instance $281 r0 *1 78.425,44.005 pfet_03v3
M$281 VDD \$376 \$375 VDD pfet_03v3 L=7.75U W=1.09U AS=0.5341P AD=0.4796P
+ PS=3.16U PD=3.06U
* device instance $282 r0 *1 80.105,42.235 pfet_03v3
M$282 VDD \$329 \$328 VDD pfet_03v3 L=7.75U W=1.09U AS=0.5341P AD=0.4796P
+ PS=3.16U PD=3.06U
* device instance $283 r0 *1 84.025,44 pfet_03v3
M$283 VDD \$378 \$377 VDD pfet_03v3 L=1.03U W=1.08U AS=0.5292P AD=0.4752P
+ PS=3.14U PD=3.04U
* device instance $284 r0 *1 89.065,42.235 pfet_03v3
M$284 VDD \$331 \$330 VDD pfet_03v3 L=7.75U W=1.09U AS=0.5341P AD=0.4796P
+ PS=3.16U PD=3.06U
* device instance $285 r0 *1 90.745,44.005 pfet_03v3
M$285 VDD \$380 \$379 VDD pfet_03v3 L=7.75U W=1.09U AS=0.5341P AD=0.4796P
+ PS=3.16U PD=3.06U
* device instance $286 r0 *1 98.025,42.235 pfet_03v3
M$286 VDD \$333 \$332 VDD pfet_03v3 L=7.75U W=1.09U AS=0.5341P AD=0.4796P
+ PS=3.16U PD=3.06U
* device instance $287 r0 *1 99.705,44.005 pfet_03v3
M$287 VDD \$382 \$381 VDD pfet_03v3 L=7.75U W=1.09U AS=0.5341P AD=0.4796P
+ PS=3.16U PD=3.06U
* device instance $288 r0 *1 103.625,42.24 pfet_03v3
M$288 VDD \$335 \$334 VDD pfet_03v3 L=1.03U W=1.08U AS=0.5292P AD=0.4752P
+ PS=3.14U PD=3.04U
* device instance $289 r0 *1 106.425,44.005 pfet_03v3
M$289 VDD \$384 \$383 VDD pfet_03v3 L=3.27U W=1.09U AS=0.5341P AD=0.4796P
+ PS=3.16U PD=3.06U
* device instance $290 r0 *1 110.345,42.235 pfet_03v3
M$290 VDD \$337 \$336 VDD pfet_03v3 L=7.75U W=1.09U AS=0.5341P AD=0.4796P
+ PS=3.16U PD=3.06U
* device instance $291 r0 *1 111.36,44.15 pfet_03v3
M$291 A|Y$23 \$400 VDD VDD pfet_03v3 L=0.28U W=2.76U AS=1.4076P AD=0.7176P
+ PS=6.18U PD=3.8U
* device instance $293 r0 *1 112.96,44.15 pfet_03v3
M$293 \$400 A|Y$25 VDD VDD pfet_03v3 L=0.28U W=1.38U AS=0.3588P AD=0.6072P
+ PS=1.9U PD=3.64U
* device instance $294 r0 *1 118.185,44.005 pfet_03v3
M$294 VDD \$387 \$386 VDD pfet_03v3 L=7.75U W=1.09U AS=0.5341P AD=0.4796P
+ PS=3.16U PD=3.06U
* device instance $295 r0 *1 119.305,42.235 pfet_03v3
M$295 VDD \$339 \$338 VDD pfet_03v3 L=7.75U W=1.09U AS=0.5341P AD=0.4796P
+ PS=3.16U PD=3.06U
* device instance $296 r0 *1 128.265,42.235 pfet_03v3
M$296 VDD \$341 \$340 VDD pfet_03v3 L=7.75U W=1.09U AS=0.5341P AD=0.4796P
+ PS=3.16U PD=3.06U
* device instance $297 r0 *1 129.945,44.005 pfet_03v3
M$297 VDD \$389 \$388 VDD pfet_03v3 L=7.75U W=1.09U AS=0.5341P AD=0.4796P
+ PS=3.16U PD=3.06U
* device instance $298 r0 *1 137.225,42.235 pfet_03v3
M$298 VDD \$343 \$342 VDD pfet_03v3 L=7.75U W=1.09U AS=0.5341P AD=0.4796P
+ PS=3.16U PD=3.06U
* device instance $299 r0 *1 138.905,44.005 pfet_03v3
M$299 VDD \$391 \$390 VDD pfet_03v3 L=7.75U W=1.09U AS=0.5341P AD=0.4796P
+ PS=3.16U PD=3.06U
* device instance $300 r0 *1 142.825,42.24 pfet_03v3
M$300 VDD \$345 \$344 VDD pfet_03v3 L=1.03U W=1.08U AS=0.5292P AD=0.4752P
+ PS=3.14U PD=3.04U
* device instance $301 r0 *1 145.625,44.005 pfet_03v3
M$301 VDD \$393 \$392 VDD pfet_03v3 L=3.27U W=1.09U AS=0.5341P AD=0.4796P
+ PS=3.16U PD=3.06U
* device instance $302 r0 *1 147.305,42.235 pfet_03v3
M$302 VDD \$347 \$346 VDD pfet_03v3 L=3.27U W=1.09U AS=0.5341P AD=0.4796P
+ PS=3.16U PD=3.06U
* device instance $303 r0 *1 148.985,44 pfet_03v3
M$303 VDD \$395 \$394 VDD pfet_03v3 L=1.03U W=1.08U AS=0.5292P AD=0.4752P
+ PS=3.14U PD=3.04U
* device instance $304 r0 *1 151.44,44.15 pfet_03v3
M$304 A|Y$19 B|Y$16 VDD VDD pfet_03v3 L=0.28U W=2.76U AS=1.0764P AD=0.7176P
+ PS=5.7U PD=3.8U
* device instance $306 r0 *1 153.04,44.15 pfet_03v3
M$306 A|Y$19 \$402 VDD VDD pfet_03v3 L=0.28U W=2.76U AS=0.7176P AD=0.966P
+ PS=3.8U PD=5.54U
* device instance $308 r0 *1 151.92,42.09 pfet_03v3
M$308 B|Y$15 A|Y$19 VDD VDD pfet_03v3 L=0.28U W=2.76U AS=0.966P AD=0.7176P
+ PS=5.54U PD=3.8U
* device instance $310 r0 *1 153.52,42.09 pfet_03v3
M$310 B|Y$15 B|Y$13 VDD VDD pfet_03v3 L=0.28U W=2.76U AS=0.7176P AD=1.0764P
+ PS=3.8U PD=5.7U
* device instance $312 r0 *1 155.28,44.15 pfet_03v3
M$312 VDD A|Y$20 \$402 VDD pfet_03v3 L=0.28U W=1.38U AS=0.6072P AD=0.6348P
+ PS=3.64U PD=3.68U
* device instance $313 r0 *1 155.92,42.09 pfet_03v3
M$313 B|Y$14 B|Y$16 VDD VDD pfet_03v3 L=0.28U W=2.76U AS=1.0764P AD=0.7176P
+ PS=5.7U PD=3.8U
* device instance $315 r0 *1 157.52,42.09 pfet_03v3
M$315 B|Y$14 A|Y$20 VDD VDD pfet_03v3 L=0.28U W=2.76U AS=0.7176P AD=0.966P
+ PS=3.8U PD=5.54U
* device instance $317 r0 *1 157.385,44 pfet_03v3
M$317 VDD \$397 \$396 VDD pfet_03v3 L=1.03U W=1.08U AS=0.5292P AD=0.4752P
+ PS=3.14U PD=3.04U
* device instance $318 r0 *1 159.52,44.15 pfet_03v3
M$318 A|Y$20 \$403 VDD VDD pfet_03v3 L=0.28U W=2.76U AS=1.4076P AD=0.7176P
+ PS=6.18U PD=3.8U
* device instance $320 r0 *1 161.12,44.15 pfet_03v3
M$320 \$403 A|COARSE_MUX[7] VDD VDD pfet_03v3 L=0.28U W=1.38U AS=0.3588P
+ AD=0.6072P PS=1.9U PD=3.64U
* device instance $321 r0 *1 160.185,42.24 pfet_03v3
M$321 VDD \$352 \$351 VDD pfet_03v3 L=1.03U W=1.08U AS=0.5292P AD=0.4752P
+ PS=3.14U PD=3.04U
* device instance $322 r0 *1 31.28,49.93 pfet_03v3
M$322 A|Y$26 \$411 VDD VDD pfet_03v3 L=0.28U W=2.76U AS=1.4076P AD=0.7176P
+ PS=6.18U PD=3.8U
* device instance $324 r0 *1 32.88,49.93 pfet_03v3
M$324 \$411 A|Y$22 VDD VDD pfet_03v3 L=0.28U W=1.38U AS=0.3588P AD=0.6072P
+ PS=1.9U PD=3.64U
* device instance $325 r0 *1 34.32,49.93 pfet_03v3
M$325 VDD A|Y$26 \$413 VDD pfet_03v3 L=0.28U W=1.38U AS=0.6072P AD=0.3588P
+ PS=3.64U PD=1.9U
* device instance $326 r0 *1 35.12,49.93 pfet_03v3
M$326 A|Y$27 \$413 VDD VDD pfet_03v3 L=0.28U W=2.76U AS=0.7176P AD=1.4076P
+ PS=3.8U PD=6.18U
* device instance $328 r0 *1 37.68,49.93 pfet_03v3
M$328 VDD A|Y$27 \$415 VDD pfet_03v3 L=0.28U W=1.38U AS=0.6072P AD=0.3588P
+ PS=3.64U PD=1.9U
* device instance $329 r0 *1 38.48,49.93 pfet_03v3
M$329 A|Y$28 \$415 VDD VDD pfet_03v3 L=0.28U W=2.76U AS=0.7176P AD=1.4076P
+ PS=3.8U PD=6.18U
* device instance $331 r0 *1 41.04,49.93 pfet_03v3
M$331 VDD A|Y$28 \$417 VDD pfet_03v3 L=0.28U W=1.38U AS=0.6072P AD=0.3588P
+ PS=3.64U PD=1.9U
* device instance $332 r0 *1 41.84,49.93 pfet_03v3
M$332 A|Y$29 \$417 VDD VDD pfet_03v3 L=0.28U W=2.76U AS=0.7176P AD=1.4076P
+ PS=3.8U PD=6.18U
* device instance $334 r0 *1 44.96,49.93 pfet_03v3
M$334 VDD A|Y$49 \$419 VDD pfet_03v3 L=0.28U W=1.38U AS=0.6072P AD=0.3588P
+ PS=3.64U PD=1.9U
* device instance $335 r0 *1 45.76,49.93 pfet_03v3
M$335 A|Y$30 \$419 VDD VDD pfet_03v3 L=0.28U W=2.76U AS=0.7176P AD=1.4076P
+ PS=3.8U PD=6.18U
* device instance $337 r0 *1 49.2,49.93 pfet_03v3
M$337 A|Y$31 \$421 VDD VDD pfet_03v3 L=0.28U W=2.76U AS=1.4076P AD=0.7176P
+ PS=6.18U PD=3.8U
* device instance $339 r0 *1 50.8,49.93 pfet_03v3
M$339 \$421 A|Y$32 VDD VDD pfet_03v3 L=0.28U W=1.38U AS=0.3588P AD=0.6072P
+ PS=1.9U PD=3.64U
* device instance $340 r0 *1 54.48,49.93 pfet_03v3
M$340 VDD A|Y$33 \$426 VDD pfet_03v3 L=0.28U W=1.38U AS=0.6072P AD=0.3588P
+ PS=3.64U PD=1.9U
* device instance $341 r0 *1 55.28,49.93 pfet_03v3
M$341 A|Y$34 \$426 VDD VDD pfet_03v3 L=0.28U W=2.76U AS=0.7176P AD=1.4076P
+ PS=3.8U PD=6.18U
* device instance $343 r0 *1 60.08,49.93 pfet_03v3
M$343 VDD A|Y$53 \$431 VDD pfet_03v3 L=0.28U W=1.38U AS=0.6072P AD=0.3588P
+ PS=3.64U PD=1.9U
* device instance $344 r0 *1 60.88,49.93 pfet_03v3
M$344 A|Y$35 \$431 VDD VDD pfet_03v3 L=0.28U W=2.76U AS=0.7176P AD=1.4076P
+ PS=3.8U PD=6.18U
* device instance $346 r0 *1 100.16,49.93 pfet_03v3
M$346 A|Y$36 \$443 VDD VDD pfet_03v3 L=0.28U W=2.76U AS=1.4076P AD=0.7176P
+ PS=6.18U PD=3.8U
* device instance $348 r0 *1 101.76,49.93 pfet_03v3
M$348 \$443 A|Y$37 VDD VDD pfet_03v3 L=0.28U W=1.38U AS=0.3588P AD=0.6072P
+ PS=1.9U PD=3.64U
* device instance $349 r0 *1 106.88,49.93 pfet_03v3
M$349 A|Y$38 \$448 VDD VDD pfet_03v3 L=0.28U W=2.76U AS=1.4076P AD=0.7176P
+ PS=6.18U PD=3.8U
* device instance $351 r0 *1 108.48,49.93 pfet_03v3
M$351 \$448 A|Y$39 VDD VDD pfet_03v3 L=0.28U W=1.38U AS=0.3588P AD=0.6072P
+ PS=1.9U PD=3.64U
* device instance $352 r0 *1 109.92,49.93 pfet_03v3
M$352 VDD A|Y$38 \$451 VDD pfet_03v3 L=0.28U W=1.38U AS=0.6072P AD=0.3588P
+ PS=3.64U PD=1.9U
* device instance $353 r0 *1 110.72,49.93 pfet_03v3
M$353 A|Y$40 \$451 VDD VDD pfet_03v3 L=0.28U W=2.76U AS=0.7176P AD=1.4076P
+ PS=3.8U PD=6.18U
* device instance $355 r0 *1 113.28,49.93 pfet_03v3
M$355 VDD A|Y$40 \$453 VDD pfet_03v3 L=0.28U W=1.38U AS=0.6072P AD=0.3588P
+ PS=3.64U PD=1.9U
* device instance $356 r0 *1 114.08,49.93 pfet_03v3
M$356 A|Y$25 \$453 VDD VDD pfet_03v3 L=0.28U W=2.76U AS=0.7176P AD=1.4076P
+ PS=3.8U PD=6.18U
* device instance $358 r0 *1 116.96,49.93 pfet_03v3
M$358 A|Y$41 \$454 VDD VDD pfet_03v3 L=0.28U W=2.76U AS=1.4076P AD=0.7176P
+ PS=6.18U PD=3.8U
* device instance $360 r0 *1 118.56,49.93 pfet_03v3
M$360 \$454 A|Y$42 VDD VDD pfet_03v3 L=0.28U W=1.38U AS=0.3588P AD=0.6072P
+ PS=1.9U PD=3.64U
* device instance $361 r0 *1 149.2,49.93 pfet_03v3
M$361 A|Y$44 B|Y$17 VDD VDD pfet_03v3 L=0.28U W=2.76U AS=1.0764P AD=0.7176P
+ PS=5.7U PD=3.8U
* device instance $363 r0 *1 150.8,49.93 pfet_03v3
M$363 A|Y$44 \$469 VDD VDD pfet_03v3 L=0.28U W=2.76U AS=0.7176P AD=0.966P
+ PS=3.8U PD=5.54U
* device instance $365 r0 *1 153.04,49.93 pfet_03v3
M$365 VDD A|Y$43 \$469 VDD pfet_03v3 L=0.28U W=1.38U AS=0.6072P AD=0.6348P
+ PS=3.64U PD=3.68U
* device instance $366 r0 *1 154.8,49.93 pfet_03v3
M$366 B|Y$18 B|Y$15 VDD VDD pfet_03v3 L=0.28U W=2.76U AS=1.0764P AD=0.7176P
+ PS=5.7U PD=3.8U
* device instance $368 r0 *1 156.4,49.93 pfet_03v3
M$368 B|Y$18 A|Y$44 VDD VDD pfet_03v3 L=0.28U W=2.76U AS=0.7176P AD=0.966P
+ PS=3.8U PD=5.54U
* device instance $370 r0 *1 159.52,49.93 pfet_03v3
M$370 A|Y$16 \$473 VDD VDD pfet_03v3 L=0.28U W=2.76U AS=1.4076P AD=0.7176P
+ PS=6.18U PD=3.8U
* device instance $372 r0 *1 161.12,49.93 pfet_03v3
M$372 \$473 A|COARSE_MUX[9] VDD VDD pfet_03v3 L=0.28U W=1.38U AS=0.3588P
+ AD=0.6072P PS=1.9U PD=3.64U
* device instance $373 r0 *1 12.345,50.075 pfet_03v3
M$373 VDD \$406 \$405 VDD pfet_03v3 L=7.75U W=1.09U AS=0.5341P AD=0.4796P
+ PS=3.16U PD=3.06U
* device instance $374 r0 *1 12.345,51.845 pfet_03v3
M$374 VDD \$477 \$476 VDD pfet_03v3 L=7.75U W=1.09U AS=0.5341P AD=0.4796P
+ PS=3.16U PD=3.06U
* device instance $375 r0 *1 21.305,50.075 pfet_03v3
M$375 VDD \$408 \$407 VDD pfet_03v3 L=7.75U W=1.09U AS=0.5341P AD=0.4796P
+ PS=3.16U PD=3.06U
* device instance $376 r0 *1 17.945,51.84 pfet_03v3
M$376 VDD \$479 \$478 VDD pfet_03v3 L=1.03U W=1.08U AS=0.5292P AD=0.4752P
+ PS=3.14U PD=3.04U
* device instance $377 r0 *1 21.76,51.99 pfet_03v3
M$377 A|Y$45 \$529 VDD VDD pfet_03v3 L=0.28U W=2.76U AS=1.4076P AD=0.7176P
+ PS=6.18U PD=3.8U
* device instance $379 r0 *1 23.36,51.99 pfet_03v3
M$379 \$529 A|Y$46 VDD VDD pfet_03v3 L=0.28U W=1.38U AS=0.3588P AD=0.6072P
+ PS=1.9U PD=3.64U
* device instance $380 r0 *1 25.12,51.99 pfet_03v3
M$380 A|Y$46 \$530 VDD VDD pfet_03v3 L=0.28U W=2.76U AS=1.4076P AD=0.7176P
+ PS=6.18U PD=3.8U
* device instance $382 r0 *1 26.72,51.99 pfet_03v3
M$382 \$530 A|Y$47 VDD VDD pfet_03v3 L=0.28U W=1.38U AS=0.3588P AD=0.6072P
+ PS=1.9U PD=3.64U
* device instance $383 r0 *1 28.585,50.08 pfet_03v3
M$383 VDD \$410 \$409 VDD pfet_03v3 L=1.03U W=1.08U AS=0.5292P AD=0.4752P
+ PS=3.14U PD=3.04U
* device instance $384 r0 *1 28.48,51.99 pfet_03v3
M$384 A|Y$47 \$531 VDD VDD pfet_03v3 L=0.28U W=2.76U AS=1.4076P AD=0.7176P
+ PS=6.18U PD=3.8U
* device instance $386 r0 *1 30.08,51.99 pfet_03v3
M$386 \$531 A|Y$48 VDD VDD pfet_03v3 L=0.28U W=1.38U AS=0.3588P AD=0.6072P
+ PS=1.9U PD=3.64U
* device instance $387 r0 *1 31.52,51.99 pfet_03v3
M$387 VDD A|Y$21 \$484 VDD pfet_03v3 L=0.28U W=1.38U AS=0.6072P AD=0.3588P
+ PS=3.64U PD=1.9U
* device instance $388 r0 *1 32.32,51.99 pfet_03v3
M$388 A|Y$24 \$484 VDD VDD pfet_03v3 L=0.28U W=2.76U AS=0.7176P AD=1.4076P
+ PS=3.8U PD=6.18U
* device instance $390 r0 *1 36.425,51.845 pfet_03v3
M$390 VDD \$486 \$485 VDD pfet_03v3 L=3.27U W=1.09U AS=0.5341P AD=0.4796P
+ PS=3.16U PD=3.06U
* device instance $391 r0 *1 40.24,51.99 pfet_03v3
M$391 A|Y$49 \$532 VDD VDD pfet_03v3 L=0.28U W=2.76U AS=1.4076P AD=0.7176P
+ PS=6.18U PD=3.8U
* device instance $393 r0 *1 41.84,51.99 pfet_03v3
M$393 \$532 A|Y$29 VDD VDD pfet_03v3 L=0.28U W=1.38U AS=0.3588P AD=0.6072P
+ PS=1.9U PD=3.64U
* device instance $394 r0 *1 43.6,51.99 pfet_03v3
M$394 A|Y$50 \$533 VDD VDD pfet_03v3 L=0.28U W=2.76U AS=1.4076P AD=0.7176P
+ PS=6.18U PD=3.8U
* device instance $396 r0 *1 45.2,51.99 pfet_03v3
M$396 \$533 A|Y$30 VDD VDD pfet_03v3 L=0.28U W=1.38U AS=0.3588P AD=0.6072P
+ PS=1.9U PD=3.64U
* device instance $397 r0 *1 48.08,51.99 pfet_03v3
M$397 A|Y$51 \$534 VDD VDD pfet_03v3 L=0.28U W=2.76U AS=1.4076P AD=0.7176P
+ PS=6.18U PD=3.8U
* device instance $399 r0 *1 49.68,51.99 pfet_03v3
M$399 \$534 A|Y$31 VDD VDD pfet_03v3 L=0.28U W=1.38U AS=0.3588P AD=0.6072P
+ PS=1.9U PD=3.64U
* device instance $400 r0 *1 51.44,51.99 pfet_03v3
M$400 A|Y$33 \$535 VDD VDD pfet_03v3 L=0.28U W=2.76U AS=1.4076P AD=0.7176P
+ PS=6.18U PD=3.8U
* device instance $402 r0 *1 53.04,51.99 pfet_03v3
M$402 \$535 A|Y$52 VDD VDD pfet_03v3 L=0.28U W=1.38U AS=0.3588P AD=0.6072P
+ PS=1.9U PD=3.64U
* device instance $403 r0 *1 52.665,50.08 pfet_03v3
M$403 VDD \$425 \$424 VDD pfet_03v3 L=1.03U W=1.08U AS=0.5292P AD=0.4752P
+ PS=3.14U PD=3.04U
* device instance $404 r0 *1 54.8,51.99 pfet_03v3
M$404 A|Y$53 \$536 VDD VDD pfet_03v3 L=0.28U W=2.76U AS=1.4076P AD=0.7176P
+ PS=6.18U PD=3.8U
* device instance $406 r0 *1 56.4,51.99 pfet_03v3
M$406 \$536 A|Y$54 VDD VDD pfet_03v3 L=0.28U W=1.38U AS=0.3588P AD=0.6072P
+ PS=1.9U PD=3.64U
* device instance $407 r0 *1 58.265,50.08 pfet_03v3
M$407 VDD \$430 \$429 VDD pfet_03v3 L=1.03U W=1.08U AS=0.5292P AD=0.4752P
+ PS=3.14U PD=3.04U
* device instance $408 r0 *1 58.16,51.99 pfet_03v3
M$408 A|Y$55 \$537 VDD VDD pfet_03v3 L=0.28U W=2.76U AS=1.4076P AD=0.7176P
+ PS=6.18U PD=3.8U
* device instance $410 r0 *1 59.76,51.99 pfet_03v3
M$410 \$537 A|Y$35 VDD VDD pfet_03v3 L=0.28U W=1.38U AS=0.3588P AD=0.6072P
+ PS=1.9U PD=3.64U
* device instance $411 r0 *1 61.2,51.99 pfet_03v3
M$411 VDD A|Y$55 \$494 VDD pfet_03v3 L=0.28U W=1.38U AS=0.6072P AD=0.3588P
+ PS=3.64U PD=1.9U
* device instance $412 r0 *1 62,51.99 pfet_03v3
M$412 A|Y$56 \$494 VDD VDD pfet_03v3 L=0.28U W=2.76U AS=0.7176P AD=1.4076P
+ PS=3.8U PD=6.18U
* device instance $414 r0 *1 63.865,50.08 pfet_03v3
M$414 VDD \$434 \$433 VDD pfet_03v3 L=1.03U W=1.08U AS=0.5292P AD=0.4752P
+ PS=3.14U PD=3.04U
* device instance $415 r0 *1 64.56,51.99 pfet_03v3
M$415 VDD A|Y$56 \$496 VDD pfet_03v3 L=0.28U W=1.38U AS=0.6072P AD=0.3588P
+ PS=3.64U PD=1.9U
* device instance $416 r0 *1 65.36,51.99 pfet_03v3
M$416 A|Y$57 \$496 VDD VDD pfet_03v3 L=0.28U W=2.76U AS=0.7176P AD=1.4076P
+ PS=3.8U PD=6.18U
* device instance $418 r0 *1 71.145,50.075 pfet_03v3
M$418 VDD \$436 \$435 VDD pfet_03v3 L=7.75U W=1.09U AS=0.5341P AD=0.4796P
+ PS=3.16U PD=3.06U
* device instance $419 r0 *1 67.92,51.99 pfet_03v3
M$419 VDD A|Y$57 \$498 VDD pfet_03v3 L=0.28U W=1.38U AS=0.6072P AD=0.3588P
+ PS=3.64U PD=1.9U
* device instance $420 r0 *1 68.72,51.99 pfet_03v3
M$420 A|Y$58 \$498 VDD VDD pfet_03v3 L=0.28U W=2.76U AS=0.7176P AD=1.4076P
+ PS=3.8U PD=6.18U
* device instance $422 r0 *1 71.84,51.99 pfet_03v3
M$422 VDD A|Y$67 \$500 VDD pfet_03v3 L=0.28U W=1.38U AS=0.6072P AD=0.3588P
+ PS=3.64U PD=1.9U
* device instance $423 r0 *1 72.64,51.99 pfet_03v3
M$423 A|Y$59 \$500 VDD VDD pfet_03v3 L=0.28U W=2.76U AS=0.7176P AD=1.4076P
+ PS=3.8U PD=6.18U
* device instance $425 r0 *1 78.985,51.845 pfet_03v3
M$425 VDD \$503 \$502 VDD pfet_03v3 L=7.75U W=1.09U AS=0.5341P AD=0.4796P
+ PS=3.16U PD=3.06U
* device instance $426 r0 *1 80.105,50.075 pfet_03v3
M$426 VDD \$438 \$437 VDD pfet_03v3 L=7.75U W=1.09U AS=0.5341P AD=0.4796P
+ PS=3.16U PD=3.06U
* device instance $427 r0 *1 89.065,50.075 pfet_03v3
M$427 VDD \$440 \$439 VDD pfet_03v3 L=7.75U W=1.09U AS=0.5341P AD=0.4796P
+ PS=3.16U PD=3.06U
* device instance $428 r0 *1 90.745,51.845 pfet_03v3
M$428 VDD \$505 \$504 VDD pfet_03v3 L=7.75U W=1.09U AS=0.5341P AD=0.4796P
+ PS=3.16U PD=3.06U
* device instance $429 r0 *1 95.785,50.075 pfet_03v3
M$429 VDD \$442 \$441 VDD pfet_03v3 L=3.27U W=1.09U AS=0.5341P AD=0.4796P
+ PS=3.16U PD=3.06U
* device instance $430 r0 *1 97.36,51.99 pfet_03v3
M$430 A|Y$60 \$539 VDD VDD pfet_03v3 L=0.28U W=2.76U AS=1.4076P AD=0.7176P
+ PS=6.18U PD=3.8U
* device instance $432 r0 *1 98.96,51.99 pfet_03v3
M$432 \$539 A|Y$61 VDD VDD pfet_03v3 L=0.28U W=1.38U AS=0.3588P AD=0.6072P
+ PS=1.9U PD=3.64U
* device instance $433 r0 *1 100.4,51.99 pfet_03v3
M$433 VDD A|Y$60 \$508 VDD pfet_03v3 L=0.28U W=1.38U AS=0.6072P AD=0.3588P
+ PS=3.64U PD=1.9U
* device instance $434 r0 *1 101.2,51.99 pfet_03v3
M$434 A|Y$37 \$508 VDD VDD pfet_03v3 L=0.28U W=2.76U AS=0.7176P AD=1.4076P
+ PS=3.8U PD=6.18U
* device instance $436 r0 *1 103.625,50.08 pfet_03v3
M$436 VDD \$447 \$446 VDD pfet_03v3 L=1.03U W=1.08U AS=0.5292P AD=0.4752P
+ PS=3.14U PD=3.04U
* device instance $437 r0 *1 103.76,51.99 pfet_03v3
M$437 VDD A|Y$36 \$509 VDD pfet_03v3 L=0.28U W=1.38U AS=0.6072P AD=0.3588P
+ PS=3.64U PD=1.9U
* device instance $438 r0 *1 104.56,51.99 pfet_03v3
M$438 A|Y$62 \$509 VDD VDD pfet_03v3 L=0.28U W=2.76U AS=0.7176P AD=1.4076P
+ PS=3.8U PD=6.18U
* device instance $440 r0 *1 107.12,51.99 pfet_03v3
M$440 VDD A|Y$62 \$511 VDD pfet_03v3 L=0.28U W=1.38U AS=0.6072P AD=0.3588P
+ PS=3.64U PD=1.9U
* device instance $441 r0 *1 107.92,51.99 pfet_03v3
M$441 A|Y$39 \$511 VDD VDD pfet_03v3 L=0.28U W=2.76U AS=0.7176P AD=1.4076P
+ PS=3.8U PD=6.18U
* device instance $443 r0 *1 110.905,51.84 pfet_03v3
M$443 VDD \$513 \$512 VDD pfet_03v3 L=1.03U W=1.08U AS=0.5292P AD=0.4752P
+ PS=3.14U PD=3.04U
* device instance $444 r0 *1 112.72,51.99 pfet_03v3
M$444 VDD A|Y$23 \$514 VDD pfet_03v3 L=0.28U W=1.38U AS=0.6072P AD=0.3588P
+ PS=3.64U PD=1.9U
* device instance $445 r0 *1 113.52,51.99 pfet_03v3
M$445 A|Y$63 \$514 VDD VDD pfet_03v3 L=0.28U W=2.76U AS=0.7176P AD=1.4076P
+ PS=3.8U PD=6.18U
* device instance $447 r0 *1 116.4,51.99 pfet_03v3
M$447 A|Y$64 \$540 VDD VDD pfet_03v3 L=0.28U W=2.76U AS=1.4076P AD=0.7176P
+ PS=6.18U PD=3.8U
* device instance $449 r0 *1 118,51.99 pfet_03v3
M$449 \$540 A|Y$41 VDD VDD pfet_03v3 L=0.28U W=1.38U AS=0.3588P AD=0.6072P
+ PS=1.9U PD=3.64U
* device instance $450 r0 *1 119.44,51.99 pfet_03v3
M$450 VDD A|Y$63 \$517 VDD pfet_03v3 L=0.28U W=1.38U AS=0.6072P AD=0.3588P
+ PS=3.64U PD=1.9U
* device instance $451 r0 *1 120.24,51.99 pfet_03v3
M$451 A|Y$42 \$517 VDD VDD pfet_03v3 L=0.28U W=2.76U AS=0.7176P AD=1.4076P
+ PS=3.8U PD=6.18U
* device instance $453 r0 *1 123.785,50.075 pfet_03v3
M$453 VDD \$458 \$457 VDD pfet_03v3 L=7.75U W=1.09U AS=0.5341P AD=0.4796P
+ PS=3.16U PD=3.06U
* device instance $454 r0 *1 123.225,51.84 pfet_03v3
M$454 VDD \$519 \$518 VDD pfet_03v3 L=1.03U W=1.08U AS=0.5292P AD=0.4752P
+ PS=3.14U PD=3.04U
* device instance $455 r0 *1 129.945,51.845 pfet_03v3
M$455 VDD \$521 \$520 VDD pfet_03v3 L=7.75U W=1.09U AS=0.5341P AD=0.4796P
+ PS=3.16U PD=3.06U
* device instance $456 r0 *1 132.745,50.075 pfet_03v3
M$456 VDD \$460 \$459 VDD pfet_03v3 L=7.75U W=1.09U AS=0.5341P AD=0.4796P
+ PS=3.16U PD=3.06U
* device instance $457 r0 *1 138.905,51.845 pfet_03v3
M$457 VDD \$523 \$522 VDD pfet_03v3 L=7.75U W=1.09U AS=0.5341P AD=0.4796P
+ PS=3.16U PD=3.06U
* device instance $458 r0 *1 139.465,50.075 pfet_03v3
M$458 VDD \$462 \$461 VDD pfet_03v3 L=3.27U W=1.09U AS=0.5341P AD=0.4796P
+ PS=3.16U PD=3.06U
* device instance $459 r0 *1 142.825,50.08 pfet_03v3
M$459 VDD \$464 \$463 VDD pfet_03v3 L=1.03U W=1.08U AS=0.5292P AD=0.4752P
+ PS=3.14U PD=3.04U
* device instance $460 r0 *1 145.2,51.99 pfet_03v3
M$460 B|Y$19 A|Y$65 VDD VDD pfet_03v3 L=0.28U W=2.76U AS=0.966P AD=0.7176P
+ PS=5.54U PD=3.8U
* device instance $462 r0 *1 146.8,51.99 pfet_03v3
M$462 B|Y$19 B|Y$18 VDD VDD pfet_03v3 L=0.28U W=2.76U AS=0.7176P AD=1.0764P
+ PS=3.8U PD=5.7U
* device instance $464 r0 *1 146.185,50.08 pfet_03v3
M$464 VDD \$466 \$465 VDD pfet_03v3 L=1.03U W=1.08U AS=0.5292P AD=0.4752P
+ PS=3.14U PD=3.04U
* device instance $465 r0 *1 149.2,51.99 pfet_03v3
M$465 B|Y$17 B|Y$20 VDD VDD pfet_03v3 L=0.28U W=2.76U AS=1.0764P AD=0.7176P
+ PS=5.7U PD=3.8U
* device instance $467 r0 *1 150.8,51.99 pfet_03v3
M$467 B|Y$17 A|Y$66 VDD VDD pfet_03v3 L=0.28U W=2.76U AS=0.7176P AD=0.966P
+ PS=3.8U PD=5.54U
* device instance $469 r0 *1 153.04,51.99 pfet_03v3
M$469 B|Y$16 A|Y$43 VDD VDD pfet_03v3 L=0.28U W=2.76U AS=0.966P AD=0.7176P
+ PS=5.54U PD=3.8U
* device instance $471 r0 *1 154.64,51.99 pfet_03v3
M$471 B|Y$16 B|Y$17 VDD VDD pfet_03v3 L=0.28U W=2.76U AS=0.7176P AD=1.0764P
+ PS=3.8U PD=5.7U
* device instance $473 r0 *1 157.385,51.84 pfet_03v3
M$473 VDD \$528 \$527 VDD pfet_03v3 L=1.03U W=1.08U AS=0.5292P AD=0.4752P
+ PS=3.14U PD=3.04U
* device instance $474 r0 *1 159.52,51.99 pfet_03v3
M$474 A|Y$43 \$542 VDD VDD pfet_03v3 L=0.28U W=2.76U AS=1.4076P AD=0.7176P
+ PS=6.18U PD=3.8U
* device instance $476 r0 *1 161.12,51.99 pfet_03v3
M$476 \$542 A|COARSE_MUX[6] VDD VDD pfet_03v3 L=0.28U W=1.38U AS=0.3588P
+ AD=0.6072P PS=1.9U PD=3.64U
* device instance $477 r0 *1 12.345,57.915 pfet_03v3
M$477 VDD \$564 \$563 VDD pfet_03v3 L=7.75U W=1.09U AS=0.5341P AD=0.4796P
+ PS=3.16U PD=3.06U
* device instance $478 r0 *1 12.345,59.685 pfet_03v3
M$478 VDD \$644 \$614 VDD pfet_03v3 L=7.75U W=1.09U AS=0.5341P AD=0.4796P
+ PS=3.16U PD=3.06U
* device instance $479 r0 *1 21.305,57.915 pfet_03v3
M$479 VDD \$566 \$565 VDD pfet_03v3 L=7.75U W=1.09U AS=0.5341P AD=0.4796P
+ PS=3.16U PD=3.06U
* device instance $480 r0 *1 21.305,59.685 pfet_03v3
M$480 VDD \$645 \$615 VDD pfet_03v3 L=7.75U W=1.09U AS=0.5341P AD=0.4796P
+ PS=3.16U PD=3.06U
* device instance $481 r0 *1 28.48,59.83 pfet_03v3
M$481 A|Y$77 \$646 VDD VDD pfet_03v3 L=0.28U W=2.76U AS=1.4076P AD=0.7176P
+ PS=6.18U PD=3.8U
* device instance $483 r0 *1 30.08,59.83 pfet_03v3
M$483 \$646 A|Y$83 VDD VDD pfet_03v3 L=0.28U W=1.38U AS=0.3588P AD=0.6072P
+ PS=1.9U PD=3.64U
* device instance $484 r0 *1 28.72,57.77 pfet_03v3
M$484 VDD A|Y$77 \$567 VDD pfet_03v3 L=0.28U W=1.38U AS=0.6072P AD=0.3588P
+ PS=3.64U PD=1.9U
* device instance $485 r0 *1 29.52,57.77 pfet_03v3
M$485 A|Y$48 \$567 VDD VDD pfet_03v3 L=0.28U W=2.76U AS=0.7176P AD=1.4076P
+ PS=3.8U PD=6.18U
* device instance $487 r0 *1 31.52,59.83 pfet_03v3
M$487 VDD A|Y$89 \$616 VDD pfet_03v3 L=0.28U W=1.38U AS=0.6072P AD=0.3588P
+ PS=3.64U PD=1.9U
* device instance $488 r0 *1 32.32,59.83 pfet_03v3
M$488 A|Y$83 \$616 VDD VDD pfet_03v3 L=0.28U W=2.76U AS=0.7176P AD=1.4076P
+ PS=3.8U PD=6.18U
* device instance $490 r0 *1 35.865,57.915 pfet_03v3
M$490 VDD \$570 \$569 VDD pfet_03v3 L=7.75U W=1.09U AS=0.5341P AD=0.4796P
+ PS=3.16U PD=3.06U
* device instance $491 r0 *1 35.2,59.83 pfet_03v3
M$491 A|Y$84 \$648 VDD VDD pfet_03v3 L=0.28U W=2.76U AS=1.4076P AD=0.7176P
+ PS=6.18U PD=3.8U
* device instance $493 r0 *1 36.8,59.83 pfet_03v3
M$493 \$648 A|Y$90 VDD VDD pfet_03v3 L=0.28U W=1.38U AS=0.3588P AD=0.6072P
+ PS=1.9U PD=3.64U
* device instance $494 r0 *1 39.785,59.685 pfet_03v3
M$494 VDD \$650 \$619 VDD pfet_03v3 L=3.27U W=1.09U AS=0.5341P AD=0.4796P
+ PS=3.16U PD=3.06U
* device instance $495 r0 *1 42.585,57.915 pfet_03v3
M$495 VDD \$572 \$571 VDD pfet_03v3 L=3.27U W=1.09U AS=0.5341P AD=0.4796P
+ PS=3.16U PD=3.06U
* device instance $496 r0 *1 43.145,59.68 pfet_03v3
M$496 VDD \$651 \$620 VDD pfet_03v3 L=1.03U W=1.08U AS=0.5292P AD=0.4752P
+ PS=3.14U PD=3.04U
* device instance $497 r0 *1 45.945,57.92 pfet_03v3
M$497 VDD \$546 \$573 VDD pfet_03v3 L=1.03U W=1.08U AS=0.5292P AD=0.4752P
+ PS=3.14U PD=3.04U
* device instance $498 r0 *1 51.545,59.685 pfet_03v3
M$498 VDD \$652 \$621 VDD pfet_03v3 L=7.75U W=1.09U AS=0.5341P AD=0.4796P
+ PS=3.16U PD=3.06U
* device instance $499 r0 *1 48.32,57.77 pfet_03v3
M$499 VDD A|Y$50 \$574 VDD pfet_03v3 L=0.28U W=1.38U AS=0.6072P AD=0.3588P
+ PS=3.64U PD=1.9U
* device instance $500 r0 *1 49.12,57.77 pfet_03v3
M$500 A|Y$32 \$574 VDD VDD pfet_03v3 L=0.28U W=2.76U AS=0.7176P AD=1.4076P
+ PS=3.8U PD=6.18U
* device instance $502 r0 *1 51.68,57.77 pfet_03v3
M$502 VDD A|Y$51 \$575 VDD pfet_03v3 L=0.28U W=1.38U AS=0.6072P AD=0.3588P
+ PS=3.64U PD=1.9U
* device instance $503 r0 *1 52.48,57.77 pfet_03v3
M$503 A|Y$52 \$575 VDD VDD pfet_03v3 L=0.28U W=2.76U AS=0.7176P AD=1.4076P
+ PS=3.8U PD=6.18U
* device instance $505 r0 *1 55.465,57.92 pfet_03v3
M$505 VDD \$547 \$576 VDD pfet_03v3 L=1.03U W=1.08U AS=0.5292P AD=0.4752P
+ PS=3.14U PD=3.04U
* device instance $506 r0 *1 60.505,59.685 pfet_03v3
M$506 VDD \$653 \$622 VDD pfet_03v3 L=7.75U W=1.09U AS=0.5341P AD=0.4796P
+ PS=3.16U PD=3.06U
* device instance $507 r0 *1 57.28,57.77 pfet_03v3
M$507 VDD A|Y$34 \$577 VDD pfet_03v3 L=0.28U W=1.38U AS=0.6072P AD=0.3588P
+ PS=3.64U PD=1.9U
* device instance $508 r0 *1 58.08,57.77 pfet_03v3
M$508 A|Y$54 \$577 VDD VDD pfet_03v3 L=0.28U W=2.76U AS=0.7176P AD=1.4076P
+ PS=3.8U PD=6.18U
* device instance $510 r0 *1 62.185,57.915 pfet_03v3
M$510 VDD \$579 \$578 VDD pfet_03v3 L=3.27U W=1.09U AS=0.5341P AD=0.4796P
+ PS=3.16U PD=3.06U
* device instance $511 r0 *1 66.105,59.68 pfet_03v3
M$511 VDD \$654 \$623 VDD pfet_03v3 L=1.03U W=1.08U AS=0.5292P AD=0.4752P
+ PS=3.14U PD=3.04U
* device instance $512 r0 *1 67.785,57.92 pfet_03v3
M$512 VDD \$548 \$580 VDD pfet_03v3 L=1.03U W=1.08U AS=0.5292P AD=0.4752P
+ PS=3.14U PD=3.04U
* device instance $513 r0 *1 69.04,59.83 pfet_03v3
M$513 VDD A|Y$58 \$624 VDD pfet_03v3 L=0.28U W=1.38U AS=0.6072P AD=0.3588P
+ PS=3.64U PD=1.9U
* device instance $514 r0 *1 69.84,59.83 pfet_03v3
M$514 A|Y$67 \$624 VDD VDD pfet_03v3 L=0.28U W=2.76U AS=0.7176P AD=1.4076P
+ PS=3.8U PD=6.18U
* device instance $516 r0 *1 70.48,57.77 pfet_03v3
M$516 A|Y$78 \$581 VDD VDD pfet_03v3 L=0.28U W=2.76U AS=1.4076P AD=0.7176P
+ PS=6.18U PD=3.8U
* device instance $518 r0 *1 72.08,57.77 pfet_03v3
M$518 \$581 A|Y$59 VDD VDD pfet_03v3 L=0.28U W=1.38U AS=0.3588P AD=0.6072P
+ PS=1.9U PD=3.64U
* device instance $519 r0 *1 73.945,59.685 pfet_03v3
M$519 VDD \$655 \$625 VDD pfet_03v3 L=3.27U W=1.09U AS=0.5341P AD=0.4796P
+ PS=3.16U PD=3.06U
* device instance $520 r0 *1 73.52,57.77 pfet_03v3
M$520 VDD A|Y$78 \$582 VDD pfet_03v3 L=0.28U W=1.38U AS=0.6072P AD=0.3588P
+ PS=3.64U PD=1.9U
* device instance $521 r0 *1 74.32,57.77 pfet_03v3
M$521 A|Y$68 \$582 VDD VDD pfet_03v3 L=0.28U W=2.76U AS=0.7176P AD=1.4076P
+ PS=3.8U PD=6.18U
* device instance $523 r0 *1 76.88,57.77 pfet_03v3
M$523 VDD A|Y$68 \$584 VDD pfet_03v3 L=0.28U W=1.38U AS=0.6072P AD=0.3588P
+ PS=3.64U PD=1.9U
* device instance $524 r0 *1 77.68,57.77 pfet_03v3
M$524 A|Y$69 \$584 VDD VDD pfet_03v3 L=0.28U W=2.76U AS=0.7176P AD=1.4076P
+ PS=3.8U PD=6.18U
* device instance $526 r0 *1 77.305,59.68 pfet_03v3
M$526 VDD \$656 \$626 VDD pfet_03v3 L=1.03U W=1.08U AS=0.5292P AD=0.4752P
+ PS=3.14U PD=3.04U
* device instance $527 r0 *1 79.44,59.83 pfet_03v3
M$527 A|Y$79 \$657 VDD VDD pfet_03v3 L=0.28U W=2.76U AS=1.4076P AD=0.7176P
+ PS=6.18U PD=3.8U
* device instance $529 r0 *1 81.04,59.83 pfet_03v3
M$529 \$657 A|Y$70 VDD VDD pfet_03v3 L=0.28U W=1.38U AS=0.3588P AD=0.6072P
+ PS=1.9U PD=3.64U
* device instance $530 r0 *1 80.24,57.77 pfet_03v3
M$530 VDD A|Y$69 \$585 VDD pfet_03v3 L=0.28U W=1.38U AS=0.6072P AD=0.3588P
+ PS=3.64U PD=1.9U
* device instance $531 r0 *1 81.04,57.77 pfet_03v3
M$531 A|Y$70 \$585 VDD VDD pfet_03v3 L=0.28U W=2.76U AS=0.7176P AD=1.4076P
+ PS=3.8U PD=6.18U
* device instance $533 r0 *1 82.8,59.83 pfet_03v3
M$533 A|Y$85 \$658 VDD VDD pfet_03v3 L=0.28U W=2.76U AS=1.4076P AD=0.7176P
+ PS=6.18U PD=3.8U
* device instance $535 r0 *1 84.4,59.83 pfet_03v3
M$535 \$658 A|Y$71 VDD VDD pfet_03v3 L=0.28U W=1.38U AS=0.3588P AD=0.6072P
+ PS=1.9U PD=3.64U
* device instance $536 r0 *1 84.16,57.77 pfet_03v3
M$536 VDD A|Y$79 \$587 VDD pfet_03v3 L=0.28U W=1.38U AS=0.6072P AD=0.3588P
+ PS=3.64U PD=1.9U
* device instance $537 r0 *1 84.96,57.77 pfet_03v3
M$537 A|Y$71 \$587 VDD VDD pfet_03v3 L=0.28U W=2.76U AS=0.7176P AD=1.4076P
+ PS=3.8U PD=6.18U
* device instance $539 r0 *1 87.52,57.77 pfet_03v3
M$539 VDD A|Y$85 \$588 VDD pfet_03v3 L=0.28U W=1.38U AS=0.6072P AD=0.3588P
+ PS=3.64U PD=1.9U
* device instance $540 r0 *1 88.32,57.77 pfet_03v3
M$540 A|Y$72 \$588 VDD VDD pfet_03v3 L=0.28U W=2.76U AS=0.7176P AD=1.4076P
+ PS=3.8U PD=6.18U
* device instance $542 r0 *1 88.08,59.83 pfet_03v3
M$542 VDD A|Y$72 \$628 VDD pfet_03v3 L=0.28U W=1.38U AS=0.6072P AD=0.3588P
+ PS=3.64U PD=1.9U
* device instance $543 r0 *1 88.88,59.83 pfet_03v3
M$543 A|Y$86 \$628 VDD VDD pfet_03v3 L=0.28U W=2.76U AS=0.7176P AD=1.4076P
+ PS=3.8U PD=6.18U
* device instance $545 r0 *1 91.305,57.92 pfet_03v3
M$545 VDD \$554 \$589 VDD pfet_03v3 L=1.03U W=1.08U AS=0.5292P AD=0.4752P
+ PS=3.14U PD=3.04U
* device instance $546 r0 *1 91.44,59.83 pfet_03v3
M$546 VDD A|Y$86 \$630 VDD pfet_03v3 L=0.28U W=1.38U AS=0.6072P AD=0.3588P
+ PS=3.64U PD=1.9U
* device instance $547 r0 *1 92.24,59.83 pfet_03v3
M$547 A|Y$80 \$630 VDD VDD pfet_03v3 L=0.28U W=2.76U AS=0.7176P AD=1.4076P
+ PS=3.8U PD=6.18U
* device instance $549 r0 *1 93.12,57.77 pfet_03v3
M$549 VDD A|Y$80 \$590 VDD pfet_03v3 L=0.28U W=1.38U AS=0.6072P AD=0.3588P
+ PS=3.64U PD=1.9U
* device instance $550 r0 *1 93.92,57.77 pfet_03v3
M$550 A|Y$73 \$590 VDD VDD pfet_03v3 L=0.28U W=2.76U AS=0.7176P AD=1.4076P
+ PS=3.8U PD=6.18U
* device instance $552 r0 *1 98.585,59.685 pfet_03v3
M$552 VDD \$659 \$631 VDD pfet_03v3 L=7.75U W=1.09U AS=0.5341P AD=0.4796P
+ PS=3.16U PD=3.06U
* device instance $553 r0 *1 96.48,57.77 pfet_03v3
M$553 VDD A|Y$73 \$592 VDD pfet_03v3 L=0.28U W=1.38U AS=0.6072P AD=0.3588P
+ PS=3.64U PD=1.9U
* device instance $554 r0 *1 97.28,57.77 pfet_03v3
M$554 A|Y$74 \$592 VDD VDD pfet_03v3 L=0.28U W=2.76U AS=0.7176P AD=1.4076P
+ PS=3.8U PD=6.18U
* device instance $556 r0 *1 99.84,57.77 pfet_03v3
M$556 VDD A|Y$74 \$593 VDD pfet_03v3 L=0.28U W=1.38U AS=0.6072P AD=0.3588P
+ PS=3.64U PD=1.9U
* device instance $557 r0 *1 100.64,57.77 pfet_03v3
M$557 A|Y$61 \$593 VDD VDD pfet_03v3 L=0.28U W=2.76U AS=0.7176P AD=1.4076P
+ PS=3.8U PD=6.18U
* device instance $559 r0 *1 103.625,57.92 pfet_03v3
M$559 VDD \$557 \$594 VDD pfet_03v3 L=1.03U W=1.08U AS=0.5292P AD=0.4752P
+ PS=3.14U PD=3.04U
* device instance $560 r0 *1 107.545,59.685 pfet_03v3
M$560 VDD \$660 \$632 VDD pfet_03v3 L=7.75U W=1.09U AS=0.5341P AD=0.4796P
+ PS=3.16U PD=3.06U
* device instance $561 r0 *1 108.105,57.915 pfet_03v3
M$561 VDD \$596 \$595 VDD pfet_03v3 L=3.27U W=1.09U AS=0.5341P AD=0.4796P
+ PS=3.16U PD=3.06U
* device instance $562 r0 *1 111.465,57.92 pfet_03v3
M$562 VDD \$558 \$597 VDD pfet_03v3 L=1.03U W=1.08U AS=0.5292P AD=0.4752P
+ PS=3.14U PD=3.04U
* device instance $563 r0 *1 113.145,59.68 pfet_03v3
M$563 VDD \$661 \$633 VDD pfet_03v3 L=1.03U W=1.08U AS=0.5292P AD=0.4752P
+ PS=3.14U PD=3.04U
* device instance $564 r0 *1 114.72,57.77 pfet_03v3
M$564 A|Y$81 \$598 VDD VDD pfet_03v3 L=0.28U W=2.76U AS=1.4076P AD=0.7176P
+ PS=6.18U PD=3.8U
* device instance $566 r0 *1 116.32,57.77 pfet_03v3
M$566 \$598 A|Y$64 VDD VDD pfet_03v3 L=0.28U W=1.38U AS=0.3588P AD=0.6072P
+ PS=1.9U PD=3.64U
* device instance $567 r0 *1 115.28,59.83 pfet_03v3
M$567 A|Y$87 \$662 VDD VDD pfet_03v3 L=0.28U W=2.76U AS=1.4076P AD=0.7176P
+ PS=6.18U PD=3.8U
* device instance $569 r0 *1 116.88,59.83 pfet_03v3
M$569 \$662 A|Y$75 VDD VDD pfet_03v3 L=0.28U W=1.38U AS=0.3588P AD=0.6072P
+ PS=1.9U PD=3.64U
* device instance $570 r0 *1 117.76,57.77 pfet_03v3
M$570 VDD A|Y$81 \$599 VDD pfet_03v3 L=0.28U W=1.38U AS=0.6072P AD=0.3588P
+ PS=3.64U PD=1.9U
* device instance $571 r0 *1 118.56,57.77 pfet_03v3
M$571 A|Y$75 \$599 VDD VDD pfet_03v3 L=0.28U W=2.76U AS=0.7176P AD=1.4076P
+ PS=3.8U PD=6.18U
* device instance $573 r0 *1 118.32,59.83 pfet_03v3
M$573 VDD A|Y$87 \$635 VDD pfet_03v3 L=0.28U W=1.38U AS=0.6072P AD=0.3588P
+ PS=3.64U PD=1.9U
* device instance $574 r0 *1 119.12,59.83 pfet_03v3
M$574 A|Y$88 \$635 VDD VDD pfet_03v3 L=0.28U W=2.76U AS=0.7176P AD=1.4076P
+ PS=3.8U PD=6.18U
* device instance $576 r0 *1 124.905,57.915 pfet_03v3
M$576 VDD \$602 \$601 VDD pfet_03v3 L=7.75U W=1.09U AS=0.5341P AD=0.4796P
+ PS=3.16U PD=3.06U
* device instance $577 r0 *1 122.105,59.68 pfet_03v3
M$577 VDD \$663 \$637 VDD pfet_03v3 L=1.03U W=1.08U AS=0.5292P AD=0.4752P
+ PS=3.14U PD=3.04U
* device instance $578 r0 *1 129.945,59.685 pfet_03v3
M$578 VDD \$664 \$638 VDD pfet_03v3 L=7.75U W=1.09U AS=0.5341P AD=0.4796P
+ PS=3.16U PD=3.06U
* device instance $579 r0 *1 133.865,57.915 pfet_03v3
M$579 VDD \$604 \$603 VDD pfet_03v3 L=7.75U W=1.09U AS=0.5341P AD=0.4796P
+ PS=3.16U PD=3.06U
* device instance $580 r0 *1 135.545,59.68 pfet_03v3
M$580 VDD \$665 \$639 VDD pfet_03v3 L=1.03U W=1.08U AS=0.5292P AD=0.4752P
+ PS=3.14U PD=3.04U
* device instance $581 r0 *1 138.56,59.83 pfet_03v3
M$581 A|Y$82 B|Y$22 VDD VDD pfet_03v3 L=0.28U W=2.76U AS=1.0764P AD=0.7176P
+ PS=5.7U PD=3.8U
* device instance $583 r0 *1 140.16,59.83 pfet_03v3
M$583 A|Y$82 \$667 VDD VDD pfet_03v3 L=0.28U W=2.76U AS=0.7176P AD=0.966P
+ PS=3.8U PD=5.54U
* device instance $585 r0 *1 140.16,57.77 pfet_03v3
M$585 B|Y$21 A|Y$82 VDD VDD pfet_03v3 L=0.28U W=2.76U AS=0.966P AD=0.7176P
+ PS=5.54U PD=3.8U
* device instance $587 r0 *1 141.76,57.77 pfet_03v3
M$587 B|Y$21 B|Y$19 VDD VDD pfet_03v3 L=0.28U W=2.76U AS=0.7176P AD=1.0764P
+ PS=3.8U PD=5.7U
* device instance $589 r0 *1 142.4,59.83 pfet_03v3
M$589 VDD A|Y$76 \$667 VDD pfet_03v3 L=0.28U W=1.38U AS=0.6072P AD=0.6348P
+ PS=3.64U PD=3.68U
* device instance $590 r0 *1 144.08,59.83 pfet_03v3
M$590 B|Y$20 A|Y$76 VDD VDD pfet_03v3 L=0.28U W=2.76U AS=0.966P AD=0.7176P
+ PS=5.54U PD=3.8U
* device instance $592 r0 *1 145.68,59.83 pfet_03v3
M$592 B|Y$20 B|Y$22 VDD VDD pfet_03v3 L=0.28U W=2.76U AS=0.7176P AD=1.0764P
+ PS=3.8U PD=5.7U
* device instance $594 r0 *1 145.84,57.77 pfet_03v3
M$594 A|Y$65 B|Y$20 VDD VDD pfet_03v3 L=0.28U W=2.76U AS=1.0764P AD=0.7176P
+ PS=5.7U PD=3.8U
* device instance $596 r0 *1 147.44,57.77 pfet_03v3
M$596 A|Y$65 \$606 VDD VDD pfet_03v3 L=0.28U W=2.76U AS=0.7176P AD=0.966P
+ PS=3.8U PD=5.54U
* device instance $598 r0 *1 149.545,59.685 pfet_03v3
M$598 VDD \$669 \$640 VDD pfet_03v3 L=3.27U W=1.09U AS=0.5341P AD=0.4796P
+ PS=3.16U PD=3.06U
* device instance $599 r0 *1 149.68,57.77 pfet_03v3
M$599 VDD A|Y$66 \$606 VDD pfet_03v3 L=0.28U W=1.38U AS=0.6072P AD=0.6348P
+ PS=3.64U PD=3.68U
* device instance $600 r0 *1 152.905,57.915 pfet_03v3
M$600 VDD \$608 \$607 VDD pfet_03v3 L=3.27U W=1.09U AS=0.5341P AD=0.4796P
+ PS=3.16U PD=3.06U
* device instance $601 r0 *1 153.6,59.83 pfet_03v3
M$601 Y$4 A|Y$91 VDD VDD pfet_03v3 L=0.28U W=2.76U AS=0.966P AD=0.7176P
+ PS=5.54U PD=3.8U
* device instance $603 r0 *1 155.2,59.83 pfet_03v3
M$603 Y$4 A|B|Y VDD VDD pfet_03v3 L=0.28U W=2.76U AS=0.7176P AD=1.1592P PS=3.8U
+ PD=4.44U
* device instance $605 r0 *1 157.44,59.83 pfet_03v3
M$605 Y$4 C|Y$4 VDD VDD pfet_03v3 L=0.28U W=2.76U AS=1.1592P AD=0.9798P
+ PS=4.44U PD=5.56U
* device instance $607 r0 *1 156.16,57.77 pfet_03v3
M$607 A|Y$66 \$609 VDD VDD pfet_03v3 L=0.28U W=2.76U AS=1.4076P AD=0.7176P
+ PS=6.18U PD=3.8U
* device instance $609 r0 *1 157.76,57.77 pfet_03v3
M$609 \$609 A|COARSE_MUX[5] VDD VDD pfet_03v3 L=0.28U W=1.38U AS=0.3588P
+ AD=0.6072P PS=1.9U PD=3.64U
* device instance $610 r0 *1 159.52,57.77 pfet_03v3
M$610 A|Y$76 \$611 VDD VDD pfet_03v3 L=0.28U W=2.76U AS=1.4076P AD=0.7176P
+ PS=6.18U PD=3.8U
* device instance $612 r0 *1 161.12,57.77 pfet_03v3
M$612 \$611 A|COARSE_MUX[4] VDD VDD pfet_03v3 L=0.28U W=1.38U AS=0.3588P
+ AD=0.6072P PS=1.9U PD=3.64U
* device instance $613 r0 *1 160.185,59.68 pfet_03v3
M$613 VDD \$671 \$642 VDD pfet_03v3 L=1.03U W=1.08U AS=0.5292P AD=0.4752P
+ PS=3.14U PD=3.04U
* device instance $614 r0 *1 8.985,67.52 pfet_03v3
M$614 VDD \$764 \$737 VDD pfet_03v3 L=1.03U W=1.08U AS=0.5292P AD=0.4752P
+ PS=3.14U PD=3.04U
* device instance $615 r0 *1 12.345,65.755 pfet_03v3
M$615 VDD \$678 \$677 VDD pfet_03v3 L=7.75U W=1.09U AS=0.5341P AD=0.4796P
+ PS=3.16U PD=3.06U
* device instance $616 r0 *1 12.8,67.67 pfet_03v3
M$616 A|Y$103 \$765 VDD VDD pfet_03v3 L=0.28U W=2.76U AS=1.4076P AD=0.7176P
+ PS=6.18U PD=3.8U
* device instance $618 r0 *1 14.4,67.67 pfet_03v3
M$618 \$765 A|Q VDD VDD pfet_03v3 L=0.28U W=1.38U AS=0.3588P AD=0.6072P PS=1.9U
+ PD=3.64U
* device instance $619 r0 *1 16.265,67.52 pfet_03v3
M$619 VDD \$767 \$739 VDD pfet_03v3 L=1.03U W=1.08U AS=0.5292P AD=0.4752P
+ PS=3.14U PD=3.04U
* device instance $620 r0 *1 21.305,65.755 pfet_03v3
M$620 VDD \$680 \$679 VDD pfet_03v3 L=7.75U W=1.09U AS=0.5341P AD=0.4796P
+ PS=3.16U PD=3.06U
* device instance $621 r0 *1 18.08,67.67 pfet_03v3
M$621 VDD A|CLK|REF \$740 VDD pfet_03v3 L=0.28U W=1.38U AS=0.6072P AD=0.3588P
+ PS=3.64U PD=1.9U
* device instance $622 r0 *1 18.88,67.67 pfet_03v3
M$622 \$741 \$740 VDD VDD pfet_03v3 L=0.28U W=1.38U AS=0.3588P AD=0.6693P
+ PS=1.9U PD=3.73U
* device instance $623 r0 *1 20.892,67.67 pfet_03v3
M$623 \$816 \$740 VDD VDD pfet_03v3 L=0.285U W=1.38U AS=1.3317P AD=0.2139P
+ PS=4.69U PD=1.69U
* device instance $624 r0 *1 21.485,67.67 pfet_03v3
M$624 \$770 D|Y \$816 VDD pfet_03v3 L=0.28U W=1.38U AS=0.2139P AD=0.5313P
+ PS=1.69U PD=2.15U
* device instance $625 r0 *1 22.537,67.67 pfet_03v3
M$625 \$817 \$741 \$770 VDD pfet_03v3 L=0.285U W=1.38U AS=0.5313P AD=0.86595P
+ PS=2.15U PD=2.635U
* device instance $626 r0 *1 24.075,67.67 pfet_03v3
M$626 VDD \$771 \$817 VDD pfet_03v3 L=0.28U W=1.38U AS=0.86595P AD=0.3588P
+ PS=2.635U PD=1.9U
* device instance $627 r0 *1 24.875,67.67 pfet_03v3
M$627 \$771 \$770 VDD VDD pfet_03v3 L=0.28U W=1.38U AS=0.3588P AD=0.83145P
+ PS=1.9U PD=2.585U
* device instance $628 r0 *1 26.36,67.67 pfet_03v3
M$628 \$772 \$741 \$771 VDD pfet_03v3 L=0.28U W=1.38U AS=0.83145P AD=0.8418P
+ PS=2.585U PD=2.6U
* device instance $629 r0 *1 27.86,67.67 pfet_03v3
M$629 \$818 \$740 \$772 VDD pfet_03v3 L=0.28U W=1.38U AS=0.8418P AD=0.20355P
+ PS=2.6U PD=1.675U
* device instance $630 r0 *1 28.435,67.67 pfet_03v3
M$630 VDD \$773 \$818 VDD pfet_03v3 L=0.28U W=1.38U AS=0.20355P AD=0.3588P
+ PS=1.675U PD=1.9U
* device instance $631 r0 *1 29.235,67.67 pfet_03v3
M$631 \$773 \$772 VDD VDD pfet_03v3 L=0.28U W=1.38U AS=0.3588P AD=0.759P
+ PS=1.9U PD=3.86U
* device instance $632 r0 *1 28.585,65.76 pfet_03v3
M$632 VDD \$682 \$681 VDD pfet_03v3 L=1.03U W=1.08U AS=0.5292P AD=0.4752P
+ PS=3.14U PD=3.04U
* device instance $633 r0 *1 30.785,67.67 pfet_03v3
M$633 A|Q$1 \$773 VDD VDD pfet_03v3 L=0.28U W=2.76U AS=0.966P AD=1.2075P
+ PS=5.54U PD=5.89U
* device instance $635 r0 *1 31.28,65.61 pfet_03v3
M$635 A|Y$89 \$725 VDD VDD pfet_03v3 L=0.28U W=2.76U AS=1.4076P AD=0.7176P
+ PS=6.18U PD=3.8U
* device instance $637 r0 *1 32.88,65.61 pfet_03v3
M$637 \$725 A|Y$84 VDD VDD pfet_03v3 L=0.28U W=1.38U AS=0.3588P AD=0.6072P
+ PS=1.9U PD=3.64U
* device instance $638 r0 *1 33.625,67.52 pfet_03v3
M$638 VDD \$775 \$742 VDD pfet_03v3 L=1.03U W=1.08U AS=0.5292P AD=0.4752P
+ PS=3.14U PD=3.04U
* device instance $639 r0 *1 34.64,65.61 pfet_03v3
M$639 A|Y$90 \$726 VDD VDD pfet_03v3 L=0.28U W=2.76U AS=1.4076P AD=0.7176P
+ PS=6.18U PD=3.8U
* device instance $641 r0 *1 36.24,65.61 pfet_03v3
M$641 \$726 A|Y$92 VDD VDD pfet_03v3 L=0.28U W=1.38U AS=0.3588P AD=0.6072P
+ PS=1.9U PD=3.64U
* device instance $642 r0 *1 36.32,67.67 pfet_03v3
M$642 A|Y$99 \$776 VDD VDD pfet_03v3 L=0.28U W=2.76U AS=1.4076P AD=0.7176P
+ PS=6.18U PD=3.8U
* device instance $644 r0 *1 37.92,67.67 pfet_03v3
M$644 \$776 A|Y$110 VDD VDD pfet_03v3 L=0.28U W=1.38U AS=0.3588P AD=0.6072P
+ PS=1.9U PD=3.64U
* device instance $645 r0 *1 37.68,65.61 pfet_03v3
M$645 VDD A|Y$99 \$683 VDD pfet_03v3 L=0.28U W=1.38U AS=0.6072P AD=0.3588P
+ PS=3.64U PD=1.9U
* device instance $646 r0 *1 38.48,65.61 pfet_03v3
M$646 A|Y$92 \$683 VDD VDD pfet_03v3 L=0.28U W=2.76U AS=0.7176P AD=1.4076P
+ PS=3.8U PD=6.18U
* device instance $648 r0 *1 39.68,67.67 pfet_03v3
M$648 A|Y$110 \$778 VDD VDD pfet_03v3 L=0.28U W=2.76U AS=1.4076P AD=0.7176P
+ PS=6.18U PD=3.8U
* device instance $650 r0 *1 41.28,67.67 pfet_03v3
M$650 \$778 A|Y$111 VDD VDD pfet_03v3 L=0.28U W=1.38U AS=0.3588P AD=0.6072P
+ PS=1.9U PD=3.64U
* device instance $651 r0 *1 44.825,65.755 pfet_03v3
M$651 VDD \$686 \$685 VDD pfet_03v3 L=7.75U W=1.09U AS=0.5341P AD=0.4796P
+ PS=3.16U PD=3.06U
* device instance $652 r0 *1 42.72,67.67 pfet_03v3
M$652 VDD A|Y$112 \$743 VDD pfet_03v3 L=0.28U W=1.38U AS=0.6072P AD=0.3588P
+ PS=3.64U PD=1.9U
* device instance $653 r0 *1 43.52,67.67 pfet_03v3
M$653 A|Y$104 \$743 VDD VDD pfet_03v3 L=0.28U W=2.76U AS=0.7176P AD=1.4076P
+ PS=3.8U PD=6.18U
* device instance $655 r0 *1 48.185,67.52 pfet_03v3
M$655 VDD \$781 \$745 VDD pfet_03v3 L=1.03U W=1.08U AS=0.5292P AD=0.4752P
+ PS=3.14U PD=3.04U
* device instance $656 r0 *1 50.32,67.67 pfet_03v3
M$656 A|Y$94 \$782 VDD VDD pfet_03v3 L=0.28U W=2.76U AS=1.4076P AD=0.7176P
+ PS=6.18U PD=3.8U
* device instance $658 r0 *1 51.92,67.67 pfet_03v3
M$658 \$782 A|Y$113 VDD VDD pfet_03v3 L=0.28U W=1.38U AS=0.3588P AD=0.6072P
+ PS=1.9U PD=3.64U
* device instance $659 r0 *1 50.32,65.61 pfet_03v3
M$659 A|Y$93 \$728 VDD VDD pfet_03v3 L=0.28U W=2.76U AS=1.4076P AD=0.7176P
+ PS=6.18U PD=3.8U
* device instance $661 r0 *1 51.92,65.61 pfet_03v3
M$661 \$728 A|Y$94 VDD VDD pfet_03v3 L=0.28U W=1.38U AS=0.3588P AD=0.6072P
+ PS=1.9U PD=3.64U
* device instance $662 r0 *1 54.905,65.755 pfet_03v3
M$662 VDD \$690 \$689 VDD pfet_03v3 L=3.27U W=1.09U AS=0.5341P AD=0.4796P
+ PS=3.16U PD=3.06U
* device instance $663 r0 *1 53.68,67.67 pfet_03v3
M$663 A|Y$113 \$784 VDD VDD pfet_03v3 L=0.28U W=2.76U AS=1.4076P AD=0.7176P
+ PS=6.18U PD=3.8U
* device instance $665 r0 *1 55.28,67.67 pfet_03v3
M$665 \$784 A|Y$114 VDD VDD pfet_03v3 L=0.28U W=1.38U AS=0.3588P AD=0.6072P
+ PS=1.9U PD=3.64U
* device instance $666 r0 *1 57.04,67.67 pfet_03v3
M$666 A|Y$114 \$786 VDD VDD pfet_03v3 L=0.28U W=2.76U AS=1.4076P AD=0.7176P
+ PS=6.18U PD=3.8U
* device instance $668 r0 *1 58.64,67.67 pfet_03v3
M$668 \$786 A|Y$95 VDD VDD pfet_03v3 L=0.28U W=1.38U AS=0.3588P AD=0.6072P
+ PS=1.9U PD=3.64U
* device instance $669 r0 *1 58.265,65.76 pfet_03v3
M$669 VDD \$692 \$691 VDD pfet_03v3 L=1.03U W=1.08U AS=0.5292P AD=0.4752P
+ PS=3.14U PD=3.04U
* device instance $670 r0 *1 60.4,67.67 pfet_03v3
M$670 A|Y$96 \$787 VDD VDD pfet_03v3 L=0.28U W=2.76U AS=1.4076P AD=0.7176P
+ PS=6.18U PD=3.8U
* device instance $672 r0 *1 62,67.67 pfet_03v3
M$672 \$787 A|Y$115 VDD VDD pfet_03v3 L=0.28U W=1.38U AS=0.3588P AD=0.6072P
+ PS=1.9U PD=3.64U
* device instance $673 r0 *1 60.96,65.61 pfet_03v3
M$673 A|Y$95 \$729 VDD VDD pfet_03v3 L=0.28U W=2.76U AS=1.4076P AD=0.7176P
+ PS=6.18U PD=3.8U
* device instance $675 r0 *1 62.56,65.61 pfet_03v3
M$675 \$729 A|Y$96 VDD VDD pfet_03v3 L=0.28U W=1.38U AS=0.3588P AD=0.6072P
+ PS=1.9U PD=3.64U
* device instance $676 r0 *1 63.76,67.67 pfet_03v3
M$676 A|Y$115 \$789 VDD VDD pfet_03v3 L=0.28U W=2.76U AS=1.4076P AD=0.7176P
+ PS=6.18U PD=3.8U
* device instance $678 r0 *1 65.36,67.67 pfet_03v3
M$678 \$789 A|Y$116 VDD VDD pfet_03v3 L=0.28U W=1.38U AS=0.3588P AD=0.6072P
+ PS=1.9U PD=3.64U
* device instance $679 r0 *1 64.425,65.76 pfet_03v3
M$679 VDD \$696 \$695 VDD pfet_03v3 L=1.03U W=1.08U AS=0.5292P AD=0.4752P
+ PS=3.14U PD=3.04U
* device instance $680 r0 *1 70.585,67.525 pfet_03v3
M$680 VDD \$791 \$746 VDD pfet_03v3 L=7.75U W=1.09U AS=0.5341P AD=0.4796P
+ PS=3.16U PD=3.06U
* device instance $681 r0 *1 71.145,65.755 pfet_03v3
M$681 VDD \$698 \$697 VDD pfet_03v3 L=7.75U W=1.09U AS=0.5341P AD=0.4796P
+ PS=3.16U PD=3.06U
* device instance $682 r0 *1 79.545,67.525 pfet_03v3
M$682 VDD \$792 \$747 VDD pfet_03v3 L=7.75U W=1.09U AS=0.5341P AD=0.4796P
+ PS=3.16U PD=3.06U
* device instance $683 r0 *1 80.105,65.755 pfet_03v3
M$683 VDD \$700 \$699 VDD pfet_03v3 L=7.75U W=1.09U AS=0.5341P AD=0.4796P
+ PS=3.16U PD=3.06U
* device instance $684 r0 *1 89.065,65.755 pfet_03v3
M$684 VDD \$702 \$701 VDD pfet_03v3 L=7.75U W=1.09U AS=0.5341P AD=0.4796P
+ PS=3.16U PD=3.06U
* device instance $685 r0 *1 90.745,67.525 pfet_03v3
M$685 VDD \$793 \$748 VDD pfet_03v3 L=7.75U W=1.09U AS=0.5341P AD=0.4796P
+ PS=3.16U PD=3.06U
* device instance $686 r0 *1 98.025,65.755 pfet_03v3
M$686 VDD \$704 \$703 VDD pfet_03v3 L=7.75U W=1.09U AS=0.5341P AD=0.4796P
+ PS=3.16U PD=3.06U
* device instance $687 r0 *1 96.345,67.52 pfet_03v3
M$687 VDD \$794 \$749 VDD pfet_03v3 L=1.03U W=1.08U AS=0.5292P AD=0.4752P
+ PS=3.14U PD=3.04U
* device instance $688 r0 *1 99.04,67.67 pfet_03v3
M$688 A|Y$105 \$795 VDD VDD pfet_03v3 L=0.28U W=2.76U AS=1.4076P AD=0.7176P
+ PS=6.18U PD=3.8U
* device instance $690 r0 *1 100.64,67.67 pfet_03v3
M$690 \$795 A|Y$117 VDD VDD pfet_03v3 L=0.28U W=1.38U AS=0.3588P AD=0.6072P
+ PS=1.9U PD=3.64U
* device instance $691 r0 *1 102.4,67.67 pfet_03v3
M$691 A|Y$106 \$797 VDD VDD pfet_03v3 L=0.28U W=2.76U AS=1.4076P AD=0.7176P
+ PS=6.18U PD=3.8U
* device instance $693 r0 *1 104,67.67 pfet_03v3
M$693 \$797 A|Y$118 VDD VDD pfet_03v3 L=0.28U W=1.38U AS=0.3588P AD=0.6072P
+ PS=1.9U PD=3.64U
* device instance $694 r0 *1 103.625,65.76 pfet_03v3
M$694 VDD \$706 \$705 VDD pfet_03v3 L=1.03U W=1.08U AS=0.5292P AD=0.4752P
+ PS=3.14U PD=3.04U
* device instance $695 r0 *1 106.32,67.67 pfet_03v3
M$695 A|Y$107 \$799 VDD VDD pfet_03v3 L=0.28U W=2.76U AS=1.4076P AD=0.7176P
+ PS=6.18U PD=3.8U
* device instance $697 r0 *1 107.92,67.67 pfet_03v3
M$697 \$799 A|Y$119 VDD VDD pfet_03v3 L=0.28U W=1.38U AS=0.3588P AD=0.6072P
+ PS=1.9U PD=3.64U
* device instance $698 r0 *1 110.345,65.755 pfet_03v3
M$698 VDD \$708 \$707 VDD pfet_03v3 L=7.75U W=1.09U AS=0.5341P AD=0.4796P
+ PS=3.16U PD=3.06U
* device instance $699 r0 *1 110.905,67.525 pfet_03v3
M$699 VDD \$801 \$753 VDD pfet_03v3 L=3.27U W=1.09U AS=0.5341P AD=0.4796P
+ PS=3.16U PD=3.06U
* device instance $700 r0 *1 115.28,67.67 pfet_03v3
M$700 A|Y$108 \$802 VDD VDD pfet_03v3 L=0.28U W=2.76U AS=1.4076P AD=0.7176P
+ PS=6.18U PD=3.8U
* device instance $702 r0 *1 116.88,67.67 pfet_03v3
M$702 \$802 A|Y$120 VDD VDD pfet_03v3 L=0.28U W=1.38U AS=0.3588P AD=0.6072P
+ PS=1.9U PD=3.64U
* device instance $703 r0 *1 117.52,65.61 pfet_03v3
M$703 A|Y$97 \$730 VDD VDD pfet_03v3 L=0.28U W=2.76U AS=1.4076P AD=0.7176P
+ PS=6.18U PD=3.8U
* device instance $705 r0 *1 119.12,65.61 pfet_03v3
M$705 \$730 A|Y$98 VDD VDD pfet_03v3 L=0.28U W=1.38U AS=0.3588P AD=0.6072P
+ PS=1.9U PD=3.64U
* device instance $706 r0 *1 118.32,67.67 pfet_03v3
M$706 VDD A|Y$97 \$755 VDD pfet_03v3 L=0.28U W=1.38U AS=0.6072P AD=0.3588P
+ PS=3.64U PD=1.9U
* device instance $707 r0 *1 119.12,67.67 pfet_03v3
M$707 A|Y$120 \$755 VDD VDD pfet_03v3 L=0.28U W=2.76U AS=0.7176P AD=1.4076P
+ PS=3.8U PD=6.18U
* device instance $709 r0 *1 120.56,65.61 pfet_03v3
M$709 VDD A|Y$88 \$711 VDD pfet_03v3 L=0.28U W=1.38U AS=0.6072P AD=0.3588P
+ PS=3.64U PD=1.9U
* device instance $710 r0 *1 121.36,65.61 pfet_03v3
M$710 A|Y$98 \$711 VDD VDD pfet_03v3 L=0.28U W=2.76U AS=0.7176P AD=1.4076P
+ PS=3.8U PD=6.18U
* device instance $712 r0 *1 122.105,67.52 pfet_03v3
M$712 VDD \$804 \$756 VDD pfet_03v3 L=1.03U W=1.08U AS=0.5292P AD=0.4752P
+ PS=3.14U PD=3.04U
* device instance $713 r0 *1 127.705,65.755 pfet_03v3
M$713 VDD \$713 \$712 VDD pfet_03v3 L=7.75U W=1.09U AS=0.5341P AD=0.4796P
+ PS=3.16U PD=3.06U
* device instance $714 r0 *1 127.705,67.525 pfet_03v3
M$714 VDD \$805 \$757 VDD pfet_03v3 L=3.27U W=1.09U AS=0.5341P AD=0.4796P
+ PS=3.16U PD=3.06U
* device instance $715 r0 *1 131.065,67.52 pfet_03v3
M$715 VDD \$806 \$758 VDD pfet_03v3 L=1.03U W=1.08U AS=0.5292P AD=0.4752P
+ PS=3.14U PD=3.04U
* device instance $716 r0 *1 132.96,65.61 pfet_03v3
M$716 B|Y$22 B|Y$24 VDD VDD pfet_03v3 L=0.28U W=2.76U AS=1.0764P AD=0.7176P
+ PS=5.7U PD=3.8U
* device instance $718 r0 *1 134.56,65.61 pfet_03v3
M$718 B|Y$22 A|Y$100 VDD VDD pfet_03v3 L=0.28U W=2.76U AS=0.7176P AD=0.966P
+ PS=3.8U PD=5.54U
* device instance $720 r0 *1 134.64,67.67 pfet_03v3
M$720 A|Y$101 B|Y$24 VDD VDD pfet_03v3 L=0.28U W=2.76U AS=1.0764P AD=0.7176P
+ PS=5.7U PD=3.8U
* device instance $722 r0 *1 136.24,67.67 pfet_03v3
M$722 A|Y$101 \$807 VDD VDD pfet_03v3 L=0.28U W=2.76U AS=0.7176P AD=0.966P
+ PS=3.8U PD=5.54U
* device instance $724 r0 *1 136.8,65.61 pfet_03v3
M$724 B|Y$23 A|Y$101 VDD VDD pfet_03v3 L=0.28U W=2.76U AS=0.966P AD=0.7176P
+ PS=5.54U PD=3.8U
* device instance $726 r0 *1 138.4,65.61 pfet_03v3
M$726 B|Y$23 B|Y$21 VDD VDD pfet_03v3 L=0.28U W=2.76U AS=0.7176P AD=1.0764P
+ PS=3.8U PD=5.7U
* device instance $728 r0 *1 138.48,67.67 pfet_03v3
M$728 VDD A|Y$100 \$807 VDD pfet_03v3 L=0.28U W=1.38U AS=0.6072P AD=0.6348P
+ PS=3.64U PD=3.68U
* device instance $729 r0 *1 141.705,67.525 pfet_03v3
M$729 VDD \$808 \$759 VDD pfet_03v3 L=3.27U W=1.09U AS=0.5341P AD=0.4796P
+ PS=3.16U PD=3.06U
* device instance $730 r0 *1 141.145,65.76 pfet_03v3
M$730 VDD \$718 \$717 VDD pfet_03v3 L=1.03U W=1.08U AS=0.5292P AD=0.4752P
+ PS=3.14U PD=3.04U
* device instance $731 r0 *1 145.065,67.52 pfet_03v3
M$731 VDD \$809 \$760 VDD pfet_03v3 L=1.03U W=1.08U AS=0.5292P AD=0.4752P
+ PS=3.14U PD=3.04U
* device instance $732 r0 *1 146.185,65.76 pfet_03v3
M$732 VDD \$720 \$719 VDD pfet_03v3 L=1.03U W=1.08U AS=0.5292P AD=0.4752P
+ PS=3.14U PD=3.04U
* device instance $733 r0 *1 148,67.67 pfet_03v3
M$733 C|Y$7 A|Y$121 VDD VDD pfet_03v3 L=0.28U W=2.76U AS=0.966P AD=0.966P
+ PS=5.54U PD=5.54U
* device instance $735 r0 *1 148.56,65.61 pfet_03v3
M$735 C|Y$4 A|Y$91 VDD VDD pfet_03v3 L=0.28U W=2.76U AS=0.966P AD=0.966P
+ PS=5.54U PD=5.54U
* device instance $737 r0 *1 150.24,67.67 pfet_03v3
M$737 C|Y$6 A|Y$109 VDD VDD pfet_03v3 L=0.28U W=2.76U AS=0.966P AD=0.966P
+ PS=5.54U PD=5.54U
* device instance $739 r0 *1 150.8,65.61 pfet_03v3
M$739 C|Y$5 A|Y$102 VDD VDD pfet_03v3 L=0.28U W=2.76U AS=0.966P AD=0.966P
+ PS=5.54U PD=5.54U
* device instance $741 r0 *1 152.48,67.67 pfet_03v3
M$741 Y$6 A|Y$121 VDD VDD pfet_03v3 L=0.28U W=2.76U AS=0.966P AD=0.7176P
+ PS=5.54U PD=3.8U
* device instance $743 r0 *1 154.08,67.67 pfet_03v3
M$743 Y$6 A|B|Y VDD VDD pfet_03v3 L=0.28U W=2.76U AS=0.7176P AD=1.1592P PS=3.8U
+ PD=4.44U
* device instance $745 r0 *1 156.32,67.67 pfet_03v3
M$745 Y$6 C|Y$7 VDD VDD pfet_03v3 L=0.28U W=2.76U AS=1.1592P AD=0.9798P
+ PS=4.44U PD=5.56U
* device instance $747 r0 *1 153.12,65.61 pfet_03v3
M$747 Y$5 C|Y$5 VDD VDD pfet_03v3 L=0.28U W=2.76U AS=0.9798P AD=1.1592P
+ PS=5.56U PD=4.44U
* device instance $749 r0 *1 155.36,65.61 pfet_03v3
M$749 Y$5 A|B|Y VDD VDD pfet_03v3 L=0.28U W=2.76U AS=1.1592P AD=0.7176P
+ PS=4.44U PD=3.8U
* device instance $751 r0 *1 156.96,65.61 pfet_03v3
M$751 Y$5 A|Y$102 VDD VDD pfet_03v3 L=0.28U W=2.76U AS=0.7176P AD=0.966P
+ PS=3.8U PD=5.54U
* device instance $753 r0 *1 159.52,65.61 pfet_03v3
M$753 A|Y$102 \$736 VDD VDD pfet_03v3 L=0.28U W=2.76U AS=1.4076P AD=0.7176P
+ PS=6.18U PD=3.8U
* device instance $755 r0 *1 161.12,65.61 pfet_03v3
M$755 \$736 A|MID_MUX[9] VDD VDD pfet_03v3 L=0.28U W=1.38U AS=0.3588P
+ AD=0.6072P PS=1.9U PD=3.64U
* device instance $756 r0 *1 159.52,67.67 pfet_03v3
M$756 A|Y$109 \$813 VDD VDD pfet_03v3 L=0.28U W=2.76U AS=1.4076P AD=0.7176P
+ PS=6.18U PD=3.8U
* device instance $758 r0 *1 161.12,67.67 pfet_03v3
M$758 \$813 A|MID_MUX[2] VDD VDD pfet_03v3 L=0.28U W=1.38U AS=0.3588P
+ AD=0.6072P PS=1.9U PD=3.64U
* device instance $759 r0 *1 8.735,73.45 pfet_03v3
M$759 A|Q \$826 VDD VDD pfet_03v3 L=0.28U W=2.76U AS=1.2075P AD=0.966P PS=5.89U
+ PD=5.54U
* device instance $761 r0 *1 8.88,75.51 pfet_03v3
M$761 SS_BBPD[1]|Y \$898 VDD VDD pfet_03v3 L=0.28U W=2.76U AS=1.4076P
+ AD=0.7176P PS=6.18U PD=3.8U
* device instance $763 r0 *1 10.48,75.51 pfet_03v3
M$763 \$898 A|Y$103 VDD VDD pfet_03v3 L=0.28U W=1.38U AS=0.3588P AD=0.6072P
+ PS=1.9U PD=3.64U
* device instance $764 r0 *1 11.085,73.45 pfet_03v3
M$764 VDD \$827 \$826 VDD pfet_03v3 L=0.28U W=1.38U AS=0.759P AD=0.3588P
+ PS=3.86U PD=1.9U
* device instance $765 r0 *1 11.885,73.45 pfet_03v3
M$765 \$895 \$826 VDD VDD pfet_03v3 L=0.28U W=1.38U AS=0.3588P AD=0.20355P
+ PS=1.9U PD=1.675U
* device instance $766 r0 *1 12.46,73.45 pfet_03v3
M$766 \$827 \$880 \$895 VDD pfet_03v3 L=0.28U W=1.38U AS=0.20355P AD=0.8418P
+ PS=1.675U PD=2.6U
* device instance $767 r0 *1 13.96,73.45 pfet_03v3
M$767 \$829 \$828 \$827 VDD pfet_03v3 L=0.28U W=1.38U AS=0.8418P AD=0.83145P
+ PS=2.6U PD=2.585U
* device instance $768 r0 *1 15.445,73.45 pfet_03v3
M$768 VDD \$830 \$829 VDD pfet_03v3 L=0.28U W=1.38U AS=0.83145P AD=0.3588P
+ PS=2.585U PD=1.9U
* device instance $769 r0 *1 16.245,73.45 pfet_03v3
M$769 \$896 \$829 VDD VDD pfet_03v3 L=0.28U W=1.38U AS=0.3588P AD=0.86595P
+ PS=1.9U PD=2.635U
* device instance $770 r0 *1 17.782,73.45 pfet_03v3
M$770 \$830 \$828 \$896 VDD pfet_03v3 L=0.285U W=1.38U AS=0.86595P AD=0.5313P
+ PS=2.635U PD=2.15U
* device instance $771 r0 *1 18.835,73.45 pfet_03v3
M$771 \$897 D|Y$1 \$830 VDD pfet_03v3 L=0.28U W=1.38U AS=0.5313P AD=0.2139P
+ PS=2.15U PD=1.69U
* device instance $772 r0 *1 19.427,73.45 pfet_03v3
M$772 VDD \$880 \$897 VDD pfet_03v3 L=0.285U W=1.38U AS=0.2139P AD=1.3317P
+ PS=1.69U PD=4.69U
* device instance $773 r0 *1 12.8,75.51 pfet_03v3
M$773 A|Y$135 \$900 VDD VDD pfet_03v3 L=0.28U W=2.76U AS=1.4076P AD=0.7176P
+ PS=6.18U PD=3.8U
* device instance $775 r0 *1 14.4,75.51 pfet_03v3
M$775 \$900 A|CLK|REF VDD VDD pfet_03v3 L=0.28U W=1.38U AS=0.3588P AD=0.6072P
+ PS=1.9U PD=3.64U
* device instance $776 r0 *1 16.16,75.51 pfet_03v3
M$776 D|Y$1 \$902 VDD VDD pfet_03v3 L=0.28U W=2.76U AS=1.4076P AD=0.7176P
+ PS=6.18U PD=3.8U
* device instance $778 r0 *1 17.76,75.51 pfet_03v3
M$778 \$902 A|B|Y$1 VDD VDD pfet_03v3 L=0.28U W=1.38U AS=0.3588P AD=0.6072P
+ PS=1.9U PD=3.64U
* device instance $779 r0 *1 20.88,75.51 pfet_03v3
M$779 VDD A|B|Y$2 \$904 VDD pfet_03v3 L=0.28U W=1.38U AS=0.6072P AD=0.3588P
+ PS=3.64U PD=1.9U
* device instance $780 r0 *1 21.68,75.51 pfet_03v3
M$780 D|Y \$904 VDD VDD pfet_03v3 L=0.28U W=2.76U AS=0.7176P AD=1.4076P PS=3.8U
+ PD=6.18U
* device instance $782 r0 *1 21.44,73.45 pfet_03v3
M$782 VDD \$880 \$828 VDD pfet_03v3 L=0.28U W=1.38U AS=0.6693P AD=0.3588P
+ PS=3.73U PD=1.9U
* device instance $783 r0 *1 22.24,73.45 pfet_03v3
M$783 \$880 A|CLK|REF VDD VDD pfet_03v3 L=0.28U W=1.38U AS=0.3588P AD=0.6072P
+ PS=1.9U PD=3.64U
* device instance $784 r0 *1 24.105,73.6 pfet_03v3
M$784 VDD \$832 \$831 VDD pfet_03v3 L=1.03U W=1.08U AS=0.5292P AD=0.4752P
+ PS=3.14U PD=3.04U
* device instance $785 r0 *1 24.665,75.36 pfet_03v3
M$785 VDD \$906 \$905 VDD pfet_03v3 L=1.03U W=1.08U AS=0.5292P AD=0.4752P
+ PS=3.14U PD=3.04U
* device instance $786 r0 *1 31.945,73.595 pfet_03v3
M$786 VDD \$834 \$833 VDD pfet_03v3 L=7.75U W=1.09U AS=0.5341P AD=0.4796P
+ PS=3.16U PD=3.06U
* device instance $787 r0 *1 28.48,75.51 pfet_03v3
M$787 A|Y$145 \$907 VDD VDD pfet_03v3 L=0.28U W=2.76U AS=1.4076P AD=0.7176P
+ PS=6.18U PD=3.8U
* device instance $789 r0 *1 30.08,75.51 pfet_03v3
M$789 \$907 A|Q$1 VDD VDD pfet_03v3 L=0.28U W=1.38U AS=0.3588P AD=0.6072P
+ PS=1.9U PD=3.64U
* device instance $790 r0 *1 35.305,75.365 pfet_03v3
M$790 VDD \$909 \$908 VDD pfet_03v3 L=7.75U W=1.09U AS=0.5341P AD=0.4796P
+ PS=3.16U PD=3.06U
* device instance $791 r0 *1 37.545,73.6 pfet_03v3
M$791 VDD \$836 \$835 VDD pfet_03v3 L=1.03U W=1.08U AS=0.5292P AD=0.4752P
+ PS=3.14U PD=3.04U
* device instance $792 r0 *1 41.36,73.45 pfet_03v3
M$792 A|Y$112 \$882 VDD VDD pfet_03v3 L=0.28U W=2.76U AS=1.4076P AD=0.7176P
+ PS=6.18U PD=3.8U
* device instance $794 r0 *1 42.96,73.45 pfet_03v3
M$794 \$882 A|Y$122 VDD VDD pfet_03v3 L=0.28U W=1.38U AS=0.3588P AD=0.6072P
+ PS=1.9U PD=3.64U
* device instance $795 r0 *1 41.92,75.51 pfet_03v3
M$795 A|Y$111 \$910 VDD VDD pfet_03v3 L=0.28U W=2.76U AS=1.4076P AD=0.7176P
+ PS=6.18U PD=3.8U
* device instance $797 r0 *1 43.52,75.51 pfet_03v3
M$797 \$910 A|Y$104 VDD VDD pfet_03v3 L=0.28U W=1.38U AS=0.3588P AD=0.6072P
+ PS=1.9U PD=3.64U
* device instance $798 r0 *1 44.72,73.45 pfet_03v3
M$798 A|Y$122 \$883 VDD VDD pfet_03v3 L=0.28U W=2.76U AS=1.4076P AD=0.7176P
+ PS=6.18U PD=3.8U
* device instance $800 r0 *1 46.32,73.45 pfet_03v3
M$800 \$883 A|Y$123 VDD VDD pfet_03v3 L=0.28U W=1.38U AS=0.3588P AD=0.6072P
+ PS=1.9U PD=3.64U
* device instance $801 r0 *1 51.545,75.365 pfet_03v3
M$801 VDD \$912 \$911 VDD pfet_03v3 L=7.75U W=1.09U AS=0.5341P AD=0.4796P
+ PS=3.16U PD=3.06U
* device instance $802 r0 *1 48.08,73.45 pfet_03v3
M$802 A|Y$123 \$884 VDD VDD pfet_03v3 L=0.28U W=2.76U AS=1.4076P AD=0.7176P
+ PS=6.18U PD=3.8U
* device instance $804 r0 *1 49.68,73.45 pfet_03v3
M$804 \$884 A|Y$93 VDD VDD pfet_03v3 L=0.28U W=1.38U AS=0.3588P AD=0.6072P
+ PS=1.9U PD=3.64U
* device instance $805 r0 *1 54.905,73.595 pfet_03v3
M$805 VDD \$840 \$839 VDD pfet_03v3 L=7.75U W=1.09U AS=0.5341P AD=0.4796P
+ PS=3.16U PD=3.06U
* device instance $806 r0 *1 58.265,75.365 pfet_03v3
M$806 VDD \$914 \$913 VDD pfet_03v3 L=3.27U W=1.09U AS=0.5341P AD=0.4796P
+ PS=3.16U PD=3.06U
* device instance $807 r0 *1 60.505,73.6 pfet_03v3
M$807 VDD \$842 \$841 VDD pfet_03v3 L=1.03U W=1.08U AS=0.5292P AD=0.4752P
+ PS=3.14U PD=3.04U
* device instance $808 r0 *1 61.76,75.51 pfet_03v3
M$808 VDD A|Y$144 \$915 VDD pfet_03v3 L=0.28U W=1.38U AS=0.6072P AD=0.3588P
+ PS=3.64U PD=1.9U
* device instance $809 r0 *1 62.56,75.51 pfet_03v3
M$809 A|Y$136 \$915 VDD VDD pfet_03v3 L=0.28U W=2.76U AS=0.7176P AD=1.4076P
+ PS=3.8U PD=6.18U
* device instance $811 r0 *1 63.2,73.45 pfet_03v3
M$811 A|Y$124 \$885 VDD VDD pfet_03v3 L=0.28U W=2.76U AS=1.4076P AD=0.7176P
+ PS=6.18U PD=3.8U
* device instance $813 r0 *1 64.8,73.45 pfet_03v3
M$813 \$885 A|Y$125 VDD VDD pfet_03v3 L=0.28U W=1.38U AS=0.3588P AD=0.6072P
+ PS=1.9U PD=3.64U
* device instance $814 r0 *1 65.12,75.51 pfet_03v3
M$814 VDD A|Y$136 \$917 VDD pfet_03v3 L=0.28U W=1.38U AS=0.6072P AD=0.3588P
+ PS=3.64U PD=1.9U
* device instance $815 r0 *1 65.92,75.51 pfet_03v3
M$815 A|Y$137 \$917 VDD VDD pfet_03v3 L=0.28U W=2.76U AS=0.7176P AD=1.4076P
+ PS=3.8U PD=6.18U
* device instance $817 r0 *1 67.36,73.45 pfet_03v3
M$817 VDD A|Y$124 \$845 VDD pfet_03v3 L=0.28U W=1.38U AS=0.6072P AD=0.3588P
+ PS=3.64U PD=1.9U
* device instance $818 r0 *1 68.16,73.45 pfet_03v3
M$818 A|Y$116 \$845 VDD VDD pfet_03v3 L=0.28U W=2.76U AS=0.7176P AD=1.4076P
+ PS=3.8U PD=6.18U
* device instance $820 r0 *1 68.48,75.51 pfet_03v3
M$820 VDD A|Y$137 \$919 VDD pfet_03v3 L=0.28U W=1.38U AS=0.6072P AD=0.3588P
+ PS=3.64U PD=1.9U
* device instance $821 r0 *1 69.28,75.51 pfet_03v3
M$821 A|Y$125 \$919 VDD VDD pfet_03v3 L=0.28U W=2.76U AS=0.7176P AD=1.4076P
+ PS=3.8U PD=6.18U
* device instance $823 r0 *1 74.505,73.595 pfet_03v3
M$823 VDD \$847 \$846 VDD pfet_03v3 L=7.75U W=1.09U AS=0.5341P AD=0.4796P
+ PS=3.16U PD=3.06U
* device instance $824 r0 *1 72.265,75.36 pfet_03v3
M$824 VDD \$921 \$920 VDD pfet_03v3 L=1.03U W=1.08U AS=0.5292P AD=0.4752P
+ PS=3.14U PD=3.04U
* device instance $825 r0 *1 76.08,75.51 pfet_03v3
M$825 A|Y$138 \$922 VDD VDD pfet_03v3 L=0.28U W=2.76U AS=1.4076P AD=0.7176P
+ PS=6.18U PD=3.8U
* device instance $827 r0 *1 77.68,75.51 pfet_03v3
M$827 \$922 A|Y$127 VDD VDD pfet_03v3 L=0.28U W=1.38U AS=0.3588P AD=0.6072P
+ PS=1.9U PD=3.64U
* device instance $828 r0 *1 79.44,75.51 pfet_03v3
M$828 A|Y$126 \$924 VDD VDD pfet_03v3 L=0.28U W=2.76U AS=1.4076P AD=0.7176P
+ PS=6.18U PD=3.8U
* device instance $830 r0 *1 81.04,75.51 pfet_03v3
M$830 \$924 A|Y$139 VDD VDD pfet_03v3 L=0.28U W=1.38U AS=0.3588P AD=0.6072P
+ PS=1.9U PD=3.64U
* device instance $831 r0 *1 80.8,73.45 pfet_03v3
M$831 VDD A|Y$126 \$848 VDD pfet_03v3 L=0.28U W=1.38U AS=0.6072P AD=0.3588P
+ PS=3.64U PD=1.9U
* device instance $832 r0 *1 81.6,73.45 pfet_03v3
M$832 A|Y$127 \$848 VDD VDD pfet_03v3 L=0.28U W=2.76U AS=0.7176P AD=1.4076P
+ PS=3.8U PD=6.18U
* device instance $834 r0 *1 82.8,75.51 pfet_03v3
M$834 A|Y$139 \$926 VDD VDD pfet_03v3 L=0.28U W=2.76U AS=1.4076P AD=0.7176P
+ PS=6.18U PD=3.8U
* device instance $836 r0 *1 84.4,75.51 pfet_03v3
M$836 \$926 A|Y$140 VDD VDD pfet_03v3 L=0.28U W=1.38U AS=0.3588P AD=0.6072P
+ PS=1.9U PD=3.64U
* device instance $837 r0 *1 87.945,73.595 pfet_03v3
M$837 VDD \$852 \$851 VDD pfet_03v3 L=7.75U W=1.09U AS=0.5341P AD=0.4796P
+ PS=3.16U PD=3.06U
* device instance $838 r0 *1 90.745,75.365 pfet_03v3
M$838 VDD \$929 \$928 VDD pfet_03v3 L=7.75U W=1.09U AS=0.5341P AD=0.4796P
+ PS=3.16U PD=3.06U
* device instance $839 r0 *1 94.665,73.595 pfet_03v3
M$839 VDD \$854 \$853 VDD pfet_03v3 L=3.27U W=1.09U AS=0.5341P AD=0.4796P
+ PS=3.16U PD=3.06U
* device instance $840 r0 *1 96.345,75.36 pfet_03v3
M$840 VDD \$931 \$930 VDD pfet_03v3 L=1.03U W=1.08U AS=0.5292P AD=0.4752P
+ PS=3.14U PD=3.04U
* device instance $841 r0 *1 97.92,73.45 pfet_03v3
M$841 A|Y$128 \$886 VDD VDD pfet_03v3 L=0.28U W=2.76U AS=1.4076P AD=0.7176P
+ PS=6.18U PD=3.8U
* device instance $843 r0 *1 99.52,73.45 pfet_03v3
M$843 \$886 A|Y$129 VDD VDD pfet_03v3 L=0.28U W=1.38U AS=0.3588P AD=0.6072P
+ PS=1.9U PD=3.64U
* device instance $844 r0 *1 98.48,75.51 pfet_03v3
M$844 A|Y$141 \$932 VDD VDD pfet_03v3 L=0.28U W=2.76U AS=1.4076P AD=0.7176P
+ PS=6.18U PD=3.8U
* device instance $846 r0 *1 100.08,75.51 pfet_03v3
M$846 \$932 A|Y$128 VDD VDD pfet_03v3 L=0.28U W=1.38U AS=0.3588P AD=0.6072P
+ PS=1.9U PD=3.64U
* device instance $847 r0 *1 100.96,73.45 pfet_03v3
M$847 VDD A|Y$105 \$857 VDD pfet_03v3 L=0.28U W=1.38U AS=0.6072P AD=0.3588P
+ PS=3.64U PD=1.9U
* device instance $848 r0 *1 101.76,73.45 pfet_03v3
M$848 A|Y$129 \$857 VDD VDD pfet_03v3 L=0.28U W=2.76U AS=0.7176P AD=1.4076P
+ PS=3.8U PD=6.18U
* device instance $850 r0 *1 101.84,75.51 pfet_03v3
M$850 A|Y$117 \$934 VDD VDD pfet_03v3 L=0.28U W=2.76U AS=1.4076P AD=0.7176P
+ PS=6.18U PD=3.8U
* device instance $852 r0 *1 103.44,75.51 pfet_03v3
M$852 \$934 A|Y$106 VDD VDD pfet_03v3 L=0.28U W=1.38U AS=0.3588P AD=0.6072P
+ PS=1.9U PD=3.64U
* device instance $853 r0 *1 108.665,75.365 pfet_03v3
M$853 VDD \$936 \$935 VDD pfet_03v3 L=7.75U W=1.09U AS=0.5341P AD=0.4796P
+ PS=3.16U PD=3.06U
* device instance $854 r0 *1 106.88,73.45 pfet_03v3
M$854 A|Y$118 \$887 VDD VDD pfet_03v3 L=0.28U W=2.76U AS=1.4076P AD=0.7176P
+ PS=6.18U PD=3.8U
* device instance $856 r0 *1 108.48,73.45 pfet_03v3
M$856 \$887 A|Y$107 VDD VDD pfet_03v3 L=0.28U W=1.38U AS=0.3588P AD=0.6072P
+ PS=1.9U PD=3.64U
* device instance $857 r0 *1 110.24,73.45 pfet_03v3
M$857 A|Y$119 \$888 VDD VDD pfet_03v3 L=0.28U W=2.76U AS=1.4076P AD=0.7176P
+ PS=6.18U PD=3.8U
* device instance $859 r0 *1 111.84,73.45 pfet_03v3
M$859 \$888 A|Y$130 VDD VDD pfet_03v3 L=0.28U W=1.38U AS=0.3588P AD=0.6072P
+ PS=1.9U PD=3.64U
* device instance $860 r0 *1 113.6,73.45 pfet_03v3
M$860 A|Y$130 \$889 VDD VDD pfet_03v3 L=0.28U W=2.76U AS=1.4076P AD=0.7176P
+ PS=6.18U PD=3.8U
* device instance $862 r0 *1 115.2,73.45 pfet_03v3
M$862 \$889 A|Y$131 VDD VDD pfet_03v3 L=0.28U W=1.38U AS=0.3588P AD=0.6072P
+ PS=1.9U PD=3.64U
* device instance $863 r0 *1 117.625,75.365 pfet_03v3
M$863 VDD \$938 \$937 VDD pfet_03v3 L=7.75U W=1.09U AS=0.5341P AD=0.4796P
+ PS=3.16U PD=3.06U
* device instance $864 r0 *1 116.64,73.45 pfet_03v3
M$864 VDD A|Y$108 \$860 VDD pfet_03v3 L=0.28U W=1.38U AS=0.6072P AD=0.3588P
+ PS=3.64U PD=1.9U
* device instance $865 r0 *1 117.44,73.45 pfet_03v3
M$865 A|Y$131 \$860 VDD VDD pfet_03v3 L=0.28U W=2.76U AS=0.7176P AD=1.4076P
+ PS=3.8U PD=6.18U
* device instance $867 r0 *1 123.785,73.595 pfet_03v3
M$867 VDD \$862 \$861 VDD pfet_03v3 L=7.75U W=1.09U AS=0.5341P AD=0.4796P
+ PS=3.16U PD=3.06U
* device instance $868 r0 *1 123.225,75.36 pfet_03v3
M$868 VDD \$940 \$939 VDD pfet_03v3 L=1.03U W=1.08U AS=0.5292P AD=0.4752P
+ PS=3.14U PD=3.04U
* device instance $869 r0 *1 127.705,75.365 pfet_03v3
M$869 VDD \$942 \$941 VDD pfet_03v3 L=3.27U W=1.09U AS=0.5341P AD=0.4796P
+ PS=3.16U PD=3.06U
* device instance $870 r0 *1 128.96,73.45 pfet_03v3
M$870 B|Y$24 A|Y$132 VDD VDD pfet_03v3 L=0.28U W=2.76U AS=0.966P AD=0.7176P
+ PS=5.54U PD=3.8U
* device instance $872 r0 *1 130.56,73.45 pfet_03v3
M$872 B|Y$24 B|Y$25 VDD VDD pfet_03v3 L=0.28U W=2.76U AS=0.7176P AD=1.0764P
+ PS=3.8U PD=5.7U
* device instance $874 r0 *1 131.065,75.36 pfet_03v3
M$874 VDD \$944 \$943 VDD pfet_03v3 L=1.03U W=1.08U AS=0.5292P AD=0.4752P
+ PS=3.14U PD=3.04U
* device instance $875 r0 *1 133.12,73.45 pfet_03v3
M$875 \$867 A|Y$132 VDD VDD pfet_03v3 L=0.28U W=1.38U AS=0.6348P AD=0.6072P
+ PS=3.68U PD=3.64U
* device instance $876 r0 *1 134,75.51 pfet_03v3
M$876 B|Y$27 A|Y$142 VDD VDD pfet_03v3 L=0.28U W=2.76U AS=0.966P AD=0.7176P
+ PS=5.54U PD=3.8U
* device instance $878 r0 *1 135.6,75.51 pfet_03v3
M$878 B|Y$27 B|Y$26 VDD VDD pfet_03v3 L=0.28U W=2.76U AS=0.7176P AD=1.0764P
+ PS=3.8U PD=5.7U
* device instance $880 r0 *1 134.56,73.45 pfet_03v3
M$880 A|Y$134 \$867 VDD VDD pfet_03v3 L=0.28U W=2.76U AS=0.966P AD=0.7176P
+ PS=5.54U PD=3.8U
* device instance $882 r0 *1 136.16,73.45 pfet_03v3
M$882 A|Y$134 B|Y$25 VDD VDD pfet_03v3 L=0.28U W=2.76U AS=0.7176P AD=1.0764P
+ PS=3.8U PD=5.7U
* device instance $884 r0 *1 141.705,75.365 pfet_03v3
M$884 VDD \$948 \$947 VDD pfet_03v3 L=7.75U W=1.09U AS=0.5341P AD=0.4796P
+ PS=3.16U PD=3.06U
* device instance $885 r0 *1 138.56,73.45 pfet_03v3
M$885 B|Y$26 B|Y$23 VDD VDD pfet_03v3 L=0.28U W=2.76U AS=1.0764P AD=0.7176P
+ PS=5.7U PD=3.8U
* device instance $887 r0 *1 140.16,73.45 pfet_03v3
M$887 B|Y$26 A|Y$134 VDD VDD pfet_03v3 L=0.28U W=2.76U AS=0.7176P AD=0.966P
+ PS=3.8U PD=5.54U
* device instance $889 r0 *1 142.825,73.6 pfet_03v3
M$889 VDD \$871 \$870 VDD pfet_03v3 L=1.03U W=1.08U AS=0.5292P AD=0.4752P
+ PS=3.14U PD=3.04U
* device instance $890 r0 *1 146.08,73.45 pfet_03v3
M$890 A|Y$100 \$891 VDD VDD pfet_03v3 L=0.28U W=2.76U AS=1.4076P AD=0.7176P
+ PS=6.18U PD=3.8U
* device instance $892 r0 *1 147.68,73.45 pfet_03v3
M$892 \$891 A|COARSE_MUX[3] VDD VDD pfet_03v3 L=0.28U W=1.38U AS=0.3588P
+ AD=0.6072P PS=1.9U PD=3.64U
* device instance $893 r0 *1 147.305,75.36 pfet_03v3
M$893 VDD \$950 \$949 VDD pfet_03v3 L=1.03U W=1.08U AS=0.5292P AD=0.4752P
+ PS=3.14U PD=3.04U
* device instance $894 r0 *1 149.44,75.51 pfet_03v3
M$894 A|Y$121 \$951 VDD VDD pfet_03v3 L=0.28U W=2.76U AS=1.4076P AD=0.7176P
+ PS=6.18U PD=3.8U
* device instance $896 r0 *1 151.04,75.51 pfet_03v3
M$896 \$951 A|MID_MUX[0] VDD VDD pfet_03v3 L=0.28U W=1.38U AS=0.3588P
+ AD=0.6072P PS=1.9U PD=3.64U
* device instance $897 r0 *1 149.44,73.45 pfet_03v3
M$897 A|Y$91 \$892 VDD VDD pfet_03v3 L=0.28U W=2.76U AS=1.4076P AD=0.7176P
+ PS=6.18U PD=3.8U
* device instance $899 r0 *1 151.04,73.45 pfet_03v3
M$899 \$892 A|MID_MUX[3] VDD VDD pfet_03v3 L=0.28U W=1.38U AS=0.3588P
+ AD=0.6072P PS=1.9U PD=3.64U
* device instance $900 r0 *1 152.56,73.45 pfet_03v3
M$900 Y$7 C|Y$6 VDD VDD pfet_03v3 L=0.28U W=2.76U AS=0.9798P AD=1.1592P
+ PS=5.56U PD=4.44U
* device instance $902 r0 *1 154.8,73.45 pfet_03v3
M$902 Y$7 A|B|Y VDD VDD pfet_03v3 L=0.28U W=2.76U AS=1.1592P AD=0.7176P
+ PS=4.44U PD=3.8U
* device instance $904 r0 *1 156.4,73.45 pfet_03v3
M$904 Y$7 A|Y$109 VDD VDD pfet_03v3 L=0.28U W=2.76U AS=0.7176P AD=0.966P
+ PS=3.8U PD=5.54U
* device instance $906 r0 *1 152.8,75.51 pfet_03v3
M$906 A|Y$132 \$953 VDD VDD pfet_03v3 L=0.28U W=2.76U AS=1.4076P AD=0.7176P
+ PS=6.18U PD=3.8U
* device instance $908 r0 *1 154.4,75.51 pfet_03v3
M$908 \$953 A|COARSE_MUX[2] VDD VDD pfet_03v3 L=0.28U W=1.38U AS=0.3588P
+ AD=0.6072P PS=1.9U PD=3.64U
* device instance $909 r0 *1 156.16,75.51 pfet_03v3
M$909 A|Y$143 \$955 VDD VDD pfet_03v3 L=0.28U W=2.76U AS=1.4076P AD=0.7176P
+ PS=6.18U PD=3.8U
* device instance $911 r0 *1 157.76,75.51 pfet_03v3
M$911 \$955 A|MID_MUX[7] VDD VDD pfet_03v3 L=0.28U W=1.38U AS=0.3588P
+ AD=0.6072P PS=1.9U PD=3.64U
* device instance $912 r0 *1 159.52,75.51 pfet_03v3
M$912 A|Y$176 \$958 VDD VDD pfet_03v3 L=0.28U W=2.76U AS=1.4076P AD=0.7176P
+ PS=6.18U PD=3.8U
* device instance $914 r0 *1 161.12,75.51 pfet_03v3
M$914 \$958 A|MID_MUX[1] VDD VDD pfet_03v3 L=0.28U W=1.38U AS=0.3588P
+ AD=0.6072P PS=1.9U PD=3.64U
* device instance $915 r0 *1 159.52,73.45 pfet_03v3
M$915 A|Y$133 \$893 VDD VDD pfet_03v3 L=0.28U W=2.76U AS=1.4076P AD=0.7176P
+ PS=6.18U PD=3.8U
* device instance $917 r0 *1 161.12,73.45 pfet_03v3
M$917 \$893 A|COARSE_MUX[1] VDD VDD pfet_03v3 L=0.28U W=1.38U AS=0.3588P
+ AD=0.6072P PS=1.9U PD=3.64U
* device instance $918 r0 *1 8.88,81.29 pfet_03v3
M$918 INJ_EDGE|Y \$965 VDD VDD pfet_03v3 L=0.28U W=2.76U AS=1.4076P AD=0.7176P
+ PS=6.18U PD=3.8U
* device instance $920 r0 *1 10.48,81.29 pfet_03v3
M$920 \$965 A|Y$135 VDD VDD pfet_03v3 L=0.28U W=1.38U AS=0.3588P AD=0.6072P
+ PS=1.9U PD=3.64U
* device instance $921 r0 *1 12.24,81.29 pfet_03v3
M$921 SS_BBPD[0]|Y \$966 VDD VDD pfet_03v3 L=0.28U W=2.76U AS=1.4076P
+ AD=0.7176P PS=6.18U PD=3.8U
* device instance $923 r0 *1 13.84,81.29 pfet_03v3
M$923 \$966 A|Y$145 VDD VDD pfet_03v3 L=0.28U W=1.38U AS=0.3588P AD=0.6072P
+ PS=1.9U PD=3.64U
* device instance $924 r0 *1 15.28,81.29 pfet_03v3
M$924 A|B|Y$2 A|Y$146 VDD VDD pfet_03v3 L=0.28U W=2.76U AS=0.966P AD=0.7176P
+ PS=5.54U PD=3.8U
* device instance $926 r0 *1 16.88,81.29 pfet_03v3
M$926 A|B|Y$2 A|B|Y$1 VDD VDD pfet_03v3 L=0.28U W=2.76U AS=0.7176P AD=1.0764P
+ PS=3.8U PD=5.7U
* device instance $928 r0 *1 19.28,81.29 pfet_03v3
M$928 A|B|Y$1 A|B|Y$2 VDD VDD pfet_03v3 L=0.28U W=2.76U AS=1.0764P AD=0.7176P
+ PS=5.7U PD=3.8U
* device instance $930 r0 *1 20.88,81.29 pfet_03v3
M$930 A|B|Y$1 A|Y$147 VDD VDD pfet_03v3 L=0.28U W=2.76U AS=0.7176P AD=0.966P
+ PS=3.8U PD=5.54U
* device instance $932 r0 *1 23.545,81.44 pfet_03v3
M$932 VDD \$973 \$972 VDD pfet_03v3 L=1.03U W=1.08U AS=0.5292P AD=0.4752P
+ PS=3.14U PD=3.04U
* device instance $933 r0 *1 31.945,81.435 pfet_03v3
M$933 VDD \$975 \$974 VDD pfet_03v3 L=7.75U W=1.09U AS=0.5341P AD=0.4796P
+ PS=3.16U PD=3.06U
* device instance $934 r0 *1 40.905,81.435 pfet_03v3
M$934 VDD \$977 \$976 VDD pfet_03v3 L=7.75U W=1.09U AS=0.5341P AD=0.4796P
+ PS=3.16U PD=3.06U
* device instance $935 r0 *1 47.2,81.29 pfet_03v3
M$935 VDD A|Y$148 \$978 VDD pfet_03v3 L=0.28U W=1.38U AS=0.6072P AD=0.3588P
+ PS=3.64U PD=1.9U
* device instance $936 r0 *1 48,81.29 pfet_03v3
M$936 A|Y$149 \$978 VDD VDD pfet_03v3 L=0.28U W=2.76U AS=0.7176P AD=1.4076P
+ PS=3.8U PD=6.18U
* device instance $938 r0 *1 50.985,81.44 pfet_03v3
M$938 VDD \$982 \$981 VDD pfet_03v3 L=1.03U W=1.08U AS=0.5292P AD=0.4752P
+ PS=3.14U PD=3.04U
* device instance $939 r0 *1 52.8,81.29 pfet_03v3
M$939 VDD A|Y$150 \$983 VDD pfet_03v3 L=0.28U W=1.38U AS=0.6072P AD=0.3588P
+ PS=3.64U PD=1.9U
* device instance $940 r0 *1 53.6,81.29 pfet_03v3
M$940 A|Y$151 \$983 VDD VDD pfet_03v3 L=0.28U W=2.76U AS=0.7176P AD=1.4076P
+ PS=3.8U PD=6.18U
* device instance $942 r0 *1 56.585,81.44 pfet_03v3
M$942 VDD \$987 \$986 VDD pfet_03v3 L=1.03U W=1.08U AS=0.5292P AD=0.4752P
+ PS=3.14U PD=3.04U
* device instance $943 r0 *1 60.08,81.29 pfet_03v3
M$943 VDD A|Y$152 \$988 VDD pfet_03v3 L=0.28U W=1.38U AS=0.6072P AD=0.3588P
+ PS=3.64U PD=1.9U
* device instance $944 r0 *1 60.88,81.29 pfet_03v3
M$944 A|Y$144 \$988 VDD VDD pfet_03v3 L=0.28U W=2.76U AS=0.7176P AD=1.4076P
+ PS=3.8U PD=6.18U
* device instance $946 r0 *1 63.865,81.44 pfet_03v3
M$946 VDD \$991 \$990 VDD pfet_03v3 L=1.03U W=1.08U AS=0.5292P AD=0.4752P
+ PS=3.14U PD=3.04U
* device instance $947 r0 *1 68.905,81.435 pfet_03v3
M$947 VDD \$993 \$992 VDD pfet_03v3 L=3.27U W=1.09U AS=0.5341P AD=0.4796P
+ PS=3.16U PD=3.06U
* device instance $948 r0 *1 72.265,81.44 pfet_03v3
M$948 VDD \$995 \$994 VDD pfet_03v3 L=1.03U W=1.08U AS=0.5292P AD=0.4752P
+ PS=3.14U PD=3.04U
* device instance $949 r0 *1 74.4,81.29 pfet_03v3
M$949 A|Y$153 \$996 VDD VDD pfet_03v3 L=0.28U W=2.76U AS=1.4076P AD=0.7176P
+ PS=6.18U PD=3.8U
* device instance $951 r0 *1 76,81.29 pfet_03v3
M$951 \$996 A|Y$154 VDD VDD pfet_03v3 L=0.28U W=1.38U AS=0.3588P AD=0.6072P
+ PS=1.9U PD=3.64U
* device instance $952 r0 *1 77.44,81.29 pfet_03v3
M$952 VDD A|Y$138 \$999 VDD pfet_03v3 L=0.28U W=1.38U AS=0.6072P AD=0.3588P
+ PS=3.64U PD=1.9U
* device instance $953 r0 *1 78.24,81.29 pfet_03v3
M$953 A|Y$154 \$999 VDD VDD pfet_03v3 L=0.28U W=2.76U AS=0.7176P AD=1.4076P
+ PS=3.8U PD=6.18U
* device instance $955 r0 *1 81.225,81.44 pfet_03v3
M$955 VDD \$1001 \$1000 VDD pfet_03v3 L=1.03U W=1.08U AS=0.5292P AD=0.4752P
+ PS=3.14U PD=3.04U
* device instance $956 r0 *1 83.6,81.29 pfet_03v3
M$956 VDD A|Y$155 \$1002 VDD pfet_03v3 L=0.28U W=1.38U AS=0.6072P AD=0.3588P
+ PS=3.64U PD=1.9U
* device instance $957 r0 *1 84.4,81.29 pfet_03v3
M$957 A|Y$140 \$1002 VDD VDD pfet_03v3 L=0.28U W=2.76U AS=0.7176P AD=1.4076P
+ PS=3.8U PD=6.18U
* device instance $959 r0 *1 88.505,81.435 pfet_03v3
M$959 VDD \$1005 \$1004 VDD pfet_03v3 L=3.27U W=1.09U AS=0.5341P AD=0.4796P
+ PS=3.16U PD=3.06U
* device instance $960 r0 *1 91.865,81.44 pfet_03v3
M$960 VDD \$1007 \$1006 VDD pfet_03v3 L=1.03U W=1.08U AS=0.5292P AD=0.4752P
+ PS=3.14U PD=3.04U
* device instance $961 r0 *1 95.68,81.29 pfet_03v3
M$961 A|Y$156 \$1008 VDD VDD pfet_03v3 L=0.28U W=2.76U AS=1.4076P AD=0.7176P
+ PS=6.18U PD=3.8U
* device instance $963 r0 *1 97.28,81.29 pfet_03v3
M$963 \$1008 A|Y$141 VDD VDD pfet_03v3 L=0.28U W=1.38U AS=0.3588P AD=0.6072P
+ PS=1.9U PD=3.64U
* device instance $964 r0 *1 98.72,81.29 pfet_03v3
M$964 VDD A|Y$156 \$1010 VDD pfet_03v3 L=0.28U W=1.38U AS=0.6072P AD=0.3588P
+ PS=3.64U PD=1.9U
* device instance $965 r0 *1 99.52,81.29 pfet_03v3
M$965 A|Y$157 \$1010 VDD VDD pfet_03v3 L=0.28U W=2.76U AS=0.7176P AD=1.4076P
+ PS=3.8U PD=6.18U
* device instance $967 r0 *1 102.505,81.44 pfet_03v3
M$967 VDD \$1013 \$1012 VDD pfet_03v3 L=1.03U W=1.08U AS=0.5292P AD=0.4752P
+ PS=3.14U PD=3.04U
* device instance $968 r0 *1 110.345,81.435 pfet_03v3
M$968 VDD \$1015 \$1014 VDD pfet_03v3 L=7.75U W=1.09U AS=0.5341P AD=0.4796P
+ PS=3.16U PD=3.06U
* device instance $969 r0 *1 119.305,81.435 pfet_03v3
M$969 VDD \$1017 \$1016 VDD pfet_03v3 L=7.75U W=1.09U AS=0.5341P AD=0.4796P
+ PS=3.16U PD=3.06U
* device instance $970 r0 *1 126.025,81.435 pfet_03v3
M$970 VDD \$1019 \$1018 VDD pfet_03v3 L=3.27U W=1.09U AS=0.5341P AD=0.4796P
+ PS=3.16U PD=3.06U
* device instance $971 r0 *1 129.385,81.44 pfet_03v3
M$971 VDD \$1021 \$1020 VDD pfet_03v3 L=1.03U W=1.08U AS=0.5292P AD=0.4752P
+ PS=3.14U PD=3.04U
* device instance $972 r0 *1 132.4,81.29 pfet_03v3
M$972 A|Y$142 B|Y$28 VDD VDD pfet_03v3 L=0.28U W=2.76U AS=1.0764P AD=0.7176P
+ PS=5.7U PD=3.8U
* device instance $974 r0 *1 134,81.29 pfet_03v3
M$974 A|Y$142 \$1024 VDD VDD pfet_03v3 L=0.28U W=2.76U AS=0.7176P AD=0.966P
+ PS=3.8U PD=5.54U
* device instance $976 r0 *1 136.24,81.29 pfet_03v3
M$976 VDD A|Y$133 \$1024 VDD pfet_03v3 L=0.28U W=1.38U AS=0.6072P AD=0.6348P
+ PS=3.64U PD=3.68U
* device instance $977 r0 *1 138,81.29 pfet_03v3
M$977 B|Y$25 B|Y$28 VDD VDD pfet_03v3 L=0.28U W=2.76U AS=1.0764P AD=0.7176P
+ PS=5.7U PD=3.8U
* device instance $979 r0 *1 139.6,81.29 pfet_03v3
M$979 B|Y$25 A|Y$133 VDD VDD pfet_03v3 L=0.28U W=2.76U AS=0.7176P AD=0.966P
+ PS=3.8U PD=5.54U
* device instance $981 r0 *1 142.265,81.44 pfet_03v3
M$981 VDD \$1027 \$1026 VDD pfet_03v3 L=1.03U W=1.08U AS=0.5292P AD=0.4752P
+ PS=3.14U PD=3.04U
* device instance $982 r0 *1 146.185,81.44 pfet_03v3
M$982 VDD \$1029 \$1028 VDD pfet_03v3 L=1.03U W=1.08U AS=0.5292P AD=0.4752P
+ PS=3.14U PD=3.04U
* device instance $983 r0 *1 149.12,81.29 pfet_03v3
M$983 C|Y$8 A|Y$158 VDD VDD pfet_03v3 L=0.28U W=2.76U AS=0.966P AD=0.966P
+ PS=5.54U PD=5.54U
* device instance $985 r0 *1 151.44,81.29 pfet_03v3
M$985 Y$8 C|Y$9 VDD VDD pfet_03v3 L=0.28U W=2.76U AS=0.9798P AD=1.1592P
+ PS=5.56U PD=4.44U
* device instance $987 r0 *1 153.68,81.29 pfet_03v3
M$987 Y$8 A|B|Y VDD VDD pfet_03v3 L=0.28U W=2.76U AS=1.1592P AD=0.7176P
+ PS=4.44U PD=3.8U
* device instance $989 r0 *1 155.28,81.29 pfet_03v3
M$989 Y$8 A|Y$143 VDD VDD pfet_03v3 L=0.28U W=2.76U AS=0.7176P AD=0.966P
+ PS=3.8U PD=5.54U
* device instance $991 r0 *1 159.52,81.29 pfet_03v3
M$991 A|Y$175 \$1036 VDD VDD pfet_03v3 L=0.28U W=2.76U AS=1.4076P AD=0.7176P
+ PS=6.18U PD=3.8U
* device instance $993 r0 *1 161.12,81.29 pfet_03v3
M$993 \$1036 A|COARSE_MUX[0] VDD VDD pfet_03v3 L=0.28U W=1.38U AS=0.3588P
+ AD=0.6072P PS=1.9U PD=3.64U
* device instance $994 r0 *1 10.105,83.205 pfet_03v3
M$994 VDD \$1074 \$1040 VDD pfet_03v3 L=3.27U W=1.09U AS=0.5341P AD=0.4796P
+ PS=3.16U PD=3.06U
* device instance $995 r0 *1 13.465,83.2 pfet_03v3
M$995 VDD \$1075 \$1041 VDD pfet_03v3 L=1.03U W=1.08U AS=0.5292P AD=0.4752P
+ PS=3.14U PD=3.04U
* device instance $996 r0 *1 16.4,83.35 pfet_03v3
M$996 A|Y$146 A|CLK|REF VDD VDD pfet_03v3 L=0.28U W=2.76U AS=0.966P AD=0.966P
+ PS=5.54U PD=5.54U
* device instance $998 r0 *1 18.64,83.35 pfet_03v3
M$998 Y$9 A|Y$146 VDD VDD pfet_03v3 L=0.28U W=2.76U AS=0.966P AD=0.966P
+ PS=5.54U PD=5.54U
* device instance $1000 r0 *1 21.305,83.2 pfet_03v3
M$1000 VDD \$1076 \$1043 VDD pfet_03v3 L=1.03U W=1.08U AS=0.5292P AD=0.4752P
+ PS=3.14U PD=3.04U
* device instance $1001 r0 *1 23.68,83.35 pfet_03v3
M$1001 Y$10 A|Y$147 VDD VDD pfet_03v3 L=0.28U W=2.76U AS=0.966P AD=0.966P
+ PS=5.54U PD=5.54U
* device instance $1003 r0 *1 27.465,83.205 pfet_03v3
M$1003 VDD \$1077 \$1045 VDD pfet_03v3 L=3.27U W=1.09U AS=0.5341P AD=0.4796P
+ PS=3.16U PD=3.06U
* device instance $1004 r0 *1 30.825,83.2 pfet_03v3
M$1004 VDD \$1078 \$1046 VDD pfet_03v3 L=1.03U W=1.08U AS=0.5292P AD=0.4752P
+ PS=3.14U PD=3.04U
* device instance $1005 r0 *1 34.32,83.35 pfet_03v3
M$1005 VDD A|Y$166 \$1047 VDD pfet_03v3 L=0.28U W=1.38U AS=0.6072P AD=0.3588P
+ PS=3.64U PD=1.9U
* device instance $1006 r0 *1 35.12,83.35 pfet_03v3
M$1006 A|Y$159 \$1047 VDD VDD pfet_03v3 L=0.28U W=2.76U AS=0.7176P AD=1.4076P
+ PS=3.8U PD=6.18U
* device instance $1008 r0 *1 37.68,83.35 pfet_03v3
M$1008 VDD A|Y$179 \$1049 VDD pfet_03v3 L=0.28U W=1.38U AS=0.6072P AD=0.3588P
+ PS=3.64U PD=1.9U
* device instance $1009 r0 *1 38.48,83.35 pfet_03v3
M$1009 A|Y$160 \$1049 VDD VDD pfet_03v3 L=0.28U W=2.76U AS=0.7176P AD=1.4076P
+ PS=3.8U PD=6.18U
* device instance $1011 r0 *1 41.465,83.2 pfet_03v3
M$1011 VDD \$1080 \$1051 VDD pfet_03v3 L=1.03U W=1.08U AS=0.5292P AD=0.4752P
+ PS=3.14U PD=3.04U
* device instance $1012 r0 *1 43.28,83.35 pfet_03v3
M$1012 VDD A|Y$167 \$1052 VDD pfet_03v3 L=0.28U W=1.38U AS=0.6072P AD=0.3588P
+ PS=3.64U PD=1.9U
* device instance $1013 r0 *1 44.08,83.35 pfet_03v3
M$1013 A|Y$161 \$1052 VDD VDD pfet_03v3 L=0.28U W=2.76U AS=0.7176P AD=1.4076P
+ PS=3.8U PD=6.18U
* device instance $1015 r0 *1 48.88,83.35 pfet_03v3
M$1015 VDD A|Y$168 \$1054 VDD pfet_03v3 L=0.28U W=1.38U AS=0.6072P AD=0.3588P
+ PS=3.64U PD=1.9U
* device instance $1016 r0 *1 49.68,83.35 pfet_03v3
M$1016 A|Y$150 \$1054 VDD VDD pfet_03v3 L=0.28U W=2.76U AS=0.7176P AD=1.4076P
+ PS=3.8U PD=6.18U
* device instance $1018 r0 *1 52.56,83.35 pfet_03v3
M$1018 A|Y$169 \$1083 VDD VDD pfet_03v3 L=0.28U W=2.76U AS=1.4076P AD=0.7176P
+ PS=6.18U PD=3.8U
* device instance $1020 r0 *1 54.16,83.35 pfet_03v3
M$1020 \$1083 A|Y$151 VDD VDD pfet_03v3 L=0.28U W=1.38U AS=0.3588P AD=0.6072P
+ PS=1.9U PD=3.64U
* device instance $1021 r0 *1 55.6,83.35 pfet_03v3
M$1021 VDD A|Y$169 \$1055 VDD pfet_03v3 L=0.28U W=1.38U AS=0.6072P AD=0.3588P
+ PS=3.64U PD=1.9U
* device instance $1022 r0 *1 56.4,83.35 pfet_03v3
M$1022 A|Y$162 \$1055 VDD VDD pfet_03v3 L=0.28U W=2.76U AS=0.7176P AD=1.4076P
+ PS=3.8U PD=6.18U
* device instance $1024 r0 *1 58.96,83.35 pfet_03v3
M$1024 VDD A|Y$162 \$1057 VDD pfet_03v3 L=0.28U W=1.38U AS=0.6072P AD=0.3588P
+ PS=3.64U PD=1.9U
* device instance $1025 r0 *1 59.76,83.35 pfet_03v3
M$1025 A|Y$152 \$1057 VDD VDD pfet_03v3 L=0.28U W=2.76U AS=0.7176P AD=1.4076P
+ PS=3.8U PD=6.18U
* device instance $1027 r0 *1 66.105,83.205 pfet_03v3
M$1027 VDD \$1085 \$1058 VDD pfet_03v3 L=7.75U W=1.09U AS=0.5341P AD=0.4796P
+ PS=3.16U PD=3.06U
* device instance $1028 r0 *1 72.72,83.35 pfet_03v3
M$1028 A|Y$163 \$1086 VDD VDD pfet_03v3 L=0.28U W=2.76U AS=1.4076P AD=0.7176P
+ PS=6.18U PD=3.8U
* device instance $1030 r0 *1 74.32,83.35 pfet_03v3
M$1030 \$1086 A|Y$170 VDD VDD pfet_03v3 L=0.28U W=1.38U AS=0.3588P AD=0.6072P
+ PS=1.9U PD=3.64U
* device instance $1031 r0 *1 75.76,83.35 pfet_03v3
M$1031 VDD A|Y$153 \$1060 VDD pfet_03v3 L=0.28U W=1.38U AS=0.6072P AD=0.3588P
+ PS=3.64U PD=1.9U
* device instance $1032 r0 *1 76.56,83.35 pfet_03v3
M$1032 A|Y$170 \$1060 VDD VDD pfet_03v3 L=0.28U W=2.76U AS=0.7176P AD=1.4076P
+ PS=3.8U PD=6.18U
* device instance $1034 r0 *1 79.545,83.2 pfet_03v3
M$1034 VDD \$1088 \$1061 VDD pfet_03v3 L=1.03U W=1.08U AS=0.5292P AD=0.4752P
+ PS=3.14U PD=3.04U
* device instance $1035 r0 *1 82.8,83.35 pfet_03v3
M$1035 A|Y$155 \$1089 VDD VDD pfet_03v3 L=0.28U W=2.76U AS=1.4076P AD=0.7176P
+ PS=6.18U PD=3.8U
* device instance $1037 r0 *1 84.4,83.35 pfet_03v3
M$1037 \$1089 A|Y$172 VDD VDD pfet_03v3 L=0.28U W=1.38U AS=0.3588P AD=0.6072P
+ PS=1.9U PD=3.64U
* device instance $1038 r0 *1 86.96,83.35 pfet_03v3
M$1038 VDD A|Y$171 \$1062 VDD pfet_03v3 L=0.28U W=1.38U AS=0.6072P AD=0.3588P
+ PS=3.64U PD=1.9U
* device instance $1039 r0 *1 87.76,83.35 pfet_03v3
M$1039 A|Y$172 \$1062 VDD VDD pfet_03v3 L=0.28U W=2.76U AS=0.7176P AD=1.4076P
+ PS=3.8U PD=6.18U
* device instance $1041 r0 *1 94.105,83.205 pfet_03v3
M$1041 VDD \$1092 \$1063 VDD pfet_03v3 L=7.75U W=1.09U AS=0.5341P AD=0.4796P
+ PS=3.16U PD=3.06U
* device instance $1042 r0 *1 99.28,83.35 pfet_03v3
M$1042 VDD A|Y$157 \$1064 VDD pfet_03v3 L=0.28U W=1.38U AS=0.6072P AD=0.3588P
+ PS=3.64U PD=1.9U
* device instance $1043 r0 *1 100.08,83.35 pfet_03v3
M$1043 A|Y$164 \$1064 VDD VDD pfet_03v3 L=0.28U W=2.76U AS=0.7176P AD=1.4076P
+ PS=3.8U PD=6.18U
* device instance $1045 r0 *1 106.425,83.205 pfet_03v3
M$1045 VDD \$1093 \$1066 VDD pfet_03v3 L=7.75U W=1.09U AS=0.5341P AD=0.4796P
+ PS=3.16U PD=3.06U
* device instance $1046 r0 *1 115.385,83.205 pfet_03v3
M$1046 VDD \$1094 \$1067 VDD pfet_03v3 L=7.75U W=1.09U AS=0.5341P AD=0.4796P
+ PS=3.16U PD=3.06U
* device instance $1047 r0 *1 122.105,83.205 pfet_03v3
M$1047 VDD \$1095 \$1068 VDD pfet_03v3 L=3.27U W=1.09U AS=0.5341P AD=0.4796P
+ PS=3.16U PD=3.06U
* device instance $1048 r0 *1 127.705,83.205 pfet_03v3
M$1048 VDD \$1096 \$1069 VDD pfet_03v3 L=3.27U W=1.09U AS=0.5341P AD=0.4796P
+ PS=3.16U PD=3.06U
* device instance $1049 r0 *1 131.065,83.2 pfet_03v3
M$1049 VDD \$1097 \$1070 VDD pfet_03v3 L=1.03U W=1.08U AS=0.5292P AD=0.4752P
+ PS=3.14U PD=3.04U
* device instance $1050 r0 *1 133.44,83.35 pfet_03v3
M$1050 A|Y$174 A|Y$173 VDD VDD pfet_03v3 L=0.28U W=2.76U AS=0.966P AD=0.7176P
+ PS=5.54U PD=3.8U
* device instance $1052 r0 *1 135.04,83.35 pfet_03v3
M$1052 A|Y$174 B|Y$27 VDD VDD pfet_03v3 L=0.28U W=2.76U AS=0.7176P AD=1.0764P
+ PS=3.8U PD=5.7U
* device instance $1054 r0 *1 137.44,83.35 pfet_03v3
M$1054 B|Y$28 B|Y$29 VDD VDD pfet_03v3 L=0.28U W=2.76U AS=1.0764P AD=0.7176P
+ PS=5.7U PD=3.8U
* device instance $1056 r0 *1 139.04,83.35 pfet_03v3
M$1056 B|Y$28 A|Y$175 VDD VDD pfet_03v3 L=0.28U W=2.76U AS=0.7176P AD=0.966P
+ PS=3.8U PD=5.54U
* device instance $1058 r0 *1 142.825,83.205 pfet_03v3
M$1058 VDD \$1101 \$1071 VDD pfet_03v3 L=3.27U W=1.09U AS=0.5341P AD=0.4796P
+ PS=3.16U PD=3.06U
* device instance $1059 r0 *1 145.76,83.35 pfet_03v3
M$1059 C|Y$9 A|Y$143 VDD VDD pfet_03v3 L=0.28U W=2.76U AS=0.966P AD=0.966P
+ PS=5.54U PD=5.54U
* device instance $1061 r0 *1 148.32,83.35 pfet_03v3
M$1061 A|Y$158 \$1102 VDD VDD pfet_03v3 L=0.28U W=2.76U AS=1.4076P AD=0.7176P
+ PS=6.18U PD=3.8U
* device instance $1063 r0 *1 149.92,83.35 pfet_03v3
M$1063 \$1102 A|MID_MUX[12] VDD VDD pfet_03v3 L=0.28U W=1.38U AS=0.3588P
+ AD=0.6072P PS=1.9U PD=3.64U
* device instance $1064 r0 *1 151.44,83.35 pfet_03v3
M$1064 Y$11 C|Y$10 VDD VDD pfet_03v3 L=0.28U W=2.76U AS=0.9798P AD=1.1592P
+ PS=5.56U PD=4.44U
* device instance $1066 r0 *1 153.68,83.35 pfet_03v3
M$1066 Y$11 A|B|Y VDD VDD pfet_03v3 L=0.28U W=2.76U AS=1.1592P AD=0.7176P
+ PS=4.44U PD=3.8U
* device instance $1068 r0 *1 155.28,83.35 pfet_03v3
M$1068 Y$11 A|Y$176 VDD VDD pfet_03v3 L=0.28U W=2.76U AS=0.7176P AD=0.966P
+ PS=3.8U PD=5.54U
* device instance $1070 r0 *1 159.52,83.35 pfet_03v3
M$1070 A|Y$165 \$1106 VDD VDD pfet_03v3 L=0.28U W=2.76U AS=1.4076P AD=0.7176P
+ PS=6.18U PD=3.8U
* device instance $1072 r0 *1 161.12,83.35 pfet_03v3
M$1072 \$1106 A|MID_MUX[13] VDD VDD pfet_03v3 L=0.28U W=1.38U AS=0.3588P
+ AD=0.6072P PS=1.9U PD=3.64U
* device instance $1073 r0 *1 8.56,89.13 pfet_03v3
M$1073 VDD A|DCO_EN \$1113 VDD pfet_03v3 L=0.28U W=1.38U AS=0.6072P AD=0.3588P
+ PS=3.64U PD=1.9U
* device instance $1074 r0 *1 9.36,89.13 pfet_03v3
M$1074 A|Y$177 \$1113 VDD VDD pfet_03v3 L=0.28U W=2.76U AS=0.7176P AD=1.4076P
+ PS=3.8U PD=6.18U
* device instance $1076 r0 *1 12.24,89.13 pfet_03v3
M$1076 OUT|Y \$1115 VDD VDD pfet_03v3 L=0.28U W=2.76U AS=1.4076P AD=0.7176P
+ PS=6.18U PD=3.8U
* device instance $1078 r0 *1 13.84,89.13 pfet_03v3
M$1078 \$1115 A|Y$178 VDD VDD pfet_03v3 L=0.28U W=1.38U AS=0.3588P AD=0.6072P
+ PS=1.9U PD=3.64U
* device instance $1079 r0 *1 15.705,89.28 pfet_03v3
M$1079 VDD \$1119 \$1118 VDD pfet_03v3 L=1.03U W=1.08U AS=0.5292P AD=0.4752P
+ PS=3.14U PD=3.04U
* device instance $1080 r0 *1 19.44,89.13 pfet_03v3
M$1080 \$1121 A|Y$146 VDD VDD pfet_03v3 L=0.28U W=1.38U AS=0.6348P AD=0.6072P
+ PS=3.68U PD=3.64U
* device instance $1081 r0 *1 20.88,89.13 pfet_03v3
M$1081 A|Y$189 \$1121 VDD VDD pfet_03v3 L=0.28U W=2.76U AS=0.966P AD=0.7176P
+ PS=5.54U PD=3.8U
* device instance $1083 r0 *1 22.48,89.13 pfet_03v3
M$1083 A|Y$189 B|ZERO VDD VDD pfet_03v3 L=0.28U W=2.76U AS=0.7176P AD=1.0764P
+ PS=3.8U PD=5.7U
* device instance $1085 r0 *1 24.8,89.13 pfet_03v3
M$1085 \$1123 \$1123 VDD VDD pfet_03v3 L=0.28U W=1.38U AS=0.6072P AD=0.6072P
+ PS=3.64U PD=3.64U
* device instance $1086 r0 *1 29.705,89.275 pfet_03v3
M$1086 VDD \$1125 \$1124 VDD pfet_03v3 L=3.27U W=1.09U AS=0.5341P AD=0.4796P
+ PS=3.16U PD=3.06U
* device instance $1087 r0 *1 34.08,89.13 pfet_03v3
M$1087 A|Y$179 \$1126 VDD VDD pfet_03v3 L=0.28U W=2.76U AS=1.4076P AD=0.7176P
+ PS=6.18U PD=3.8U
* device instance $1089 r0 *1 35.68,89.13 pfet_03v3
M$1089 \$1126 A|Y$159 VDD VDD pfet_03v3 L=0.28U W=1.38U AS=0.3588P AD=0.6072P
+ PS=1.9U PD=3.64U
* device instance $1090 r0 *1 37.44,89.13 pfet_03v3
M$1090 A|Y$180 \$1128 VDD VDD pfet_03v3 L=0.28U W=2.76U AS=1.4076P AD=0.7176P
+ PS=6.18U PD=3.8U
* device instance $1092 r0 *1 39.04,89.13 pfet_03v3
M$1092 \$1128 A|Y$160 VDD VDD pfet_03v3 L=0.28U W=1.38U AS=0.3588P AD=0.6072P
+ PS=1.9U PD=3.64U
* device instance $1093 r0 *1 40.48,89.13 pfet_03v3
M$1093 VDD A|Y$180 \$1130 VDD pfet_03v3 L=0.28U W=1.38U AS=0.6072P AD=0.3588P
+ PS=3.64U PD=1.9U
* device instance $1094 r0 *1 41.28,89.13 pfet_03v3
M$1094 A|Y$167 \$1130 VDD VDD pfet_03v3 L=0.28U W=2.76U AS=0.7176P AD=1.4076P
+ PS=3.8U PD=6.18U
* device instance $1096 r0 *1 44.4,89.13 pfet_03v3
M$1096 VDD A|Y$161 \$1131 VDD pfet_03v3 L=0.28U W=1.38U AS=0.6072P AD=0.3588P
+ PS=3.64U PD=1.9U
* device instance $1097 r0 *1 45.2,89.13 pfet_03v3
M$1097 A|Y$148 \$1131 VDD VDD pfet_03v3 L=0.28U W=2.76U AS=0.7176P AD=1.4076P
+ PS=3.8U PD=6.18U
* device instance $1099 r0 *1 48.32,89.13 pfet_03v3
M$1099 VDD A|Y$149 \$1132 VDD pfet_03v3 L=0.28U W=1.38U AS=0.6072P AD=0.3588P
+ PS=3.64U PD=1.9U
* device instance $1100 r0 *1 49.12,89.13 pfet_03v3
M$1100 A|Y$168 \$1132 VDD VDD pfet_03v3 L=0.28U W=2.76U AS=0.7176P AD=1.4076P
+ PS=3.8U PD=6.18U
* device instance $1102 r0 *1 55.465,89.275 pfet_03v3
M$1102 VDD \$1134 \$1133 VDD pfet_03v3 L=7.75U W=1.09U AS=0.5341P AD=0.4796P
+ PS=3.16U PD=3.06U
* device instance $1103 r0 *1 62.185,89.275 pfet_03v3
M$1103 VDD \$1136 \$1135 VDD pfet_03v3 L=3.27U W=1.09U AS=0.5341P AD=0.4796P
+ PS=3.16U PD=3.06U
* device instance $1104 r0 *1 67.785,89.28 pfet_03v3
M$1104 VDD \$1138 \$1137 VDD pfet_03v3 L=1.03U W=1.08U AS=0.5292P AD=0.4752P
+ PS=3.14U PD=3.04U
* device instance $1105 r0 *1 70.48,89.13 pfet_03v3
M$1105 A|Y$181 \$1139 VDD VDD pfet_03v3 L=0.28U W=2.76U AS=1.4076P AD=0.7176P
+ PS=6.18U PD=3.8U
* device instance $1107 r0 *1 72.08,89.13 pfet_03v3
M$1107 \$1139 A|Y$182 VDD VDD pfet_03v3 L=0.28U W=1.38U AS=0.3588P AD=0.6072P
+ PS=1.9U PD=3.64U
* device instance $1108 r0 *1 73.52,89.13 pfet_03v3
M$1108 VDD A|Y$163 \$1142 VDD pfet_03v3 L=0.28U W=1.38U AS=0.6072P AD=0.3588P
+ PS=3.64U PD=1.9U
* device instance $1109 r0 *1 74.32,89.13 pfet_03v3
M$1109 A|Y$182 \$1142 VDD VDD pfet_03v3 L=0.28U W=2.76U AS=0.7176P AD=1.4076P
+ PS=3.8U PD=6.18U
* device instance $1111 r0 *1 78.425,89.275 pfet_03v3
M$1111 VDD \$1144 \$1143 VDD pfet_03v3 L=3.27U W=1.09U AS=0.5341P AD=0.4796P
+ PS=3.16U PD=3.06U
* device instance $1112 r0 *1 82.8,89.13 pfet_03v3
M$1112 A|Y$171 \$1145 VDD VDD pfet_03v3 L=0.28U W=2.76U AS=1.4076P AD=0.7176P
+ PS=6.18U PD=3.8U
* device instance $1114 r0 *1 84.4,89.13 pfet_03v3
M$1114 \$1145 A|Y$183 VDD VDD pfet_03v3 L=0.28U W=1.38U AS=0.3588P AD=0.6072P
+ PS=1.9U PD=3.64U
* device instance $1115 r0 *1 86.16,89.13 pfet_03v3
M$1115 A|Y$183 \$1147 VDD VDD pfet_03v3 L=0.28U W=2.76U AS=1.4076P AD=0.7176P
+ PS=6.18U PD=3.8U
* device instance $1117 r0 *1 87.76,89.13 pfet_03v3
M$1117 \$1147 A|Y$184 VDD VDD pfet_03v3 L=0.28U W=1.38U AS=0.3588P AD=0.6072P
+ PS=1.9U PD=3.64U
* device instance $1118 r0 *1 89.52,89.13 pfet_03v3
M$1118 A|Y$184 \$1149 VDD VDD pfet_03v3 L=0.28U W=2.76U AS=1.4076P AD=0.7176P
+ PS=6.18U PD=3.8U
* device instance $1120 r0 *1 91.12,89.13 pfet_03v3
M$1120 \$1149 A|Y$185 VDD VDD pfet_03v3 L=0.28U W=1.38U AS=0.3588P AD=0.6072P
+ PS=1.9U PD=3.64U
* device instance $1121 r0 *1 94.105,89.275 pfet_03v3
M$1121 VDD \$1152 \$1151 VDD pfet_03v3 L=3.27U W=1.09U AS=0.5341P AD=0.4796P
+ PS=3.16U PD=3.06U
* device instance $1122 r0 *1 99.04,89.13 pfet_03v3
M$1122 A|Y$186 \$1153 VDD VDD pfet_03v3 L=0.28U W=2.76U AS=1.4076P AD=0.7176P
+ PS=6.18U PD=3.8U
* device instance $1124 r0 *1 100.64,89.13 pfet_03v3
M$1124 \$1153 A|Y$187 VDD VDD pfet_03v3 L=0.28U W=1.38U AS=0.3588P AD=0.6072P
+ PS=1.9U PD=3.64U
* device instance $1125 r0 *1 102.08,89.13 pfet_03v3
M$1125 VDD A|Y$164 \$1156 VDD pfet_03v3 L=0.28U W=1.38U AS=0.6072P AD=0.3588P
+ PS=3.64U PD=1.9U
* device instance $1126 r0 *1 102.88,89.13 pfet_03v3
M$1126 A|Y$187 \$1156 VDD VDD pfet_03v3 L=0.28U W=2.76U AS=0.7176P AD=1.4076P
+ PS=3.8U PD=6.18U
* device instance $1128 r0 *1 110.345,89.275 pfet_03v3
M$1128 VDD \$1158 \$1157 VDD pfet_03v3 L=7.75U W=1.09U AS=0.5341P AD=0.4796P
+ PS=3.16U PD=3.06U
* device instance $1129 r0 *1 119.305,89.275 pfet_03v3
M$1129 VDD \$1160 \$1159 VDD pfet_03v3 L=7.75U W=1.09U AS=0.5341P AD=0.4796P
+ PS=3.16U PD=3.06U
* device instance $1130 r0 *1 126.025,89.275 pfet_03v3
M$1130 VDD \$1162 \$1161 VDD pfet_03v3 L=3.27U W=1.09U AS=0.5341P AD=0.4796P
+ PS=3.16U PD=3.06U
* device instance $1131 r0 *1 129.385,89.28 pfet_03v3
M$1131 VDD \$1164 \$1163 VDD pfet_03v3 L=1.03U W=1.08U AS=0.5292P AD=0.4752P
+ PS=3.14U PD=3.04U
* device instance $1132 r0 *1 132.4,89.13 pfet_03v3
M$1132 A|Y$173 B|Y$29 VDD VDD pfet_03v3 L=0.28U W=2.76U AS=1.0764P AD=0.7176P
+ PS=5.7U PD=3.8U
* device instance $1134 r0 *1 134,89.13 pfet_03v3
M$1134 A|Y$173 \$1167 VDD VDD pfet_03v3 L=0.28U W=2.76U AS=0.7176P AD=0.966P
+ PS=3.8U PD=5.54U
* device instance $1136 r0 *1 136.24,89.13 pfet_03v3
M$1136 VDD A|Y$175 \$1167 VDD pfet_03v3 L=0.28U W=1.38U AS=0.6072P AD=0.6348P
+ PS=3.64U PD=3.68U
* device instance $1137 r0 *1 137.92,89.13 pfet_03v3
M$1137 A|B|Y A|Y$174 VDD VDD pfet_03v3 L=0.28U W=5.52U AS=1.6836P AD=1.794P
+ PS=9.34U PD=9.5U
* device instance $1141 r0 *1 142.265,89.28 pfet_03v3
M$1141 VDD \$1169 \$1168 VDD pfet_03v3 L=1.03U W=1.08U AS=0.5292P AD=0.4752P
+ PS=3.14U PD=3.04U
* device instance $1142 r0 *1 146.185,89.28 pfet_03v3
M$1142 VDD \$1171 \$1170 VDD pfet_03v3 L=1.03U W=1.08U AS=0.5292P AD=0.4752P
+ PS=3.14U PD=3.04U
* device instance $1143 r0 *1 149.68,89.13 pfet_03v3
M$1143 C|Y$10 A|Y$176 VDD VDD pfet_03v3 L=0.28U W=2.76U AS=0.966P AD=0.966P
+ PS=5.54U PD=5.54U
* device instance $1145 r0 *1 151.92,89.13 pfet_03v3
M$1145 Y$12 A|Y$158 VDD VDD pfet_03v3 L=0.28U W=2.76U AS=0.966P AD=0.7176P
+ PS=5.54U PD=3.8U
* device instance $1147 r0 *1 153.52,89.13 pfet_03v3
M$1147 Y$12 A|B|Y VDD VDD pfet_03v3 L=0.28U W=2.76U AS=0.7176P AD=1.1592P
+ PS=3.8U PD=4.44U
* device instance $1149 r0 *1 155.76,89.13 pfet_03v3
M$1149 Y$12 C|Y$8 VDD VDD pfet_03v3 L=0.28U W=2.76U AS=1.1592P AD=0.9798P
+ PS=4.44U PD=5.56U
* device instance $1151 r0 *1 159.52,89.13 pfet_03v3
M$1151 A|Y$188 \$1174 VDD VDD pfet_03v3 L=0.28U W=2.76U AS=1.4076P AD=0.7176P
+ PS=6.18U PD=3.8U
* device instance $1153 r0 *1 161.12,89.13 pfet_03v3
M$1153 \$1174 A|MID_MUX[5] VDD VDD pfet_03v3 L=0.28U W=1.38U AS=0.3588P
+ AD=0.6072P PS=1.9U PD=3.64U
* device instance $1154 r0 *1 8.56,91.19 pfet_03v3
M$1154 VDD A|FINE_MUX[8] \$1180 VDD pfet_03v3 L=0.28U W=1.38U AS=0.6072P
+ AD=0.3588P PS=3.64U PD=1.9U
* device instance $1155 r0 *1 9.36,91.19 pfet_03v3
M$1155 A|Y$190 \$1180 VDD VDD pfet_03v3 L=0.28U W=2.76U AS=0.7176P AD=1.4076P
+ PS=3.8U PD=6.18U
* device instance $1157 r0 *1 11.36,96.97 pfet_03v3
M$1157 Y$15 A|Y$190 VDD VDD pfet_03v3 L=0.28U W=2.76U AS=0.966P AD=0.7176P
+ PS=5.54U PD=3.8U
* device instance $1159 r0 *1 12.96,96.97 pfet_03v3
M$1159 Y$15 A|B|Y$3 VDD VDD pfet_03v3 L=0.28U W=2.76U AS=0.7176P AD=1.1592P
+ PS=3.8U PD=4.44U
* device instance $1161 r0 *1 15.2,96.97 pfet_03v3
M$1161 Y$15 C|Y$13 VDD VDD pfet_03v3 L=0.28U W=2.76U AS=1.1592P AD=0.9798P
+ PS=4.44U PD=5.56U
* device instance $1163 r0 *1 12.16,91.19 pfet_03v3
M$1163 \$1182 A|Y$177 VDD VDD pfet_03v3 L=0.28U W=1.38U AS=0.6141P AD=0.6072P
+ PS=3.65U PD=3.64U
* device instance $1164 r0 *1 13.6,91.19 pfet_03v3
M$1164 VDD \$1182 \$1183 VDD pfet_03v3 L=0.28U W=2.76U AS=0.966P AD=0.7176P
+ PS=5.54U PD=3.8U
* device instance $1166 r0 *1 15.2,91.19 pfet_03v3
M$1166 B|Y$30 B|ZERO$1 \$1183 VDD pfet_03v3 L=0.28U W=2.76U AS=0.7176P
+ AD=1.0764P PS=3.8U PD=5.7U
* device instance $1168 r0 *1 17.52,91.19 pfet_03v3
M$1168 \$1240 \$1240 VDD VDD pfet_03v3 L=0.28U W=1.38U AS=0.6072P AD=0.6072P
+ PS=3.64U PD=3.64U
* device instance $1169 r0 *1 19.2,96.97 pfet_03v3
M$1169 B|Y$31 A|Y$147 VDD VDD pfet_03v3 L=0.28U W=2.76U AS=0.966P AD=0.7176P
+ PS=5.54U PD=3.8U
* device instance $1171 r0 *1 20.8,96.97 pfet_03v3
M$1171 B|Y$31 B|Y$30 VDD VDD pfet_03v3 L=0.28U W=2.76U AS=0.7176P AD=1.0764P
+ PS=3.8U PD=5.7U
* device instance $1173 r0 *1 20.96,91.19 pfet_03v3
M$1173 A|Y$178 B|Y$31 VDD VDD pfet_03v3 L=0.28U W=2.76U AS=1.0764P AD=0.7176P
+ PS=5.7U PD=3.8U
* device instance $1175 r0 *1 22.56,91.19 pfet_03v3
M$1175 A|Y$178 A|Y$189 VDD VDD pfet_03v3 L=0.28U W=2.76U AS=0.7176P AD=0.966P
+ PS=3.8U PD=5.54U
* device instance $1177 r0 *1 24.8,96.97 pfet_03v3
M$1177 A|Y$147 A|Y$200 VDD VDD pfet_03v3 L=0.28U W=2.76U AS=0.966P AD=0.966P
+ PS=5.54U PD=5.54U
* device instance $1179 r0 *1 25.225,91.04 pfet_03v3
M$1179 VDD \$1188 \$1187 VDD pfet_03v3 L=1.03U W=1.08U AS=0.5292P AD=0.4752P
+ PS=3.14U PD=3.04U
* device instance $1180 r0 *1 27.6,91.19 pfet_03v3
M$1180 VDD A|Y$178 \$1189 VDD pfet_03v3 L=0.28U W=1.38U AS=0.6072P AD=0.3588P
+ PS=3.64U PD=1.9U
* device instance $1181 r0 *1 28.4,91.19 pfet_03v3
M$1181 A|Y$191 \$1189 VDD VDD pfet_03v3 L=0.28U W=2.76U AS=0.7176P AD=1.4076P
+ PS=3.8U PD=6.18U
* device instance $1183 r0 *1 28.16,96.97 pfet_03v3
M$1183 A|Y$200 A|B|Y$3 VDD VDD pfet_03v3 L=0.28U W=8.28U AS=2.4012P AD=2.622P
+ PS=13.14U PD=13.46U
* device instance $1189 r0 *1 32.08,91.19 pfet_03v3
M$1189 VDD A|Y$191 \$1191 VDD pfet_03v3 L=0.28U W=1.38U AS=0.6072P AD=0.3588P
+ PS=3.64U PD=1.9U
* device instance $1190 r0 *1 32.88,91.19 pfet_03v3
M$1190 A|Y$166 \$1191 VDD VDD pfet_03v3 L=0.28U W=2.76U AS=0.7176P AD=1.4076P
+ PS=3.8U PD=6.18U
* device instance $1192 r0 *1 39.225,91.045 pfet_03v3
M$1192 VDD \$1193 \$1192 VDD pfet_03v3 L=7.75U W=1.09U AS=0.5341P AD=0.4796P
+ PS=3.16U PD=3.06U
* device instance $1193 r0 *1 44.825,91.04 pfet_03v3
M$1193 VDD \$1195 \$1194 VDD pfet_03v3 L=1.03U W=1.08U AS=0.5292P AD=0.4752P
+ PS=3.14U PD=3.04U
* device instance $1194 r0 *1 51.545,91.045 pfet_03v3
M$1194 VDD \$1197 \$1196 VDD pfet_03v3 L=7.75U W=1.09U AS=0.5341P AD=0.4796P
+ PS=3.16U PD=3.06U
* device instance $1195 r0 *1 60.505,91.045 pfet_03v3
M$1195 VDD \$1199 \$1198 VDD pfet_03v3 L=7.75U W=1.09U AS=0.5341P AD=0.4796P
+ PS=3.16U PD=3.06U
* device instance $1196 r0 *1 66,91.19 pfet_03v3
M$1196 A|Y$192 \$1200 VDD VDD pfet_03v3 L=0.28U W=2.76U AS=1.4076P AD=0.7176P
+ PS=6.18U PD=3.8U
* device instance $1198 r0 *1 67.6,91.19 pfet_03v3
M$1198 \$1200 A|Y$193 VDD VDD pfet_03v3 L=0.28U W=1.38U AS=0.3588P AD=0.6072P
+ PS=1.9U PD=3.64U
* device instance $1199 r0 *1 69.04,91.19 pfet_03v3
M$1199 VDD A|Y$192 \$1203 VDD pfet_03v3 L=0.28U W=1.38U AS=0.6072P AD=0.3588P
+ PS=3.64U PD=1.9U
* device instance $1200 r0 *1 69.84,91.19 pfet_03v3
M$1200 A|Y$194 \$1203 VDD VDD pfet_03v3 L=0.28U W=2.76U AS=0.7176P AD=1.4076P
+ PS=3.8U PD=6.18U
* device instance $1202 r0 *1 69.92,96.97 pfet_03v3
M$1202 A|Y$201 \$1265 VDD VDD pfet_03v3 L=0.28U W=2.76U AS=1.4076P AD=0.7176P
+ PS=6.18U PD=3.8U
* device instance $1204 r0 *1 71.52,96.97 pfet_03v3
M$1204 \$1265 A|Y$202 VDD VDD pfet_03v3 L=0.28U W=1.38U AS=0.3588P AD=0.6072P
+ PS=1.9U PD=3.64U
* device instance $1205 r0 *1 72.4,91.19 pfet_03v3
M$1205 VDD A|Y$181 \$1205 VDD pfet_03v3 L=0.28U W=1.38U AS=0.6072P AD=0.3588P
+ PS=3.64U PD=1.9U
* device instance $1206 r0 *1 73.2,91.19 pfet_03v3
M$1206 A|Y$193 \$1205 VDD VDD pfet_03v3 L=0.28U W=2.76U AS=0.7176P AD=1.4076P
+ PS=3.8U PD=6.18U
* device instance $1208 r0 *1 72.96,96.97 pfet_03v3
M$1208 VDD A|Y$194 \$1268 VDD pfet_03v3 L=0.28U W=1.38U AS=0.6072P AD=0.3588P
+ PS=3.64U PD=1.9U
* device instance $1209 r0 *1 73.76,96.97 pfet_03v3
M$1209 A|Y$202 \$1268 VDD VDD pfet_03v3 L=0.28U W=2.76U AS=0.7176P AD=1.4076P
+ PS=3.8U PD=6.18U
* device instance $1211 r0 *1 79.545,91.045 pfet_03v3
M$1211 VDD \$1207 \$1206 VDD pfet_03v3 L=7.75U W=1.09U AS=0.5341P AD=0.4796P
+ PS=3.16U PD=3.06U
* device instance $1212 r0 *1 87.385,91.04 pfet_03v3
M$1212 VDD \$1209 \$1208 VDD pfet_03v3 L=1.03U W=1.08U AS=0.5292P AD=0.4752P
+ PS=3.14U PD=3.04U
* device instance $1213 r0 *1 90.08,91.19 pfet_03v3
M$1213 A|Y$185 \$1210 VDD VDD pfet_03v3 L=0.28U W=2.76U AS=1.4076P AD=0.7176P
+ PS=6.18U PD=3.8U
* device instance $1215 r0 *1 91.68,91.19 pfet_03v3
M$1215 \$1210 A|Y$195 VDD VDD pfet_03v3 L=0.28U W=1.38U AS=0.3588P AD=0.6072P
+ PS=1.9U PD=3.64U
* device instance $1216 r0 *1 93.44,91.19 pfet_03v3
M$1216 A|Y$195 \$1212 VDD VDD pfet_03v3 L=0.28U W=2.76U AS=1.4076P AD=0.7176P
+ PS=6.18U PD=3.8U
* device instance $1218 r0 *1 95.04,91.19 pfet_03v3
M$1218 \$1212 A|Y$196 VDD VDD pfet_03v3 L=0.28U W=1.38U AS=0.3588P AD=0.6072P
+ PS=1.9U PD=3.64U
* device instance $1219 r0 *1 96.8,91.19 pfet_03v3
M$1219 A|Y$196 \$1214 VDD VDD pfet_03v3 L=0.28U W=2.76U AS=1.4076P AD=0.7176P
+ PS=6.18U PD=3.8U
* device instance $1221 r0 *1 98.4,91.19 pfet_03v3
M$1221 \$1214 A|Y$197 VDD VDD pfet_03v3 L=0.28U W=1.38U AS=0.3588P AD=0.6072P
+ PS=1.9U PD=3.64U
* device instance $1222 r0 *1 99.36,96.97 pfet_03v3
M$1222 A|Y$211 A|B|Y VDD VDD pfet_03v3 L=0.28U W=5.52U AS=1.794P AD=1.6836P
+ PS=9.5U PD=9.34U
* device instance $1226 r0 *1 99.84,91.19 pfet_03v3
M$1226 VDD A|Y$186 \$1216 VDD pfet_03v3 L=0.28U W=1.38U AS=0.6072P AD=0.3588P
+ PS=3.64U PD=1.9U
* device instance $1227 r0 *1 100.64,91.19 pfet_03v3
M$1227 A|Y$197 \$1216 VDD VDD pfet_03v3 L=0.28U W=2.76U AS=0.7176P AD=1.4076P
+ PS=3.8U PD=6.18U
* device instance $1229 r0 *1 106.985,91.045 pfet_03v3
M$1229 VDD \$1218 \$1217 VDD pfet_03v3 L=7.75U W=1.09U AS=0.5341P AD=0.4796P
+ PS=3.16U PD=3.06U
* device instance $1230 r0 *1 115.945,91.045 pfet_03v3
M$1230 VDD \$1220 \$1219 VDD pfet_03v3 L=7.75U W=1.09U AS=0.5341P AD=0.4796P
+ PS=3.16U PD=3.06U
* device instance $1231 r0 *1 121.545,91.04 pfet_03v3
M$1231 VDD \$1222 \$1221 VDD pfet_03v3 L=1.03U W=1.08U AS=0.5292P AD=0.4752P
+ PS=3.14U PD=3.04U
* device instance $1232 r0 *1 127.705,91.045 pfet_03v3
M$1232 VDD \$1224 \$1223 VDD pfet_03v3 L=3.27U W=1.09U AS=0.5341P AD=0.4796P
+ PS=3.16U PD=3.06U
* device instance $1233 r0 *1 130.4,96.97 pfet_03v3
M$1233 A|Y$199 \$1283 VDD VDD pfet_03v3 L=0.28U W=2.76U AS=1.4076P AD=0.7176P
+ PS=6.18U PD=3.8U
* device instance $1235 r0 *1 132,96.97 pfet_03v3
M$1235 \$1283 A|Y$203 VDD VDD pfet_03v3 L=0.28U W=1.38U AS=0.3588P AD=0.6072P
+ PS=1.9U PD=3.64U
* device instance $1236 r0 *1 131.065,91.04 pfet_03v3
M$1236 VDD \$1226 \$1225 VDD pfet_03v3 L=1.03U W=1.08U AS=0.5292P AD=0.4752P
+ PS=3.14U PD=3.04U
* device instance $1237 r0 *1 133.44,96.97 pfet_03v3
M$1237 VDD A|Y$204 \$1285 VDD pfet_03v3 L=0.28U W=1.38U AS=0.6072P AD=0.3588P
+ PS=3.64U PD=1.9U
* device instance $1238 r0 *1 134.24,96.97 pfet_03v3
M$1238 A|Y$205 \$1285 VDD VDD pfet_03v3 L=0.28U W=2.76U AS=0.7176P AD=1.4076P
+ PS=3.8U PD=6.18U
* device instance $1240 r0 *1 134,91.19 pfet_03v3
M$1240 VDD A|Y$199 \$1227 VDD pfet_03v3 L=0.28U W=1.38U AS=0.6072P AD=0.3588P
+ PS=3.64U PD=1.9U
* device instance $1241 r0 *1 134.8,91.19 pfet_03v3
M$1241 A|Y$198 \$1227 VDD VDD pfet_03v3 L=0.28U W=2.76U AS=0.7176P AD=1.4076P
+ PS=3.8U PD=6.18U
* device instance $1243 r0 *1 137.36,91.19 pfet_03v3
M$1243 VDD A|Y$198 \$1229 VDD pfet_03v3 L=0.28U W=1.38U AS=0.6072P AD=0.3588P
+ PS=3.64U PD=1.9U
* device instance $1244 r0 *1 138.16,91.19 pfet_03v3
M$1244 B|Y$29 \$1229 VDD VDD pfet_03v3 L=0.28U W=2.76U AS=0.7176P AD=1.4076P
+ PS=3.8U PD=6.18U
* device instance $1246 r0 *1 142.265,91.045 pfet_03v3
M$1246 VDD \$1231 \$1230 VDD pfet_03v3 L=3.27U W=1.09U AS=0.5341P AD=0.4796P
+ PS=3.16U PD=3.06U
* device instance $1247 r0 *1 145.625,91.04 pfet_03v3
M$1247 VDD \$1233 \$1232 VDD pfet_03v3 L=1.03U W=1.08U AS=0.5292P AD=0.4752P
+ PS=3.14U PD=3.04U
* device instance $1248 r0 *1 148.56,91.19 pfet_03v3
M$1248 C|Y$11 A|Y$165 VDD VDD pfet_03v3 L=0.28U W=2.76U AS=0.966P AD=0.966P
+ PS=5.54U PD=5.54U
* device instance $1250 r0 *1 150.88,91.19 pfet_03v3
M$1250 Y$13 C|Y$11 VDD VDD pfet_03v3 L=0.28U W=2.76U AS=0.9798P AD=1.1592P
+ PS=5.56U PD=4.44U
* device instance $1252 r0 *1 153.12,91.19 pfet_03v3
M$1252 Y$13 A|B|Y VDD VDD pfet_03v3 L=0.28U W=2.76U AS=1.1592P AD=0.7176P
+ PS=4.44U PD=3.8U
* device instance $1254 r0 *1 154.72,91.19 pfet_03v3
M$1254 Y$13 A|Y$165 VDD VDD pfet_03v3 L=0.28U W=2.76U AS=0.7176P AD=0.966P
+ PS=3.8U PD=5.54U
* device instance $1256 r0 *1 152.56,96.97 pfet_03v3
M$1256 Y$14 C|Y$14 VDD VDD pfet_03v3 L=0.28U W=2.76U AS=0.9798P AD=1.1592P
+ PS=5.56U PD=4.44U
* device instance $1258 r0 *1 154.8,96.97 pfet_03v3
M$1258 Y$14 A|B|Y VDD VDD pfet_03v3 L=0.28U W=2.76U AS=1.1592P AD=0.7176P
+ PS=4.44U PD=3.8U
* device instance $1260 r0 *1 156.4,96.97 pfet_03v3
M$1260 Y$14 A|Y$206 VDD VDD pfet_03v3 L=0.28U W=2.76U AS=0.7176P AD=0.966P
+ PS=3.8U PD=5.54U
* device instance $1262 r0 *1 156.96,91.19 pfet_03v3
M$1262 C|Y$12 A|Y$188 VDD VDD pfet_03v3 L=0.28U W=2.76U AS=0.966P AD=0.966P
+ PS=5.54U PD=5.54U
* device instance $1264 r0 *1 159.52,91.19 pfet_03v3
M$1264 A|Y$206 \$1237 VDD VDD pfet_03v3 L=0.28U W=2.76U AS=1.4076P AD=0.7176P
+ PS=6.18U PD=3.8U
* device instance $1266 r0 *1 161.12,91.19 pfet_03v3
M$1266 \$1237 A|MID_MUX[4] VDD VDD pfet_03v3 L=0.28U W=1.38U AS=0.3588P
+ AD=0.6072P PS=1.9U PD=3.64U
* device instance $1267 r0 *1 159.52,96.97 pfet_03v3
M$1267 A|Y$214 \$1301 VDD VDD pfet_03v3 L=0.28U W=2.76U AS=1.4076P AD=0.7176P
+ PS=6.18U PD=3.8U
* device instance $1269 r0 *1 161.12,96.97 pfet_03v3
M$1269 \$1301 A|MID_MUX[10] VDD VDD pfet_03v3 L=0.28U W=1.38U AS=0.3588P
+ AD=0.6072P PS=1.9U PD=3.64U
* device instance $1270 r0 *1 8.985,97.12 pfet_03v3
M$1270 VDD \$1248 \$1247 VDD pfet_03v3 L=1.03U W=1.08U AS=0.5292P AD=0.4752P
+ PS=3.14U PD=3.04U
* device instance $1271 r0 *1 9.12,99.03 pfet_03v3
M$1271 C|Y$13 A|Y$190 VDD VDD pfet_03v3 L=0.28U W=2.76U AS=0.966P AD=0.966P
+ PS=5.54U PD=5.54U
* device instance $1273 r0 *1 11.44,99.03 pfet_03v3
M$1273 Y$16 C|Y$15 VDD VDD pfet_03v3 L=0.28U W=2.76U AS=0.9798P AD=1.1592P
+ PS=5.56U PD=4.44U
* device instance $1275 r0 *1 13.68,99.03 pfet_03v3
M$1275 Y$16 A|B|Y$3 VDD VDD pfet_03v3 L=0.28U W=2.76U AS=1.1592P AD=0.7176P
+ PS=4.44U PD=3.8U
* device instance $1277 r0 *1 15.28,99.03 pfet_03v3
M$1277 Y$16 A|Y$218 VDD VDD pfet_03v3 L=0.28U W=2.76U AS=0.7176P AD=0.966P
+ PS=3.8U PD=5.54U
* device instance $1279 r0 *1 21.305,98.885 pfet_03v3
M$1279 VDD \$1334 \$1306 VDD pfet_03v3 L=7.75U W=1.09U AS=0.5341P AD=0.4796P
+ PS=3.16U PD=3.06U
* device instance $1280 r0 *1 30.265,98.885 pfet_03v3
M$1280 VDD \$1335 \$1307 VDD pfet_03v3 L=7.75U W=1.09U AS=0.5341P AD=0.4796P
+ PS=3.16U PD=3.06U
* device instance $1281 r0 *1 37.545,97.115 pfet_03v3
M$1281 VDD \$1256 \$1255 VDD pfet_03v3 L=7.75U W=1.09U AS=0.5341P AD=0.4796P
+ PS=3.16U PD=3.06U
* device instance $1282 r0 *1 39.225,98.885 pfet_03v3
M$1282 VDD \$1336 \$1308 VDD pfet_03v3 L=7.75U W=1.09U AS=0.5341P AD=0.4796P
+ PS=3.16U PD=3.06U
* device instance $1283 r0 *1 46.505,97.115 pfet_03v3
M$1283 VDD \$1258 \$1257 VDD pfet_03v3 L=7.75U W=1.09U AS=0.5341P AD=0.4796P
+ PS=3.16U PD=3.06U
* device instance $1284 r0 *1 44.825,98.88 pfet_03v3
M$1284 VDD \$1337 \$1309 VDD pfet_03v3 L=1.03U W=1.08U AS=0.5292P AD=0.4752P
+ PS=3.14U PD=3.04U
* device instance $1285 r0 *1 51.545,98.885 pfet_03v3
M$1285 VDD \$1338 \$1310 VDD pfet_03v3 L=7.75U W=1.09U AS=0.5341P AD=0.4796P
+ PS=3.16U PD=3.06U
* device instance $1286 r0 *1 55.465,97.115 pfet_03v3
M$1286 VDD \$1260 \$1259 VDD pfet_03v3 L=7.75U W=1.09U AS=0.5341P AD=0.4796P
+ PS=3.16U PD=3.06U
* device instance $1287 r0 *1 60.505,98.885 pfet_03v3
M$1287 VDD \$1339 \$1311 VDD pfet_03v3 L=7.75U W=1.09U AS=0.5341P AD=0.4796P
+ PS=3.16U PD=3.06U
* device instance $1288 r0 *1 62.185,97.115 pfet_03v3
M$1288 VDD \$1262 \$1261 VDD pfet_03v3 L=3.27U W=1.09U AS=0.5341P AD=0.4796P
+ PS=3.16U PD=3.06U
* device instance $1289 r0 *1 66.105,98.88 pfet_03v3
M$1289 VDD \$1340 \$1312 VDD pfet_03v3 L=1.03U W=1.08U AS=0.5292P AD=0.4752P
+ PS=3.14U PD=3.04U
* device instance $1290 r0 *1 67.785,97.12 pfet_03v3
M$1290 VDD \$1264 \$1263 VDD pfet_03v3 L=1.03U W=1.08U AS=0.5292P AD=0.4752P
+ PS=3.14U PD=3.04U
* device instance $1291 r0 *1 68.24,99.03 pfet_03v3
M$1291 A|Y$209 \$1341 VDD VDD pfet_03v3 L=0.28U W=2.76U AS=1.4076P AD=0.7176P
+ PS=6.18U PD=3.8U
* device instance $1293 r0 *1 69.84,99.03 pfet_03v3
M$1293 \$1341 A|Y$201 VDD VDD pfet_03v3 L=0.28U W=1.38U AS=0.3588P AD=0.6072P
+ PS=1.9U PD=3.64U
* device instance $1294 r0 *1 71.28,99.03 pfet_03v3
M$1294 VDD A|Y$209 \$1313 VDD pfet_03v3 L=0.28U W=1.38U AS=0.6072P AD=0.3588P
+ PS=3.64U PD=1.9U
* device instance $1295 r0 *1 72.08,99.03 pfet_03v3
M$1295 A|Y$207 \$1313 VDD VDD pfet_03v3 L=0.28U W=2.76U AS=0.7176P AD=1.4076P
+ PS=3.8U PD=6.18U
* device instance $1297 r0 *1 75.76,99.03 pfet_03v3
M$1297 VDD A|Y$210 \$1315 VDD pfet_03v3 L=0.28U W=1.38U AS=0.6072P AD=0.3588P
+ PS=3.64U PD=1.9U
* device instance $1298 r0 *1 76.56,99.03 pfet_03v3
M$1298 A|Y$208 \$1315 VDD VDD pfet_03v3 L=0.28U W=2.76U AS=0.7176P AD=1.4076P
+ PS=3.8U PD=6.18U
* device instance $1300 r0 *1 80.105,97.115 pfet_03v3
M$1300 VDD \$1270 \$1269 VDD pfet_03v3 L=7.75U W=1.09U AS=0.5341P AD=0.4796P
+ PS=3.16U PD=3.06U
* device instance $1301 r0 *1 80.665,98.885 pfet_03v3
M$1301 VDD \$1344 \$1317 VDD pfet_03v3 L=3.27U W=1.09U AS=0.5341P AD=0.4796P
+ PS=3.16U PD=3.06U
* device instance $1302 r0 *1 84.025,98.88 pfet_03v3
M$1302 VDD \$1345 \$1318 VDD pfet_03v3 L=1.03U W=1.08U AS=0.5292P AD=0.4752P
+ PS=3.14U PD=3.04U
* device instance $1303 r0 *1 89.065,97.115 pfet_03v3
M$1303 VDD \$1272 \$1271 VDD pfet_03v3 L=7.75U W=1.09U AS=0.5341P AD=0.4796P
+ PS=3.16U PD=3.06U
* device instance $1304 r0 *1 88.505,98.885 pfet_03v3
M$1304 VDD \$1346 \$1319 VDD pfet_03v3 L=3.27U W=1.09U AS=0.5341P AD=0.4796P
+ PS=3.16U PD=3.06U
* device instance $1305 r0 *1 91.865,98.88 pfet_03v3
M$1305 VDD \$1347 \$1320 VDD pfet_03v3 L=1.03U W=1.08U AS=0.5292P AD=0.4752P
+ PS=3.14U PD=3.04U
* device instance $1306 r0 *1 93.84,99.03 pfet_03v3
M$1306 A|B|Y$3 A|Y$211 VDD VDD pfet_03v3 L=0.28U W=8.28U AS=2.622P AD=2.4012P
+ PS=13.46U PD=13.14U
* device instance $1312 r0 *1 95.785,97.115 pfet_03v3
M$1312 VDD \$1274 \$1273 VDD pfet_03v3 L=3.27U W=1.09U AS=0.5341P AD=0.4796P
+ PS=3.16U PD=3.06U
* device instance $1313 r0 *1 103.065,98.885 pfet_03v3
M$1313 VDD \$1349 \$1321 VDD pfet_03v3 L=7.75U W=1.09U AS=0.5341P AD=0.4796P
+ PS=3.16U PD=3.06U
* device instance $1314 r0 *1 103.625,97.12 pfet_03v3
M$1314 VDD \$1276 \$1275 VDD pfet_03v3 L=1.03U W=1.08U AS=0.5292P AD=0.4752P
+ PS=3.14U PD=3.04U
* device instance $1315 r0 *1 110.345,97.115 pfet_03v3
M$1315 VDD \$1278 \$1277 VDD pfet_03v3 L=7.75U W=1.09U AS=0.5341P AD=0.4796P
+ PS=3.16U PD=3.06U
* device instance $1316 r0 *1 112.025,98.885 pfet_03v3
M$1316 VDD \$1350 \$1322 VDD pfet_03v3 L=7.75U W=1.09U AS=0.5341P AD=0.4796P
+ PS=3.16U PD=3.06U
* device instance $1317 r0 *1 119.305,97.115 pfet_03v3
M$1317 VDD \$1280 \$1279 VDD pfet_03v3 L=7.75U W=1.09U AS=0.5341P AD=0.4796P
+ PS=3.16U PD=3.06U
* device instance $1318 r0 *1 118.745,98.885 pfet_03v3
M$1318 VDD \$1351 \$1323 VDD pfet_03v3 L=3.27U W=1.09U AS=0.5341P AD=0.4796P
+ PS=3.16U PD=3.06U
* device instance $1319 r0 *1 122.105,98.88 pfet_03v3
M$1319 VDD \$1352 \$1324 VDD pfet_03v3 L=1.03U W=1.08U AS=0.5292P AD=0.4752P
+ PS=3.14U PD=3.04U
* device instance $1320 r0 *1 126.025,97.115 pfet_03v3
M$1320 VDD \$1282 \$1281 VDD pfet_03v3 L=3.27U W=1.09U AS=0.5341P AD=0.4796P
+ PS=3.16U PD=3.06U
* device instance $1321 r0 *1 127.705,98.885 pfet_03v3
M$1321 VDD \$1353 \$1325 VDD pfet_03v3 L=3.27U W=1.09U AS=0.5341P AD=0.4796P
+ PS=3.16U PD=3.06U
* device instance $1322 r0 *1 131.52,99.03 pfet_03v3
M$1322 A|Y$204 \$1354 VDD VDD pfet_03v3 L=0.28U W=2.76U AS=1.4076P AD=0.7176P
+ PS=6.18U PD=3.8U
* device instance $1324 r0 *1 133.12,99.03 pfet_03v3
M$1324 \$1354 A|Y$212 VDD VDD pfet_03v3 L=0.28U W=1.38U AS=0.3588P AD=0.6072P
+ PS=1.9U PD=3.64U
* device instance $1325 r0 *1 134.56,99.03 pfet_03v3
M$1325 VDD A|Y$213 \$1326 VDD pfet_03v3 L=0.28U W=1.38U AS=0.6072P AD=0.3588P
+ PS=3.64U PD=1.9U
* device instance $1326 r0 *1 135.36,99.03 pfet_03v3
M$1326 A|Y$212 \$1326 VDD VDD pfet_03v3 L=0.28U W=2.76U AS=0.7176P AD=1.4076P
+ PS=3.8U PD=6.18U
* device instance $1328 r0 *1 138.345,97.115 pfet_03v3
M$1328 VDD \$1289 \$1288 VDD pfet_03v3 L=3.27U W=1.09U AS=0.5341P AD=0.4796P
+ PS=3.16U PD=3.06U
* device instance $1329 r0 *1 137.92,99.03 pfet_03v3
M$1329 VDD A|Y$205 \$1327 VDD pfet_03v3 L=0.28U W=1.38U AS=0.6072P AD=0.3588P
+ PS=3.64U PD=1.9U
* device instance $1330 r0 *1 138.72,99.03 pfet_03v3
M$1330 A|Y$203 \$1327 VDD VDD pfet_03v3 L=0.28U W=2.76U AS=0.7176P AD=1.4076P
+ PS=3.8U PD=6.18U
* device instance $1332 r0 *1 145.065,98.885 pfet_03v3
M$1332 VDD \$1357 \$1328 VDD pfet_03v3 L=7.75U W=1.09U AS=0.5341P AD=0.4796P
+ PS=3.16U PD=3.06U
* device instance $1333 r0 *1 141.705,97.12 pfet_03v3
M$1333 VDD \$1291 \$1290 VDD pfet_03v3 L=1.03U W=1.08U AS=0.5292P AD=0.4752P
+ PS=3.14U PD=3.04U
* device instance $1334 r0 *1 147.305,97.115 pfet_03v3
M$1334 VDD \$1293 \$1292 VDD pfet_03v3 L=3.27U W=1.09U AS=0.5341P AD=0.4796P
+ PS=3.16U PD=3.06U
* device instance $1335 r0 *1 150.24,99.03 pfet_03v3
M$1335 C|Y$16 A|Y$214 VDD VDD pfet_03v3 L=0.28U W=2.76U AS=0.966P AD=0.966P
+ PS=5.54U PD=5.54U
* device instance $1337 r0 *1 150.665,97.12 pfet_03v3
M$1337 VDD \$1295 \$1294 VDD pfet_03v3 L=1.03U W=1.08U AS=0.5292P AD=0.4752P
+ PS=3.14U PD=3.04U
* device instance $1338 r0 *1 152.56,99.03 pfet_03v3
M$1338 Y$17 C|Y$16 VDD VDD pfet_03v3 L=0.28U W=2.76U AS=0.9798P AD=1.1592P
+ PS=5.56U PD=4.44U
* device instance $1340 r0 *1 154.8,99.03 pfet_03v3
M$1340 Y$17 A|B|Y VDD VDD pfet_03v3 L=0.28U W=2.76U AS=1.1592P AD=0.7176P
+ PS=4.44U PD=3.8U
* device instance $1342 r0 *1 156.4,99.03 pfet_03v3
M$1342 Y$17 A|Y$214 VDD VDD pfet_03v3 L=0.28U W=2.76U AS=0.7176P AD=0.966P
+ PS=3.8U PD=5.54U
* device instance $1344 r0 *1 159.2,99.03 pfet_03v3
M$1344 VDD A|Y$211 \$1330 VDD pfet_03v3 L=0.28U W=1.38U AS=0.6072P AD=0.3588P
+ PS=3.64U PD=1.9U
* device instance $1345 r0 *1 160,99.03 pfet_03v3
M$1345 MID_OUT|Y \$1330 VDD VDD pfet_03v3 L=0.28U W=2.76U AS=0.7176P AD=1.4076P
+ PS=3.8U PD=6.18U
* device instance $1347 r0 *1 9.12,106.87 pfet_03v3
M$1347 C|Y$18 A|Y$233 VDD VDD pfet_03v3 L=0.28U W=2.76U AS=0.966P AD=0.966P
+ PS=5.54U PD=5.54U
* device instance $1349 r0 *1 9.12,104.81 pfet_03v3
M$1349 C|Y$15 A|Y$218 VDD VDD pfet_03v3 L=0.28U W=2.76U AS=0.966P AD=0.966P
+ PS=5.54U PD=5.54U
* device instance $1351 r0 *1 11.36,106.87 pfet_03v3
M$1351 Y$20 A|Y$233 VDD VDD pfet_03v3 L=0.28U W=2.76U AS=0.966P AD=0.7176P
+ PS=5.54U PD=3.8U
* device instance $1353 r0 *1 12.96,106.87 pfet_03v3
M$1353 Y$20 A|B|Y$3 VDD VDD pfet_03v3 L=0.28U W=2.76U AS=0.7176P AD=1.1592P
+ PS=3.8U PD=4.44U
* device instance $1355 r0 *1 15.2,106.87 pfet_03v3
M$1355 Y$20 C|Y$18 VDD VDD pfet_03v3 L=0.28U W=2.76U AS=1.1592P AD=0.9798P
+ PS=4.44U PD=5.56U
* device instance $1357 r0 *1 11.36,104.81 pfet_03v3
M$1357 Y$19 A|Y$219 VDD VDD pfet_03v3 L=0.28U W=2.76U AS=0.966P AD=0.7176P
+ PS=5.54U PD=3.8U
* device instance $1359 r0 *1 12.96,104.81 pfet_03v3
M$1359 Y$19 A|B|Y$3 VDD VDD pfet_03v3 L=0.28U W=2.76U AS=0.7176P AD=1.1592P
+ PS=3.8U PD=4.44U
* device instance $1361 r0 *1 15.2,104.81 pfet_03v3
M$1361 Y$19 C|Y$17 VDD VDD pfet_03v3 L=0.28U W=2.76U AS=1.1592P AD=0.9798P
+ PS=4.44U PD=5.56U
* device instance $1363 r0 *1 17.52,104.81 pfet_03v3
M$1363 VDD A|FINE_MUX[19] \$1368 VDD pfet_03v3 L=0.28U W=1.38U AS=0.6072P
+ AD=0.3588P PS=3.64U PD=1.9U
* device instance $1364 r0 *1 18.32,104.81 pfet_03v3
M$1364 A|Y$218 \$1368 VDD VDD pfet_03v3 L=0.28U W=2.76U AS=0.7176P AD=1.4076P
+ PS=3.8U PD=6.18U
* device instance $1366 r0 *1 17.52,106.87 pfet_03v3
M$1366 C|Y$17 A|Y$219 VDD VDD pfet_03v3 L=0.28U W=2.76U AS=0.966P AD=0.966P
+ PS=5.54U PD=5.54U
* device instance $1368 r0 *1 20.185,106.72 pfet_03v3
M$1368 VDD \$1459 \$1427 VDD pfet_03v3 L=1.03U W=1.08U AS=0.5292P AD=0.4752P
+ PS=3.14U PD=3.04U
* device instance $1369 r0 *1 22.425,104.955 pfet_03v3
M$1369 VDD \$1387 \$1386 VDD pfet_03v3 L=3.27U W=1.09U AS=0.5341P AD=0.4796P
+ PS=3.16U PD=3.06U
* device instance $1370 r0 *1 22.56,106.87 pfet_03v3
M$1370 C|Y$19 A|Y$234 VDD VDD pfet_03v3 L=0.28U W=2.76U AS=0.966P AD=0.966P
+ PS=5.54U PD=5.54U
* device instance $1372 r0 *1 24.8,106.87 pfet_03v3
M$1372 Y$21 A|Y$234 VDD VDD pfet_03v3 L=0.28U W=2.76U AS=0.966P AD=0.7176P
+ PS=5.54U PD=3.8U
* device instance $1374 r0 *1 26.4,106.87 pfet_03v3
M$1374 Y$21 A|B|Y$3 VDD VDD pfet_03v3 L=0.28U W=2.76U AS=0.7176P AD=1.1592P
+ PS=3.8U PD=4.44U
* device instance $1376 r0 *1 28.64,106.87 pfet_03v3
M$1376 Y$21 C|Y$19 VDD VDD pfet_03v3 L=0.28U W=2.76U AS=1.1592P AD=0.9798P
+ PS=4.44U PD=5.56U
* device instance $1378 r0 *1 31.945,104.955 pfet_03v3
M$1378 VDD \$1389 \$1388 VDD pfet_03v3 L=7.75U W=1.09U AS=0.5341P AD=0.4796P
+ PS=3.16U PD=3.06U
* device instance $1379 r0 *1 34.745,106.725 pfet_03v3
M$1379 VDD \$1462 \$1429 VDD pfet_03v3 L=7.75U W=1.09U AS=0.5341P AD=0.4796P
+ PS=3.16U PD=3.06U
* device instance $1380 r0 *1 40.905,104.955 pfet_03v3
M$1380 VDD \$1391 \$1390 VDD pfet_03v3 L=7.75U W=1.09U AS=0.5341P AD=0.4796P
+ PS=3.16U PD=3.06U
* device instance $1381 r0 *1 41.465,106.725 pfet_03v3
M$1381 VDD \$1463 \$1430 VDD pfet_03v3 L=3.27U W=1.09U AS=0.5341P AD=0.4796P
+ PS=3.16U PD=3.06U
* device instance $1382 r0 *1 44.825,106.72 pfet_03v3
M$1382 VDD \$1464 \$1431 VDD pfet_03v3 L=1.03U W=1.08U AS=0.5292P AD=0.4752P
+ PS=3.14U PD=3.04U
* device instance $1383 r0 *1 49.865,104.955 pfet_03v3
M$1383 VDD \$1393 \$1392 VDD pfet_03v3 L=7.75U W=1.09U AS=0.5341P AD=0.4796P
+ PS=3.16U PD=3.06U
* device instance $1384 r0 *1 51.545,106.725 pfet_03v3
M$1384 VDD \$1465 \$1432 VDD pfet_03v3 L=7.75U W=1.09U AS=0.5341P AD=0.4796P
+ PS=3.16U PD=3.06U
* device instance $1385 r0 *1 58.825,104.955 pfet_03v3
M$1385 VDD \$1395 \$1394 VDD pfet_03v3 L=7.75U W=1.09U AS=0.5341P AD=0.4796P
+ PS=3.16U PD=3.06U
* device instance $1386 r0 *1 60.505,106.725 pfet_03v3
M$1386 VDD \$1466 \$1433 VDD pfet_03v3 L=7.75U W=1.09U AS=0.5341P AD=0.4796P
+ PS=3.16U PD=3.06U
* device instance $1387 r0 *1 64.425,104.96 pfet_03v3
M$1387 VDD \$1369 \$1396 VDD pfet_03v3 L=1.03U W=1.08U AS=0.5292P AD=0.4752P
+ PS=3.14U PD=3.04U
* device instance $1388 r0 *1 67.225,106.725 pfet_03v3
M$1388 VDD \$1467 \$1434 VDD pfet_03v3 L=3.27U W=1.09U AS=0.5341P AD=0.4796P
+ PS=3.16U PD=3.06U
* device instance $1389 r0 *1 67.785,104.96 pfet_03v3
M$1389 VDD \$1370 \$1397 VDD pfet_03v3 L=1.03U W=1.08U AS=0.5292P AD=0.4752P
+ PS=3.14U PD=3.04U
* device instance $1390 r0 *1 70.585,106.72 pfet_03v3
M$1390 VDD \$1468 \$1435 VDD pfet_03v3 L=1.03U W=1.08U AS=0.5292P AD=0.4752P
+ PS=3.14U PD=3.04U
* device instance $1391 r0 *1 70.48,104.81 pfet_03v3
M$1391 A|Y$210 \$1398 VDD VDD pfet_03v3 L=0.28U W=2.76U AS=1.4076P AD=0.7176P
+ PS=6.18U PD=3.8U
* device instance $1393 r0 *1 72.08,104.81 pfet_03v3
M$1393 \$1398 A|Y$220 VDD VDD pfet_03v3 L=0.28U W=1.38U AS=0.3588P AD=0.6072P
+ PS=1.9U PD=3.64U
* device instance $1394 r0 *1 72.96,106.87 pfet_03v3
M$1394 VDD A|Y$207 \$1436 VDD pfet_03v3 L=0.28U W=1.38U AS=0.6072P AD=0.3588P
+ PS=3.64U PD=1.9U
* device instance $1395 r0 *1 73.76,106.87 pfet_03v3
M$1395 A|Y$220 \$1436 VDD VDD pfet_03v3 L=0.28U W=2.76U AS=0.7176P AD=1.4076P
+ PS=3.8U PD=6.18U
* device instance $1397 r0 *1 73.84,104.81 pfet_03v3
M$1397 A|Y$215 \$1400 VDD VDD pfet_03v3 L=0.28U W=2.76U AS=1.4076P AD=0.7176P
+ PS=6.18U PD=3.8U
* device instance $1399 r0 *1 75.44,104.81 pfet_03v3
M$1399 \$1400 A|Y$208 VDD VDD pfet_03v3 L=0.28U W=1.38U AS=0.3588P AD=0.6072P
+ PS=1.9U PD=3.64U
* device instance $1400 r0 *1 76.745,106.72 pfet_03v3
M$1400 VDD \$1469 \$1437 VDD pfet_03v3 L=1.03U W=1.08U AS=0.5292P AD=0.4752P
+ PS=3.14U PD=3.04U
* device instance $1401 r0 *1 76.88,104.81 pfet_03v3
M$1401 VDD A|Y$215 \$1372 VDD pfet_03v3 L=0.28U W=1.38U AS=0.6072P AD=0.3588P
+ PS=3.64U PD=1.9U
* device instance $1402 r0 *1 77.68,104.81 pfet_03v3
M$1402 A|Y$216 \$1372 VDD VDD pfet_03v3 L=0.28U W=2.76U AS=0.7176P AD=1.4076P
+ PS=3.8U PD=6.18U
* device instance $1404 r0 *1 79.44,106.87 pfet_03v3
M$1404 A|Y$223 \$1470 VDD VDD pfet_03v3 L=0.28U W=2.76U AS=1.4076P AD=0.7176P
+ PS=6.18U PD=3.8U
* device instance $1406 r0 *1 81.04,106.87 pfet_03v3
M$1406 \$1470 A|Y$217 VDD VDD pfet_03v3 L=0.28U W=1.38U AS=0.3588P AD=0.6072P
+ PS=1.9U PD=3.64U
* device instance $1407 r0 *1 80.24,104.81 pfet_03v3
M$1407 VDD A|Y$216 \$1374 VDD pfet_03v3 L=0.28U W=1.38U AS=0.6072P AD=0.3588P
+ PS=3.64U PD=1.9U
* device instance $1408 r0 *1 81.04,104.81 pfet_03v3
M$1408 A|Y$217 \$1374 VDD VDD pfet_03v3 L=0.28U W=2.76U AS=0.7176P AD=1.4076P
+ PS=3.8U PD=6.18U
* device instance $1410 r0 *1 82.48,106.87 pfet_03v3
M$1410 VDD A|Y$223 \$1439 VDD pfet_03v3 L=0.28U W=1.38U AS=0.6072P AD=0.3588P
+ PS=3.64U PD=1.9U
* device instance $1411 r0 *1 83.28,106.87 pfet_03v3
M$1411 A|Y$224 \$1439 VDD VDD pfet_03v3 L=0.28U W=2.76U AS=0.7176P AD=1.4076P
+ PS=3.8U PD=6.18U
* device instance $1413 r0 *1 87.385,104.955 pfet_03v3
M$1413 VDD \$1402 \$1401 VDD pfet_03v3 L=7.75U W=1.09U AS=0.5341P AD=0.4796P
+ PS=3.16U PD=3.06U
* device instance $1414 r0 *1 86.96,106.87 pfet_03v3
M$1414 VDD A|Y$224 \$1441 VDD pfet_03v3 L=0.28U W=1.38U AS=0.6072P AD=0.3588P
+ PS=3.64U PD=1.9U
* device instance $1415 r0 *1 87.76,106.87 pfet_03v3
M$1415 A|Y$225 \$1441 VDD VDD pfet_03v3 L=0.28U W=2.76U AS=0.7176P AD=1.4076P
+ PS=3.8U PD=6.18U
* device instance $1417 r0 *1 90.32,106.87 pfet_03v3
M$1417 VDD A|Y$235 \$1443 VDD pfet_03v3 L=0.28U W=1.38U AS=0.6072P AD=0.3588P
+ PS=3.64U PD=1.9U
* device instance $1418 r0 *1 91.12,106.87 pfet_03v3
M$1418 A|Y$226 \$1443 VDD VDD pfet_03v3 L=0.28U W=2.76U AS=0.7176P AD=1.4076P
+ PS=3.8U PD=6.18U
* device instance $1420 r0 *1 96.345,104.955 pfet_03v3
M$1420 VDD \$1404 \$1403 VDD pfet_03v3 L=7.75U W=1.09U AS=0.5341P AD=0.4796P
+ PS=3.16U PD=3.06U
* device instance $1421 r0 *1 95.68,106.87 pfet_03v3
M$1421 A|Y$227 \$1472 VDD VDD pfet_03v3 L=0.28U W=2.76U AS=1.4076P AD=0.7176P
+ PS=6.18U PD=3.8U
* device instance $1423 r0 *1 97.28,106.87 pfet_03v3
M$1423 \$1472 A|Y$236 VDD VDD pfet_03v3 L=0.28U W=1.38U AS=0.3588P AD=0.6072P
+ PS=1.9U PD=3.64U
* device instance $1424 r0 *1 99.04,106.87 pfet_03v3
M$1424 A|Y$228 \$1474 VDD VDD pfet_03v3 L=0.28U W=2.76U AS=1.4076P AD=0.7176P
+ PS=6.18U PD=3.8U
* device instance $1426 r0 *1 100.64,106.87 pfet_03v3
M$1426 \$1474 A|Y$237 VDD VDD pfet_03v3 L=0.28U W=1.38U AS=0.3588P AD=0.6072P
+ PS=1.9U PD=3.64U
* device instance $1427 r0 *1 101.945,104.96 pfet_03v3
M$1427 VDD \$1376 \$1405 VDD pfet_03v3 L=1.03U W=1.08U AS=0.5292P AD=0.4752P
+ PS=3.14U PD=3.04U
* device instance $1428 r0 *1 102.4,106.87 pfet_03v3
M$1428 A|Y$229 \$1476 VDD VDD pfet_03v3 L=0.28U W=2.76U AS=1.4076P AD=0.7176P
+ PS=6.18U PD=3.8U
* device instance $1430 r0 *1 104,106.87 pfet_03v3
M$1430 \$1476 A|Y$238 VDD VDD pfet_03v3 L=0.28U W=1.38U AS=0.3588P AD=0.6072P
+ PS=1.9U PD=3.64U
* device instance $1431 r0 *1 106.32,106.87 pfet_03v3
M$1431 A|Y$230 \$1478 VDD VDD pfet_03v3 L=0.28U W=2.76U AS=1.4076P AD=0.7176P
+ PS=6.18U PD=3.8U
* device instance $1433 r0 *1 107.92,106.87 pfet_03v3
M$1433 \$1478 A|Y$239 VDD VDD pfet_03v3 L=0.28U W=1.38U AS=0.3588P AD=0.6072P
+ PS=1.9U PD=3.64U
* device instance $1434 r0 *1 110.345,104.955 pfet_03v3
M$1434 VDD \$1407 \$1406 VDD pfet_03v3 L=7.75U W=1.09U AS=0.5341P AD=0.4796P
+ PS=3.16U PD=3.06U
* device instance $1435 r0 *1 109.785,106.72 pfet_03v3
M$1435 VDD \$1480 \$1449 VDD pfet_03v3 L=1.03U W=1.08U AS=0.5292P AD=0.4752P
+ PS=3.14U PD=3.04U
* device instance $1436 r0 *1 113.04,106.87 pfet_03v3
M$1436 A|Y$231 \$1481 VDD VDD pfet_03v3 L=0.28U W=2.76U AS=1.4076P AD=0.7176P
+ PS=6.18U PD=3.8U
* device instance $1438 r0 *1 114.64,106.87 pfet_03v3
M$1438 \$1481 A|Y$240 VDD VDD pfet_03v3 L=0.28U W=1.38U AS=0.3588P AD=0.6072P
+ PS=1.9U PD=3.64U
* device instance $1439 r0 *1 119.305,104.955 pfet_03v3
M$1439 VDD \$1409 \$1408 VDD pfet_03v3 L=7.75U W=1.09U AS=0.5341P AD=0.4796P
+ PS=3.16U PD=3.06U
* device instance $1440 r0 *1 116.4,106.87 pfet_03v3
M$1440 A|Y$232 \$1483 VDD VDD pfet_03v3 L=0.28U W=2.76U AS=1.4076P AD=0.7176P
+ PS=6.18U PD=3.8U
* device instance $1442 r0 *1 118,106.87 pfet_03v3
M$1442 \$1483 A|Y$241 VDD VDD pfet_03v3 L=0.28U W=1.38U AS=0.3588P AD=0.6072P
+ PS=1.9U PD=3.64U
* device instance $1443 r0 *1 120.985,106.725 pfet_03v3
M$1443 VDD \$1485 \$1452 VDD pfet_03v3 L=3.27U W=1.09U AS=0.5341P AD=0.4796P
+ PS=3.16U PD=3.06U
* device instance $1444 r0 *1 126.025,104.955 pfet_03v3
M$1444 VDD \$1411 \$1410 VDD pfet_03v3 L=3.27U W=1.09U AS=0.5341P AD=0.4796P
+ PS=3.16U PD=3.06U
* device instance $1445 r0 *1 127.705,106.725 pfet_03v3
M$1445 VDD \$1486 \$1453 VDD pfet_03v3 L=3.27U W=1.09U AS=0.5341P AD=0.4796P
+ PS=3.16U PD=3.06U
* device instance $1446 r0 *1 129.385,104.96 pfet_03v3
M$1446 VDD \$1377 \$1412 VDD pfet_03v3 L=1.03U W=1.08U AS=0.5292P AD=0.4752P
+ PS=3.14U PD=3.04U
* device instance $1447 r0 *1 132.08,104.81 pfet_03v3
M$1447 A|Y$213 \$1413 VDD VDD pfet_03v3 L=0.28U W=2.76U AS=1.4076P AD=0.7176P
+ PS=6.18U PD=3.8U
* device instance $1449 r0 *1 133.68,104.81 pfet_03v3
M$1449 \$1413 A|Y$221 VDD VDD pfet_03v3 L=0.28U W=1.38U AS=0.3588P AD=0.6072P
+ PS=1.9U PD=3.64U
* device instance $1450 r0 *1 132.64,106.87 pfet_03v3
M$1450 A|Y$222 \$1487 VDD VDD pfet_03v3 L=0.28U W=2.76U AS=1.4076P AD=0.7176P
+ PS=6.18U PD=3.8U
* device instance $1452 r0 *1 134.24,106.87 pfet_03v3
M$1452 \$1487 A|Y$242 VDD VDD pfet_03v3 L=0.28U W=1.38U AS=0.3588P AD=0.6072P
+ PS=1.9U PD=3.64U
* device instance $1453 r0 *1 135.12,104.81 pfet_03v3
M$1453 VDD A|Y$222 \$1378 VDD pfet_03v3 L=0.28U W=1.38U AS=0.6072P AD=0.3588P
+ PS=3.64U PD=1.9U
* device instance $1454 r0 *1 135.92,104.81 pfet_03v3
M$1454 A|Y$221 \$1378 VDD VDD pfet_03v3 L=0.28U W=2.76U AS=0.7176P AD=1.4076P
+ PS=3.8U PD=6.18U
* device instance $1456 r0 *1 136,106.87 pfet_03v3
M$1456 A|Y$242 \$1489 VDD VDD pfet_03v3 L=0.28U W=2.76U AS=1.4076P AD=0.7176P
+ PS=6.18U PD=3.8U
* device instance $1458 r0 *1 137.6,106.87 pfet_03v3
M$1458 \$1489 A|Y$243 VDD VDD pfet_03v3 L=0.28U W=1.38U AS=0.3588P AD=0.6072P
+ PS=1.9U PD=3.64U
* device instance $1459 r0 *1 140.025,104.955 pfet_03v3
M$1459 VDD \$1417 \$1416 VDD pfet_03v3 L=3.27U W=1.09U AS=0.5341P AD=0.4796P
+ PS=3.16U PD=3.06U
* device instance $1460 r0 *1 142.825,106.725 pfet_03v3
M$1460 VDD \$1491 \$1454 VDD pfet_03v3 L=7.75U W=1.09U AS=0.5341P AD=0.4796P
+ PS=3.16U PD=3.06U
* device instance $1461 r0 *1 147.305,104.955 pfet_03v3
M$1461 VDD \$1419 \$1418 VDD pfet_03v3 L=3.27U W=1.09U AS=0.5341P AD=0.4796P
+ PS=3.16U PD=3.06U
* device instance $1462 r0 *1 151.785,106.725 pfet_03v3
M$1462 VDD \$1492 \$1455 VDD pfet_03v3 L=7.75U W=1.09U AS=0.5341P AD=0.4796P
+ PS=3.16U PD=3.06U
* device instance $1463 r0 *1 150.665,104.96 pfet_03v3
M$1463 VDD \$1379 \$1420 VDD pfet_03v3 L=1.03U W=1.08U AS=0.5292P AD=0.4752P
+ PS=3.14U PD=3.04U
* device instance $1464 r0 *1 152.56,104.81 pfet_03v3
M$1464 Y$18 C|Y$12 VDD VDD pfet_03v3 L=0.28U W=2.76U AS=0.9798P AD=1.1592P
+ PS=5.56U PD=4.44U
* device instance $1466 r0 *1 154.8,104.81 pfet_03v3
M$1466 Y$18 A|B|Y VDD VDD pfet_03v3 L=0.28U W=2.76U AS=1.1592P AD=0.7176P
+ PS=4.44U PD=3.8U
* device instance $1468 r0 *1 156.4,104.81 pfet_03v3
M$1468 Y$18 A|Y$188 VDD VDD pfet_03v3 L=0.28U W=2.76U AS=0.7176P AD=0.966P
+ PS=3.8U PD=5.54U
* device instance $1470 r0 *1 158.505,106.725 pfet_03v3
M$1470 VDD \$1493 \$1456 VDD pfet_03v3 L=3.27U W=1.09U AS=0.5341P AD=0.4796P
+ PS=3.16U PD=3.06U
* device instance $1471 r0 *1 158.64,104.81 pfet_03v3
M$1471 C|Y$14 A|Y$206 VDD VDD pfet_03v3 L=0.28U W=2.76U AS=0.966P AD=0.966P
+ PS=5.54U PD=5.54U
* device instance $1473 r0 *1 8.56,114.71 pfet_03v3
M$1473 VDD A|FINE_MUX[22] \$1548 VDD pfet_03v3 L=0.28U W=1.38U AS=0.6072P
+ AD=0.3588P PS=3.64U PD=1.9U
* device instance $1474 r0 *1 9.36,114.71 pfet_03v3
M$1474 A|Y$219 \$1548 VDD VDD pfet_03v3 L=0.28U W=2.76U AS=0.7176P AD=1.4076P
+ PS=3.8U PD=6.18U
* device instance $1476 r0 *1 8.56,112.65 pfet_03v3
M$1476 VDD A|FINE_MUX[0] \$1498 VDD pfet_03v3 L=0.28U W=1.38U AS=0.6072P
+ AD=0.3588P PS=3.64U PD=1.9U
* device instance $1477 r0 *1 9.36,112.65 pfet_03v3
M$1477 A|Y$234 \$1498 VDD VDD pfet_03v3 L=0.28U W=2.76U AS=0.7176P AD=1.4076P
+ PS=3.8U PD=6.18U
* device instance $1479 r0 *1 11.92,112.65 pfet_03v3
M$1479 VDD A|FINE_MUX[26] \$1499 VDD pfet_03v3 L=0.28U W=1.38U AS=0.6072P
+ AD=0.3588P PS=3.64U PD=1.9U
* device instance $1480 r0 *1 12.72,112.65 pfet_03v3
M$1480 A|Y$233 \$1499 VDD VDD pfet_03v3 L=0.28U W=2.76U AS=0.7176P AD=1.4076P
+ PS=3.8U PD=6.18U
* device instance $1482 r0 *1 11.92,114.71 pfet_03v3
M$1482 VDD A|FINE_MUX[28] \$1549 VDD pfet_03v3 L=0.28U W=1.38U AS=0.6072P
+ AD=0.3588P PS=3.64U PD=1.9U
* device instance $1483 r0 *1 12.72,114.71 pfet_03v3
M$1483 A|Y$250 \$1549 VDD VDD pfet_03v3 L=0.28U W=2.76U AS=0.7176P AD=1.4076P
+ PS=3.8U PD=6.18U
* device instance $1485 r0 *1 15.705,114.56 pfet_03v3
M$1485 VDD \$1580 \$1551 VDD pfet_03v3 L=1.03U W=1.08U AS=0.5292P AD=0.4752P
+ PS=3.14U PD=3.04U
* device instance $1486 r0 *1 19.065,112.795 pfet_03v3
M$1486 VDD \$1501 \$1500 VDD pfet_03v3 L=7.75U W=1.09U AS=0.5341P AD=0.4796P
+ PS=3.16U PD=3.06U
* device instance $1487 r0 *1 17.52,114.71 pfet_03v3
M$1487 C|Y$21 A|Y$254 VDD VDD pfet_03v3 L=0.28U W=2.76U AS=0.966P AD=0.966P
+ PS=5.54U PD=5.54U
* device instance $1489 r0 *1 20.185,114.56 pfet_03v3
M$1489 VDD \$1581 \$1553 VDD pfet_03v3 L=1.03U W=1.08U AS=0.5292P AD=0.4752P
+ PS=3.14U PD=3.04U
* device instance $1490 r0 *1 23.12,114.71 pfet_03v3
M$1490 Y$22 A|Y$255 VDD VDD pfet_03v3 L=0.28U W=2.76U AS=0.966P AD=0.7176P
+ PS=5.54U PD=3.8U
* device instance $1492 r0 *1 24.72,114.71 pfet_03v3
M$1492 Y$22 A|B|Y$3 VDD VDD pfet_03v3 L=0.28U W=2.76U AS=0.7176P AD=1.1592P
+ PS=3.8U PD=4.44U
* device instance $1494 r0 *1 26.96,114.71 pfet_03v3
M$1494 Y$22 C|Y$20 VDD VDD pfet_03v3 L=0.28U W=2.76U AS=1.1592P AD=0.9798P
+ PS=4.44U PD=5.56U
* device instance $1496 r0 *1 24.8,112.65 pfet_03v3
M$1496 C|Y$20 A|Y$255 VDD VDD pfet_03v3 L=0.28U W=2.76U AS=0.966P AD=0.966P
+ PS=5.54U PD=5.54U
* device instance $1498 r0 *1 31.945,112.795 pfet_03v3
M$1498 VDD \$1504 \$1503 VDD pfet_03v3 L=7.75U W=1.09U AS=0.5341P AD=0.4796P
+ PS=3.16U PD=3.06U
* device instance $1499 r0 *1 29.28,114.71 pfet_03v3
M$1499 C|Y$22 A|Y$250 VDD VDD pfet_03v3 L=0.28U W=2.76U AS=0.966P AD=0.966P
+ PS=5.54U PD=5.54U
* device instance $1501 r0 *1 35.305,114.565 pfet_03v3
M$1501 VDD \$1583 \$1556 VDD pfet_03v3 L=7.75U W=1.09U AS=0.5341P AD=0.4796P
+ PS=3.16U PD=3.06U
* device instance $1502 r0 *1 40.905,112.795 pfet_03v3
M$1502 VDD \$1506 \$1505 VDD pfet_03v3 L=7.75U W=1.09U AS=0.5341P AD=0.4796P
+ PS=3.16U PD=3.06U
* device instance $1503 r0 *1 42.025,114.565 pfet_03v3
M$1503 VDD \$1584 \$1557 VDD pfet_03v3 L=3.27U W=1.09U AS=0.5341P AD=0.4796P
+ PS=3.16U PD=3.06U
* device instance $1504 r0 *1 49.865,112.795 pfet_03v3
M$1504 VDD \$1508 \$1507 VDD pfet_03v3 L=7.75U W=1.09U AS=0.5341P AD=0.4796P
+ PS=3.16U PD=3.06U
* device instance $1505 r0 *1 51.545,114.565 pfet_03v3
M$1505 VDD \$1585 \$1558 VDD pfet_03v3 L=7.75U W=1.09U AS=0.5341P AD=0.4796P
+ PS=3.16U PD=3.06U
* device instance $1506 r0 *1 58.825,112.795 pfet_03v3
M$1506 VDD \$1510 \$1509 VDD pfet_03v3 L=7.75U W=1.09U AS=0.5341P AD=0.4796P
+ PS=3.16U PD=3.06U
* device instance $1507 r0 *1 60.505,114.565 pfet_03v3
M$1507 VDD \$1586 \$1559 VDD pfet_03v3 L=7.75U W=1.09U AS=0.5341P AD=0.4796P
+ PS=3.16U PD=3.06U
* device instance $1508 r0 *1 64.425,112.8 pfet_03v3
M$1508 VDD \$1512 \$1511 VDD pfet_03v3 L=1.03U W=1.08U AS=0.5292P AD=0.4752P
+ PS=3.14U PD=3.04U
* device instance $1509 r0 *1 69.465,114.565 pfet_03v3
M$1509 VDD \$1587 \$1560 VDD pfet_03v3 L=7.75U W=1.09U AS=0.5341P AD=0.4796P
+ PS=3.16U PD=3.06U
* device instance $1510 r0 *1 71.145,112.795 pfet_03v3
M$1510 VDD \$1514 \$1513 VDD pfet_03v3 L=7.75U W=1.09U AS=0.5341P AD=0.4796P
+ PS=3.16U PD=3.06U
* device instance $1511 r0 *1 78.425,114.565 pfet_03v3
M$1511 VDD \$1588 \$1561 VDD pfet_03v3 L=7.75U W=1.09U AS=0.5341P AD=0.4796P
+ PS=3.16U PD=3.06U
* device instance $1512 r0 *1 80.105,112.795 pfet_03v3
M$1512 VDD \$1516 \$1515 VDD pfet_03v3 L=7.75U W=1.09U AS=0.5341P AD=0.4796P
+ PS=3.16U PD=3.06U
* device instance $1513 r0 *1 84.025,114.56 pfet_03v3
M$1513 VDD \$1589 \$1562 VDD pfet_03v3 L=1.03U W=1.08U AS=0.5292P AD=0.4752P
+ PS=3.14U PD=3.04U
* device instance $1514 r0 *1 86.16,112.65 pfet_03v3
M$1514 A|Y$244 \$1517 VDD VDD pfet_03v3 L=0.28U W=2.76U AS=1.4076P AD=0.7176P
+ PS=6.18U PD=3.8U
* device instance $1516 r0 *1 87.76,112.65 pfet_03v3
M$1516 \$1517 A|Y$225 VDD VDD pfet_03v3 L=0.28U W=1.38U AS=0.3588P AD=0.6072P
+ PS=1.9U PD=3.64U
* device instance $1517 r0 *1 90.745,114.565 pfet_03v3
M$1517 VDD \$1590 \$1563 VDD pfet_03v3 L=7.75U W=1.09U AS=0.5341P AD=0.4796P
+ PS=3.16U PD=3.06U
* device instance $1518 r0 *1 89.2,112.65 pfet_03v3
M$1518 VDD A|Y$244 \$1518 VDD pfet_03v3 L=0.28U W=1.38U AS=0.6072P AD=0.3588P
+ PS=3.64U PD=1.9U
* device instance $1519 r0 *1 90,112.65 pfet_03v3
M$1519 A|Y$235 \$1518 VDD VDD pfet_03v3 L=0.28U W=2.76U AS=0.7176P AD=1.4076P
+ PS=3.8U PD=6.18U
* device instance $1521 r0 *1 92.56,112.65 pfet_03v3
M$1521 VDD A|Y$226 \$1520 VDD pfet_03v3 L=0.28U W=1.38U AS=0.6072P AD=0.3588P
+ PS=3.64U PD=1.9U
* device instance $1522 r0 *1 93.36,112.65 pfet_03v3
M$1522 A|Y$245 \$1520 VDD VDD pfet_03v3 L=0.28U W=2.76U AS=0.7176P AD=1.4076P
+ PS=3.8U PD=6.18U
* device instance $1524 r0 *1 95.92,112.65 pfet_03v3
M$1524 VDD A|Y$245 \$1522 VDD pfet_03v3 L=0.28U W=1.38U AS=0.6072P AD=0.3588P
+ PS=3.64U PD=1.9U
* device instance $1525 r0 *1 96.72,112.65 pfet_03v3
M$1525 A|Y$236 \$1522 VDD VDD pfet_03v3 L=0.28U W=2.76U AS=0.7176P AD=1.4076P
+ PS=3.8U PD=6.18U
* device instance $1527 r0 *1 96.345,114.56 pfet_03v3
M$1527 VDD \$1591 \$1564 VDD pfet_03v3 L=1.03U W=1.08U AS=0.5292P AD=0.4752P
+ PS=3.14U PD=3.04U
* device instance $1528 r0 *1 99.04,114.71 pfet_03v3
M$1528 A|Y$237 \$1592 VDD VDD pfet_03v3 L=0.28U W=2.76U AS=1.4076P AD=0.7176P
+ PS=6.18U PD=3.8U
* device instance $1530 r0 *1 100.64,114.71 pfet_03v3
M$1530 \$1592 A|Y$246 VDD VDD pfet_03v3 L=0.28U W=1.38U AS=0.3588P AD=0.6072P
+ PS=1.9U PD=3.64U
* device instance $1531 r0 *1 99.28,112.65 pfet_03v3
M$1531 VDD A|Y$227 \$1523 VDD pfet_03v3 L=0.28U W=1.38U AS=0.6072P AD=0.3588P
+ PS=3.64U PD=1.9U
* device instance $1532 r0 *1 100.08,112.65 pfet_03v3
M$1532 A|Y$246 \$1523 VDD VDD pfet_03v3 L=0.28U W=2.76U AS=0.7176P AD=1.4076P
+ PS=3.8U PD=6.18U
* device instance $1534 r0 *1 102.08,114.71 pfet_03v3
M$1534 VDD A|Y$228 \$1565 VDD pfet_03v3 L=0.28U W=1.38U AS=0.6072P AD=0.3588P
+ PS=3.64U PD=1.9U
* device instance $1535 r0 *1 102.88,114.71 pfet_03v3
M$1535 A|Y$238 \$1565 VDD VDD pfet_03v3 L=0.28U W=2.76U AS=0.7176P AD=1.4076P
+ PS=3.8U PD=6.18U
* device instance $1537 r0 *1 103.065,112.8 pfet_03v3
M$1537 VDD \$1526 \$1525 VDD pfet_03v3 L=1.03U W=1.08U AS=0.5292P AD=0.4752P
+ PS=3.14U PD=3.04U
* device instance $1538 r0 *1 109.225,114.565 pfet_03v3
M$1538 VDD \$1593 \$1566 VDD pfet_03v3 L=7.75U W=1.09U AS=0.5341P AD=0.4796P
+ PS=3.16U PD=3.06U
* device instance $1539 r0 *1 106.56,112.65 pfet_03v3
M$1539 VDD A|Y$229 \$1527 VDD pfet_03v3 L=0.28U W=1.38U AS=0.6072P AD=0.3588P
+ PS=3.64U PD=1.9U
* device instance $1540 r0 *1 107.36,112.65 pfet_03v3
M$1540 A|Y$239 \$1527 VDD VDD pfet_03v3 L=0.28U W=2.76U AS=0.7176P AD=1.4076P
+ PS=3.8U PD=6.18U
* device instance $1542 r0 *1 109.92,112.65 pfet_03v3
M$1542 VDD A|Y$230 \$1528 VDD pfet_03v3 L=0.28U W=1.38U AS=0.6072P AD=0.3588P
+ PS=3.64U PD=1.9U
* device instance $1543 r0 *1 110.72,112.65 pfet_03v3
M$1543 A|Y$247 \$1528 VDD VDD pfet_03v3 L=0.28U W=2.76U AS=0.7176P AD=1.4076P
+ PS=3.8U PD=6.18U
* device instance $1545 r0 *1 113.28,112.65 pfet_03v3
M$1545 VDD A|Y$247 \$1530 VDD pfet_03v3 L=0.28U W=1.38U AS=0.6072P AD=0.3588P
+ PS=3.64U PD=1.9U
* device instance $1546 r0 *1 114.08,112.65 pfet_03v3
M$1546 A|Y$240 \$1530 VDD VDD pfet_03v3 L=0.28U W=2.76U AS=0.7176P AD=1.4076P
+ PS=3.8U PD=6.18U
* device instance $1548 r0 *1 114.825,114.56 pfet_03v3
M$1548 VDD \$1594 \$1567 VDD pfet_03v3 L=1.03U W=1.08U AS=0.5292P AD=0.4752P
+ PS=3.14U PD=3.04U
* device instance $1549 r0 *1 116.64,112.65 pfet_03v3
M$1549 VDD A|Y$231 \$1531 VDD pfet_03v3 L=0.28U W=1.38U AS=0.6072P AD=0.3588P
+ PS=3.64U PD=1.9U
* device instance $1550 r0 *1 117.44,112.65 pfet_03v3
M$1550 A|Y$241 \$1531 VDD VDD pfet_03v3 L=0.28U W=2.76U AS=0.7176P AD=1.4076P
+ PS=3.8U PD=6.18U
* device instance $1552 r0 *1 116.64,114.71 pfet_03v3
M$1552 VDD A|Y$232 \$1568 VDD pfet_03v3 L=0.28U W=1.38U AS=0.6072P AD=0.3588P
+ PS=3.64U PD=1.9U
* device instance $1553 r0 *1 117.44,114.71 pfet_03v3
M$1553 A|Y$251 \$1568 VDD VDD pfet_03v3 L=0.28U W=2.76U AS=0.7176P AD=1.4076P
+ PS=3.8U PD=6.18U
* device instance $1555 r0 *1 120,114.71 pfet_03v3
M$1555 VDD A|Y$251 \$1570 VDD pfet_03v3 L=0.28U W=1.38U AS=0.6072P AD=0.3588P
+ PS=3.64U PD=1.9U
* device instance $1556 r0 *1 120.8,114.71 pfet_03v3
M$1556 A|Y$252 \$1570 VDD VDD pfet_03v3 L=0.28U W=2.76U AS=0.7176P AD=1.4076P
+ PS=3.8U PD=6.18U
* device instance $1558 r0 *1 123.785,112.795 pfet_03v3
M$1558 VDD \$1533 \$1532 VDD pfet_03v3 L=7.75U W=1.09U AS=0.5341P AD=0.4796P
+ PS=3.16U PD=3.06U
* device instance $1559 r0 *1 127.705,114.565 pfet_03v3
M$1559 VDD \$1595 \$1572 VDD pfet_03v3 L=3.27U W=1.09U AS=0.5341P AD=0.4796P
+ PS=3.16U PD=3.06U
* device instance $1560 r0 *1 129.385,112.8 pfet_03v3
M$1560 VDD \$1535 \$1534 VDD pfet_03v3 L=1.03U W=1.08U AS=0.5292P AD=0.4752P
+ PS=3.14U PD=3.04U
* device instance $1561 r0 *1 132.08,114.71 pfet_03v3
M$1561 A|Y$253 \$1596 VDD VDD pfet_03v3 L=0.28U W=2.76U AS=1.4076P AD=0.7176P
+ PS=6.18U PD=3.8U
* device instance $1563 r0 *1 133.68,114.71 pfet_03v3
M$1563 \$1596 A|Y$256 VDD VDD pfet_03v3 L=0.28U W=1.38U AS=0.3588P AD=0.6072P
+ PS=1.9U PD=3.64U
* device instance $1564 r0 *1 132.64,112.65 pfet_03v3
M$1564 A|Y$248 \$1536 VDD VDD pfet_03v3 L=0.28U W=2.76U AS=1.4076P AD=0.7176P
+ PS=6.18U PD=3.8U
* device instance $1566 r0 *1 134.24,112.65 pfet_03v3
M$1566 \$1536 A|Y$249 VDD VDD pfet_03v3 L=0.28U W=1.38U AS=0.3588P AD=0.6072P
+ PS=1.9U PD=3.64U
* device instance $1567 r0 *1 135.12,114.71 pfet_03v3
M$1567 VDD A|Y$253 \$1574 VDD pfet_03v3 L=0.28U W=1.38U AS=0.6072P AD=0.3588P
+ PS=3.64U PD=1.9U
* device instance $1568 r0 *1 135.92,114.71 pfet_03v3
M$1568 A|Y$249 \$1574 VDD VDD pfet_03v3 L=0.28U W=2.76U AS=0.7176P AD=1.4076P
+ PS=3.8U PD=6.18U
* device instance $1570 r0 *1 135.68,112.65 pfet_03v3
M$1570 VDD A|Y$248 \$1539 VDD pfet_03v3 L=0.28U W=1.38U AS=0.6072P AD=0.3588P
+ PS=3.64U PD=1.9U
* device instance $1571 r0 *1 136.48,112.65 pfet_03v3
M$1571 A|Y$243 \$1539 VDD VDD pfet_03v3 L=0.28U W=2.76U AS=0.7176P AD=1.4076P
+ PS=3.8U PD=6.18U
* device instance $1573 r0 *1 142.265,114.565 pfet_03v3
M$1573 VDD \$1598 \$1575 VDD pfet_03v3 L=7.75U W=1.09U AS=0.5341P AD=0.4796P
+ PS=3.16U PD=3.06U
* device instance $1574 r0 *1 140.585,112.795 pfet_03v3
M$1574 VDD \$1541 \$1540 VDD pfet_03v3 L=3.27U W=1.09U AS=0.5341P AD=0.4796P
+ PS=3.16U PD=3.06U
* device instance $1575 r0 *1 149.545,112.795 pfet_03v3
M$1575 VDD \$1543 \$1542 VDD pfet_03v3 L=7.75U W=1.09U AS=0.5341P AD=0.4796P
+ PS=3.16U PD=3.06U
* device instance $1576 r0 *1 151.225,114.565 pfet_03v3
M$1576 VDD \$1599 \$1576 VDD pfet_03v3 L=7.75U W=1.09U AS=0.5341P AD=0.4796P
+ PS=3.16U PD=3.06U
* device instance $1577 r0 *1 156.265,112.795 pfet_03v3
M$1577 VDD \$1545 \$1544 VDD pfet_03v3 L=3.27U W=1.09U AS=0.5341P AD=0.4796P
+ PS=3.16U PD=3.06U
* device instance $1578 r0 *1 157.945,114.565 pfet_03v3
M$1578 VDD \$1600 \$1577 VDD pfet_03v3 L=3.27U W=1.09U AS=0.5341P AD=0.4796P
+ PS=3.16U PD=3.06U
* device instance $1579 r0 *1 159.625,112.8 pfet_03v3
M$1579 VDD \$1547 \$1546 VDD pfet_03v3 L=1.03U W=1.08U AS=0.5292P AD=0.4752P
+ PS=3.14U PD=3.04U
* device instance $1580 r0 *1 8.56,120.49 pfet_03v3
M$1580 VDD A|FINE_MUX[7] \$1605 VDD pfet_03v3 L=0.28U W=1.38U AS=0.6072P
+ AD=0.3588P PS=3.64U PD=1.9U
* device instance $1581 r0 *1 9.36,120.49 pfet_03v3
M$1581 A|Y$255 \$1605 VDD VDD pfet_03v3 L=0.28U W=2.76U AS=0.7176P AD=1.4076P
+ PS=3.8U PD=6.18U
* device instance $1583 r0 *1 9.12,122.55 pfet_03v3
M$1583 C|Y$23 A|Y$266 VDD VDD pfet_03v3 L=0.28U W=2.76U AS=0.966P AD=0.966P
+ PS=5.54U PD=5.54U
* device instance $1585 r0 *1 11.44,122.55 pfet_03v3
M$1585 Y$25 C|Y$23 VDD VDD pfet_03v3 L=0.28U W=2.76U AS=0.9798P AD=1.1592P
+ PS=5.56U PD=4.44U
* device instance $1587 r0 *1 13.68,122.55 pfet_03v3
M$1587 Y$25 A|B|Y$3 VDD VDD pfet_03v3 L=0.28U W=2.76U AS=1.1592P AD=0.7176P
+ PS=4.44U PD=3.8U
* device instance $1589 r0 *1 15.28,122.55 pfet_03v3
M$1589 Y$25 A|Y$266 VDD VDD pfet_03v3 L=0.28U W=2.76U AS=0.7176P AD=0.966P
+ PS=3.8U PD=5.54U
* device instance $1591 r0 *1 11.92,120.49 pfet_03v3
M$1591 VDD A|FINE_MUX[4] \$1606 VDD pfet_03v3 L=0.28U W=1.38U AS=0.6072P
+ AD=0.3588P PS=3.64U PD=1.9U
* device instance $1592 r0 *1 12.72,120.49 pfet_03v3
M$1592 A|Y$254 \$1606 VDD VDD pfet_03v3 L=0.28U W=2.76U AS=0.7176P AD=1.4076P
+ PS=3.8U PD=6.18U
* device instance $1594 r0 *1 15.84,120.49 pfet_03v3
M$1594 Y$23 A|Y$254 VDD VDD pfet_03v3 L=0.28U W=2.76U AS=0.966P AD=0.7176P
+ PS=5.54U PD=3.8U
* device instance $1596 r0 *1 17.44,120.49 pfet_03v3
M$1596 Y$23 A|B|Y$3 VDD VDD pfet_03v3 L=0.28U W=2.76U AS=0.7176P AD=1.1592P
+ PS=3.8U PD=4.44U
* device instance $1598 r0 *1 19.68,120.49 pfet_03v3
M$1598 Y$23 C|Y$21 VDD VDD pfet_03v3 L=0.28U W=2.76U AS=1.1592P AD=0.9798P
+ PS=4.44U PD=5.56U
* device instance $1600 r0 *1 21.305,122.405 pfet_03v3
M$1600 VDD \$1688 \$1658 VDD pfet_03v3 L=7.75U W=1.09U AS=0.5341P AD=0.4796P
+ PS=3.16U PD=3.06U
* device instance $1601 r0 *1 23.545,120.635 pfet_03v3
M$1601 VDD \$1610 \$1609 VDD pfet_03v3 L=3.27U W=1.09U AS=0.5341P AD=0.4796P
+ PS=3.16U PD=3.06U
* device instance $1602 r0 *1 30.265,122.405 pfet_03v3
M$1602 VDD \$1689 \$1659 VDD pfet_03v3 L=7.75U W=1.09U AS=0.5341P AD=0.4796P
+ PS=3.16U PD=3.06U
* device instance $1603 r0 *1 28.16,120.49 pfet_03v3
M$1603 Y$24 A|Y$250 VDD VDD pfet_03v3 L=0.28U W=2.76U AS=0.966P AD=0.7176P
+ PS=5.54U PD=3.8U
* device instance $1605 r0 *1 29.76,120.49 pfet_03v3
M$1605 Y$24 A|B|Y$3 VDD VDD pfet_03v3 L=0.28U W=2.76U AS=0.7176P AD=1.1592P
+ PS=3.8U PD=4.44U
* device instance $1607 r0 *1 32,120.49 pfet_03v3
M$1607 Y$24 C|Y$22 VDD VDD pfet_03v3 L=0.28U W=2.76U AS=1.1592P AD=0.9798P
+ PS=4.44U PD=5.56U
* device instance $1609 r0 *1 38.105,120.635 pfet_03v3
M$1609 VDD \$1614 \$1613 VDD pfet_03v3 L=7.75U W=1.09U AS=0.5341P AD=0.4796P
+ PS=3.16U PD=3.06U
* device instance $1610 r0 *1 39.225,122.405 pfet_03v3
M$1610 VDD \$1690 \$1660 VDD pfet_03v3 L=7.75U W=1.09U AS=0.5341P AD=0.4796P
+ PS=3.16U PD=3.06U
* device instance $1611 r0 *1 47.065,120.635 pfet_03v3
M$1611 VDD \$1616 \$1615 VDD pfet_03v3 L=7.75U W=1.09U AS=0.5341P AD=0.4796P
+ PS=3.16U PD=3.06U
* device instance $1612 r0 *1 44.825,122.4 pfet_03v3
M$1612 VDD \$1691 \$1661 VDD pfet_03v3 L=1.03U W=1.08U AS=0.5292P AD=0.4752P
+ PS=3.14U PD=3.04U
* device instance $1613 r0 *1 51.545,122.405 pfet_03v3
M$1613 VDD \$1692 \$1662 VDD pfet_03v3 L=7.75U W=1.09U AS=0.5341P AD=0.4796P
+ PS=3.16U PD=3.06U
* device instance $1614 r0 *1 56.025,120.635 pfet_03v3
M$1614 VDD \$1618 \$1617 VDD pfet_03v3 L=7.75U W=1.09U AS=0.5341P AD=0.4796P
+ PS=3.16U PD=3.06U
* device instance $1615 r0 *1 60.505,122.405 pfet_03v3
M$1615 VDD \$1693 \$1663 VDD pfet_03v3 L=7.75U W=1.09U AS=0.5341P AD=0.4796P
+ PS=3.16U PD=3.06U
* device instance $1616 r0 *1 62.745,120.635 pfet_03v3
M$1616 VDD \$1620 \$1619 VDD pfet_03v3 L=3.27U W=1.09U AS=0.5341P AD=0.4796P
+ PS=3.16U PD=3.06U
* device instance $1617 r0 *1 69.465,122.405 pfet_03v3
M$1617 VDD \$1694 \$1664 VDD pfet_03v3 L=7.75U W=1.09U AS=0.5341P AD=0.4796P
+ PS=3.16U PD=3.06U
* device instance $1618 r0 *1 71.145,120.635 pfet_03v3
M$1618 VDD \$1622 \$1621 VDD pfet_03v3 L=7.75U W=1.09U AS=0.5341P AD=0.4796P
+ PS=3.16U PD=3.06U
* device instance $1619 r0 *1 78.425,122.405 pfet_03v3
M$1619 VDD \$1695 \$1665 VDD pfet_03v3 L=7.75U W=1.09U AS=0.5341P AD=0.4796P
+ PS=3.16U PD=3.06U
* device instance $1620 r0 *1 80.105,120.635 pfet_03v3
M$1620 VDD \$1624 \$1623 VDD pfet_03v3 L=7.75U W=1.09U AS=0.5341P AD=0.4796P
+ PS=3.16U PD=3.06U
* device instance $1621 r0 *1 84.025,122.4 pfet_03v3
M$1621 VDD \$1696 \$1666 VDD pfet_03v3 L=1.03U W=1.08U AS=0.5292P AD=0.4752P
+ PS=3.14U PD=3.04U
* device instance $1622 r0 *1 89.065,120.635 pfet_03v3
M$1622 VDD \$1626 \$1625 VDD pfet_03v3 L=7.75U W=1.09U AS=0.5341P AD=0.4796P
+ PS=3.16U PD=3.06U
* device instance $1623 r0 *1 90.745,122.405 pfet_03v3
M$1623 VDD \$1697 \$1667 VDD pfet_03v3 L=7.75U W=1.09U AS=0.5341P AD=0.4796P
+ PS=3.16U PD=3.06U
* device instance $1624 r0 *1 98.025,120.635 pfet_03v3
M$1624 VDD \$1628 \$1627 VDD pfet_03v3 L=7.75U W=1.09U AS=0.5341P AD=0.4796P
+ PS=3.16U PD=3.06U
* device instance $1625 r0 *1 97.465,122.405 pfet_03v3
M$1625 VDD \$1698 \$1668 VDD pfet_03v3 L=3.27U W=1.09U AS=0.5341P AD=0.4796P
+ PS=3.16U PD=3.06U
* device instance $1626 r0 *1 100.825,122.4 pfet_03v3
M$1626 VDD \$1699 \$1669 VDD pfet_03v3 L=1.03U W=1.08U AS=0.5292P AD=0.4752P
+ PS=3.14U PD=3.04U
* device instance $1627 r0 *1 102.96,122.55 pfet_03v3
M$1627 A|Y$261 \$1700 VDD VDD pfet_03v3 L=0.28U W=2.76U AS=1.4076P AD=0.7176P
+ PS=6.18U PD=3.8U
* device instance $1629 r0 *1 104.56,122.55 pfet_03v3
M$1629 \$1700 A|Y$267 VDD VDD pfet_03v3 L=0.28U W=1.38U AS=0.3588P AD=0.6072P
+ PS=1.9U PD=3.64U
* device instance $1630 r0 *1 103.625,120.64 pfet_03v3
M$1630 VDD \$1630 \$1629 VDD pfet_03v3 L=1.03U W=1.08U AS=0.5292P AD=0.4752P
+ PS=3.14U PD=3.04U
* device instance $1631 r0 *1 107.545,122.405 pfet_03v3
M$1631 VDD \$1702 \$1671 VDD pfet_03v3 L=3.27U W=1.09U AS=0.5341P AD=0.4796P
+ PS=3.16U PD=3.06U
* device instance $1632 r0 *1 110.345,120.635 pfet_03v3
M$1632 VDD \$1632 \$1631 VDD pfet_03v3 L=7.75U W=1.09U AS=0.5341P AD=0.4796P
+ PS=3.16U PD=3.06U
* device instance $1633 r0 *1 110.905,122.4 pfet_03v3
M$1633 VDD \$1703 \$1672 VDD pfet_03v3 L=1.03U W=1.08U AS=0.5292P AD=0.4752P
+ PS=3.14U PD=3.04U
* device instance $1634 r0 *1 113.04,122.55 pfet_03v3
M$1634 A|Y$262 \$1704 VDD VDD pfet_03v3 L=0.28U W=2.76U AS=1.4076P AD=0.7176P
+ PS=6.18U PD=3.8U
* device instance $1636 r0 *1 114.64,122.55 pfet_03v3
M$1636 \$1704 A|Y$268 VDD VDD pfet_03v3 L=0.28U W=1.38U AS=0.3588P AD=0.6072P
+ PS=1.9U PD=3.64U
* device instance $1637 r0 *1 115.945,120.64 pfet_03v3
M$1637 VDD \$1634 \$1633 VDD pfet_03v3 L=1.03U W=1.08U AS=0.5292P AD=0.4752P
+ PS=3.14U PD=3.04U
* device instance $1638 r0 *1 116.505,122.4 pfet_03v3
M$1638 VDD \$1706 \$1674 VDD pfet_03v3 L=1.03U W=1.08U AS=0.5292P AD=0.4752P
+ PS=3.14U PD=3.04U
* device instance $1639 r0 *1 118.32,122.55 pfet_03v3
M$1639 VDD A|Y$257 \$1675 VDD pfet_03v3 L=0.28U W=1.38U AS=0.6072P AD=0.3588P
+ PS=3.64U PD=1.9U
* device instance $1640 r0 *1 119.12,122.55 pfet_03v3
M$1640 A|Y$263 \$1675 VDD VDD pfet_03v3 L=0.28U W=2.76U AS=0.7176P AD=1.4076P
+ PS=3.8U PD=6.18U
* device instance $1642 r0 *1 118.64,120.49 pfet_03v3
M$1642 A|Y$257 \$1635 VDD VDD pfet_03v3 L=0.28U W=2.76U AS=1.4076P AD=0.7176P
+ PS=6.18U PD=3.8U
* device instance $1644 r0 *1 120.24,120.49 pfet_03v3
M$1644 \$1635 A|Y$252 VDD VDD pfet_03v3 L=0.28U W=1.38U AS=0.3588P AD=0.6072P
+ PS=1.9U PD=3.64U
* device instance $1645 r0 *1 121.68,122.55 pfet_03v3
M$1645 VDD A|Y$263 \$1677 VDD pfet_03v3 L=0.28U W=1.38U AS=0.6072P AD=0.3588P
+ PS=3.64U PD=1.9U
* device instance $1646 r0 *1 122.48,122.55 pfet_03v3
M$1646 A|Y$264 \$1677 VDD VDD pfet_03v3 L=0.28U W=2.76U AS=0.7176P AD=1.4076P
+ PS=3.8U PD=6.18U
* device instance $1648 r0 *1 125.465,120.635 pfet_03v3
M$1648 VDD \$1638 \$1637 VDD pfet_03v3 L=7.75U W=1.09U AS=0.5341P AD=0.4796P
+ PS=3.16U PD=3.06U
* device instance $1649 r0 *1 127.705,122.405 pfet_03v3
M$1649 VDD \$1707 \$1679 VDD pfet_03v3 L=3.27U W=1.09U AS=0.5341P AD=0.4796P
+ PS=3.16U PD=3.06U
* device instance $1650 r0 *1 131.52,120.49 pfet_03v3
M$1650 A|Y$258 \$1639 VDD VDD pfet_03v3 L=0.28U W=2.76U AS=1.4076P AD=0.7176P
+ PS=6.18U PD=3.8U
* device instance $1652 r0 *1 133.12,120.49 pfet_03v3
M$1652 \$1639 A|Y$259 VDD VDD pfet_03v3 L=0.28U W=1.38U AS=0.3588P AD=0.6072P
+ PS=1.9U PD=3.64U
* device instance $1653 r0 *1 131.52,122.55 pfet_03v3
M$1653 A|Y$265 \$1708 VDD VDD pfet_03v3 L=0.28U W=2.76U AS=1.4076P AD=0.7176P
+ PS=6.18U PD=3.8U
* device instance $1655 r0 *1 133.12,122.55 pfet_03v3
M$1655 \$1708 A|Y$269 VDD VDD pfet_03v3 L=0.28U W=1.38U AS=0.3588P AD=0.6072P
+ PS=1.9U PD=3.64U
* device instance $1656 r0 *1 134.56,122.55 pfet_03v3
M$1656 VDD A|Y$265 \$1681 VDD pfet_03v3 L=0.28U W=1.38U AS=0.6072P AD=0.3588P
+ PS=3.64U PD=1.9U
* device instance $1657 r0 *1 135.36,122.55 pfet_03v3
M$1657 A|Y$260 \$1681 VDD VDD pfet_03v3 L=0.28U W=2.76U AS=0.7176P AD=1.4076P
+ PS=3.8U PD=6.18U
* device instance $1659 r0 *1 134.56,120.49 pfet_03v3
M$1659 VDD A|Y$258 \$1642 VDD pfet_03v3 L=0.28U W=1.38U AS=0.6072P AD=0.3588P
+ PS=3.64U PD=1.9U
* device instance $1660 r0 *1 135.36,120.49 pfet_03v3
M$1660 A|Y$256 \$1642 VDD VDD pfet_03v3 L=0.28U W=2.76U AS=0.7176P AD=1.4076P
+ PS=3.8U PD=6.18U
* device instance $1662 r0 *1 137.92,120.49 pfet_03v3
M$1662 VDD A|Y$260 \$1643 VDD pfet_03v3 L=0.28U W=1.38U AS=0.6072P AD=0.3588P
+ PS=3.64U PD=1.9U
* device instance $1663 r0 *1 138.72,120.49 pfet_03v3
M$1663 A|Y$259 \$1643 VDD VDD pfet_03v3 L=0.28U W=2.76U AS=0.7176P AD=1.4076P
+ PS=3.8U PD=6.18U
* device instance $1665 r0 *1 137.92,122.55 pfet_03v3
M$1665 VDD A|Y$270 \$1682 VDD pfet_03v3 L=0.28U W=1.38U AS=0.6072P AD=0.3588P
+ PS=3.64U PD=1.9U
* device instance $1666 r0 *1 138.72,122.55 pfet_03v3
M$1666 A|Y$269 \$1682 VDD VDD pfet_03v3 L=0.28U W=2.76U AS=0.7176P AD=1.4076P
+ PS=3.8U PD=6.18U
* device instance $1668 r0 *1 141.705,120.64 pfet_03v3
M$1668 VDD \$1646 \$1645 VDD pfet_03v3 L=1.03U W=1.08U AS=0.5292P AD=0.4752P
+ PS=3.14U PD=3.04U
* device instance $1669 r0 *1 145.065,122.405 pfet_03v3
M$1669 VDD \$1711 \$1683 VDD pfet_03v3 L=7.75U W=1.09U AS=0.5341P AD=0.4796P
+ PS=3.16U PD=3.06U
* device instance $1670 r0 *1 149.545,120.635 pfet_03v3
M$1670 VDD \$1648 \$1647 VDD pfet_03v3 L=7.75U W=1.09U AS=0.5341P AD=0.4796P
+ PS=3.16U PD=3.06U
* device instance $1671 r0 *1 154.025,122.405 pfet_03v3
M$1671 VDD \$1712 \$1684 VDD pfet_03v3 L=7.75U W=1.09U AS=0.5341P AD=0.4796P
+ PS=3.16U PD=3.06U
* device instance $1672 r0 *1 156.265,120.635 pfet_03v3
M$1672 VDD \$1650 \$1649 VDD pfet_03v3 L=3.27U W=1.09U AS=0.5341P AD=0.4796P
+ PS=3.16U PD=3.06U
* device instance $1673 r0 *1 159.625,122.4 pfet_03v3
M$1673 VDD \$1713 \$1685 VDD pfet_03v3 L=1.03U W=1.08U AS=0.5292P AD=0.4752P
+ PS=3.14U PD=3.04U
* device instance $1674 r0 *1 159.625,120.64 pfet_03v3
M$1674 VDD \$1652 \$1651 VDD pfet_03v3 L=1.03U W=1.08U AS=0.5292P AD=0.4752P
+ PS=3.14U PD=3.04U
* device instance $1675 r0 *1 9.12,128.33 pfet_03v3
M$1675 C|Y$24 A|Y$271 VDD VDD pfet_03v3 L=0.28U W=2.76U AS=0.966P AD=0.966P
+ PS=5.54U PD=5.54U
* device instance $1677 r0 *1 11.36,128.33 pfet_03v3
M$1677 Y$26 A|Y$271 VDD VDD pfet_03v3 L=0.28U W=2.76U AS=0.966P AD=0.7176P
+ PS=5.54U PD=3.8U
* device instance $1679 r0 *1 12.96,128.33 pfet_03v3
M$1679 Y$26 A|B|Y$3 VDD VDD pfet_03v3 L=0.28U W=2.76U AS=0.7176P AD=1.1592P
+ PS=3.8U PD=4.44U
* device instance $1681 r0 *1 15.2,128.33 pfet_03v3
M$1681 Y$26 C|Y$24 VDD VDD pfet_03v3 L=0.28U W=2.76U AS=1.1592P AD=0.9798P
+ PS=4.44U PD=5.56U
* device instance $1683 r0 *1 17.52,128.33 pfet_03v3
M$1683 VDD A|FINE_MUX[1] \$1723 VDD pfet_03v3 L=0.28U W=1.38U AS=0.6072P
+ AD=0.3588P PS=3.64U PD=1.9U
* device instance $1684 r0 *1 18.32,128.33 pfet_03v3
M$1684 A|Y$266 \$1723 VDD VDD pfet_03v3 L=0.28U W=2.76U AS=0.7176P AD=1.4076P
+ PS=3.8U PD=6.18U
* device instance $1686 r0 *1 20.88,128.33 pfet_03v3
M$1686 Y$27 A|Y$272 VDD VDD pfet_03v3 L=0.28U W=2.76U AS=0.966P AD=0.7176P
+ PS=5.54U PD=3.8U
* device instance $1688 r0 *1 22.48,128.33 pfet_03v3
M$1688 Y$27 A|B|Y$3 VDD VDD pfet_03v3 L=0.28U W=2.76U AS=0.7176P AD=1.1592P
+ PS=3.8U PD=4.44U
* device instance $1690 r0 *1 24.72,128.33 pfet_03v3
M$1690 Y$27 C|Y$25 VDD VDD pfet_03v3 L=0.28U W=2.76U AS=1.1592P AD=0.9798P
+ PS=4.44U PD=5.56U
* device instance $1692 r0 *1 28.16,128.33 pfet_03v3
M$1692 C|Y$25 A|Y$272 VDD VDD pfet_03v3 L=0.28U W=2.76U AS=0.966P AD=0.966P
+ PS=5.54U PD=5.54U
* device instance $1694 r0 *1 34.185,128.475 pfet_03v3
M$1694 VDD \$1729 \$1728 VDD pfet_03v3 L=7.75U W=1.09U AS=0.5341P AD=0.4796P
+ PS=3.16U PD=3.06U
* device instance $1695 r0 *1 43.145,128.475 pfet_03v3
M$1695 VDD \$1731 \$1730 VDD pfet_03v3 L=7.75U W=1.09U AS=0.5341P AD=0.4796P
+ PS=3.16U PD=3.06U
* device instance $1696 r0 *1 52.105,128.475 pfet_03v3
M$1696 VDD \$1733 \$1732 VDD pfet_03v3 L=7.75U W=1.09U AS=0.5341P AD=0.4796P
+ PS=3.16U PD=3.06U
* device instance $1697 r0 *1 61.065,128.475 pfet_03v3
M$1697 VDD \$1735 \$1734 VDD pfet_03v3 L=7.75U W=1.09U AS=0.5341P AD=0.4796P
+ PS=3.16U PD=3.06U
* device instance $1698 r0 *1 71.145,128.475 pfet_03v3
M$1698 VDD \$1737 \$1736 VDD pfet_03v3 L=7.75U W=1.09U AS=0.5341P AD=0.4796P
+ PS=3.16U PD=3.06U
* device instance $1699 r0 *1 80.105,128.475 pfet_03v3
M$1699 VDD \$1739 \$1738 VDD pfet_03v3 L=7.75U W=1.09U AS=0.5341P AD=0.4796P
+ PS=3.16U PD=3.06U
* device instance $1700 r0 *1 89.065,128.475 pfet_03v3
M$1700 VDD \$1741 \$1740 VDD pfet_03v3 L=7.75U W=1.09U AS=0.5341P AD=0.4796P
+ PS=3.16U PD=3.06U
* device instance $1701 r0 *1 95.68,128.33 pfet_03v3
M$1701 A|Y$273 \$1742 VDD VDD pfet_03v3 L=0.28U W=2.76U AS=1.4076P AD=0.7176P
+ PS=6.18U PD=3.8U
* device instance $1703 r0 *1 97.28,128.33 pfet_03v3
M$1703 \$1742 A|Y$274 VDD VDD pfet_03v3 L=0.28U W=1.38U AS=0.3588P AD=0.6072P
+ PS=1.9U PD=3.64U
* device instance $1704 r0 *1 99.04,128.33 pfet_03v3
M$1704 A|Y$275 \$1745 VDD VDD pfet_03v3 L=0.28U W=2.76U AS=1.4076P AD=0.7176P
+ PS=6.18U PD=3.8U
* device instance $1706 r0 *1 100.64,128.33 pfet_03v3
M$1706 \$1745 A|Y$276 VDD VDD pfet_03v3 L=0.28U W=1.38U AS=0.3588P AD=0.6072P
+ PS=1.9U PD=3.64U
* device instance $1707 r0 *1 102.4,128.33 pfet_03v3
M$1707 A|Y$276 \$1748 VDD VDD pfet_03v3 L=0.28U W=2.76U AS=1.4076P AD=0.7176P
+ PS=6.18U PD=3.8U
* device instance $1709 r0 *1 104,128.33 pfet_03v3
M$1709 \$1748 A|Y$261 VDD VDD pfet_03v3 L=0.28U W=1.38U AS=0.3588P AD=0.6072P
+ PS=1.9U PD=3.64U
* device instance $1710 r0 *1 106.88,128.33 pfet_03v3
M$1710 A|Y$267 \$1749 VDD VDD pfet_03v3 L=0.28U W=2.76U AS=1.4076P AD=0.7176P
+ PS=6.18U PD=3.8U
* device instance $1712 r0 *1 108.48,128.33 pfet_03v3
M$1712 \$1749 A|Y$277 VDD VDD pfet_03v3 L=0.28U W=1.38U AS=0.3588P AD=0.6072P
+ PS=1.9U PD=3.64U
* device instance $1713 r0 *1 110.24,128.33 pfet_03v3
M$1713 A|Y$277 \$1751 VDD VDD pfet_03v3 L=0.28U W=2.76U AS=1.4076P AD=0.7176P
+ PS=6.18U PD=3.8U
* device instance $1715 r0 *1 111.84,128.33 pfet_03v3
M$1715 \$1751 A|Y$278 VDD VDD pfet_03v3 L=0.28U W=1.38U AS=0.3588P AD=0.6072P
+ PS=1.9U PD=3.64U
* device instance $1716 r0 *1 113.28,128.33 pfet_03v3
M$1716 VDD A|Y$262 \$1753 VDD pfet_03v3 L=0.28U W=1.38U AS=0.6072P AD=0.3588P
+ PS=3.64U PD=1.9U
* device instance $1717 r0 *1 114.08,128.33 pfet_03v3
M$1717 A|Y$278 \$1753 VDD VDD pfet_03v3 L=0.28U W=2.76U AS=0.7176P AD=1.4076P
+ PS=3.8U PD=6.18U
* device instance $1719 r0 *1 116.96,128.33 pfet_03v3
M$1719 A|Y$268 \$1754 VDD VDD pfet_03v3 L=0.28U W=2.76U AS=1.4076P AD=0.7176P
+ PS=6.18U PD=3.8U
* device instance $1721 r0 *1 118.56,128.33 pfet_03v3
M$1721 \$1754 A|Y$279 VDD VDD pfet_03v3 L=0.28U W=1.38U AS=0.3588P AD=0.6072P
+ PS=1.9U PD=3.64U
* device instance $1722 r0 *1 120.32,128.33 pfet_03v3
M$1722 A|Y$280 \$1756 VDD VDD pfet_03v3 L=0.28U W=2.76U AS=1.4076P AD=0.7176P
+ PS=6.18U PD=3.8U
* device instance $1724 r0 *1 121.92,128.33 pfet_03v3
M$1724 \$1756 A|Y$264 VDD VDD pfet_03v3 L=0.28U W=1.38U AS=0.3588P AD=0.6072P
+ PS=1.9U PD=3.64U
* device instance $1725 r0 *1 127.145,128.475 pfet_03v3
M$1725 VDD \$1759 \$1758 VDD pfet_03v3 L=7.75U W=1.09U AS=0.5341P AD=0.4796P
+ PS=3.16U PD=3.06U
* device instance $1726 r0 *1 134.88,128.33 pfet_03v3
M$1726 A|Y$270 \$1762 VDD VDD pfet_03v3 L=0.28U W=2.76U AS=1.4076P AD=0.7176P
+ PS=6.18U PD=3.8U
* device instance $1728 r0 *1 136.48,128.33 pfet_03v3
M$1728 \$1762 A|Y$281 VDD VDD pfet_03v3 L=0.28U W=1.38U AS=0.3588P AD=0.6072P
+ PS=1.9U PD=3.64U
* device instance $1729 r0 *1 137.92,128.33 pfet_03v3
M$1729 VDD A|Y$282 \$1765 VDD pfet_03v3 L=0.28U W=1.38U AS=0.6072P AD=0.3588P
+ PS=3.64U PD=1.9U
* device instance $1730 r0 *1 138.72,128.33 pfet_03v3
M$1730 A|Y$281 \$1765 VDD VDD pfet_03v3 L=0.28U W=2.76U AS=0.7176P AD=1.4076P
+ PS=3.8U PD=6.18U
* device instance $1732 r0 *1 149.545,128.475 pfet_03v3
M$1732 VDD \$1769 \$1768 VDD pfet_03v3 L=7.75U W=1.09U AS=0.5341P AD=0.4796P
+ PS=3.16U PD=3.06U
* device instance $1733 r0 *1 156.265,128.475 pfet_03v3
M$1733 VDD \$1771 \$1770 VDD pfet_03v3 L=3.27U W=1.09U AS=0.5341P AD=0.4796P
+ PS=3.16U PD=3.06U
* device instance $1734 r0 *1 8.56,136.17 pfet_03v3
M$1734 VDD A|FINE_MUX[3] \$1830 VDD pfet_03v3 L=0.28U W=1.38U AS=0.6072P
+ AD=0.3588P PS=3.64U PD=1.9U
* device instance $1735 r0 *1 9.36,136.17 pfet_03v3
M$1735 A|Y$272 \$1830 VDD VDD pfet_03v3 L=0.28U W=2.76U AS=0.7176P AD=1.4076P
+ PS=3.8U PD=6.18U
* device instance $1737 r0 *1 9.12,130.39 pfet_03v3
M$1737 C|Y$26 A|Y$288 VDD VDD pfet_03v3 L=0.28U W=2.76U AS=0.966P AD=0.966P
+ PS=5.54U PD=5.54U
* device instance $1739 r0 *1 11.36,130.39 pfet_03v3
M$1739 Y$28 A|Y$288 VDD VDD pfet_03v3 L=0.28U W=2.76U AS=0.966P AD=0.7176P
+ PS=5.54U PD=3.8U
* device instance $1741 r0 *1 12.96,130.39 pfet_03v3
M$1741 Y$28 A|B|Y$3 VDD VDD pfet_03v3 L=0.28U W=2.76U AS=0.7176P AD=1.1592P
+ PS=3.8U PD=4.44U
* device instance $1743 r0 *1 15.2,130.39 pfet_03v3
M$1743 Y$28 C|Y$26 VDD VDD pfet_03v3 L=0.28U W=2.76U AS=1.1592P AD=0.9798P
+ PS=4.44U PD=5.56U
* device instance $1745 r0 *1 11.92,136.17 pfet_03v3
M$1745 VDD A|FINE_MUX[15] \$1831 VDD pfet_03v3 L=0.28U W=1.38U AS=0.6072P
+ AD=0.3588P PS=3.64U PD=1.9U
* device instance $1746 r0 *1 12.72,136.17 pfet_03v3
M$1746 A|Y$271 \$1831 VDD VDD pfet_03v3 L=0.28U W=2.76U AS=0.7176P AD=1.4076P
+ PS=3.8U PD=6.18U
* device instance $1748 r0 *1 15.28,136.17 pfet_03v3
M$1748 C|Y$27 A|Y$320 VDD VDD pfet_03v3 L=0.28U W=2.76U AS=0.966P AD=0.966P
+ PS=5.54U PD=5.54U
* device instance $1750 r0 *1 21.305,130.245 pfet_03v3
M$1750 VDD \$1780 \$1779 VDD pfet_03v3 L=7.75U W=1.09U AS=0.5341P AD=0.4796P
+ PS=3.16U PD=3.06U
* device instance $1751 r0 *1 30.265,130.245 pfet_03v3
M$1751 VDD \$1782 \$1781 VDD pfet_03v3 L=7.75U W=1.09U AS=0.5341P AD=0.4796P
+ PS=3.16U PD=3.06U
* device instance $1752 r0 *1 39.225,130.245 pfet_03v3
M$1752 VDD \$1784 \$1783 VDD pfet_03v3 L=7.75U W=1.09U AS=0.5341P AD=0.4796P
+ PS=3.16U PD=3.06U
* device instance $1753 r0 *1 44.825,130.24 pfet_03v3
M$1753 VDD \$1786 \$1785 VDD pfet_03v3 L=1.03U W=1.08U AS=0.5292P AD=0.4752P
+ PS=3.14U PD=3.04U
* device instance $1754 r0 *1 51.545,130.245 pfet_03v3
M$1754 VDD \$1788 \$1787 VDD pfet_03v3 L=7.75U W=1.09U AS=0.5341P AD=0.4796P
+ PS=3.16U PD=3.06U
* device instance $1755 r0 *1 60.505,130.245 pfet_03v3
M$1755 VDD \$1790 \$1789 VDD pfet_03v3 L=7.75U W=1.09U AS=0.5341P AD=0.4796P
+ PS=3.16U PD=3.06U
* device instance $1756 r0 *1 69.465,130.245 pfet_03v3
M$1756 VDD \$1792 \$1791 VDD pfet_03v3 L=7.75U W=1.09U AS=0.5341P AD=0.4796P
+ PS=3.16U PD=3.06U
* device instance $1757 r0 *1 78.425,130.245 pfet_03v3
M$1757 VDD \$1794 \$1793 VDD pfet_03v3 L=7.75U W=1.09U AS=0.5341P AD=0.4796P
+ PS=3.16U PD=3.06U
* device instance $1758 r0 *1 84.025,130.24 pfet_03v3
M$1758 VDD \$1796 \$1795 VDD pfet_03v3 L=1.03U W=1.08U AS=0.5292P AD=0.4752P
+ PS=3.14U PD=3.04U
* device instance $1759 r0 *1 87.385,130.24 pfet_03v3
M$1759 VDD \$1798 \$1797 VDD pfet_03v3 L=1.03U W=1.08U AS=0.5292P AD=0.4752P
+ PS=3.14U PD=3.04U
* device instance $1760 r0 *1 88.4,136.17 pfet_03v3
M$1760 A|Y$290 \$1871 VDD VDD pfet_03v3 L=0.28U W=2.76U AS=1.4076P AD=0.7176P
+ PS=6.18U PD=3.8U
* device instance $1762 r0 *1 90,136.17 pfet_03v3
M$1762 \$1871 A|Y$292 VDD VDD pfet_03v3 L=0.28U W=1.38U AS=0.3588P AD=0.6072P
+ PS=1.9U PD=3.64U
* device instance $1763 r0 *1 90.08,130.39 pfet_03v3
M$1763 A|Y$283 \$1799 VDD VDD pfet_03v3 L=0.28U W=2.76U AS=1.4076P AD=0.7176P
+ PS=6.18U PD=3.8U
* device instance $1765 r0 *1 91.68,130.39 pfet_03v3
M$1765 \$1799 A|Y$284 VDD VDD pfet_03v3 L=0.28U W=1.38U AS=0.3588P AD=0.6072P
+ PS=1.9U PD=3.64U
* device instance $1766 r0 *1 91.44,136.17 pfet_03v3
M$1766 VDD A|Y$283 \$1852 VDD pfet_03v3 L=0.28U W=1.38U AS=0.6072P AD=0.3588P
+ PS=3.64U PD=1.9U
* device instance $1767 r0 *1 92.24,136.17 pfet_03v3
M$1767 A|Y$292 \$1852 VDD VDD pfet_03v3 L=0.28U W=2.76U AS=0.7176P AD=1.4076P
+ PS=3.8U PD=6.18U
* device instance $1769 r0 *1 93.44,130.39 pfet_03v3
M$1769 A|Y$284 \$1802 VDD VDD pfet_03v3 L=0.28U W=2.76U AS=1.4076P AD=0.7176P
+ PS=6.18U PD=3.8U
* device instance $1771 r0 *1 95.04,130.39 pfet_03v3
M$1771 \$1802 A|Y$285 VDD VDD pfet_03v3 L=0.28U W=1.38U AS=0.3588P AD=0.6072P
+ PS=1.9U PD=3.64U
* device instance $1772 r0 *1 96.48,130.39 pfet_03v3
M$1772 VDD A|Y$273 \$1804 VDD pfet_03v3 L=0.28U W=1.38U AS=0.6072P AD=0.3588P
+ PS=3.64U PD=1.9U
* device instance $1773 r0 *1 97.28,130.39 pfet_03v3
M$1773 A|Y$285 \$1804 VDD VDD pfet_03v3 L=0.28U W=2.76U AS=0.7176P AD=1.4076P
+ PS=3.8U PD=6.18U
* device instance $1775 r0 *1 99.84,130.39 pfet_03v3
M$1775 VDD A|Y$275 \$1805 VDD pfet_03v3 L=0.28U W=1.38U AS=0.6072P AD=0.3588P
+ PS=3.64U PD=1.9U
* device instance $1776 r0 *1 100.64,130.39 pfet_03v3
M$1776 A|Y$274 \$1805 VDD VDD pfet_03v3 L=0.28U W=2.76U AS=0.7176P AD=1.4076P
+ PS=3.8U PD=6.18U
* device instance $1778 r0 *1 106.985,130.245 pfet_03v3
M$1778 VDD \$1807 \$1806 VDD pfet_03v3 L=7.75U W=1.09U AS=0.5341P AD=0.4796P
+ PS=3.16U PD=3.06U
* device instance $1779 r0 *1 112.585,130.24 pfet_03v3
M$1779 VDD \$1809 \$1808 VDD pfet_03v3 L=1.03U W=1.08U AS=0.5292P AD=0.4752P
+ PS=3.14U PD=3.04U
* device instance $1780 r0 *1 116.4,130.39 pfet_03v3
M$1780 A|Y$279 \$1810 VDD VDD pfet_03v3 L=0.28U W=2.76U AS=1.4076P AD=0.7176P
+ PS=6.18U PD=3.8U
* device instance $1782 r0 *1 118,130.39 pfet_03v3
M$1782 \$1810 A|Y$286 VDD VDD pfet_03v3 L=0.28U W=1.38U AS=0.3588P AD=0.6072P
+ PS=1.9U PD=3.64U
* device instance $1783 r0 *1 119.76,130.39 pfet_03v3
M$1783 A|Y$286 \$1812 VDD VDD pfet_03v3 L=0.28U W=2.76U AS=1.4076P AD=0.7176P
+ PS=6.18U PD=3.8U
* device instance $1785 r0 *1 121.36,130.39 pfet_03v3
M$1785 \$1812 A|Y$280 VDD VDD pfet_03v3 L=0.28U W=1.38U AS=0.3588P AD=0.6072P
+ PS=1.9U PD=3.64U
* device instance $1786 r0 *1 123.225,130.24 pfet_03v3
M$1786 VDD \$1814 \$1813 VDD pfet_03v3 L=1.03U W=1.08U AS=0.5292P AD=0.4752P
+ PS=3.14U PD=3.04U
* device instance $1787 r0 *1 129.945,130.245 pfet_03v3
M$1787 VDD \$1816 \$1815 VDD pfet_03v3 L=7.75U W=1.09U AS=0.5341P AD=0.4796P
+ PS=3.16U PD=3.06U
* device instance $1788 r0 *1 132.745,128.48 pfet_03v3
M$1788 VDD \$1761 \$1760 VDD pfet_03v3 L=1.03U W=1.08U AS=0.5292P AD=0.4752P
+ PS=3.14U PD=3.04U
* device instance $1789 r0 *1 136,130.39 pfet_03v3
M$1789 A|Y$282 \$1817 VDD VDD pfet_03v3 L=0.28U W=2.76U AS=1.4076P AD=0.7176P
+ PS=6.18U PD=3.8U
* device instance $1791 r0 *1 137.6,130.39 pfet_03v3
M$1791 \$1817 A|Y$287 VDD VDD pfet_03v3 L=0.28U W=1.38U AS=0.3588P AD=0.6072P
+ PS=1.9U PD=3.64U
* device instance $1792 r0 *1 137.68,136.17 pfet_03v3
M$1792 A|Y$289 \$1873 VDD VDD pfet_03v3 L=0.28U W=2.76U AS=1.4076P AD=0.7176P
+ PS=6.18U PD=3.8U
* device instance $1794 r0 *1 139.28,136.17 pfet_03v3
M$1794 \$1873 A|Y$291 VDD VDD pfet_03v3 L=0.28U W=1.38U AS=0.3588P AD=0.6072P
+ PS=1.9U PD=3.64U
* device instance $1795 r0 *1 139.04,130.39 pfet_03v3
M$1795 VDD A|Y$289 \$1819 VDD pfet_03v3 L=0.28U W=1.38U AS=0.6072P AD=0.3588P
+ PS=3.64U PD=1.9U
* device instance $1796 r0 *1 139.84,130.39 pfet_03v3
M$1796 A|Y$287 \$1819 VDD VDD pfet_03v3 L=0.28U W=2.76U AS=0.7176P AD=1.4076P
+ PS=3.8U PD=6.18U
* device instance $1798 r0 *1 140.72,136.17 pfet_03v3
M$1798 VDD A|Y$293 \$1863 VDD pfet_03v3 L=0.28U W=1.38U AS=0.6072P AD=0.3588P
+ PS=3.64U PD=1.9U
* device instance $1799 r0 *1 141.52,136.17 pfet_03v3
M$1799 A|Y$291 \$1863 VDD VDD pfet_03v3 L=0.28U W=2.76U AS=0.7176P AD=1.4076P
+ PS=3.8U PD=6.18U
* device instance $1801 r0 *1 141.705,128.48 pfet_03v3
M$1801 VDD \$1767 \$1766 VDD pfet_03v3 L=1.03U W=1.08U AS=0.5292P AD=0.4752P
+ PS=3.14U PD=3.04U
* device instance $1802 r0 *1 146.185,130.245 pfet_03v3
M$1802 VDD \$1821 \$1820 VDD pfet_03v3 L=7.75U W=1.09U AS=0.5341P AD=0.4796P
+ PS=3.16U PD=3.06U
* device instance $1803 r0 *1 155.145,130.245 pfet_03v3
M$1803 VDD \$1823 \$1822 VDD pfet_03v3 L=7.75U W=1.09U AS=0.5341P AD=0.4796P
+ PS=3.16U PD=3.06U
* device instance $1804 r0 *1 159.625,128.48 pfet_03v3
M$1804 VDD \$1773 \$1772 VDD pfet_03v3 L=1.03U W=1.08U AS=0.5292P AD=0.4752P
+ PS=3.14U PD=3.04U
* device instance $1805 r0 *1 160.745,130.24 pfet_03v3
M$1805 VDD \$1825 \$1824 VDD pfet_03v3 L=1.03U W=1.08U AS=0.5292P AD=0.4752P
+ PS=3.14U PD=3.04U
* device instance $1806 r0 *1 21.305,136.315 pfet_03v3
M$1806 VDD \$1834 \$1833 VDD pfet_03v3 L=7.75U W=1.09U AS=0.5341P AD=0.4796P
+ PS=3.16U PD=3.06U
* device instance $1807 r0 *1 31.945,136.315 pfet_03v3
M$1807 VDD \$1836 \$1835 VDD pfet_03v3 L=7.75U W=1.09U AS=0.5341P AD=0.4796P
+ PS=3.16U PD=3.06U
* device instance $1808 r0 *1 40.905,136.315 pfet_03v3
M$1808 VDD \$1838 \$1837 VDD pfet_03v3 L=7.75U W=1.09U AS=0.5341P AD=0.4796P
+ PS=3.16U PD=3.06U
* device instance $1809 r0 *1 49.865,136.315 pfet_03v3
M$1809 VDD \$1840 \$1839 VDD pfet_03v3 L=7.75U W=1.09U AS=0.5341P AD=0.4796P
+ PS=3.16U PD=3.06U
* device instance $1810 r0 *1 58.825,136.315 pfet_03v3
M$1810 VDD \$1842 \$1841 VDD pfet_03v3 L=7.75U W=1.09U AS=0.5341P AD=0.4796P
+ PS=3.16U PD=3.06U
* device instance $1811 r0 *1 64.425,136.32 pfet_03v3
M$1811 VDD \$1844 \$1843 VDD pfet_03v3 L=1.03U W=1.08U AS=0.5292P AD=0.4752P
+ PS=3.14U PD=3.04U
* device instance $1812 r0 *1 71.145,136.315 pfet_03v3
M$1812 VDD \$1846 \$1845 VDD pfet_03v3 L=7.75U W=1.09U AS=0.5341P AD=0.4796P
+ PS=3.16U PD=3.06U
* device instance $1813 r0 *1 80.105,136.315 pfet_03v3
M$1813 VDD \$1848 \$1847 VDD pfet_03v3 L=7.75U W=1.09U AS=0.5341P AD=0.4796P
+ PS=3.16U PD=3.06U
* device instance $1814 r0 *1 85.705,136.32 pfet_03v3
M$1814 VDD \$1850 \$1849 VDD pfet_03v3 L=1.03U W=1.08U AS=0.5292P AD=0.4752P
+ PS=3.14U PD=3.04U
* device instance $1815 r0 *1 98.585,136.315 pfet_03v3
M$1815 VDD \$1854 \$1853 VDD pfet_03v3 L=7.75U W=1.09U AS=0.5341P AD=0.4796P
+ PS=3.16U PD=3.06U
* device instance $1816 r0 *1 110.345,136.315 pfet_03v3
M$1816 VDD \$1856 \$1855 VDD pfet_03v3 L=7.75U W=1.09U AS=0.5341P AD=0.4796P
+ PS=3.16U PD=3.06U
* device instance $1817 r0 *1 119.305,136.315 pfet_03v3
M$1817 VDD \$1858 \$1857 VDD pfet_03v3 L=7.75U W=1.09U AS=0.5341P AD=0.4796P
+ PS=3.16U PD=3.06U
* device instance $1818 r0 *1 128.265,136.315 pfet_03v3
M$1818 VDD \$1860 \$1859 VDD pfet_03v3 L=7.75U W=1.09U AS=0.5341P AD=0.4796P
+ PS=3.16U PD=3.06U
* device instance $1819 r0 *1 133.865,136.32 pfet_03v3
M$1819 VDD \$1862 \$1861 VDD pfet_03v3 L=1.03U W=1.08U AS=0.5292P AD=0.4752P
+ PS=3.14U PD=3.04U
* device instance $1820 r0 *1 149.545,136.315 pfet_03v3
M$1820 VDD \$1866 \$1865 VDD pfet_03v3 L=7.75U W=1.09U AS=0.5341P AD=0.4796P
+ PS=3.16U PD=3.06U
* device instance $1821 r0 *1 156.265,136.315 pfet_03v3
M$1821 VDD \$1868 \$1867 VDD pfet_03v3 L=3.27U W=1.09U AS=0.5341P AD=0.4796P
+ PS=3.16U PD=3.06U
* device instance $1822 r0 *1 159.625,136.32 pfet_03v3
M$1822 VDD \$1870 \$1869 VDD pfet_03v3 L=1.03U W=1.08U AS=0.5292P AD=0.4752P
+ PS=3.14U PD=3.04U
* device instance $1823 r0 *1 8.56,138.23 pfet_03v3
M$1823 VDD A|FINE_MUX[25] \$1877 VDD pfet_03v3 L=0.28U W=1.38U AS=0.6072P
+ AD=0.3588P PS=3.64U PD=1.9U
* device instance $1824 r0 *1 9.36,138.23 pfet_03v3
M$1824 A|Y$288 \$1877 VDD VDD pfet_03v3 L=0.28U W=2.76U AS=0.7176P AD=1.4076P
+ PS=3.8U PD=6.18U
* device instance $1826 r0 *1 11.92,138.23 pfet_03v3
M$1826 Y$29 A|Y$294 VDD VDD pfet_03v3 L=0.28U W=2.76U AS=0.966P AD=0.7176P
+ PS=5.54U PD=3.8U
* device instance $1828 r0 *1 13.52,138.23 pfet_03v3
M$1828 Y$29 A|B|Y$3 VDD VDD pfet_03v3 L=0.28U W=2.76U AS=0.7176P AD=1.1592P
+ PS=3.8U PD=4.44U
* device instance $1830 r0 *1 15.76,138.23 pfet_03v3
M$1830 Y$29 C|Y$28 VDD VDD pfet_03v3 L=0.28U W=2.76U AS=1.1592P AD=0.9798P
+ PS=4.44U PD=5.56U
* device instance $1832 r0 *1 18.08,138.23 pfet_03v3
M$1832 C|Y$28 A|Y$294 VDD VDD pfet_03v3 L=0.28U W=2.76U AS=0.966P AD=0.966P
+ PS=5.54U PD=5.54U
* device instance $1834 r0 *1 24.105,138.085 pfet_03v3
M$1834 VDD \$1883 \$1882 VDD pfet_03v3 L=7.75U W=1.09U AS=0.5341P AD=0.4796P
+ PS=3.16U PD=3.06U
* device instance $1835 r0 *1 33.065,138.085 pfet_03v3
M$1835 VDD \$1885 \$1884 VDD pfet_03v3 L=7.75U W=1.09U AS=0.5341P AD=0.4796P
+ PS=3.16U PD=3.06U
* device instance $1836 r0 *1 39.785,138.085 pfet_03v3
M$1836 VDD \$1887 \$1886 VDD pfet_03v3 L=3.27U W=1.09U AS=0.5341P AD=0.4796P
+ PS=3.16U PD=3.06U
* device instance $1837 r0 *1 43.145,138.08 pfet_03v3
M$1837 VDD \$1889 \$1888 VDD pfet_03v3 L=1.03U W=1.08U AS=0.5292P AD=0.4752P
+ PS=3.14U PD=3.04U
* device instance $1838 r0 *1 51.545,138.085 pfet_03v3
M$1838 VDD \$1891 \$1890 VDD pfet_03v3 L=7.75U W=1.09U AS=0.5341P AD=0.4796P
+ PS=3.16U PD=3.06U
* device instance $1839 r0 *1 60.505,138.085 pfet_03v3
M$1839 VDD \$1893 \$1892 VDD pfet_03v3 L=7.75U W=1.09U AS=0.5341P AD=0.4796P
+ PS=3.16U PD=3.06U
* device instance $1840 r0 *1 69.465,138.085 pfet_03v3
M$1840 VDD \$1895 \$1894 VDD pfet_03v3 L=7.75U W=1.09U AS=0.5341P AD=0.4796P
+ PS=3.16U PD=3.06U
* device instance $1841 r0 *1 78.425,138.085 pfet_03v3
M$1841 VDD \$1897 \$1896 VDD pfet_03v3 L=7.75U W=1.09U AS=0.5341P AD=0.4796P
+ PS=3.16U PD=3.06U
* device instance $1842 r0 *1 84.025,138.08 pfet_03v3
M$1842 VDD \$1899 \$1898 VDD pfet_03v3 L=1.03U W=1.08U AS=0.5292P AD=0.4752P
+ PS=3.14U PD=3.04U
* device instance $1843 r0 *1 88.505,138.085 pfet_03v3
M$1843 VDD \$1901 \$1900 VDD pfet_03v3 L=3.27U W=1.09U AS=0.5341P AD=0.4796P
+ PS=3.16U PD=3.06U
* device instance $1844 r0 *1 91.44,138.23 pfet_03v3
M$1844 VDD A|Y$290 \$1902 VDD pfet_03v3 L=0.28U W=1.38U AS=0.6072P AD=0.3588P
+ PS=3.64U PD=1.9U
* device instance $1845 r0 *1 92.24,138.23 pfet_03v3
M$1845 A|Y$295 \$1902 VDD VDD pfet_03v3 L=0.28U W=2.76U AS=0.7176P AD=1.4076P
+ PS=3.8U PD=6.18U
* device instance $1847 r0 *1 98.585,138.085 pfet_03v3
M$1847 VDD \$1905 \$1904 VDD pfet_03v3 L=7.75U W=1.09U AS=0.5341P AD=0.4796P
+ PS=3.16U PD=3.06U
* device instance $1848 r0 *1 107.545,138.085 pfet_03v3
M$1848 VDD \$1907 \$1906 VDD pfet_03v3 L=7.75U W=1.09U AS=0.5341P AD=0.4796P
+ PS=3.16U PD=3.06U
* device instance $1849 r0 *1 114.16,138.23 pfet_03v3
M$1849 A|Y$296 \$1908 VDD VDD pfet_03v3 L=0.28U W=2.76U AS=1.4076P AD=0.7176P
+ PS=6.18U PD=3.8U
* device instance $1851 r0 *1 115.76,138.23 pfet_03v3
M$1851 \$1908 A|Y$297 VDD VDD pfet_03v3 L=0.28U W=1.38U AS=0.3588P AD=0.6072P
+ PS=1.9U PD=3.64U
* device instance $1852 r0 *1 117.52,138.23 pfet_03v3
M$1852 A|Y$298 \$1911 VDD VDD pfet_03v3 L=0.28U W=2.76U AS=1.4076P AD=0.7176P
+ PS=6.18U PD=3.8U
* device instance $1854 r0 *1 119.12,138.23 pfet_03v3
M$1854 \$1911 A|Y$299 VDD VDD pfet_03v3 L=0.28U W=1.38U AS=0.3588P AD=0.6072P
+ PS=1.9U PD=3.64U
* device instance $1855 r0 *1 120.88,138.23 pfet_03v3
M$1855 A|Y$300 \$1914 VDD VDD pfet_03v3 L=0.28U W=2.76U AS=1.4076P AD=0.7176P
+ PS=6.18U PD=3.8U
* device instance $1857 r0 *1 122.48,138.23 pfet_03v3
M$1857 \$1914 A|Y$301 VDD VDD pfet_03v3 L=0.28U W=1.38U AS=0.3588P AD=0.6072P
+ PS=1.9U PD=3.64U
* device instance $1858 r0 *1 126.48,138.23 pfet_03v3
M$1858 A|Y$302 \$1917 VDD VDD pfet_03v3 L=0.28U W=2.76U AS=1.4076P AD=0.7176P
+ PS=6.18U PD=3.8U
* device instance $1860 r0 *1 128.08,138.23 pfet_03v3
M$1860 \$1917 A|Y$303 VDD VDD pfet_03v3 L=0.28U W=1.38U AS=0.3588P AD=0.6072P
+ PS=1.9U PD=3.64U
* device instance $1861 r0 *1 129.945,138.08 pfet_03v3
M$1861 VDD \$1921 \$1920 VDD pfet_03v3 L=1.03U W=1.08U AS=0.5292P AD=0.4752P
+ PS=3.14U PD=3.04U
* device instance $1862 r0 *1 133.76,138.23 pfet_03v3
M$1862 A|Y$304 \$1922 VDD VDD pfet_03v3 L=0.28U W=2.76U AS=1.4076P AD=0.7176P
+ PS=6.18U PD=3.8U
* device instance $1864 r0 *1 135.36,138.23 pfet_03v3
M$1864 \$1922 A|Y$305 VDD VDD pfet_03v3 L=0.28U W=1.38U AS=0.3588P AD=0.6072P
+ PS=1.9U PD=3.64U
* device instance $1865 r0 *1 137.225,138.08 pfet_03v3
M$1865 VDD \$1926 \$1925 VDD pfet_03v3 L=1.03U W=1.08U AS=0.5292P AD=0.4752P
+ PS=3.14U PD=3.04U
* device instance $1866 r0 *1 139.36,138.23 pfet_03v3
M$1866 A|Y$293 \$1927 VDD VDD pfet_03v3 L=0.28U W=2.76U AS=1.4076P AD=0.7176P
+ PS=6.18U PD=3.8U
* device instance $1868 r0 *1 140.96,138.23 pfet_03v3
M$1868 \$1927 A|Y$306 VDD VDD pfet_03v3 L=0.28U W=1.38U AS=0.3588P AD=0.6072P
+ PS=1.9U PD=3.64U
* device instance $1869 r0 *1 142.4,138.23 pfet_03v3
M$1869 VDD A|Y$307 \$1929 VDD pfet_03v3 L=0.28U W=1.38U AS=0.6072P AD=0.3588P
+ PS=3.64U PD=1.9U
* device instance $1870 r0 *1 143.2,138.23 pfet_03v3
M$1870 A|Y$306 \$1929 VDD VDD pfet_03v3 L=0.28U W=2.76U AS=0.7176P AD=1.4076P
+ PS=3.8U PD=6.18U
* device instance $1872 r0 *1 149.545,138.085 pfet_03v3
M$1872 VDD \$1931 \$1930 VDD pfet_03v3 L=7.75U W=1.09U AS=0.5341P AD=0.4796P
+ PS=3.16U PD=3.06U
* device instance $1873 r0 *1 156.265,138.085 pfet_03v3
M$1873 VDD \$1933 \$1932 VDD pfet_03v3 L=3.27U W=1.09U AS=0.5341P AD=0.4796P
+ PS=3.16U PD=3.06U
* device instance $1874 r0 *1 159.625,138.08 pfet_03v3
M$1874 VDD \$1935 \$1934 VDD pfet_03v3 L=1.03U W=1.08U AS=0.5292P AD=0.4752P
+ PS=3.14U PD=3.04U
* device instance $1875 r0 *1 8.56,144.01 pfet_03v3
M$1875 VDD A|FINE_MUX[10] \$1941 VDD pfet_03v3 L=0.28U W=1.38U AS=0.6072P
+ AD=0.3588P PS=3.64U PD=1.9U
* device instance $1876 r0 *1 9.36,144.01 pfet_03v3
M$1876 A|Y$294 \$1941 VDD VDD pfet_03v3 L=0.28U W=2.76U AS=0.7176P AD=1.4076P
+ PS=3.8U PD=6.18U
* device instance $1878 r0 *1 11.92,144.01 pfet_03v3
M$1878 Y$30 A|Y$320 VDD VDD pfet_03v3 L=0.28U W=2.76U AS=0.966P AD=0.7176P
+ PS=5.54U PD=3.8U
* device instance $1880 r0 *1 13.52,144.01 pfet_03v3
M$1880 Y$30 A|B|Y$3 VDD VDD pfet_03v3 L=0.28U W=2.76U AS=0.7176P AD=1.1592P
+ PS=3.8U PD=4.44U
* device instance $1882 r0 *1 15.76,144.01 pfet_03v3
M$1882 Y$30 C|Y$27 VDD VDD pfet_03v3 L=0.28U W=2.76U AS=1.1592P AD=0.9798P
+ PS=4.44U PD=5.56U
* device instance $1884 r0 *1 18.08,144.01 pfet_03v3
M$1884 VDD A|FINE_MUX[20] \$1945 VDD pfet_03v3 L=0.28U W=1.38U AS=0.6072P
+ AD=0.3588P PS=3.64U PD=1.9U
* device instance $1885 r0 *1 18.88,144.01 pfet_03v3
M$1885 A|Y$308 \$1945 VDD VDD pfet_03v3 L=0.28U W=2.76U AS=0.7176P AD=1.4076P
+ PS=3.8U PD=6.18U
* device instance $1887 r0 *1 21.44,144.01 pfet_03v3
M$1887 C|Y$29 A|Y$308 VDD VDD pfet_03v3 L=0.28U W=2.76U AS=0.966P AD=0.966P
+ PS=5.54U PD=5.54U
* device instance $1889 r0 *1 72.96,144.01 pfet_03v3
M$1889 C|Y$30 A|Y$321 VDD VDD pfet_03v3 L=0.28U W=2.76U AS=0.966P AD=0.966P
+ PS=5.54U PD=5.54U
* device instance $1891 r0 *1 77.44,144.01 pfet_03v3
M$1891 C|Y$31 A|Y$322 VDD VDD pfet_03v3 L=0.28U W=2.76U AS=0.966P AD=0.966P
+ PS=5.54U PD=5.54U
* device instance $1893 r0 *1 92,144.01 pfet_03v3
M$1893 VDD A|Y$295 \$1970 VDD pfet_03v3 L=0.28U W=1.38U AS=0.6072P AD=0.3588P
+ PS=3.64U PD=1.9U
* device instance $1894 r0 *1 92.8,144.01 pfet_03v3
M$1894 A|Y$309 \$1970 VDD VDD pfet_03v3 L=0.28U W=2.76U AS=0.7176P AD=1.4076P
+ PS=3.8U PD=6.18U
* device instance $1896 r0 *1 95.36,144.01 pfet_03v3
M$1896 VDD A|Y$309 \$1972 VDD pfet_03v3 L=0.28U W=1.38U AS=0.6072P AD=0.3588P
+ PS=3.64U PD=1.9U
* device instance $1897 r0 *1 96.16,144.01 pfet_03v3
M$1897 A|Y$310 \$1972 VDD VDD pfet_03v3 L=0.28U W=2.76U AS=0.7176P AD=1.4076P
+ PS=3.8U PD=6.18U
* device instance $1899 r0 *1 99.04,144.01 pfet_03v3
M$1899 A|Y$311 \$2003 VDD VDD pfet_03v3 L=0.28U W=2.76U AS=1.4076P AD=0.7176P
+ PS=6.18U PD=3.8U
* device instance $1901 r0 *1 100.64,144.01 pfet_03v3
M$1901 \$2003 A|Y$312 VDD VDD pfet_03v3 L=0.28U W=1.38U AS=0.3588P AD=0.6072P
+ PS=1.9U PD=3.64U
* device instance $1902 r0 *1 102.4,144.01 pfet_03v3
M$1902 A|Y$313 \$2004 VDD VDD pfet_03v3 L=0.28U W=2.76U AS=1.4076P AD=0.7176P
+ PS=6.18U PD=3.8U
* device instance $1904 r0 *1 104,144.01 pfet_03v3
M$1904 \$2004 A|Y$314 VDD VDD pfet_03v3 L=0.28U W=1.38U AS=0.3588P AD=0.6072P
+ PS=1.9U PD=3.64U
* device instance $1905 r0 *1 107.68,144.01 pfet_03v3
M$1905 VDD A|Y$323 \$1978 VDD pfet_03v3 L=0.28U W=1.38U AS=0.6072P AD=0.3588P
+ PS=3.64U PD=1.9U
* device instance $1906 r0 *1 108.48,144.01 pfet_03v3
M$1906 A|Y$315 \$1978 VDD VDD pfet_03v3 L=0.28U W=2.76U AS=0.7176P AD=1.4076P
+ PS=3.8U PD=6.18U
* device instance $1908 r0 *1 111.04,144.01 pfet_03v3
M$1908 VDD A|Y$315 \$1980 VDD pfet_03v3 L=0.28U W=1.38U AS=0.6072P AD=0.3588P
+ PS=3.64U PD=1.9U
* device instance $1909 r0 *1 111.84,144.01 pfet_03v3
M$1909 A|Y$316 \$1980 VDD VDD pfet_03v3 L=0.28U W=2.76U AS=0.7176P AD=1.4076P
+ PS=3.8U PD=6.18U
* device instance $1911 r0 *1 114.4,144.01 pfet_03v3
M$1911 VDD A|Y$316 \$1982 VDD pfet_03v3 L=0.28U W=1.38U AS=0.6072P AD=0.3588P
+ PS=3.64U PD=1.9U
* device instance $1912 r0 *1 115.2,144.01 pfet_03v3
M$1912 A|Y$297 \$1982 VDD VDD pfet_03v3 L=0.28U W=2.76U AS=0.7176P AD=1.4076P
+ PS=3.8U PD=6.18U
* device instance $1914 r0 *1 117.76,144.01 pfet_03v3
M$1914 VDD A|Y$296 \$1983 VDD pfet_03v3 L=0.28U W=1.38U AS=0.6072P AD=0.3588P
+ PS=3.64U PD=1.9U
* device instance $1915 r0 *1 118.56,144.01 pfet_03v3
M$1915 A|Y$299 \$1983 VDD VDD pfet_03v3 L=0.28U W=2.76U AS=0.7176P AD=1.4076P
+ PS=3.8U PD=6.18U
* device instance $1917 r0 *1 121.12,144.01 pfet_03v3
M$1917 VDD A|Y$298 \$1984 VDD pfet_03v3 L=0.28U W=1.38U AS=0.6072P AD=0.3588P
+ PS=3.64U PD=1.9U
* device instance $1918 r0 *1 121.92,144.01 pfet_03v3
M$1918 A|Y$301 \$1984 VDD VDD pfet_03v3 L=0.28U W=2.76U AS=0.7176P AD=1.4076P
+ PS=3.8U PD=6.18U
* device instance $1920 r0 *1 124.48,144.01 pfet_03v3
M$1920 VDD A|Y$300 \$1985 VDD pfet_03v3 L=0.28U W=1.38U AS=0.6072P AD=0.3588P
+ PS=3.64U PD=1.9U
* device instance $1921 r0 *1 125.28,144.01 pfet_03v3
M$1921 A|Y$317 \$1985 VDD VDD pfet_03v3 L=0.28U W=2.76U AS=0.7176P AD=1.4076P
+ PS=3.8U PD=6.18U
* device instance $1923 r0 *1 127.84,144.01 pfet_03v3
M$1923 VDD A|Y$317 \$1987 VDD pfet_03v3 L=0.28U W=1.38U AS=0.6072P AD=0.3588P
+ PS=3.64U PD=1.9U
* device instance $1924 r0 *1 128.64,144.01 pfet_03v3
M$1924 A|Y$303 \$1987 VDD VDD pfet_03v3 L=0.28U W=2.76U AS=0.7176P AD=1.4076P
+ PS=3.8U PD=6.18U
* device instance $1926 r0 *1 131.2,144.01 pfet_03v3
M$1926 VDD A|Y$324 \$1988 VDD pfet_03v3 L=0.28U W=1.38U AS=0.6072P AD=0.3588P
+ PS=3.64U PD=1.9U
* device instance $1927 r0 *1 132,144.01 pfet_03v3
M$1927 A|Y$318 \$1988 VDD VDD pfet_03v3 L=0.28U W=2.76U AS=0.7176P AD=1.4076P
+ PS=3.8U PD=6.18U
* device instance $1929 r0 *1 134.56,144.01 pfet_03v3
M$1929 VDD A|Y$318 \$1990 VDD pfet_03v3 L=0.28U W=1.38U AS=0.6072P AD=0.3588P
+ PS=3.64U PD=1.9U
* device instance $1930 r0 *1 135.36,144.01 pfet_03v3
M$1930 A|Y$305 \$1990 VDD VDD pfet_03v3 L=0.28U W=2.76U AS=0.7176P AD=1.4076P
+ PS=3.8U PD=6.18U
* device instance $1932 r0 *1 137.92,144.01 pfet_03v3
M$1932 VDD A|Y$304 \$1991 VDD pfet_03v3 L=0.28U W=1.38U AS=0.6072P AD=0.3588P
+ PS=3.64U PD=1.9U
* device instance $1933 r0 *1 138.72,144.01 pfet_03v3
M$1933 A|Y$319 \$1991 VDD VDD pfet_03v3 L=0.28U W=2.76U AS=0.7176P AD=1.4076P
+ PS=3.8U PD=6.18U
* device instance $1935 r0 *1 141.28,144.01 pfet_03v3
M$1935 VDD A|Y$325 \$1993 VDD pfet_03v3 L=0.28U W=1.38U AS=0.6072P AD=0.3588P
+ PS=3.64U PD=1.9U
* device instance $1936 r0 *1 142.08,144.01 pfet_03v3
M$1936 A|Y$307 \$1993 VDD VDD pfet_03v3 L=0.28U W=2.76U AS=0.7176P AD=1.4076P
+ PS=3.8U PD=6.18U
* device instance $1938 r0 *1 8.56,146.07 pfet_03v3
M$1938 VDD A|FINE_MUX[24] \$2009 VDD pfet_03v3 L=0.28U W=1.38U AS=0.6072P
+ AD=0.3588P PS=3.64U PD=1.9U
* device instance $1939 r0 *1 9.36,146.07 pfet_03v3
M$1939 A|Y$320 \$2009 VDD VDD pfet_03v3 L=0.28U W=2.76U AS=0.7176P AD=1.4076P
+ PS=3.8U PD=6.18U
* device instance $1941 r0 *1 12,146.07 pfet_03v3
M$1941 Y$31 C|Y$29 VDD VDD pfet_03v3 L=0.28U W=2.76U AS=0.9798P AD=1.1592P
+ PS=5.56U PD=4.44U
* device instance $1943 r0 *1 14.24,146.07 pfet_03v3
M$1943 Y$31 A|B|Y$3 VDD VDD pfet_03v3 L=0.28U W=2.76U AS=1.1592P AD=0.7176P
+ PS=4.44U PD=3.8U
* device instance $1945 r0 *1 15.84,146.07 pfet_03v3
M$1945 Y$31 A|Y$308 VDD VDD pfet_03v3 L=0.28U W=2.76U AS=0.7176P AD=0.966P
+ PS=3.8U PD=5.54U
* device instance $1947 r0 *1 18.08,146.07 pfet_03v3
M$1947 C|Y$32 A|Y$326 VDD VDD pfet_03v3 L=0.28U W=2.76U AS=0.966P AD=0.966P
+ PS=5.54U PD=5.54U
* device instance $1949 r0 *1 24.105,145.925 pfet_03v3
M$1949 VDD \$2013 \$2012 VDD pfet_03v3 L=7.75U W=1.09U AS=0.5341P AD=0.4796P
+ PS=3.16U PD=3.06U
* device instance $1950 r0 *1 24.105,144.16 pfet_03v3
M$1950 VDD \$1949 \$1948 VDD pfet_03v3 L=1.03U W=1.08U AS=0.5292P AD=0.4752P
+ PS=3.14U PD=3.04U
* device instance $1951 r0 *1 31.945,144.155 pfet_03v3
M$1951 VDD \$1951 \$1950 VDD pfet_03v3 L=7.75U W=1.09U AS=0.5341P AD=0.4796P
+ PS=3.16U PD=3.06U
* device instance $1952 r0 *1 33.065,145.925 pfet_03v3
M$1952 VDD \$2015 \$2014 VDD pfet_03v3 L=7.75U W=1.09U AS=0.5341P AD=0.4796P
+ PS=3.16U PD=3.06U
* device instance $1953 r0 *1 40.905,144.155 pfet_03v3
M$1953 VDD \$1953 \$1952 VDD pfet_03v3 L=7.75U W=1.09U AS=0.5341P AD=0.4796P
+ PS=3.16U PD=3.06U
* device instance $1954 r0 *1 39.785,145.925 pfet_03v3
M$1954 VDD \$2017 \$2016 VDD pfet_03v3 L=3.27U W=1.09U AS=0.5341P AD=0.4796P
+ PS=3.16U PD=3.06U
* device instance $1955 r0 *1 43.145,145.92 pfet_03v3
M$1955 VDD \$2019 \$2018 VDD pfet_03v3 L=1.03U W=1.08U AS=0.5292P AD=0.4752P
+ PS=3.14U PD=3.04U
* device instance $1956 r0 *1 49.865,144.155 pfet_03v3
M$1956 VDD \$1955 \$1954 VDD pfet_03v3 L=7.75U W=1.09U AS=0.5341P AD=0.4796P
+ PS=3.16U PD=3.06U
* device instance $1957 r0 *1 51.545,145.925 pfet_03v3
M$1957 VDD \$2021 \$2020 VDD pfet_03v3 L=7.75U W=1.09U AS=0.5341P AD=0.4796P
+ PS=3.16U PD=3.06U
* device instance $1958 r0 *1 58.825,144.155 pfet_03v3
M$1958 VDD \$1957 \$1956 VDD pfet_03v3 L=7.75U W=1.09U AS=0.5341P AD=0.4796P
+ PS=3.16U PD=3.06U
* device instance $1959 r0 *1 60.505,145.925 pfet_03v3
M$1959 VDD \$2023 \$2022 VDD pfet_03v3 L=7.75U W=1.09U AS=0.5341P AD=0.4796P
+ PS=3.16U PD=3.06U
* device instance $1960 r0 *1 64.425,144.16 pfet_03v3
M$1960 VDD \$1959 \$1958 VDD pfet_03v3 L=1.03U W=1.08U AS=0.5292P AD=0.4752P
+ PS=3.14U PD=3.04U
* device instance $1961 r0 *1 66.105,145.92 pfet_03v3
M$1961 VDD \$2025 \$2024 VDD pfet_03v3 L=1.03U W=1.08U AS=0.5292P AD=0.4752P
+ PS=3.14U PD=3.04U
* device instance $1962 r0 *1 68.905,144.155 pfet_03v3
M$1962 VDD \$1961 \$1960 VDD pfet_03v3 L=3.27U W=1.09U AS=0.5341P AD=0.4796P
+ PS=3.16U PD=3.06U
* device instance $1963 r0 *1 69.04,146.07 pfet_03v3
M$1963 Y$32 A|Y$321 VDD VDD pfet_03v3 L=0.28U W=2.76U AS=0.966P AD=0.7176P
+ PS=5.54U PD=3.8U
* device instance $1965 r0 *1 70.64,146.07 pfet_03v3
M$1965 Y$32 A|B|Y$3 VDD VDD pfet_03v3 L=0.28U W=2.76U AS=0.7176P AD=1.1592P
+ PS=3.8U PD=4.44U
* device instance $1967 r0 *1 72.88,146.07 pfet_03v3
M$1967 Y$32 C|Y$30 VDD VDD pfet_03v3 L=0.28U W=2.76U AS=1.1592P AD=0.9798P
+ PS=4.44U PD=5.56U
* device instance $1969 r0 *1 75.2,146.07 pfet_03v3
M$1969 Y$33 A|Y$322 VDD VDD pfet_03v3 L=0.28U W=2.76U AS=0.966P AD=0.7176P
+ PS=5.54U PD=3.8U
* device instance $1971 r0 *1 76.8,146.07 pfet_03v3
M$1971 Y$33 A|B|Y$3 VDD VDD pfet_03v3 L=0.28U W=2.76U AS=0.7176P AD=1.1592P
+ PS=3.8U PD=4.44U
* device instance $1973 r0 *1 79.04,146.07 pfet_03v3
M$1973 Y$33 C|Y$31 VDD VDD pfet_03v3 L=0.28U W=2.76U AS=1.1592P AD=0.9798P
+ PS=4.44U PD=5.56U
* device instance $1975 r0 *1 75.625,144.16 pfet_03v3
M$1975 VDD \$1964 \$1963 VDD pfet_03v3 L=1.03U W=1.08U AS=0.5292P AD=0.4752P
+ PS=3.14U PD=3.04U
* device instance $1976 r0 *1 83.465,144.155 pfet_03v3
M$1976 VDD \$1967 \$1966 VDD pfet_03v3 L=7.75U W=1.09U AS=0.5341P AD=0.4796P
+ PS=3.16U PD=3.06U
* device instance $1977 r0 *1 82.905,145.925 pfet_03v3
M$1977 VDD \$2029 \$2028 VDD pfet_03v3 L=3.27U W=1.09U AS=0.5341P AD=0.4796P
+ PS=3.16U PD=3.06U
* device instance $1978 r0 *1 88.505,145.925 pfet_03v3
M$1978 VDD \$2031 \$2030 VDD pfet_03v3 L=3.27U W=1.09U AS=0.5341P AD=0.4796P
+ PS=3.16U PD=3.06U
* device instance $1979 r0 *1 89.065,144.16 pfet_03v3
M$1979 VDD \$1969 \$1968 VDD pfet_03v3 L=1.03U W=1.08U AS=0.5292P AD=0.4752P
+ PS=3.14U PD=3.04U
* device instance $1980 r0 *1 91.865,145.92 pfet_03v3
M$1980 VDD \$2033 \$2032 VDD pfet_03v3 L=1.03U W=1.08U AS=0.5292P AD=0.4752P
+ PS=3.14U PD=3.04U
* device instance $1981 r0 *1 94,146.07 pfet_03v3
M$1981 A|Y$327 \$2034 VDD VDD pfet_03v3 L=0.28U W=2.76U AS=1.4076P AD=0.7176P
+ PS=6.18U PD=3.8U
* device instance $1983 r0 *1 95.6,146.07 pfet_03v3
M$1983 \$2034 A|Y$310 VDD VDD pfet_03v3 L=0.28U W=1.38U AS=0.3588P AD=0.6072P
+ PS=1.9U PD=3.64U
* device instance $1984 r0 *1 97.04,146.07 pfet_03v3
M$1984 VDD A|Y$327 \$2036 VDD pfet_03v3 L=0.28U W=1.38U AS=0.6072P AD=0.3588P
+ PS=3.64U PD=1.9U
* device instance $1985 r0 *1 97.84,146.07 pfet_03v3
M$1985 A|Y$328 \$2036 VDD VDD pfet_03v3 L=0.28U W=2.76U AS=0.7176P AD=1.4076P
+ PS=3.8U PD=6.18U
* device instance $1987 r0 *1 100.4,146.07 pfet_03v3
M$1987 VDD A|Y$328 \$2038 VDD pfet_03v3 L=0.28U W=1.38U AS=0.6072P AD=0.3588P
+ PS=3.64U PD=1.9U
* device instance $1988 r0 *1 101.2,146.07 pfet_03v3
M$1988 A|Y$312 \$2038 VDD VDD pfet_03v3 L=0.28U W=2.76U AS=0.7176P AD=1.4076P
+ PS=3.8U PD=6.18U
* device instance $1990 r0 *1 103.76,146.07 pfet_03v3
M$1990 VDD A|Y$311 \$2039 VDD pfet_03v3 L=0.28U W=1.38U AS=0.6072P AD=0.3588P
+ PS=3.64U PD=1.9U
* device instance $1991 r0 *1 104.56,146.07 pfet_03v3
M$1991 A|Y$314 \$2039 VDD VDD pfet_03v3 L=0.28U W=2.76U AS=0.7176P AD=1.4076P
+ PS=3.8U PD=6.18U
* device instance $1993 r0 *1 107.12,146.07 pfet_03v3
M$1993 VDD A|Y$313 \$2040 VDD pfet_03v3 L=0.28U W=1.38U AS=0.6072P AD=0.3588P
+ PS=3.64U PD=1.9U
* device instance $1994 r0 *1 107.92,146.07 pfet_03v3
M$1994 A|Y$323 \$2040 VDD VDD pfet_03v3 L=0.28U W=2.76U AS=0.7176P AD=1.4076P
+ PS=3.8U PD=6.18U
* device instance $1996 r0 *1 114.265,145.925 pfet_03v3
M$1996 VDD \$2042 \$2041 VDD pfet_03v3 L=7.75U W=1.09U AS=0.5341P AD=0.4796P
+ PS=3.16U PD=3.06U
* device instance $1997 r0 *1 120.985,145.925 pfet_03v3
M$1997 VDD \$2044 \$2043 VDD pfet_03v3 L=3.27U W=1.09U AS=0.5341P AD=0.4796P
+ PS=3.16U PD=3.06U
* device instance $1998 r0 *1 127.28,146.07 pfet_03v3
M$1998 VDD A|Y$302 \$2045 VDD pfet_03v3 L=0.28U W=1.38U AS=0.6072P AD=0.3588P
+ PS=3.64U PD=1.9U
* device instance $1999 r0 *1 128.08,146.07 pfet_03v3
M$1999 A|Y$324 \$2045 VDD VDD pfet_03v3 L=0.28U W=2.76U AS=0.7176P AD=1.4076P
+ PS=3.8U PD=6.18U
* device instance $2001 r0 *1 132.185,145.925 pfet_03v3
M$2001 VDD \$2047 \$2046 VDD pfet_03v3 L=3.27U W=1.09U AS=0.5341P AD=0.4796P
+ PS=3.16U PD=3.06U
* device instance $2002 r0 *1 137.12,146.07 pfet_03v3
M$2002 A|Y$329 \$2048 VDD VDD pfet_03v3 L=0.28U W=2.76U AS=1.4076P AD=0.7176P
+ PS=6.18U PD=3.8U
* device instance $2004 r0 *1 138.72,146.07 pfet_03v3
M$2004 \$2048 A|Y$319 VDD VDD pfet_03v3 L=0.28U W=1.38U AS=0.3588P AD=0.6072P
+ PS=1.9U PD=3.64U
* device instance $2005 r0 *1 140.16,146.07 pfet_03v3
M$2005 VDD A|Y$329 \$2050 VDD pfet_03v3 L=0.28U W=1.38U AS=0.6072P AD=0.3588P
+ PS=3.64U PD=1.9U
* device instance $2006 r0 *1 140.96,146.07 pfet_03v3
M$2006 A|Y$325 \$2050 VDD VDD pfet_03v3 L=0.28U W=2.76U AS=0.7176P AD=1.4076P
+ PS=3.8U PD=6.18U
* device instance $2008 r0 *1 147.305,145.925 pfet_03v3
M$2008 VDD \$2052 \$2051 VDD pfet_03v3 L=7.75U W=1.09U AS=0.5341P AD=0.4796P
+ PS=3.16U PD=3.06U
* device instance $2009 r0 *1 149.545,144.155 pfet_03v3
M$2009 VDD \$1995 \$1994 VDD pfet_03v3 L=7.75U W=1.09U AS=0.5341P AD=0.4796P
+ PS=3.16U PD=3.06U
* device instance $2010 r0 *1 156.265,145.925 pfet_03v3
M$2010 VDD \$2054 \$2053 VDD pfet_03v3 L=7.75U W=1.09U AS=0.5341P AD=0.4796P
+ PS=3.16U PD=3.06U
* device instance $2011 r0 *1 156.265,144.155 pfet_03v3
M$2011 VDD \$1997 \$1996 VDD pfet_03v3 L=3.27U W=1.09U AS=0.5341P AD=0.4796P
+ PS=3.16U PD=3.06U
* device instance $2012 r0 *1 159.625,144.16 pfet_03v3
M$2012 VDD \$1999 \$1998 VDD pfet_03v3 L=1.03U W=1.08U AS=0.5292P AD=0.4752P
+ PS=3.14U PD=3.04U
* device instance $2013 r0 *1 8.56,153.91 pfet_03v3
M$2013 VDD A|FINE_MUX[18] \$2108 VDD pfet_03v3 L=0.28U W=1.38U AS=0.6072P
+ AD=0.3588P PS=3.64U PD=1.9U
* device instance $2014 r0 *1 9.36,153.91 pfet_03v3
M$2014 A|Y$326 \$2108 VDD VDD pfet_03v3 L=0.28U W=2.76U AS=0.7176P AD=1.4076P
+ PS=3.8U PD=6.18U
* device instance $2016 r0 *1 8.985,152 pfet_03v3
M$2016 VDD \$2063 \$2062 VDD pfet_03v3 L=1.03U W=1.08U AS=0.5292P AD=0.4752P
+ PS=3.14U PD=3.04U
* device instance $2017 r0 *1 11.36,151.85 pfet_03v3
M$2017 Y$35 A|Y$326 VDD VDD pfet_03v3 L=0.28U W=2.76U AS=0.966P AD=0.7176P
+ PS=5.54U PD=3.8U
* device instance $2019 r0 *1 12.96,151.85 pfet_03v3
M$2019 Y$35 A|B|Y$3 VDD VDD pfet_03v3 L=0.28U W=2.76U AS=0.7176P AD=1.1592P
+ PS=3.8U PD=4.44U
* device instance $2021 r0 *1 15.2,151.85 pfet_03v3
M$2021 Y$35 C|Y$32 VDD VDD pfet_03v3 L=0.28U W=2.76U AS=1.1592P AD=0.9798P
+ PS=4.44U PD=5.56U
* device instance $2023 r0 *1 15.705,153.765 pfet_03v3
M$2023 VDD \$2110 \$2109 VDD pfet_03v3 L=7.75U W=1.09U AS=0.5341P AD=0.4796P
+ PS=3.16U PD=3.06U
* device instance $2024 r0 *1 21.305,151.995 pfet_03v3
M$2024 VDD \$2067 \$2066 VDD pfet_03v3 L=7.75U W=1.09U AS=0.5341P AD=0.4796P
+ PS=3.16U PD=3.06U
* device instance $2025 r0 *1 24.665,153.765 pfet_03v3
M$2025 VDD \$2112 \$2111 VDD pfet_03v3 L=7.75U W=1.09U AS=0.5341P AD=0.4796P
+ PS=3.16U PD=3.06U
* device instance $2026 r0 *1 31.945,151.995 pfet_03v3
M$2026 VDD \$2069 \$2068 VDD pfet_03v3 L=7.75U W=1.09U AS=0.5341P AD=0.4796P
+ PS=3.16U PD=3.06U
* device instance $2027 r0 *1 33.625,153.765 pfet_03v3
M$2027 VDD \$2114 \$2113 VDD pfet_03v3 L=7.75U W=1.09U AS=0.5341P AD=0.4796P
+ PS=3.16U PD=3.06U
* device instance $2028 r0 *1 40.905,151.995 pfet_03v3
M$2028 VDD \$2071 \$2070 VDD pfet_03v3 L=7.75U W=1.09U AS=0.5341P AD=0.4796P
+ PS=3.16U PD=3.06U
* device instance $2029 r0 *1 40.345,153.765 pfet_03v3
M$2029 VDD \$2116 \$2115 VDD pfet_03v3 L=3.27U W=1.09U AS=0.5341P AD=0.4796P
+ PS=3.16U PD=3.06U
* device instance $2030 r0 *1 43.705,153.76 pfet_03v3
M$2030 VDD \$2118 \$2117 VDD pfet_03v3 L=1.03U W=1.08U AS=0.5292P AD=0.4752P
+ PS=3.14U PD=3.04U
* device instance $2031 r0 *1 49.865,151.995 pfet_03v3
M$2031 VDD \$2073 \$2072 VDD pfet_03v3 L=7.75U W=1.09U AS=0.5341P AD=0.4796P
+ PS=3.16U PD=3.06U
* device instance $2032 r0 *1 48.185,153.76 pfet_03v3
M$2032 VDD \$2120 \$2119 VDD pfet_03v3 L=1.03U W=1.08U AS=0.5292P AD=0.4752P
+ PS=3.14U PD=3.04U
* device instance $2033 r0 *1 51.2,153.91 pfet_03v3
M$2033 Y$36 C|Y$37 VDD VDD pfet_03v3 L=0.28U W=2.76U AS=0.9798P AD=1.1592P
+ PS=5.56U PD=4.44U
* device instance $2035 r0 *1 53.44,153.91 pfet_03v3
M$2035 Y$36 A|B|Y$3 VDD VDD pfet_03v3 L=0.28U W=2.76U AS=1.1592P AD=0.7176P
+ PS=4.44U PD=3.8U
* device instance $2037 r0 *1 55.04,153.91 pfet_03v3
M$2037 Y$36 A|Y$331 VDD VDD pfet_03v3 L=0.28U W=2.76U AS=0.7176P AD=0.966P
+ PS=3.8U PD=5.54U
* device instance $2039 r0 *1 58.825,151.995 pfet_03v3
M$2039 VDD \$2075 \$2074 VDD pfet_03v3 L=7.75U W=1.09U AS=0.5341P AD=0.4796P
+ PS=3.16U PD=3.06U
* device instance $2040 r0 *1 57.28,153.91 pfet_03v3
M$2040 VDD A|FINE_MUX[9] \$2122 VDD pfet_03v3 L=0.28U W=1.38U AS=0.6072P
+ AD=0.3588P PS=3.64U PD=1.9U
* device instance $2041 r0 *1 58.08,153.91 pfet_03v3
M$2041 A|Y$331 \$2122 VDD VDD pfet_03v3 L=0.28U W=2.76U AS=0.7176P AD=1.4076P
+ PS=3.8U PD=6.18U
* device instance $2043 r0 *1 61.065,153.76 pfet_03v3
M$2043 VDD \$2124 \$2123 VDD pfet_03v3 L=1.03U W=1.08U AS=0.5292P AD=0.4752P
+ PS=3.14U PD=3.04U
* device instance $2044 r0 *1 63.44,153.91 pfet_03v3
M$2044 C|Y$34 A|Y$332 VDD VDD pfet_03v3 L=0.28U W=2.76U AS=0.966P AD=0.966P
+ PS=5.54U PD=5.54U
* device instance $2046 r0 *1 64.425,152 pfet_03v3
M$2046 VDD \$2077 \$2076 VDD pfet_03v3 L=1.03U W=1.08U AS=0.5292P AD=0.4752P
+ PS=3.14U PD=3.04U
* device instance $2047 r0 *1 67.225,153.765 pfet_03v3
M$2047 VDD \$2127 \$2126 VDD pfet_03v3 L=3.27U W=1.09U AS=0.5341P AD=0.4796P
+ PS=3.16U PD=3.06U
* device instance $2048 r0 *1 69.12,151.85 pfet_03v3
M$2048 Y$34 C|Y$33 VDD VDD pfet_03v3 L=0.28U W=2.76U AS=0.9798P AD=1.1592P
+ PS=5.56U PD=4.44U
* device instance $2050 r0 *1 71.36,151.85 pfet_03v3
M$2050 Y$34 A|B|Y$3 VDD VDD pfet_03v3 L=0.28U W=2.76U AS=1.1592P AD=0.7176P
+ PS=4.44U PD=3.8U
* device instance $2052 r0 *1 72.96,151.85 pfet_03v3
M$2052 Y$34 A|Y$330 VDD VDD pfet_03v3 L=0.28U W=2.76U AS=0.7176P AD=0.966P
+ PS=3.8U PD=5.54U
* device instance $2054 r0 *1 71.28,153.91 pfet_03v3
M$2054 C|Y$33 A|Y$330 VDD VDD pfet_03v3 L=0.28U W=2.76U AS=0.966P AD=0.966P
+ PS=5.54U PD=5.54U
* device instance $2056 r0 *1 75.065,153.765 pfet_03v3
M$2056 VDD \$2129 \$2128 VDD pfet_03v3 L=3.27U W=1.09U AS=0.5341P AD=0.4796P
+ PS=3.16U PD=3.06U
* device instance $2057 r0 *1 78.985,151.995 pfet_03v3
M$2057 VDD \$2084 \$2083 VDD pfet_03v3 L=7.75U W=1.09U AS=0.5341P AD=0.4796P
+ PS=3.16U PD=3.06U
* device instance $2058 r0 *1 78.56,153.91 pfet_03v3
M$2058 C|Y$35 A|Y$340 VDD VDD pfet_03v3 L=0.28U W=2.76U AS=0.966P AD=0.966P
+ PS=5.54U PD=5.54U
* device instance $2060 r0 *1 81.225,153.76 pfet_03v3
M$2060 VDD \$2132 \$2131 VDD pfet_03v3 L=1.03U W=1.08U AS=0.5292P AD=0.4752P
+ PS=3.14U PD=3.04U
* device instance $2061 r0 *1 83.04,153.91 pfet_03v3
M$2061 C|Y$36 A|Y$341 VDD VDD pfet_03v3 L=0.28U W=2.76U AS=0.966P AD=0.966P
+ PS=5.54U PD=5.54U
* device instance $2063 r0 *1 87.945,151.995 pfet_03v3
M$2063 VDD \$2086 \$2085 VDD pfet_03v3 L=7.75U W=1.09U AS=0.5341P AD=0.4796P
+ PS=3.16U PD=3.06U
* device instance $2064 r0 *1 86.96,153.91 pfet_03v3
M$2064 C|Y$41 A|Y$333 VDD VDD pfet_03v3 L=0.28U W=2.76U AS=0.966P AD=0.966P
+ PS=5.54U PD=5.54U
* device instance $2066 r0 *1 92.985,153.765 pfet_03v3
M$2066 VDD \$2135 \$2134 VDD pfet_03v3 L=7.75U W=1.09U AS=0.5341P AD=0.4796P
+ PS=3.16U PD=3.06U
* device instance $2067 r0 *1 96.905,151.995 pfet_03v3
M$2067 VDD \$2088 \$2087 VDD pfet_03v3 L=7.75U W=1.09U AS=0.5341P AD=0.4796P
+ PS=3.16U PD=3.06U
* device instance $2068 r0 *1 101.945,153.765 pfet_03v3
M$2068 VDD \$2137 \$2136 VDD pfet_03v3 L=7.75U W=1.09U AS=0.5341P AD=0.4796P
+ PS=3.16U PD=3.06U
* device instance $2069 r0 *1 102.505,152 pfet_03v3
M$2069 VDD \$2090 \$2089 VDD pfet_03v3 L=1.03U W=1.08U AS=0.5292P AD=0.4752P
+ PS=3.14U PD=3.04U
* device instance $2070 r0 *1 110.345,151.995 pfet_03v3
M$2070 VDD \$2092 \$2091 VDD pfet_03v3 L=7.75U W=1.09U AS=0.5341P AD=0.4796P
+ PS=3.16U PD=3.06U
* device instance $2071 r0 *1 110.905,153.765 pfet_03v3
M$2071 VDD \$2139 \$2138 VDD pfet_03v3 L=7.75U W=1.09U AS=0.5341P AD=0.4796P
+ PS=3.16U PD=3.06U
* device instance $2072 r0 *1 119.305,151.995 pfet_03v3
M$2072 VDD \$2094 \$2093 VDD pfet_03v3 L=7.75U W=1.09U AS=0.5341P AD=0.4796P
+ PS=3.16U PD=3.06U
* device instance $2073 r0 *1 119.865,153.765 pfet_03v3
M$2073 VDD \$2141 \$2140 VDD pfet_03v3 L=7.75U W=1.09U AS=0.5341P AD=0.4796P
+ PS=3.16U PD=3.06U
* device instance $2074 r0 *1 128.265,151.995 pfet_03v3
M$2074 VDD \$2096 \$2095 VDD pfet_03v3 L=7.75U W=1.09U AS=0.5341P AD=0.4796P
+ PS=3.16U PD=3.06U
* device instance $2075 r0 *1 129.945,153.765 pfet_03v3
M$2075 VDD \$2143 \$2142 VDD pfet_03v3 L=7.75U W=1.09U AS=0.5341P AD=0.4796P
+ PS=3.16U PD=3.06U
* device instance $2076 r0 *1 137.225,151.995 pfet_03v3
M$2076 VDD \$2098 \$2097 VDD pfet_03v3 L=7.75U W=1.09U AS=0.5341P AD=0.4796P
+ PS=3.16U PD=3.06U
* device instance $2077 r0 *1 138.905,153.765 pfet_03v3
M$2077 VDD \$2145 \$2144 VDD pfet_03v3 L=7.75U W=1.09U AS=0.5341P AD=0.4796P
+ PS=3.16U PD=3.06U
* device instance $2078 r0 *1 142.825,152 pfet_03v3
M$2078 VDD \$2100 \$2099 VDD pfet_03v3 L=1.03U W=1.08U AS=0.5292P AD=0.4752P
+ PS=3.14U PD=3.04U
* device instance $2079 r0 *1 147.865,153.765 pfet_03v3
M$2079 VDD \$2147 \$2146 VDD pfet_03v3 L=7.75U W=1.09U AS=0.5341P AD=0.4796P
+ PS=3.16U PD=3.06U
* device instance $2080 r0 *1 149.545,151.995 pfet_03v3
M$2080 VDD \$2102 \$2101 VDD pfet_03v3 L=7.75U W=1.09U AS=0.5341P AD=0.4796P
+ PS=3.16U PD=3.06U
* device instance $2081 r0 *1 156.825,153.765 pfet_03v3
M$2081 VDD \$2149 \$2148 VDD pfet_03v3 L=7.75U W=1.09U AS=0.5341P AD=0.4796P
+ PS=3.16U PD=3.06U
* device instance $2082 r0 *1 156.265,151.995 pfet_03v3
M$2082 VDD \$2104 \$2103 VDD pfet_03v3 L=3.27U W=1.09U AS=0.5341P AD=0.4796P
+ PS=3.16U PD=3.06U
* device instance $2083 r0 *1 159.625,152 pfet_03v3
M$2083 VDD \$2106 \$2105 VDD pfet_03v3 L=1.03U W=1.08U AS=0.5292P AD=0.4752P
+ PS=3.14U PD=3.04U
* device instance $2084 r0 *1 12.345,159.835 pfet_03v3
M$2084 VDD \$2158 \$2157 VDD pfet_03v3 L=7.75U W=1.09U AS=0.5341P AD=0.4796P
+ PS=3.16U PD=3.06U
* device instance $2085 r0 *1 21.305,159.835 pfet_03v3
M$2085 VDD \$2160 \$2159 VDD pfet_03v3 L=7.75U W=1.09U AS=0.5341P AD=0.4796P
+ PS=3.16U PD=3.06U
* device instance $2086 r0 *1 31.945,159.835 pfet_03v3
M$2086 VDD \$2162 \$2161 VDD pfet_03v3 L=7.75U W=1.09U AS=0.5341P AD=0.4796P
+ PS=3.16U PD=3.06U
* device instance $2087 r0 *1 40.905,159.835 pfet_03v3
M$2087 VDD \$2164 \$2163 VDD pfet_03v3 L=7.75U W=1.09U AS=0.5341P AD=0.4796P
+ PS=3.16U PD=3.06U
* device instance $2088 r0 *1 47.76,159.69 pfet_03v3
M$2088 C|Y$37 A|Y$331 VDD VDD pfet_03v3 L=0.28U W=2.76U AS=0.966P AD=0.966P
+ PS=5.54U PD=5.54U
* device instance $2090 r0 *1 50.32,159.69 pfet_03v3
M$2090 A|Y$338 \$2165 VDD VDD pfet_03v3 L=0.28U W=2.76U AS=1.4076P AD=0.7176P
+ PS=6.18U PD=3.8U
* device instance $2092 r0 *1 51.92,159.69 pfet_03v3
M$2092 \$2165 A|FINE_MUX[17] VDD VDD pfet_03v3 L=0.28U W=1.38U AS=0.3588P
+ AD=0.6072P PS=1.9U PD=3.64U
* device instance $2093 r0 *1 53.44,159.69 pfet_03v3
M$2093 Y$37 C|Y$38 VDD VDD pfet_03v3 L=0.28U W=2.76U AS=0.9798P AD=1.1592P
+ PS=5.56U PD=4.44U
* device instance $2095 r0 *1 55.68,159.69 pfet_03v3
M$2095 Y$37 A|B|Y$3 VDD VDD pfet_03v3 L=0.28U W=2.76U AS=1.1592P AD=0.7176P
+ PS=4.44U PD=3.8U
* device instance $2097 r0 *1 57.28,159.69 pfet_03v3
M$2097 Y$37 A|Y$339 VDD VDD pfet_03v3 L=0.28U W=2.76U AS=0.7176P AD=0.966P
+ PS=3.8U PD=5.54U
* device instance $2099 r0 *1 60.08,159.69 pfet_03v3
M$2099 Y$38 A|Y$332 VDD VDD pfet_03v3 L=0.28U W=2.76U AS=0.966P AD=0.7176P
+ PS=5.54U PD=3.8U
* device instance $2101 r0 *1 61.68,159.69 pfet_03v3
M$2101 Y$38 A|B|Y$3 VDD VDD pfet_03v3 L=0.28U W=2.76U AS=0.7176P AD=1.1592P
+ PS=3.8U PD=4.44U
* device instance $2103 r0 *1 63.92,159.69 pfet_03v3
M$2103 Y$38 C|Y$34 VDD VDD pfet_03v3 L=0.28U W=2.76U AS=1.1592P AD=0.9798P
+ PS=4.44U PD=5.56U
* device instance $2105 r0 *1 67.36,159.69 pfet_03v3
M$2105 C|Y$39 A|Y$334 VDD VDD pfet_03v3 L=0.28U W=2.76U AS=0.966P AD=0.966P
+ PS=5.54U PD=5.54U
* device instance $2107 r0 *1 69.6,159.69 pfet_03v3
M$2107 C|Y$40 A|Y$335 VDD VDD pfet_03v3 L=0.28U W=2.76U AS=0.966P AD=0.966P
+ PS=5.54U PD=5.54U
* device instance $2109 r0 *1 71.84,159.69 pfet_03v3
M$2109 VDD A|FINE_MUX[29] \$2177 VDD pfet_03v3 L=0.28U W=1.38U AS=0.6072P
+ AD=0.3588P PS=3.64U PD=1.9U
* device instance $2110 r0 *1 72.64,159.69 pfet_03v3
M$2110 A|Y$330 \$2177 VDD VDD pfet_03v3 L=0.28U W=2.76U AS=0.7176P AD=1.4076P
+ PS=3.8U PD=6.18U
* device instance $2112 r0 *1 76.32,159.69 pfet_03v3
M$2112 VDD A|FINE_MUX[2] \$2179 VDD pfet_03v3 L=0.28U W=1.38U AS=0.6072P
+ AD=0.3588P PS=3.64U PD=1.9U
* device instance $2113 r0 *1 77.12,159.69 pfet_03v3
M$2113 A|Y$322 \$2179 VDD VDD pfet_03v3 L=0.28U W=2.76U AS=0.7176P AD=1.4076P
+ PS=3.8U PD=6.18U
* device instance $2115 r0 *1 80.24,159.69 pfet_03v3
M$2115 Y$39 A|Y$333 VDD VDD pfet_03v3 L=0.28U W=2.76U AS=0.966P AD=0.7176P
+ PS=5.54U PD=3.8U
* device instance $2117 r0 *1 81.84,159.69 pfet_03v3
M$2117 Y$39 A|B|Y$3 VDD VDD pfet_03v3 L=0.28U W=2.76U AS=0.7176P AD=1.1592P
+ PS=3.8U PD=4.44U
* device instance $2119 r0 *1 84.08,159.69 pfet_03v3
M$2119 Y$39 C|Y$41 VDD VDD pfet_03v3 L=0.28U W=2.76U AS=1.1592P AD=0.9798P
+ PS=4.44U PD=5.56U
* device instance $2121 r0 *1 86.4,159.69 pfet_03v3
M$2121 Y$40 A|Y$336 VDD VDD pfet_03v3 L=0.28U W=2.76U AS=0.966P AD=0.7176P
+ PS=5.54U PD=3.8U
* device instance $2123 r0 *1 88,159.69 pfet_03v3
M$2123 Y$40 A|B|Y$3 VDD VDD pfet_03v3 L=0.28U W=2.76U AS=0.7176P AD=1.1592P
+ PS=3.8U PD=4.44U
* device instance $2125 r0 *1 90.24,159.69 pfet_03v3
M$2125 Y$40 C|Y$42 VDD VDD pfet_03v3 L=0.28U W=2.76U AS=1.1592P AD=0.9798P
+ PS=4.44U PD=5.56U
* device instance $2127 r0 *1 96.345,159.835 pfet_03v3
M$2127 VDD \$2189 \$2188 VDD pfet_03v3 L=7.75U W=1.09U AS=0.5341P AD=0.4796P
+ PS=3.16U PD=3.06U
* device instance $2128 r0 *1 110.345,159.835 pfet_03v3
M$2128 VDD \$2193 \$2192 VDD pfet_03v3 L=7.75U W=1.09U AS=0.5341P AD=0.4796P
+ PS=3.16U PD=3.06U
* device instance $2129 r0 *1 119.305,159.835 pfet_03v3
M$2129 VDD \$2195 \$2194 VDD pfet_03v3 L=7.75U W=1.09U AS=0.5341P AD=0.4796P
+ PS=3.16U PD=3.06U
* device instance $2130 r0 *1 128.265,159.835 pfet_03v3
M$2130 VDD \$2197 \$2196 VDD pfet_03v3 L=7.75U W=1.09U AS=0.5341P AD=0.4796P
+ PS=3.16U PD=3.06U
* device instance $2131 r0 *1 137.225,159.835 pfet_03v3
M$2131 VDD \$2199 \$2198 VDD pfet_03v3 L=7.75U W=1.09U AS=0.5341P AD=0.4796P
+ PS=3.16U PD=3.06U
* device instance $2132 r0 *1 149.545,159.835 pfet_03v3
M$2132 VDD \$2203 \$2202 VDD pfet_03v3 L=7.75U W=1.09U AS=0.5341P AD=0.4796P
+ PS=3.16U PD=3.06U
* device instance $2133 r0 *1 156.265,159.835 pfet_03v3
M$2133 VDD \$2205 \$2204 VDD pfet_03v3 L=3.27U W=1.09U AS=0.5341P AD=0.4796P
+ PS=3.16U PD=3.06U
* device instance $2134 r0 *1 12.345,161.605 pfet_03v3
M$2134 VDD \$2226 \$2212 VDD pfet_03v3 L=7.75U W=1.09U AS=0.5341P AD=0.4796P
+ PS=3.16U PD=3.06U
* device instance $2135 r0 *1 21.305,161.605 pfet_03v3
M$2135 VDD \$2227 \$2213 VDD pfet_03v3 L=7.75U W=1.09U AS=0.5341P AD=0.4796P
+ PS=3.16U PD=3.06U
* device instance $2136 r0 *1 30.265,161.605 pfet_03v3
M$2136 VDD \$2228 \$2214 VDD pfet_03v3 L=7.75U W=1.09U AS=0.5341P AD=0.4796P
+ PS=3.16U PD=3.06U
* device instance $2137 r0 *1 36.985,161.605 pfet_03v3
M$2137 VDD \$2229 \$2215 VDD pfet_03v3 L=3.27U W=1.09U AS=0.5341P AD=0.4796P
+ PS=3.16U PD=3.06U
* device instance $2138 r0 *1 40.345,161.6 pfet_03v3
M$2138 VDD \$2230 \$2216 VDD pfet_03v3 L=1.03U W=1.08U AS=0.5292P AD=0.4752P
+ PS=3.14U PD=3.04U
* device instance $2139 r0 *1 42.16,161.75 pfet_03v3
M$2139 C|Y$43 A|Y$337 VDD VDD pfet_03v3 L=0.28U W=2.76U AS=0.966P AD=0.966P
+ PS=5.54U PD=5.54U
* device instance $2141 r0 *1 44.4,161.75 pfet_03v3
M$2141 C|Y$44 A|Y$338 VDD VDD pfet_03v3 L=0.28U W=2.76U AS=0.966P AD=0.966P
+ PS=5.54U PD=5.54U
* device instance $2143 r0 *1 49.44,161.75 pfet_03v3
M$2143 Y$41 A|Y$338 VDD VDD pfet_03v3 L=0.28U W=2.76U AS=0.966P AD=0.7176P
+ PS=5.54U PD=3.8U
* device instance $2145 r0 *1 51.04,161.75 pfet_03v3
M$2145 Y$41 A|B|Y$3 VDD VDD pfet_03v3 L=0.28U W=2.76U AS=0.7176P AD=1.1592P
+ PS=3.8U PD=4.44U
* device instance $2147 r0 *1 53.28,161.75 pfet_03v3
M$2147 Y$41 C|Y$44 VDD VDD pfet_03v3 L=0.28U W=2.76U AS=1.1592P AD=0.9798P
+ PS=4.44U PD=5.56U
* device instance $2149 r0 *1 55.6,161.75 pfet_03v3
M$2149 C|Y$38 A|Y$339 VDD VDD pfet_03v3 L=0.28U W=2.76U AS=0.966P AD=0.966P
+ PS=5.54U PD=5.54U
* device instance $2151 r0 *1 57.84,161.75 pfet_03v3
M$2151 VDD A|FINE_MUX[27] \$2237 VDD pfet_03v3 L=0.28U W=1.38U AS=0.6072P
+ AD=0.3588P PS=3.64U PD=1.9U
* device instance $2152 r0 *1 58.64,161.75 pfet_03v3
M$2152 A|Y$339 \$2237 VDD VDD pfet_03v3 L=0.28U W=2.76U AS=0.7176P AD=1.4076P
+ PS=3.8U PD=6.18U
* device instance $2154 r0 *1 61.2,161.75 pfet_03v3
M$2154 Y$42 A|Y$334 VDD VDD pfet_03v3 L=0.28U W=2.76U AS=0.966P AD=0.7176P
+ PS=5.54U PD=3.8U
* device instance $2156 r0 *1 62.8,161.75 pfet_03v3
M$2156 Y$42 A|B|Y$3 VDD VDD pfet_03v3 L=0.28U W=2.76U AS=0.7176P AD=1.1592P
+ PS=3.8U PD=4.44U
* device instance $2158 r0 *1 65.04,161.75 pfet_03v3
M$2158 Y$42 C|Y$39 VDD VDD pfet_03v3 L=0.28U W=2.76U AS=1.1592P AD=0.9798P
+ PS=4.44U PD=5.56U
* device instance $2160 r0 *1 67.36,161.75 pfet_03v3
M$2160 Y$43 A|Y$335 VDD VDD pfet_03v3 L=0.28U W=2.76U AS=0.966P AD=0.7176P
+ PS=5.54U PD=3.8U
* device instance $2162 r0 *1 68.96,161.75 pfet_03v3
M$2162 Y$43 A|B|Y$3 VDD VDD pfet_03v3 L=0.28U W=2.76U AS=0.7176P AD=1.1592P
+ PS=3.8U PD=4.44U
* device instance $2164 r0 *1 71.2,161.75 pfet_03v3
M$2164 Y$43 C|Y$40 VDD VDD pfet_03v3 L=0.28U W=2.76U AS=1.1592P AD=0.9798P
+ PS=4.44U PD=5.56U
* device instance $2166 r0 *1 73.52,161.75 pfet_03v3
M$2166 Y$44 A|Y$340 VDD VDD pfet_03v3 L=0.28U W=2.76U AS=0.966P AD=0.7176P
+ PS=5.54U PD=3.8U
* device instance $2168 r0 *1 75.12,161.75 pfet_03v3
M$2168 Y$44 A|B|Y$3 VDD VDD pfet_03v3 L=0.28U W=2.76U AS=0.7176P AD=1.1592P
+ PS=3.8U PD=4.44U
* device instance $2170 r0 *1 77.36,161.75 pfet_03v3
M$2170 Y$44 C|Y$35 VDD VDD pfet_03v3 L=0.28U W=2.76U AS=1.1592P AD=0.9798P
+ PS=4.44U PD=5.56U
* device instance $2172 r0 *1 79.68,161.75 pfet_03v3
M$2172 Y$45 A|Y$341 VDD VDD pfet_03v3 L=0.28U W=2.76U AS=0.966P AD=0.7176P
+ PS=5.54U PD=3.8U
* device instance $2174 r0 *1 81.28,161.75 pfet_03v3
M$2174 Y$45 A|B|Y$3 VDD VDD pfet_03v3 L=0.28U W=2.76U AS=0.7176P AD=1.1592P
+ PS=3.8U PD=4.44U
* device instance $2176 r0 *1 83.52,161.75 pfet_03v3
M$2176 Y$45 C|Y$36 VDD VDD pfet_03v3 L=0.28U W=2.76U AS=1.1592P AD=0.9798P
+ PS=4.44U PD=5.56U
* device instance $2178 r0 *1 87.52,161.75 pfet_03v3
M$2178 Y$46 A|Y$342 VDD VDD pfet_03v3 L=0.28U W=2.76U AS=0.966P AD=0.7176P
+ PS=5.54U PD=3.8U
* device instance $2180 r0 *1 89.12,161.75 pfet_03v3
M$2180 Y$46 A|B|Y$3 VDD VDD pfet_03v3 L=0.28U W=2.76U AS=0.7176P AD=1.1592P
+ PS=3.8U PD=4.44U
* device instance $2182 r0 *1 91.36,161.75 pfet_03v3
M$2182 Y$46 C|Y$45 VDD VDD pfet_03v3 L=0.28U W=2.76U AS=1.1592P AD=0.9798P
+ PS=4.44U PD=5.56U
* device instance $2184 r0 *1 93.68,161.75 pfet_03v3
M$2184 C|Y$42 A|Y$336 VDD VDD pfet_03v3 L=0.28U W=2.76U AS=0.966P AD=0.966P
+ PS=5.54U PD=5.54U
* device instance $2186 r0 *1 99.705,161.605 pfet_03v3
M$2186 VDD \$2248 \$2217 VDD pfet_03v3 L=7.75U W=1.09U AS=0.5341P AD=0.4796P
+ PS=3.16U PD=3.06U
* device instance $2187 r0 *1 101.945,159.84 pfet_03v3
M$2187 VDD \$2191 \$2190 VDD pfet_03v3 L=1.03U W=1.08U AS=0.5292P AD=0.4752P
+ PS=3.14U PD=3.04U
* device instance $2188 r0 *1 108.665,161.605 pfet_03v3
M$2188 VDD \$2249 \$2218 VDD pfet_03v3 L=7.75U W=1.09U AS=0.5341P AD=0.4796P
+ PS=3.16U PD=3.06U
* device instance $2189 r0 *1 117.625,161.605 pfet_03v3
M$2189 VDD \$2250 \$2219 VDD pfet_03v3 L=7.75U W=1.09U AS=0.5341P AD=0.4796P
+ PS=3.16U PD=3.06U
* device instance $2190 r0 *1 123.225,161.6 pfet_03v3
M$2190 VDD \$2251 \$2220 VDD pfet_03v3 L=1.03U W=1.08U AS=0.5292P AD=0.4752P
+ PS=3.14U PD=3.04U
* device instance $2191 r0 *1 129.945,161.605 pfet_03v3
M$2191 VDD \$2252 \$2221 VDD pfet_03v3 L=7.75U W=1.09U AS=0.5341P AD=0.4796P
+ PS=3.16U PD=3.06U
* device instance $2192 r0 *1 138.905,161.605 pfet_03v3
M$2192 VDD \$2253 \$2222 VDD pfet_03v3 L=7.75U W=1.09U AS=0.5341P AD=0.4796P
+ PS=3.16U PD=3.06U
* device instance $2193 r0 *1 142.825,159.84 pfet_03v3
M$2193 VDD \$2201 \$2200 VDD pfet_03v3 L=1.03U W=1.08U AS=0.5292P AD=0.4752P
+ PS=3.14U PD=3.04U
* device instance $2194 r0 *1 147.865,161.605 pfet_03v3
M$2194 VDD \$2254 \$2223 VDD pfet_03v3 L=7.75U W=1.09U AS=0.5341P AD=0.4796P
+ PS=3.16U PD=3.06U
* device instance $2195 r0 *1 156.825,161.605 pfet_03v3
M$2195 VDD \$2255 \$2224 VDD pfet_03v3 L=7.75U W=1.09U AS=0.5341P AD=0.4796P
+ PS=3.16U PD=3.06U
* device instance $2196 r0 *1 159.625,159.84 pfet_03v3
M$2196 VDD \$2207 \$2206 VDD pfet_03v3 L=1.03U W=1.08U AS=0.5292P AD=0.4752P
+ PS=3.14U PD=3.04U
* device instance $2197 r0 *1 12.345,167.675 pfet_03v3
M$2197 VDD \$2273 \$2272 VDD pfet_03v3 L=7.75U W=1.09U AS=0.5341P AD=0.4796P
+ PS=3.16U PD=3.06U
* device instance $2198 r0 *1 21.305,167.675 pfet_03v3
M$2198 VDD \$2275 \$2274 VDD pfet_03v3 L=7.75U W=1.09U AS=0.5341P AD=0.4796P
+ PS=3.16U PD=3.06U
* device instance $2199 r0 *1 31.385,167.675 pfet_03v3
M$2199 VDD \$2277 \$2276 VDD pfet_03v3 L=7.75U W=1.09U AS=0.5341P AD=0.4796P
+ PS=3.16U PD=3.06U
* device instance $2200 r0 *1 38.105,167.675 pfet_03v3
M$2200 VDD \$2279 \$2278 VDD pfet_03v3 L=3.27U W=1.09U AS=0.5341P AD=0.4796P
+ PS=3.16U PD=3.06U
* device instance $2201 r0 *1 42.48,167.53 pfet_03v3
M$2201 A|Y$337 \$2280 VDD VDD pfet_03v3 L=0.28U W=2.76U AS=1.4076P AD=0.7176P
+ PS=6.18U PD=3.8U
* device instance $2203 r0 *1 44.08,167.53 pfet_03v3
M$2203 \$2280 A|FINE_MUX[23] VDD VDD pfet_03v3 L=0.28U W=1.38U AS=0.3588P
+ AD=0.6072P PS=1.9U PD=3.64U
* device instance $2204 r0 *1 47.76,167.53 pfet_03v3
M$2204 Y$47 A|Y$337 VDD VDD pfet_03v3 L=0.28U W=2.76U AS=0.966P AD=0.7176P
+ PS=5.54U PD=3.8U
* device instance $2206 r0 *1 49.36,167.53 pfet_03v3
M$2206 Y$47 A|B|Y$3 VDD VDD pfet_03v3 L=0.28U W=2.76U AS=0.7176P AD=1.1592P
+ PS=3.8U PD=4.44U
* device instance $2208 r0 *1 51.6,167.53 pfet_03v3
M$2208 Y$47 C|Y$43 VDD VDD pfet_03v3 L=0.28U W=2.76U AS=1.1592P AD=0.9798P
+ PS=4.44U PD=5.56U
* device instance $2210 r0 *1 54.8,167.53 pfet_03v3
M$2210 A|Y$332 \$2282 VDD VDD pfet_03v3 L=0.28U W=2.76U AS=1.4076P AD=0.7176P
+ PS=6.18U PD=3.8U
* device instance $2212 r0 *1 56.4,167.53 pfet_03v3
M$2212 \$2282 A|FINE_MUX[30] VDD VDD pfet_03v3 L=0.28U W=1.38U AS=0.3588P
+ AD=0.6072P PS=1.9U PD=3.64U
* device instance $2213 r0 *1 58.16,167.53 pfet_03v3
M$2213 A|Y$334 \$2284 VDD VDD pfet_03v3 L=0.28U W=2.76U AS=1.4076P AD=0.7176P
+ PS=6.18U PD=3.8U
* device instance $2215 r0 *1 59.76,167.53 pfet_03v3
M$2215 \$2284 A|FINE_MUX[6] VDD VDD pfet_03v3 L=0.28U W=1.38U AS=0.3588P
+ AD=0.6072P PS=1.9U PD=3.64U
* device instance $2216 r0 *1 61.52,167.53 pfet_03v3
M$2216 A|Y$335 \$2286 VDD VDD pfet_03v3 L=0.28U W=2.76U AS=1.4076P AD=0.7176P
+ PS=6.18U PD=3.8U
* device instance $2218 r0 *1 63.12,167.53 pfet_03v3
M$2218 \$2286 A|FINE_MUX[13] VDD VDD pfet_03v3 L=0.28U W=1.38U AS=0.3588P
+ AD=0.6072P PS=1.9U PD=3.64U
* device instance $2219 r0 *1 67.12,167.53 pfet_03v3
M$2219 A|Y$321 \$2288 VDD VDD pfet_03v3 L=0.28U W=2.76U AS=1.4076P AD=0.7176P
+ PS=6.18U PD=3.8U
* device instance $2221 r0 *1 68.72,167.53 pfet_03v3
M$2221 \$2288 A|FINE_MUX[12] VDD VDD pfet_03v3 L=0.28U W=1.38U AS=0.3588P
+ AD=0.6072P PS=1.9U PD=3.64U
* device instance $2222 r0 *1 70.48,167.53 pfet_03v3
M$2222 A|Y$340 \$2290 VDD VDD pfet_03v3 L=0.28U W=2.76U AS=1.4076P AD=0.7176P
+ PS=6.18U PD=3.8U
* device instance $2224 r0 *1 72.08,167.53 pfet_03v3
M$2224 \$2290 A|FINE_MUX[14] VDD VDD pfet_03v3 L=0.28U W=1.38U AS=0.3588P
+ AD=0.6072P PS=1.9U PD=3.64U
* device instance $2225 r0 *1 73.84,167.53 pfet_03v3
M$2225 A|Y$341 \$2292 VDD VDD pfet_03v3 L=0.28U W=2.76U AS=1.4076P AD=0.7176P
+ PS=6.18U PD=3.8U
* device instance $2227 r0 *1 75.44,167.53 pfet_03v3
M$2227 \$2292 A|FINE_MUX[16] VDD VDD pfet_03v3 L=0.28U W=1.38U AS=0.3588P
+ AD=0.6072P PS=1.9U PD=3.64U
* device instance $2228 r0 *1 77.2,167.53 pfet_03v3
M$2228 A|Y$333 \$2294 VDD VDD pfet_03v3 L=0.28U W=2.76U AS=1.4076P AD=0.7176P
+ PS=6.18U PD=3.8U
* device instance $2230 r0 *1 78.8,167.53 pfet_03v3
M$2230 \$2294 A|FINE_MUX[21] VDD VDD pfet_03v3 L=0.28U W=1.38U AS=0.3588P
+ AD=0.6072P PS=1.9U PD=3.64U
* device instance $2231 r0 *1 80.56,167.53 pfet_03v3
M$2231 A|Y$336 \$2296 VDD VDD pfet_03v3 L=0.28U W=2.76U AS=1.4076P AD=0.7176P
+ PS=6.18U PD=3.8U
* device instance $2233 r0 *1 82.16,167.53 pfet_03v3
M$2233 \$2296 A|FINE_MUX[11] VDD VDD pfet_03v3 L=0.28U W=1.38U AS=0.3588P
+ AD=0.6072P PS=1.9U PD=3.64U
* device instance $2234 r0 *1 84.72,167.53 pfet_03v3
M$2234 VDD A|FINE_MUX[5] \$2270 VDD pfet_03v3 L=0.28U W=1.38U AS=0.6072P
+ AD=0.3588P PS=3.64U PD=1.9U
* device instance $2235 r0 *1 85.52,167.53 pfet_03v3
M$2235 A|Y$342 \$2270 VDD VDD pfet_03v3 L=0.28U W=2.76U AS=0.7176P AD=1.4076P
+ PS=3.8U PD=6.18U
* device instance $2237 r0 *1 89.2,167.53 pfet_03v3
M$2237 C|Y$45 A|Y$342 VDD VDD pfet_03v3 L=0.28U W=2.76U AS=0.966P AD=0.966P
+ PS=5.54U PD=5.54U
* device instance $2239 r0 *1 95.225,167.675 pfet_03v3
M$2239 VDD \$2300 \$2299 VDD pfet_03v3 L=7.75U W=1.09U AS=0.5341P AD=0.4796P
+ PS=3.16U PD=3.06U
* device instance $2240 r0 *1 100.825,167.68 pfet_03v3
M$2240 VDD \$2271 \$2301 VDD pfet_03v3 L=1.03U W=1.08U AS=0.5292P AD=0.4752P
+ PS=3.14U PD=3.04U
* device instance $2241 r0 *1 107.545,167.675 pfet_03v3
M$2241 VDD \$2303 \$2302 VDD pfet_03v3 L=7.75U W=1.09U AS=0.5341P AD=0.4796P
+ PS=3.16U PD=3.06U
* device instance $2242 r0 *1 116.505,167.675 pfet_03v3
M$2242 VDD \$2305 \$2304 VDD pfet_03v3 L=7.75U W=1.09U AS=0.5341P AD=0.4796P
+ PS=3.16U PD=3.06U
* device instance $2243 r0 *1 126.585,167.675 pfet_03v3
M$2243 VDD \$2307 \$2306 VDD pfet_03v3 L=7.75U W=1.09U AS=0.5341P AD=0.4796P
+ PS=3.16U PD=3.06U
* device instance $2244 r0 *1 135.545,167.675 pfet_03v3
M$2244 VDD \$2309 \$2308 VDD pfet_03v3 L=7.75U W=1.09U AS=0.5341P AD=0.4796P
+ PS=3.16U PD=3.06U
* device instance $2245 r0 *1 145.625,167.675 pfet_03v3
M$2245 VDD \$2311 \$2310 VDD pfet_03v3 L=7.75U W=1.09U AS=0.5341P AD=0.4796P
+ PS=3.16U PD=3.06U
* device instance $2246 r0 *1 154.585,167.675 pfet_03v3
M$2246 VDD \$2313 \$2312 VDD pfet_03v3 L=7.75U W=1.09U AS=0.5341P AD=0.4796P
+ PS=3.16U PD=3.06U
* device instance $2247 r0 *1 12.345,16.515 nfet_03v3
M$2247 \$31 \$30 VSS VSS nfet_03v3 L=7.75U W=0.99U AS=0.4851P AD=0.4356P
+ PS=2.96U PD=2.86U
* device instance $2248 r0 *1 21.305,16.515 nfet_03v3
M$2248 \$33 \$32 VSS VSS nfet_03v3 L=7.75U W=0.99U AS=0.4851P AD=0.4356P
+ PS=2.96U PD=2.86U
* device instance $2249 r0 *1 31.385,16.515 nfet_03v3
M$2249 \$35 \$34 VSS VSS nfet_03v3 L=7.75U W=0.99U AS=0.4851P AD=0.4356P
+ PS=2.96U PD=2.86U
* device instance $2250 r0 *1 40.345,16.515 nfet_03v3
M$2250 \$37 \$36 VSS VSS nfet_03v3 L=7.75U W=0.99U AS=0.4851P AD=0.4356P
+ PS=2.96U PD=2.86U
* device instance $2251 r0 *1 50.425,16.515 nfet_03v3
M$2251 \$39 \$38 VSS VSS nfet_03v3 L=7.75U W=0.99U AS=0.4851P AD=0.4356P
+ PS=2.96U PD=2.86U
* device instance $2252 r0 *1 59.385,16.515 nfet_03v3
M$2252 \$41 \$40 VSS VSS nfet_03v3 L=7.75U W=0.99U AS=0.4851P AD=0.4356P
+ PS=2.96U PD=2.86U
* device instance $2253 r0 *1 69.465,16.515 nfet_03v3
M$2253 \$43 \$42 VSS VSS nfet_03v3 L=7.75U W=0.99U AS=0.4851P AD=0.4356P
+ PS=2.96U PD=2.86U
* device instance $2254 r0 *1 78.425,16.515 nfet_03v3
M$2254 \$45 \$44 VSS VSS nfet_03v3 L=7.75U W=0.99U AS=0.4851P AD=0.4356P
+ PS=2.96U PD=2.86U
* device instance $2255 r0 *1 85.145,16.52 nfet_03v3
M$2255 \$11 \$46 VSS VSS nfet_03v3 L=1.03U W=1U AS=0.49P AD=0.44P PS=2.98U
+ PD=2.88U
* device instance $2256 r0 *1 87.28,16.52 nfet_03v3
M$2256 A|Y \$47 VSS VSS nfet_03v3 L=0.28U W=2U AS=1.02P AD=0.52P PS=5.04U
+ PD=3.04U
* device instance $2258 r0 *1 88.88,16.52 nfet_03v3
M$2258 \$47 A|MID_MUX[6] VSS VSS nfet_03v3 L=0.28U W=1U AS=0.26P AD=0.44P
+ PS=1.52U PD=2.88U
* device instance $2259 r0 *1 90.64,16.52 nfet_03v3
M$2259 A|Y$7 \$49 VSS VSS nfet_03v3 L=0.28U W=2U AS=1.02P AD=0.52P PS=5.04U
+ PD=3.04U
* device instance $2261 r0 *1 92.24,16.52 nfet_03v3
M$2261 \$49 A|MID_MUX[14] VSS VSS nfet_03v3 L=0.28U W=1U AS=0.26P AD=0.44P
+ PS=1.52U PD=2.88U
* device instance $2262 r0 *1 93.68,16.52 nfet_03v3
M$2262 VSS A|Y \$13 VSS nfet_03v3 L=0.28U W=2U AS=0.7P AD=0.52P PS=4.4U PD=3.04U
* device instance $2264 r0 *1 95.28,16.52 nfet_03v3
M$2264 \$14 A|B|Y \$13 VSS nfet_03v3 L=0.28U W=2U AS=0.52P AD=0.7P PS=3.04U
+ PD=4.4U
* device instance $2266 r0 *1 97.52,16.52 nfet_03v3
M$2266 Y C|Y \$14 VSS nfet_03v3 L=0.28U W=2U AS=0.7P AD=0.71P PS=4.4U PD=4.42U
* device instance $2268 r0 *1 100.265,16.52 nfet_03v3
M$2268 \$15 \$52 VSS VSS nfet_03v3 L=1.03U W=1U AS=0.49P AD=0.44P PS=2.98U
+ PD=2.88U
* device instance $2269 r0 *1 103.76,16.52 nfet_03v3
M$2269 VSS A|MID_MUX[8] \$16 VSS nfet_03v3 L=0.28U W=1U AS=0.44P AD=0.26P
+ PS=2.88U PD=1.52U
* device instance $2270 r0 *1 104.56,16.52 nfet_03v3
M$2270 A|Y$14 \$16 VSS VSS nfet_03v3 L=0.28U W=2U AS=0.52P AD=1.02P PS=3.04U
+ PD=5.04U
* device instance $2272 r0 *1 107.12,16.52 nfet_03v3
M$2272 VSS A|MID_MUX[11] \$17 VSS nfet_03v3 L=0.28U W=1U AS=0.44P AD=0.26P
+ PS=2.88U PD=1.52U
* device instance $2273 r0 *1 107.92,16.52 nfet_03v3
M$2273 A|Y$8 \$17 VSS VSS nfet_03v3 L=0.28U W=2U AS=0.52P AD=1.02P PS=3.04U
+ PD=5.04U
* device instance $2275 r0 *1 114.265,16.515 nfet_03v3
M$2275 \$54 \$53 VSS VSS nfet_03v3 L=7.75U W=0.99U AS=0.4851P AD=0.4356P
+ PS=2.96U PD=2.86U
* device instance $2276 r0 *1 119.865,16.52 nfet_03v3
M$2276 \$18 \$55 VSS VSS nfet_03v3 L=1.03U W=1U AS=0.49P AD=0.44P PS=2.98U
+ PD=2.88U
* device instance $2277 r0 *1 122.8,16.52 nfet_03v3
M$2277 VSS A|COARSE_MUX[14] \$19 VSS nfet_03v3 L=0.28U W=1U AS=0.44P AD=0.26P
+ PS=2.88U PD=1.52U
* device instance $2278 r0 *1 123.6,16.52 nfet_03v3
M$2278 A|Y$1 \$19 VSS VSS nfet_03v3 L=0.28U W=2U AS=0.52P AD=1.02P PS=3.04U
+ PD=5.04U
* device instance $2280 r0 *1 126.16,16.52 nfet_03v3
M$2280 VSS A|COARSE_MUX[13] \$21 VSS nfet_03v3 L=0.28U W=1U AS=0.44P AD=0.26P
+ PS=2.88U PD=1.52U
* device instance $2281 r0 *1 126.96,16.52 nfet_03v3
M$2281 A|Y$2 \$21 VSS VSS nfet_03v3 L=0.28U W=2U AS=0.52P AD=1.02P PS=3.04U
+ PD=5.04U
* device instance $2283 r0 *1 129.52,16.52 nfet_03v3
M$2283 VSS A|COARSE_MUX[12] \$23 VSS nfet_03v3 L=0.28U W=1U AS=0.44P AD=0.26P
+ PS=2.88U PD=1.52U
* device instance $2284 r0 *1 130.32,16.52 nfet_03v3
M$2284 A|Y$3 \$23 VSS VSS nfet_03v3 L=0.28U W=2U AS=0.52P AD=1.02P PS=3.04U
+ PD=5.04U
* device instance $2286 r0 *1 133.44,16.52 nfet_03v3
M$2286 VSS A|COARSE_MUX[11] \$25 VSS nfet_03v3 L=0.28U W=1U AS=0.44P AD=0.26P
+ PS=2.88U PD=1.52U
* device instance $2287 r0 *1 134.24,16.52 nfet_03v3
M$2287 A|Y$4 \$25 VSS VSS nfet_03v3 L=0.28U W=2U AS=0.52P AD=1.02P PS=3.04U
+ PD=5.04U
* device instance $2289 r0 *1 136.8,16.52 nfet_03v3
M$2289 VSS A|COARSE_MUX[10] \$27 VSS nfet_03v3 L=0.28U W=1U AS=0.44P AD=0.26P
+ PS=2.88U PD=1.52U
* device instance $2290 r0 *1 137.6,16.52 nfet_03v3
M$2290 A|Y$5 \$27 VSS VSS nfet_03v3 L=0.28U W=2U AS=0.52P AD=1.02P PS=3.04U
+ PD=5.04U
* device instance $2292 r0 *1 145.625,16.515 nfet_03v3
M$2292 \$57 \$56 VSS VSS nfet_03v3 L=7.75U W=0.99U AS=0.4851P AD=0.4356P
+ PS=2.96U PD=2.86U
* device instance $2293 r0 *1 154.585,16.515 nfet_03v3
M$2293 \$59 \$58 VSS VSS nfet_03v3 L=7.75U W=0.99U AS=0.4851P AD=0.4356P
+ PS=2.96U PD=2.86U
* device instance $2294 r0 *1 12.345,22.685 nfet_03v3
M$2294 \$84 \$61 VSS VSS nfet_03v3 L=7.75U W=0.99U AS=0.4851P AD=0.4356P
+ PS=2.96U PD=2.86U
* device instance $2295 r0 *1 21.305,22.685 nfet_03v3
M$2295 \$85 \$62 VSS VSS nfet_03v3 L=7.75U W=0.99U AS=0.4851P AD=0.4356P
+ PS=2.96U PD=2.86U
* device instance $2296 r0 *1 30.265,22.685 nfet_03v3
M$2296 \$86 \$63 VSS VSS nfet_03v3 L=7.75U W=0.99U AS=0.4851P AD=0.4356P
+ PS=2.96U PD=2.86U
* device instance $2297 r0 *1 39.225,22.685 nfet_03v3
M$2297 \$87 \$64 VSS VSS nfet_03v3 L=7.75U W=0.99U AS=0.4851P AD=0.4356P
+ PS=2.96U PD=2.86U
* device instance $2298 r0 *1 44.825,22.68 nfet_03v3
M$2298 \$88 \$65 VSS VSS nfet_03v3 L=1.03U W=1U AS=0.49P AD=0.44P PS=2.98U
+ PD=2.88U
* device instance $2299 r0 *1 51.545,22.685 nfet_03v3
M$2299 \$89 \$66 VSS VSS nfet_03v3 L=7.75U W=0.99U AS=0.4851P AD=0.4356P
+ PS=2.96U PD=2.86U
* device instance $2300 r0 *1 60.505,22.685 nfet_03v3
M$2300 \$90 \$67 VSS VSS nfet_03v3 L=7.75U W=0.99U AS=0.4851P AD=0.4356P
+ PS=2.96U PD=2.86U
* device instance $2301 r0 *1 69.465,22.685 nfet_03v3
M$2301 \$91 \$68 VSS VSS nfet_03v3 L=7.75U W=0.99U AS=0.4851P AD=0.4356P
+ PS=2.96U PD=2.86U
* device instance $2302 r0 *1 78.425,22.685 nfet_03v3
M$2302 \$92 \$69 VSS VSS nfet_03v3 L=7.75U W=0.99U AS=0.4851P AD=0.4356P
+ PS=2.96U PD=2.86U
* device instance $2303 r0 *1 84.025,22.68 nfet_03v3
M$2303 \$93 \$70 VSS VSS nfet_03v3 L=1.03U W=1U AS=0.49P AD=0.44P PS=2.98U
+ PD=2.88U
* device instance $2304 r0 *1 87.385,22.68 nfet_03v3
M$2304 \$94 \$71 VSS VSS nfet_03v3 L=1.03U W=1U AS=0.49P AD=0.44P PS=2.98U
+ PD=2.88U
* device instance $2305 r0 *1 90.32,22.68 nfet_03v3
M$2305 C|Y$1 A|Y$7 VSS VSS nfet_03v3 L=0.28U W=2U AS=0.7P AD=0.7P PS=4.4U
+ PD=4.4U
* device instance $2307 r0 *1 92.56,22.68 nfet_03v3
M$2307 VSS A|Y$7 \$110 VSS nfet_03v3 L=0.28U W=2U AS=0.7P AD=0.52P PS=4.4U
+ PD=3.04U
* device instance $2309 r0 *1 94.16,22.68 nfet_03v3
M$2309 \$111 A|B|Y \$110 VSS nfet_03v3 L=0.28U W=2U AS=0.52P AD=0.7P PS=3.04U
+ PD=4.4U
* device instance $2311 r0 *1 96.4,22.68 nfet_03v3
M$2311 Y$1 C|Y$1 \$111 VSS nfet_03v3 L=0.28U W=2U AS=0.7P AD=0.71P PS=4.4U
+ PD=4.42U
* device instance $2313 r0 *1 99.36,22.68 nfet_03v3
M$2313 Y$2 C|Y$2 \$112 VSS nfet_03v3 L=0.28U W=2U AS=0.71P AD=0.7P PS=4.42U
+ PD=4.4U
* device instance $2315 r0 *1 101.6,22.68 nfet_03v3
M$2315 \$112 A|B|Y \$113 VSS nfet_03v3 L=0.28U W=2U AS=0.7P AD=0.52P PS=4.4U
+ PD=3.04U
* device instance $2317 r0 *1 103.2,22.68 nfet_03v3
M$2317 VSS A|Y$8 \$113 VSS nfet_03v3 L=0.28U W=2U AS=0.52P AD=0.7P PS=3.04U
+ PD=4.4U
* device instance $2319 r0 *1 109.225,22.685 nfet_03v3
M$2319 \$98 \$75 VSS VSS nfet_03v3 L=7.75U W=0.99U AS=0.4851P AD=0.4356P
+ PS=2.96U PD=2.86U
* device instance $2320 r0 *1 114.825,22.68 nfet_03v3
M$2320 \$99 \$76 VSS VSS nfet_03v3 L=1.03U W=1U AS=0.49P AD=0.44P PS=2.98U
+ PD=2.88U
* device instance $2321 r0 *1 118.4,22.68 nfet_03v3
M$2321 A|Y$6 B|Y$2 \$114 VSS nfet_03v3 L=0.28U W=2U AS=0.775P AD=0.52P PS=4.55U
+ PD=3.04U
* device instance $2323 r0 *1 120,22.68 nfet_03v3
M$2323 VSS A|Y$1 \$114 VSS nfet_03v3 L=0.28U W=2U AS=0.52P AD=0.7P PS=3.04U
+ PD=4.4U
* device instance $2325 r0 *1 122.665,22.68 nfet_03v3
M$2325 \$101 \$78 VSS VSS nfet_03v3 L=1.03U W=1U AS=0.49P AD=0.44P PS=2.98U
+ PD=2.88U
* device instance $2326 r0 *1 126.16,22.68 nfet_03v3
M$2326 VSS A|Y$2 \$115 VSS nfet_03v3 L=0.28U W=2U AS=0.7P AD=0.52P PS=4.4U
+ PD=3.04U
* device instance $2328 r0 *1 127.76,22.68 nfet_03v3
M$2328 B|Y$2 B|Y$3 \$115 VSS nfet_03v3 L=0.28U W=2U AS=0.52P AD=0.775P PS=3.04U
+ PD=4.55U
* device instance $2330 r0 *1 130.08,22.68 nfet_03v3
M$2330 VSS A|Y$3 \$116 VSS nfet_03v3 L=0.28U W=2U AS=0.7P AD=0.52P PS=4.4U
+ PD=3.04U
* device instance $2332 r0 *1 131.68,22.68 nfet_03v3
M$2332 B|Y$3 B|Y$4 \$116 VSS nfet_03v3 L=0.28U W=2U AS=0.52P AD=0.775P PS=3.04U
+ PD=4.55U
* device instance $2334 r0 *1 135.12,22.68 nfet_03v3
M$2334 VSS A|Y$4 \$117 VSS nfet_03v3 L=0.28U W=2U AS=0.7P AD=0.52P PS=4.4U
+ PD=3.04U
* device instance $2336 r0 *1 136.72,22.68 nfet_03v3
M$2336 B|Y$4 B|Y$5 \$117 VSS nfet_03v3 L=0.28U W=2U AS=0.52P AD=0.775P PS=3.04U
+ PD=4.55U
* device instance $2338 r0 *1 140.72,22.68 nfet_03v3
M$2338 VSS A|Y$9 \$118 VSS nfet_03v3 L=0.28U W=2U AS=0.7P AD=0.52P PS=4.4U
+ PD=3.04U
* device instance $2340 r0 *1 142.32,22.68 nfet_03v3
M$2340 B|Y B|Y$10 \$118 VSS nfet_03v3 L=0.28U W=2U AS=0.52P AD=0.775P PS=3.04U
+ PD=4.55U
* device instance $2342 r0 *1 145.065,22.68 nfet_03v3
M$2342 \$106 \$80 VSS VSS nfet_03v3 L=1.03U W=1U AS=0.49P AD=0.44P PS=2.98U
+ PD=2.88U
* device instance $2343 r0 *1 146.96,22.68 nfet_03v3
M$2343 B|Y$1 B|Y \$119 VSS nfet_03v3 L=0.28U W=2U AS=0.775P AD=0.52P PS=4.55U
+ PD=3.04U
* device instance $2345 r0 *1 148.56,22.68 nfet_03v3
M$2345 VSS A|Y$10 \$119 VSS nfet_03v3 L=0.28U W=2U AS=0.52P AD=0.7P PS=3.04U
+ PD=4.4U
* device instance $2347 r0 *1 154.585,22.685 nfet_03v3
M$2347 \$108 \$82 VSS VSS nfet_03v3 L=7.75U W=0.99U AS=0.4851P AD=0.4356P
+ PS=2.96U PD=2.86U
* device instance $2348 r0 *1 160.185,22.68 nfet_03v3
M$2348 \$109 \$83 VSS VSS nfet_03v3 L=1.03U W=1U AS=0.49P AD=0.44P PS=2.98U
+ PD=2.88U
* device instance $2349 r0 *1 12.345,24.355 nfet_03v3
M$2349 \$120 \$155 VSS VSS nfet_03v3 L=7.75U W=0.99U AS=0.4851P AD=0.4356P
+ PS=2.96U PD=2.86U
* device instance $2350 r0 *1 21.305,24.355 nfet_03v3
M$2350 \$121 \$156 VSS VSS nfet_03v3 L=7.75U W=0.99U AS=0.4851P AD=0.4356P
+ PS=2.96U PD=2.86U
* device instance $2351 r0 *1 31.945,24.355 nfet_03v3
M$2351 \$122 \$157 VSS VSS nfet_03v3 L=7.75U W=0.99U AS=0.4851P AD=0.4356P
+ PS=2.96U PD=2.86U
* device instance $2352 r0 *1 40.905,24.355 nfet_03v3
M$2352 \$123 \$158 VSS VSS nfet_03v3 L=7.75U W=0.99U AS=0.4851P AD=0.4356P
+ PS=2.96U PD=2.86U
* device instance $2353 r0 *1 49.865,24.355 nfet_03v3
M$2353 \$124 \$159 VSS VSS nfet_03v3 L=7.75U W=0.99U AS=0.4851P AD=0.4356P
+ PS=2.96U PD=2.86U
* device instance $2354 r0 *1 58.825,24.355 nfet_03v3
M$2354 \$125 \$160 VSS VSS nfet_03v3 L=7.75U W=0.99U AS=0.4851P AD=0.4356P
+ PS=2.96U PD=2.86U
* device instance $2355 r0 *1 64.425,24.36 nfet_03v3
M$2355 \$126 \$161 VSS VSS nfet_03v3 L=1.03U W=1U AS=0.49P AD=0.44P PS=2.98U
+ PD=2.88U
* device instance $2356 r0 *1 71.145,24.355 nfet_03v3
M$2356 \$127 \$162 VSS VSS nfet_03v3 L=7.75U W=0.99U AS=0.4851P AD=0.4356P
+ PS=2.96U PD=2.86U
* device instance $2357 r0 *1 80.105,24.355 nfet_03v3
M$2357 \$128 \$163 VSS VSS nfet_03v3 L=7.75U W=0.99U AS=0.4851P AD=0.4356P
+ PS=2.96U PD=2.86U
* device instance $2358 r0 *1 86.825,24.355 nfet_03v3
M$2358 \$129 \$164 VSS VSS nfet_03v3 L=3.27U W=0.99U AS=0.4851P AD=0.4356P
+ PS=2.96U PD=2.86U
* device instance $2359 r0 *1 90.185,24.36 nfet_03v3
M$2359 \$130 \$165 VSS VSS nfet_03v3 L=1.03U W=1U AS=0.49P AD=0.44P PS=2.98U
+ PD=2.88U
* device instance $2360 r0 *1 92,24.36 nfet_03v3
M$2360 C|Y A|Y VSS VSS nfet_03v3 L=0.28U W=2U AS=0.7P AD=0.7P PS=4.4U PD=4.4U
* device instance $2362 r0 *1 94.32,24.36 nfet_03v3
M$2362 Y$3 C|Y$3 \$131 VSS nfet_03v3 L=0.28U W=2U AS=0.71P AD=0.7P PS=4.42U
+ PD=4.4U
* device instance $2364 r0 *1 96.56,24.36 nfet_03v3
M$2364 \$131 A|B|Y \$133 VSS nfet_03v3 L=0.28U W=2U AS=0.7P AD=0.52P PS=4.4U
+ PD=3.04U
* device instance $2366 r0 *1 98.16,24.36 nfet_03v3
M$2366 VSS A|Y$14 \$133 VSS nfet_03v3 L=0.28U W=2U AS=0.52P AD=0.7P PS=3.04U
+ PD=4.4U
* device instance $2368 r0 *1 101.52,24.36 nfet_03v3
M$2368 C|Y$2 A|Y$8 VSS VSS nfet_03v3 L=0.28U W=2U AS=0.7P AD=0.7P PS=4.4U
+ PD=4.4U
* device instance $2370 r0 *1 108.105,24.355 nfet_03v3
M$2370 \$134 \$168 VSS VSS nfet_03v3 L=3.27U W=0.99U AS=0.4851P AD=0.4356P
+ PS=2.96U PD=2.86U
* device instance $2371 r0 *1 111.465,24.36 nfet_03v3
M$2371 \$135 \$169 VSS VSS nfet_03v3 L=1.03U W=1U AS=0.49P AD=0.44P PS=2.98U
+ PD=2.88U
* device instance $2372 r0 *1 115.28,24.36 nfet_03v3
M$2372 B|Y$6 \$170 VSS VSS nfet_03v3 L=0.28U W=2U AS=1.02P AD=0.52P PS=5.04U
+ PD=3.04U
* device instance $2374 r0 *1 116.88,24.36 nfet_03v3
M$2374 \$170 A|Y$6 VSS VSS nfet_03v3 L=0.28U W=1U AS=0.26P AD=0.44P PS=1.52U
+ PD=2.88U
* device instance $2375 r0 *1 118.56,24.36 nfet_03v3
M$2375 \$137 A|Y$1 VSS VSS nfet_03v3 L=0.28U W=1U AS=0.46P AD=0.44P PS=2.92U
+ PD=2.88U
* device instance $2376 r0 *1 120,24.36 nfet_03v3
M$2376 VSS \$137 \$138 VSS nfet_03v3 L=0.28U W=2U AS=0.7P AD=0.52P PS=4.4U
+ PD=3.04U
* device instance $2378 r0 *1 121.6,24.36 nfet_03v3
M$2378 A|Y$11 B|Y$2 \$138 VSS nfet_03v3 L=0.28U W=2U AS=0.52P AD=0.775P
+ PS=3.04U PD=4.55U
* device instance $2380 r0 *1 124.16,24.36 nfet_03v3
M$2380 \$140 A|Y$2 VSS VSS nfet_03v3 L=0.28U W=1U AS=0.46P AD=0.44P PS=2.92U
+ PD=2.88U
* device instance $2381 r0 *1 125.6,24.36 nfet_03v3
M$2381 VSS \$140 \$141 VSS nfet_03v3 L=0.28U W=2U AS=0.7P AD=0.52P PS=4.4U
+ PD=3.04U
* device instance $2383 r0 *1 127.2,24.36 nfet_03v3
M$2383 A|Y$12 B|Y$3 \$141 VSS nfet_03v3 L=0.28U W=2U AS=0.52P AD=0.775P
+ PS=3.04U PD=4.55U
* device instance $2385 r0 *1 130.88,24.36 nfet_03v3
M$2385 \$143 A|Y$3 VSS VSS nfet_03v3 L=0.28U W=1U AS=0.46P AD=0.44P PS=2.92U
+ PD=2.88U
* device instance $2386 r0 *1 132.32,24.36 nfet_03v3
M$2386 VSS \$143 \$144 VSS nfet_03v3 L=0.28U W=2U AS=0.7P AD=0.52P PS=4.4U
+ PD=3.04U
* device instance $2388 r0 *1 133.92,24.36 nfet_03v3
M$2388 A|Y$13 B|Y$4 \$144 VSS nfet_03v3 L=0.28U W=2U AS=0.52P AD=0.775P
+ PS=3.04U PD=4.55U
* device instance $2390 r0 *1 137.04,24.36 nfet_03v3
M$2390 \$146 A|Y$4 VSS VSS nfet_03v3 L=0.28U W=1U AS=0.46P AD=0.44P PS=2.92U
+ PD=2.88U
* device instance $2391 r0 *1 138.48,24.36 nfet_03v3
M$2391 VSS \$146 \$147 VSS nfet_03v3 L=0.28U W=2U AS=0.7P AD=0.52P PS=4.4U
+ PD=3.04U
* device instance $2393 r0 *1 140.08,24.36 nfet_03v3
M$2393 A|Y$9 B|Y$5 \$147 VSS nfet_03v3 L=0.28U W=2U AS=0.52P AD=0.775P PS=3.04U
+ PD=4.55U
* device instance $2395 r0 *1 142.825,24.36 nfet_03v3
M$2395 \$148 \$171 VSS VSS nfet_03v3 L=1.03U W=1U AS=0.49P AD=0.44P PS=2.98U
+ PD=2.88U
* device instance $2396 r0 *1 146,24.36 nfet_03v3
M$2396 \$149 A|Y$5 VSS VSS nfet_03v3 L=0.28U W=1U AS=0.46P AD=0.44P PS=2.92U
+ PD=2.88U
* device instance $2397 r0 *1 147.44,24.36 nfet_03v3
M$2397 VSS \$149 \$150 VSS nfet_03v3 L=0.28U W=2U AS=0.7P AD=0.52P PS=4.4U
+ PD=3.04U
* device instance $2399 r0 *1 149.04,24.36 nfet_03v3
M$2399 A|Y$10 B|Y$11 \$150 VSS nfet_03v3 L=0.28U W=2U AS=0.52P AD=0.775P
+ PS=3.04U PD=4.55U
* device instance $2401 r0 *1 151.36,24.36 nfet_03v3
M$2401 VSS A|Y$15 \$151 VSS nfet_03v3 L=0.28U W=2U AS=0.7P AD=0.52P PS=4.4U
+ PD=3.04U
* device instance $2403 r0 *1 152.96,24.36 nfet_03v3
M$2403 B|Y$7 B|Y$1 \$151 VSS nfet_03v3 L=0.28U W=2U AS=0.52P AD=0.775P PS=3.04U
+ PD=4.55U
* device instance $2405 r0 *1 156.825,24.355 nfet_03v3
M$2405 \$153 \$173 VSS VSS nfet_03v3 L=3.27U W=0.99U AS=0.4851P AD=0.4356P
+ PS=2.96U PD=2.86U
* device instance $2406 r0 *1 160.185,24.36 nfet_03v3
M$2406 \$154 \$174 VSS VSS nfet_03v3 L=1.03U W=1U AS=0.49P AD=0.44P PS=2.98U
+ PD=2.88U
* device instance $2407 r0 *1 12.345,30.525 nfet_03v3
M$2407 \$176 \$175 VSS VSS nfet_03v3 L=7.75U W=0.99U AS=0.4851P AD=0.4356P
+ PS=2.96U PD=2.86U
* device instance $2408 r0 *1 12.345,32.195 nfet_03v3
M$2408 \$223 \$222 VSS VSS nfet_03v3 L=7.75U W=0.99U AS=0.4851P AD=0.4356P
+ PS=2.96U PD=2.86U
* device instance $2409 r0 *1 21.305,30.525 nfet_03v3
M$2409 \$178 \$177 VSS VSS nfet_03v3 L=7.75U W=0.99U AS=0.4851P AD=0.4356P
+ PS=2.96U PD=2.86U
* device instance $2410 r0 *1 21.305,32.195 nfet_03v3
M$2410 \$225 \$224 VSS VSS nfet_03v3 L=7.75U W=0.99U AS=0.4851P AD=0.4356P
+ PS=2.96U PD=2.86U
* device instance $2411 r0 *1 30.265,30.525 nfet_03v3
M$2411 \$180 \$179 VSS VSS nfet_03v3 L=7.75U W=0.99U AS=0.4851P AD=0.4356P
+ PS=2.96U PD=2.86U
* device instance $2412 r0 *1 31.945,32.195 nfet_03v3
M$2412 \$227 \$226 VSS VSS nfet_03v3 L=7.75U W=0.99U AS=0.4851P AD=0.4356P
+ PS=2.96U PD=2.86U
* device instance $2413 r0 *1 39.225,30.525 nfet_03v3
M$2413 \$182 \$181 VSS VSS nfet_03v3 L=7.75U W=0.99U AS=0.4851P AD=0.4356P
+ PS=2.96U PD=2.86U
* device instance $2414 r0 *1 40.905,32.195 nfet_03v3
M$2414 \$229 \$228 VSS VSS nfet_03v3 L=7.75U W=0.99U AS=0.4851P AD=0.4356P
+ PS=2.96U PD=2.86U
* device instance $2415 r0 *1 44.825,30.52 nfet_03v3
M$2415 \$184 \$183 VSS VSS nfet_03v3 L=1.03U W=1U AS=0.49P AD=0.44P PS=2.98U
+ PD=2.88U
* device instance $2416 r0 *1 49.865,32.195 nfet_03v3
M$2416 \$231 \$230 VSS VSS nfet_03v3 L=7.75U W=0.99U AS=0.4851P AD=0.4356P
+ PS=2.96U PD=2.86U
* device instance $2417 r0 *1 51.545,30.525 nfet_03v3
M$2417 \$186 \$185 VSS VSS nfet_03v3 L=7.75U W=0.99U AS=0.4851P AD=0.4356P
+ PS=2.96U PD=2.86U
* device instance $2418 r0 *1 58.825,32.195 nfet_03v3
M$2418 \$233 \$232 VSS VSS nfet_03v3 L=7.75U W=0.99U AS=0.4851P AD=0.4356P
+ PS=2.96U PD=2.86U
* device instance $2419 r0 *1 60.505,30.525 nfet_03v3
M$2419 \$188 \$187 VSS VSS nfet_03v3 L=7.75U W=0.99U AS=0.4851P AD=0.4356P
+ PS=2.96U PD=2.86U
* device instance $2420 r0 *1 64.425,32.2 nfet_03v3
M$2420 \$235 \$234 VSS VSS nfet_03v3 L=1.03U W=1U AS=0.49P AD=0.44P PS=2.98U
+ PD=2.88U
* device instance $2421 r0 *1 69.465,30.525 nfet_03v3
M$2421 \$190 \$189 VSS VSS nfet_03v3 L=7.75U W=0.99U AS=0.4851P AD=0.4356P
+ PS=2.96U PD=2.86U
* device instance $2422 r0 *1 71.145,32.195 nfet_03v3
M$2422 \$237 \$236 VSS VSS nfet_03v3 L=7.75U W=0.99U AS=0.4851P AD=0.4356P
+ PS=2.96U PD=2.86U
* device instance $2423 r0 *1 78.425,30.525 nfet_03v3
M$2423 \$192 \$191 VSS VSS nfet_03v3 L=7.75U W=0.99U AS=0.4851P AD=0.4356P
+ PS=2.96U PD=2.86U
* device instance $2424 r0 *1 80.105,32.195 nfet_03v3
M$2424 \$239 \$238 VSS VSS nfet_03v3 L=7.75U W=0.99U AS=0.4851P AD=0.4356P
+ PS=2.96U PD=2.86U
* device instance $2425 r0 *1 84.025,30.52 nfet_03v3
M$2425 \$194 \$193 VSS VSS nfet_03v3 L=1.03U W=1U AS=0.49P AD=0.44P PS=2.98U
+ PD=2.88U
* device instance $2426 r0 *1 89.065,32.195 nfet_03v3
M$2426 \$241 \$240 VSS VSS nfet_03v3 L=7.75U W=0.99U AS=0.4851P AD=0.4356P
+ PS=2.96U PD=2.86U
* device instance $2427 r0 *1 90.745,30.525 nfet_03v3
M$2427 \$196 \$195 VSS VSS nfet_03v3 L=7.75U W=0.99U AS=0.4851P AD=0.4356P
+ PS=2.96U PD=2.86U
* device instance $2428 r0 *1 98.025,32.195 nfet_03v3
M$2428 \$243 \$242 VSS VSS nfet_03v3 L=7.75U W=0.99U AS=0.4851P AD=0.4356P
+ PS=2.96U PD=2.86U
* device instance $2429 r0 *1 95.92,30.52 nfet_03v3
M$2429 C|Y$3 A|Y$14 VSS VSS nfet_03v3 L=0.28U W=2U AS=0.7P AD=0.7P PS=4.4U
+ PD=4.4U
* device instance $2431 r0 *1 101.945,30.525 nfet_03v3
M$2431 \$198 \$197 VSS VSS nfet_03v3 L=7.75U W=0.99U AS=0.4851P AD=0.4356P
+ PS=2.96U PD=2.86U
* device instance $2432 r0 *1 103.625,32.2 nfet_03v3
M$2432 \$245 \$244 VSS VSS nfet_03v3 L=1.03U W=1U AS=0.49P AD=0.44P PS=2.98U
+ PD=2.88U
* device instance $2433 r0 *1 110.345,32.195 nfet_03v3
M$2433 \$247 \$246 VSS VSS nfet_03v3 L=7.75U W=0.99U AS=0.4851P AD=0.4356P
+ PS=2.96U PD=2.86U
* device instance $2434 r0 *1 110.905,30.525 nfet_03v3
M$2434 \$200 \$199 VSS VSS nfet_03v3 L=7.75U W=0.99U AS=0.4851P AD=0.4356P
+ PS=2.96U PD=2.86U
* device instance $2435 r0 *1 119.305,32.195 nfet_03v3
M$2435 \$249 \$248 VSS VSS nfet_03v3 L=7.75U W=0.99U AS=0.4851P AD=0.4356P
+ PS=2.96U PD=2.86U
* device instance $2436 r0 *1 117.625,30.525 nfet_03v3
M$2436 \$202 \$201 VSS VSS nfet_03v3 L=3.27U W=0.99U AS=0.4851P AD=0.4356P
+ PS=2.96U PD=2.86U
* device instance $2437 r0 *1 121.12,30.52 nfet_03v3
M$2437 VSS A|Y$11 \$216 VSS nfet_03v3 L=0.28U W=2U AS=0.7P AD=0.52P PS=4.4U
+ PD=3.04U
* device instance $2439 r0 *1 122.72,30.52 nfet_03v3
M$2439 B|Y$8 B|Y$6 \$216 VSS nfet_03v3 L=0.28U W=2U AS=0.52P AD=0.775P PS=3.04U
+ PD=4.55U
* device instance $2441 r0 *1 128.265,32.195 nfet_03v3
M$2441 \$251 \$250 VSS VSS nfet_03v3 L=7.75U W=0.99U AS=0.4851P AD=0.4356P
+ PS=2.96U PD=2.86U
* device instance $2442 r0 *1 126.24,30.52 nfet_03v3
M$2442 B|Y$9 B|Y$8 \$217 VSS nfet_03v3 L=0.28U W=2U AS=0.775P AD=0.52P PS=4.55U
+ PD=3.04U
* device instance $2444 r0 *1 127.84,30.52 nfet_03v3
M$2444 VSS A|Y$12 \$217 VSS nfet_03v3 L=0.28U W=2U AS=0.52P AD=0.7P PS=3.04U
+ PD=4.4U
* device instance $2446 r0 *1 130.505,30.52 nfet_03v3
M$2446 \$206 \$205 VSS VSS nfet_03v3 L=1.03U W=1U AS=0.49P AD=0.44P PS=2.98U
+ PD=2.88U
* device instance $2447 r0 *1 133.44,30.52 nfet_03v3
M$2447 VSS A|Y$13 \$218 VSS nfet_03v3 L=0.28U W=2U AS=0.7P AD=0.52P PS=4.4U
+ PD=3.04U
* device instance $2449 r0 *1 135.04,30.52 nfet_03v3
M$2449 B|Y$10 B|Y$9 \$218 VSS nfet_03v3 L=0.28U W=2U AS=0.52P AD=0.775P
+ PS=3.04U PD=4.55U
* device instance $2451 r0 *1 137.225,32.195 nfet_03v3
M$2451 \$253 \$252 VSS VSS nfet_03v3 L=7.75U W=0.99U AS=0.4851P AD=0.4356P
+ PS=2.96U PD=2.86U
* device instance $2452 r0 *1 138.905,30.525 nfet_03v3
M$2452 \$209 \$208 VSS VSS nfet_03v3 L=3.27U W=0.99U AS=0.4851P AD=0.4356P
+ PS=2.96U PD=2.86U
* device instance $2453 r0 *1 141.92,30.52 nfet_03v3
M$2453 B|Y$5 B|Y$11 \$219 VSS nfet_03v3 L=0.28U W=2U AS=0.775P AD=0.52P
+ PS=4.55U PD=3.04U
* device instance $2455 r0 *1 143.52,30.52 nfet_03v3
M$2455 VSS A|Y$5 \$219 VSS nfet_03v3 L=0.28U W=2U AS=0.52P AD=0.7P PS=3.04U
+ PD=4.4U
* device instance $2457 r0 *1 142.825,32.2 nfet_03v3
M$2457 \$255 \$254 VSS VSS nfet_03v3 L=1.03U W=1U AS=0.49P AD=0.44P PS=2.98U
+ PD=2.88U
* device instance $2458 r0 *1 147.305,32.195 nfet_03v3
M$2458 \$257 \$256 VSS VSS nfet_03v3 L=3.27U W=0.99U AS=0.4851P AD=0.4356P
+ PS=2.96U PD=2.86U
* device instance $2459 r0 *1 147.52,30.52 nfet_03v3
M$2459 B|Y$11 B|Y$12 \$220 VSS nfet_03v3 L=0.28U W=2U AS=0.775P AD=0.52P
+ PS=4.55U PD=3.04U
* device instance $2461 r0 *1 149.12,30.52 nfet_03v3
M$2461 VSS A|Y$16 \$220 VSS nfet_03v3 L=0.28U W=2U AS=0.52P AD=0.7P PS=3.04U
+ PD=4.4U
* device instance $2463 r0 *1 150.665,32.2 nfet_03v3
M$2463 \$259 \$258 VSS VSS nfet_03v3 L=1.03U W=1U AS=0.49P AD=0.44P PS=2.98U
+ PD=2.88U
* device instance $2464 r0 *1 151.44,30.52 nfet_03v3
M$2464 A|Y$15 B|Y$12 \$221 VSS nfet_03v3 L=0.28U W=2U AS=0.775P AD=0.52P
+ PS=4.55U PD=3.04U
* device instance $2466 r0 *1 153.04,30.52 nfet_03v3
M$2466 VSS \$215 \$221 VSS nfet_03v3 L=0.28U W=2U AS=0.52P AD=0.7P PS=3.04U
+ PD=4.4U
* device instance $2468 r0 *1 152.48,32.2 nfet_03v3
M$2468 VSS A|Y$17 \$260 VSS nfet_03v3 L=0.28U W=2U AS=0.7P AD=0.52P PS=4.4U
+ PD=3.04U
* device instance $2470 r0 *1 154.08,32.2 nfet_03v3
M$2470 B|Y$13 B|Y$7 \$260 VSS nfet_03v3 L=0.28U W=2U AS=0.52P AD=0.775P
+ PS=3.04U PD=4.55U
* device instance $2472 r0 *1 155.28,30.52 nfet_03v3
M$2472 VSS A|Y$16 \$215 VSS nfet_03v3 L=0.28U W=1U AS=0.44P AD=0.46P PS=2.88U
+ PD=2.92U
* device instance $2473 r0 *1 156.825,32.2 nfet_03v3
M$2473 \$264 \$263 VSS VSS nfet_03v3 L=1.03U W=1U AS=0.49P AD=0.44P PS=2.98U
+ PD=2.88U
* device instance $2474 r0 *1 158.505,30.525 nfet_03v3
M$2474 \$214 \$213 VSS VSS nfet_03v3 L=3.27U W=0.99U AS=0.4851P AD=0.4356P
+ PS=2.96U PD=2.86U
* device instance $2475 r0 *1 159.52,32.2 nfet_03v3
M$2475 A|Y$18 \$265 VSS VSS nfet_03v3 L=0.28U W=2U AS=1.02P AD=0.52P PS=5.04U
+ PD=3.04U
* device instance $2477 r0 *1 161.12,32.2 nfet_03v3
M$2477 \$265 A|COARSE_MUX[8] VSS VSS nfet_03v3 L=0.28U W=1U AS=0.26P AD=0.44P
+ PS=1.52U PD=2.88U
* device instance $2478 r0 *1 12.345,38.365 nfet_03v3
M$2478 \$269 \$268 VSS VSS nfet_03v3 L=7.75U W=0.99U AS=0.4851P AD=0.4356P
+ PS=2.96U PD=2.86U
* device instance $2479 r0 *1 21.305,38.365 nfet_03v3
M$2479 \$271 \$270 VSS VSS nfet_03v3 L=7.75U W=0.99U AS=0.4851P AD=0.4356P
+ PS=2.96U PD=2.86U
* device instance $2480 r0 *1 30.265,38.365 nfet_03v3
M$2480 \$273 \$272 VSS VSS nfet_03v3 L=7.75U W=0.99U AS=0.4851P AD=0.4356P
+ PS=2.96U PD=2.86U
* device instance $2481 r0 *1 39.225,38.365 nfet_03v3
M$2481 \$275 \$274 VSS VSS nfet_03v3 L=7.75U W=0.99U AS=0.4851P AD=0.4356P
+ PS=2.96U PD=2.86U
* device instance $2482 r0 *1 44.825,38.36 nfet_03v3
M$2482 \$277 \$276 VSS VSS nfet_03v3 L=1.03U W=1U AS=0.49P AD=0.44P PS=2.98U
+ PD=2.88U
* device instance $2483 r0 *1 51.545,38.365 nfet_03v3
M$2483 \$279 \$278 VSS VSS nfet_03v3 L=7.75U W=0.99U AS=0.4851P AD=0.4356P
+ PS=2.96U PD=2.86U
* device instance $2484 r0 *1 60.505,38.365 nfet_03v3
M$2484 \$281 \$280 VSS VSS nfet_03v3 L=7.75U W=0.99U AS=0.4851P AD=0.4356P
+ PS=2.96U PD=2.86U
* device instance $2485 r0 *1 69.465,38.365 nfet_03v3
M$2485 \$283 \$282 VSS VSS nfet_03v3 L=7.75U W=0.99U AS=0.4851P AD=0.4356P
+ PS=2.96U PD=2.86U
* device instance $2486 r0 *1 78.425,38.365 nfet_03v3
M$2486 \$285 \$284 VSS VSS nfet_03v3 L=7.75U W=0.99U AS=0.4851P AD=0.4356P
+ PS=2.96U PD=2.86U
* device instance $2487 r0 *1 84.025,38.36 nfet_03v3
M$2487 \$287 \$286 VSS VSS nfet_03v3 L=1.03U W=1U AS=0.49P AD=0.44P PS=2.98U
+ PD=2.88U
* device instance $2488 r0 *1 90.745,38.365 nfet_03v3
M$2488 \$289 \$288 VSS VSS nfet_03v3 L=7.75U W=0.99U AS=0.4851P AD=0.4356P
+ PS=2.96U PD=2.86U
* device instance $2489 r0 *1 99.705,38.365 nfet_03v3
M$2489 \$291 \$290 VSS VSS nfet_03v3 L=7.75U W=0.99U AS=0.4851P AD=0.4356P
+ PS=2.96U PD=2.86U
* device instance $2490 r0 *1 108.665,38.365 nfet_03v3
M$2490 \$293 \$292 VSS VSS nfet_03v3 L=7.75U W=0.99U AS=0.4851P AD=0.4356P
+ PS=2.96U PD=2.86U
* device instance $2491 r0 *1 117.625,38.365 nfet_03v3
M$2491 \$295 \$294 VSS VSS nfet_03v3 L=7.75U W=0.99U AS=0.4851P AD=0.4356P
+ PS=2.96U PD=2.86U
* device instance $2492 r0 *1 123.225,38.36 nfet_03v3
M$2492 \$297 \$296 VSS VSS nfet_03v3 L=1.03U W=1U AS=0.49P AD=0.44P PS=2.98U
+ PD=2.88U
* device instance $2493 r0 *1 129.945,38.365 nfet_03v3
M$2493 \$299 \$298 VSS VSS nfet_03v3 L=7.75U W=0.99U AS=0.4851P AD=0.4356P
+ PS=2.96U PD=2.86U
* device instance $2494 r0 *1 138.905,38.365 nfet_03v3
M$2494 \$301 \$300 VSS VSS nfet_03v3 L=7.75U W=0.99U AS=0.4851P AD=0.4356P
+ PS=2.96U PD=2.86U
* device instance $2495 r0 *1 145.625,38.365 nfet_03v3
M$2495 \$303 \$302 VSS VSS nfet_03v3 L=3.27U W=0.99U AS=0.4851P AD=0.4356P
+ PS=2.96U PD=2.86U
* device instance $2496 r0 *1 148.985,38.36 nfet_03v3
M$2496 \$305 \$304 VSS VSS nfet_03v3 L=1.03U W=1U AS=0.49P AD=0.44P PS=2.98U
+ PD=2.88U
* device instance $2497 r0 *1 152,38.36 nfet_03v3
M$2497 A|Y$17 B|Y$14 \$308 VSS nfet_03v3 L=0.28U W=2U AS=0.775P AD=0.52P
+ PS=4.55U PD=3.04U
* device instance $2499 r0 *1 153.6,38.36 nfet_03v3
M$2499 VSS \$307 \$308 VSS nfet_03v3 L=0.28U W=2U AS=0.52P AD=0.7P PS=3.04U
+ PD=4.4U
* device instance $2501 r0 *1 155.84,38.36 nfet_03v3
M$2501 VSS A|Y$18 \$307 VSS nfet_03v3 L=0.28U W=1U AS=0.44P AD=0.46P PS=2.88U
+ PD=2.92U
* device instance $2502 r0 *1 157.6,38.36 nfet_03v3
M$2502 B|Y$12 B|Y$14 \$309 VSS nfet_03v3 L=0.28U W=2U AS=0.775P AD=0.52P
+ PS=4.55U PD=3.04U
* device instance $2504 r0 *1 159.2,38.36 nfet_03v3
M$2504 VSS A|Y$18 \$309 VSS nfet_03v3 L=0.28U W=2U AS=0.52P AD=0.7P PS=3.04U
+ PD=4.4U
* device instance $2506 r0 *1 12.345,40.035 nfet_03v3
M$2506 \$313 \$311 VSS VSS nfet_03v3 L=7.75U W=0.99U AS=0.4851P AD=0.4356P
+ PS=2.96U PD=2.86U
* device instance $2507 r0 *1 21.305,40.035 nfet_03v3
M$2507 \$315 \$314 VSS VSS nfet_03v3 L=7.75U W=0.99U AS=0.4851P AD=0.4356P
+ PS=2.96U PD=2.86U
* device instance $2508 r0 *1 26.905,46.2 nfet_03v3
M$2508 \$362 \$361 VSS VSS nfet_03v3 L=1.03U W=1U AS=0.49P AD=0.44P PS=2.98U
+ PD=2.88U
* device instance $2509 r0 *1 31.945,40.035 nfet_03v3
M$2509 \$317 \$316 VSS VSS nfet_03v3 L=7.75U W=0.99U AS=0.4851P AD=0.4356P
+ PS=2.96U PD=2.86U
* device instance $2510 r0 *1 29.28,46.2 nfet_03v3
M$2510 VSS A|Y$45 \$363 VSS nfet_03v3 L=0.28U W=1U AS=0.44P AD=0.26P PS=2.88U
+ PD=1.52U
* device instance $2511 r0 *1 30.08,46.2 nfet_03v3
M$2511 A|Y$21 \$363 VSS VSS nfet_03v3 L=0.28U W=2U AS=0.52P AD=1.02P PS=3.04U
+ PD=5.04U
* device instance $2513 r0 *1 32.64,46.2 nfet_03v3
M$2513 VSS A|Y$24 \$365 VSS nfet_03v3 L=0.28U W=1U AS=0.44P AD=0.26P PS=2.88U
+ PD=1.52U
* device instance $2514 r0 *1 33.44,46.2 nfet_03v3
M$2514 A|Y$22 \$365 VSS VSS nfet_03v3 L=0.28U W=2U AS=0.52P AD=1.02P PS=3.04U
+ PD=5.04U
* device instance $2516 r0 *1 40.905,40.035 nfet_03v3
M$2516 \$319 \$318 VSS VSS nfet_03v3 L=7.75U W=0.99U AS=0.4851P AD=0.4356P
+ PS=2.96U PD=2.86U
* device instance $2517 r0 *1 49.865,40.035 nfet_03v3
M$2517 \$321 \$320 VSS VSS nfet_03v3 L=7.75U W=0.99U AS=0.4851P AD=0.4356P
+ PS=2.96U PD=2.86U
* device instance $2518 r0 *1 58.825,40.035 nfet_03v3
M$2518 \$323 \$322 VSS VSS nfet_03v3 L=7.75U W=0.99U AS=0.4851P AD=0.4356P
+ PS=2.96U PD=2.86U
* device instance $2519 r0 *1 64.425,40.04 nfet_03v3
M$2519 \$325 \$324 VSS VSS nfet_03v3 L=1.03U W=1U AS=0.49P AD=0.44P PS=2.98U
+ PD=2.88U
* device instance $2520 r0 *1 71.145,40.035 nfet_03v3
M$2520 \$327 \$326 VSS VSS nfet_03v3 L=7.75U W=0.99U AS=0.4851P AD=0.4356P
+ PS=2.96U PD=2.86U
* device instance $2521 r0 *1 80.105,40.035 nfet_03v3
M$2521 \$329 \$328 VSS VSS nfet_03v3 L=7.75U W=0.99U AS=0.4851P AD=0.4356P
+ PS=2.96U PD=2.86U
* device instance $2522 r0 *1 84.025,46.2 nfet_03v3
M$2522 \$378 \$377 VSS VSS nfet_03v3 L=1.03U W=1U AS=0.49P AD=0.44P PS=2.98U
+ PD=2.88U
* device instance $2523 r0 *1 89.065,40.035 nfet_03v3
M$2523 \$331 \$330 VSS VSS nfet_03v3 L=7.75U W=0.99U AS=0.4851P AD=0.4356P
+ PS=2.96U PD=2.86U
* device instance $2524 r0 *1 98.025,40.035 nfet_03v3
M$2524 \$333 \$332 VSS VSS nfet_03v3 L=7.75U W=0.99U AS=0.4851P AD=0.4356P
+ PS=2.96U PD=2.86U
* device instance $2525 r0 *1 103.625,40.04 nfet_03v3
M$2525 \$335 \$334 VSS VSS nfet_03v3 L=1.03U W=1U AS=0.49P AD=0.44P PS=2.98U
+ PD=2.88U
* device instance $2526 r0 *1 110.345,40.035 nfet_03v3
M$2526 \$337 \$336 VSS VSS nfet_03v3 L=7.75U W=0.99U AS=0.4851P AD=0.4356P
+ PS=2.96U PD=2.86U
* device instance $2527 r0 *1 111.36,46.2 nfet_03v3
M$2527 A|Y$23 \$400 VSS VSS nfet_03v3 L=0.28U W=2U AS=1.02P AD=0.52P PS=5.04U
+ PD=3.04U
* device instance $2529 r0 *1 112.96,46.2 nfet_03v3
M$2529 \$400 A|Y$25 VSS VSS nfet_03v3 L=0.28U W=1U AS=0.26P AD=0.44P PS=1.52U
+ PD=2.88U
* device instance $2530 r0 *1 119.305,40.035 nfet_03v3
M$2530 \$339 \$338 VSS VSS nfet_03v3 L=7.75U W=0.99U AS=0.4851P AD=0.4356P
+ PS=2.96U PD=2.86U
* device instance $2531 r0 *1 128.265,40.035 nfet_03v3
M$2531 \$341 \$340 VSS VSS nfet_03v3 L=7.75U W=0.99U AS=0.4851P AD=0.4356P
+ PS=2.96U PD=2.86U
* device instance $2532 r0 *1 137.225,40.035 nfet_03v3
M$2532 \$343 \$342 VSS VSS nfet_03v3 L=7.75U W=0.99U AS=0.4851P AD=0.4356P
+ PS=2.96U PD=2.86U
* device instance $2533 r0 *1 142.825,40.04 nfet_03v3
M$2533 \$345 \$344 VSS VSS nfet_03v3 L=1.03U W=1U AS=0.49P AD=0.44P PS=2.98U
+ PD=2.88U
* device instance $2534 r0 *1 147.305,40.035 nfet_03v3
M$2534 \$347 \$346 VSS VSS nfet_03v3 L=3.27U W=0.99U AS=0.4851P AD=0.4356P
+ PS=2.96U PD=2.86U
* device instance $2535 r0 *1 148.985,46.2 nfet_03v3
M$2535 \$395 \$394 VSS VSS nfet_03v3 L=1.03U W=1U AS=0.49P AD=0.44P PS=2.98U
+ PD=2.88U
* device instance $2536 r0 *1 151.44,46.2 nfet_03v3
M$2536 A|Y$19 B|Y$16 \$404 VSS nfet_03v3 L=0.28U W=2U AS=0.775P AD=0.52P
+ PS=4.55U PD=3.04U
* device instance $2538 r0 *1 153.04,46.2 nfet_03v3
M$2538 VSS \$402 \$404 VSS nfet_03v3 L=0.28U W=2U AS=0.52P AD=0.7P PS=3.04U
+ PD=4.4U
* device instance $2540 r0 *1 151.92,40.04 nfet_03v3
M$2540 VSS A|Y$19 \$348 VSS nfet_03v3 L=0.28U W=2U AS=0.7P AD=0.52P PS=4.4U
+ PD=3.04U
* device instance $2542 r0 *1 153.52,40.04 nfet_03v3
M$2542 B|Y$15 B|Y$13 \$348 VSS nfet_03v3 L=0.28U W=2U AS=0.52P AD=0.775P
+ PS=3.04U PD=4.55U
* device instance $2544 r0 *1 155.28,46.2 nfet_03v3
M$2544 VSS A|Y$20 \$402 VSS nfet_03v3 L=0.28U W=1U AS=0.44P AD=0.46P PS=2.88U
+ PD=2.92U
* device instance $2545 r0 *1 155.92,40.04 nfet_03v3
M$2545 B|Y$14 B|Y$16 \$350 VSS nfet_03v3 L=0.28U W=2U AS=0.775P AD=0.52P
+ PS=4.55U PD=3.04U
* device instance $2547 r0 *1 157.52,40.04 nfet_03v3
M$2547 VSS A|Y$20 \$350 VSS nfet_03v3 L=0.28U W=2U AS=0.52P AD=0.7P PS=3.04U
+ PD=4.4U
* device instance $2549 r0 *1 157.385,46.2 nfet_03v3
M$2549 \$397 \$396 VSS VSS nfet_03v3 L=1.03U W=1U AS=0.49P AD=0.44P PS=2.98U
+ PD=2.88U
* device instance $2550 r0 *1 159.52,46.2 nfet_03v3
M$2550 A|Y$20 \$403 VSS VSS nfet_03v3 L=0.28U W=2U AS=1.02P AD=0.52P PS=5.04U
+ PD=3.04U
* device instance $2552 r0 *1 161.12,46.2 nfet_03v3
M$2552 \$403 A|COARSE_MUX[7] VSS VSS nfet_03v3 L=0.28U W=1U AS=0.26P AD=0.44P
+ PS=1.52U PD=2.88U
* device instance $2553 r0 *1 160.185,40.04 nfet_03v3
M$2553 \$352 \$351 VSS VSS nfet_03v3 L=1.03U W=1U AS=0.49P AD=0.44P PS=2.98U
+ PD=2.88U
* device instance $2554 r0 *1 12.345,47.875 nfet_03v3
M$2554 \$406 \$405 VSS VSS nfet_03v3 L=7.75U W=0.99U AS=0.4851P AD=0.4356P
+ PS=2.96U PD=2.86U
* device instance $2555 r0 *1 12.345,46.205 nfet_03v3
M$2555 \$358 \$357 VSS VSS nfet_03v3 L=7.75U W=0.99U AS=0.4851P AD=0.4356P
+ PS=2.96U PD=2.86U
* device instance $2556 r0 *1 21.305,47.875 nfet_03v3
M$2556 \$408 \$407 VSS VSS nfet_03v3 L=7.75U W=0.99U AS=0.4851P AD=0.4356P
+ PS=2.96U PD=2.86U
* device instance $2557 r0 *1 21.305,46.205 nfet_03v3
M$2557 \$360 \$359 VSS VSS nfet_03v3 L=7.75U W=0.99U AS=0.4851P AD=0.4356P
+ PS=2.96U PD=2.86U
* device instance $2558 r0 *1 28.585,47.88 nfet_03v3
M$2558 \$410 \$409 VSS VSS nfet_03v3 L=1.03U W=1U AS=0.49P AD=0.44P PS=2.98U
+ PD=2.88U
* device instance $2559 r0 *1 31.28,47.88 nfet_03v3
M$2559 A|Y$26 \$411 VSS VSS nfet_03v3 L=0.28U W=2U AS=1.02P AD=0.52P PS=5.04U
+ PD=3.04U
* device instance $2561 r0 *1 32.88,47.88 nfet_03v3
M$2561 \$411 A|Y$22 VSS VSS nfet_03v3 L=0.28U W=1U AS=0.26P AD=0.44P PS=1.52U
+ PD=2.88U
* device instance $2562 r0 *1 34.32,47.88 nfet_03v3
M$2562 VSS A|Y$26 \$413 VSS nfet_03v3 L=0.28U W=1U AS=0.44P AD=0.26P PS=2.88U
+ PD=1.52U
* device instance $2563 r0 *1 35.12,47.88 nfet_03v3
M$2563 A|Y$27 \$413 VSS VSS nfet_03v3 L=0.28U W=2U AS=0.52P AD=1.02P PS=3.04U
+ PD=5.04U
* device instance $2565 r0 *1 39.785,46.205 nfet_03v3
M$2565 \$368 \$367 VSS VSS nfet_03v3 L=7.75U W=0.99U AS=0.4851P AD=0.4356P
+ PS=2.96U PD=2.86U
* device instance $2566 r0 *1 37.68,47.88 nfet_03v3
M$2566 VSS A|Y$27 \$415 VSS nfet_03v3 L=0.28U W=1U AS=0.44P AD=0.26P PS=2.88U
+ PD=1.52U
* device instance $2567 r0 *1 38.48,47.88 nfet_03v3
M$2567 A|Y$28 \$415 VSS VSS nfet_03v3 L=0.28U W=2U AS=0.52P AD=1.02P PS=3.04U
+ PD=5.04U
* device instance $2569 r0 *1 41.04,47.88 nfet_03v3
M$2569 VSS A|Y$28 \$417 VSS nfet_03v3 L=0.28U W=1U AS=0.44P AD=0.26P PS=2.88U
+ PD=1.52U
* device instance $2570 r0 *1 41.84,47.88 nfet_03v3
M$2570 A|Y$29 \$417 VSS VSS nfet_03v3 L=0.28U W=2U AS=0.52P AD=1.02P PS=3.04U
+ PD=5.04U
* device instance $2572 r0 *1 44.96,47.88 nfet_03v3
M$2572 VSS A|Y$49 \$419 VSS nfet_03v3 L=0.28U W=1U AS=0.44P AD=0.26P PS=2.88U
+ PD=1.52U
* device instance $2573 r0 *1 45.76,47.88 nfet_03v3
M$2573 A|Y$30 \$419 VSS VSS nfet_03v3 L=0.28U W=2U AS=0.52P AD=1.02P PS=3.04U
+ PD=5.04U
* device instance $2575 r0 *1 51.545,46.205 nfet_03v3
M$2575 \$370 \$369 VSS VSS nfet_03v3 L=7.75U W=0.99U AS=0.4851P AD=0.4356P
+ PS=2.96U PD=2.86U
* device instance $2576 r0 *1 49.2,47.88 nfet_03v3
M$2576 A|Y$31 \$421 VSS VSS nfet_03v3 L=0.28U W=2U AS=1.02P AD=0.52P PS=5.04U
+ PD=3.04U
* device instance $2578 r0 *1 50.8,47.88 nfet_03v3
M$2578 \$421 A|Y$32 VSS VSS nfet_03v3 L=0.28U W=1U AS=0.26P AD=0.44P PS=1.52U
+ PD=2.88U
* device instance $2579 r0 *1 52.665,47.88 nfet_03v3
M$2579 \$425 \$424 VSS VSS nfet_03v3 L=1.03U W=1U AS=0.49P AD=0.44P PS=2.98U
+ PD=2.88U
* device instance $2580 r0 *1 54.48,47.88 nfet_03v3
M$2580 VSS A|Y$33 \$426 VSS nfet_03v3 L=0.28U W=1U AS=0.44P AD=0.26P PS=2.88U
+ PD=1.52U
* device instance $2581 r0 *1 55.28,47.88 nfet_03v3
M$2581 A|Y$34 \$426 VSS VSS nfet_03v3 L=0.28U W=2U AS=0.52P AD=1.02P PS=3.04U
+ PD=5.04U
* device instance $2583 r0 *1 60.505,46.205 nfet_03v3
M$2583 \$372 \$371 VSS VSS nfet_03v3 L=7.75U W=0.99U AS=0.4851P AD=0.4356P
+ PS=2.96U PD=2.86U
* device instance $2584 r0 *1 58.265,47.88 nfet_03v3
M$2584 \$430 \$429 VSS VSS nfet_03v3 L=1.03U W=1U AS=0.49P AD=0.44P PS=2.98U
+ PD=2.88U
* device instance $2585 r0 *1 60.08,47.88 nfet_03v3
M$2585 VSS A|Y$53 \$431 VSS nfet_03v3 L=0.28U W=1U AS=0.44P AD=0.26P PS=2.88U
+ PD=1.52U
* device instance $2586 r0 *1 60.88,47.88 nfet_03v3
M$2586 A|Y$35 \$431 VSS VSS nfet_03v3 L=0.28U W=2U AS=0.52P AD=1.02P PS=3.04U
+ PD=5.04U
* device instance $2588 r0 *1 63.865,47.88 nfet_03v3
M$2588 \$434 \$433 VSS VSS nfet_03v3 L=1.03U W=1U AS=0.49P AD=0.44P PS=2.98U
+ PD=2.88U
* device instance $2589 r0 *1 69.465,46.205 nfet_03v3
M$2589 \$374 \$373 VSS VSS nfet_03v3 L=7.75U W=0.99U AS=0.4851P AD=0.4356P
+ PS=2.96U PD=2.86U
* device instance $2590 r0 *1 71.145,47.875 nfet_03v3
M$2590 \$436 \$435 VSS VSS nfet_03v3 L=7.75U W=0.99U AS=0.4851P AD=0.4356P
+ PS=2.96U PD=2.86U
* device instance $2591 r0 *1 78.425,46.205 nfet_03v3
M$2591 \$376 \$375 VSS VSS nfet_03v3 L=7.75U W=0.99U AS=0.4851P AD=0.4356P
+ PS=2.96U PD=2.86U
* device instance $2592 r0 *1 80.105,47.875 nfet_03v3
M$2592 \$438 \$437 VSS VSS nfet_03v3 L=7.75U W=0.99U AS=0.4851P AD=0.4356P
+ PS=2.96U PD=2.86U
* device instance $2593 r0 *1 89.065,47.875 nfet_03v3
M$2593 \$440 \$439 VSS VSS nfet_03v3 L=7.75U W=0.99U AS=0.4851P AD=0.4356P
+ PS=2.96U PD=2.86U
* device instance $2594 r0 *1 90.745,46.205 nfet_03v3
M$2594 \$380 \$379 VSS VSS nfet_03v3 L=7.75U W=0.99U AS=0.4851P AD=0.4356P
+ PS=2.96U PD=2.86U
* device instance $2595 r0 *1 95.785,47.875 nfet_03v3
M$2595 \$442 \$441 VSS VSS nfet_03v3 L=3.27U W=0.99U AS=0.4851P AD=0.4356P
+ PS=2.96U PD=2.86U
* device instance $2596 r0 *1 99.705,46.205 nfet_03v3
M$2596 \$382 \$381 VSS VSS nfet_03v3 L=7.75U W=0.99U AS=0.4851P AD=0.4356P
+ PS=2.96U PD=2.86U
* device instance $2597 r0 *1 100.16,47.88 nfet_03v3
M$2597 A|Y$36 \$443 VSS VSS nfet_03v3 L=0.28U W=2U AS=1.02P AD=0.52P PS=5.04U
+ PD=3.04U
* device instance $2599 r0 *1 101.76,47.88 nfet_03v3
M$2599 \$443 A|Y$37 VSS VSS nfet_03v3 L=0.28U W=1U AS=0.26P AD=0.44P PS=1.52U
+ PD=2.88U
* device instance $2600 r0 *1 103.625,47.88 nfet_03v3
M$2600 \$447 \$446 VSS VSS nfet_03v3 L=1.03U W=1U AS=0.49P AD=0.44P PS=2.98U
+ PD=2.88U
* device instance $2601 r0 *1 106.425,46.205 nfet_03v3
M$2601 \$384 \$383 VSS VSS nfet_03v3 L=3.27U W=0.99U AS=0.4851P AD=0.4356P
+ PS=2.96U PD=2.86U
* device instance $2602 r0 *1 106.88,47.88 nfet_03v3
M$2602 A|Y$38 \$448 VSS VSS nfet_03v3 L=0.28U W=2U AS=1.02P AD=0.52P PS=5.04U
+ PD=3.04U
* device instance $2604 r0 *1 108.48,47.88 nfet_03v3
M$2604 \$448 A|Y$39 VSS VSS nfet_03v3 L=0.28U W=1U AS=0.26P AD=0.44P PS=1.52U
+ PD=2.88U
* device instance $2605 r0 *1 109.92,47.88 nfet_03v3
M$2605 VSS A|Y$38 \$451 VSS nfet_03v3 L=0.28U W=1U AS=0.44P AD=0.26P PS=2.88U
+ PD=1.52U
* device instance $2606 r0 *1 110.72,47.88 nfet_03v3
M$2606 A|Y$40 \$451 VSS VSS nfet_03v3 L=0.28U W=2U AS=0.52P AD=1.02P PS=3.04U
+ PD=5.04U
* device instance $2608 r0 *1 113.28,47.88 nfet_03v3
M$2608 VSS A|Y$40 \$453 VSS nfet_03v3 L=0.28U W=1U AS=0.44P AD=0.26P PS=2.88U
+ PD=1.52U
* device instance $2609 r0 *1 114.08,47.88 nfet_03v3
M$2609 A|Y$25 \$453 VSS VSS nfet_03v3 L=0.28U W=2U AS=0.52P AD=1.02P PS=3.04U
+ PD=5.04U
* device instance $2611 r0 *1 118.185,46.205 nfet_03v3
M$2611 \$387 \$386 VSS VSS nfet_03v3 L=7.75U W=0.99U AS=0.4851P AD=0.4356P
+ PS=2.96U PD=2.86U
* device instance $2612 r0 *1 116.96,47.88 nfet_03v3
M$2612 A|Y$41 \$454 VSS VSS nfet_03v3 L=0.28U W=2U AS=1.02P AD=0.52P PS=5.04U
+ PD=3.04U
* device instance $2614 r0 *1 118.56,47.88 nfet_03v3
M$2614 \$454 A|Y$42 VSS VSS nfet_03v3 L=0.28U W=1U AS=0.26P AD=0.44P PS=1.52U
+ PD=2.88U
* device instance $2615 r0 *1 123.785,47.875 nfet_03v3
M$2615 \$458 \$457 VSS VSS nfet_03v3 L=7.75U W=0.99U AS=0.4851P AD=0.4356P
+ PS=2.96U PD=2.86U
* device instance $2616 r0 *1 129.945,46.205 nfet_03v3
M$2616 \$389 \$388 VSS VSS nfet_03v3 L=7.75U W=0.99U AS=0.4851P AD=0.4356P
+ PS=2.96U PD=2.86U
* device instance $2617 r0 *1 132.745,47.875 nfet_03v3
M$2617 \$460 \$459 VSS VSS nfet_03v3 L=7.75U W=0.99U AS=0.4851P AD=0.4356P
+ PS=2.96U PD=2.86U
* device instance $2618 r0 *1 138.905,46.205 nfet_03v3
M$2618 \$391 \$390 VSS VSS nfet_03v3 L=7.75U W=0.99U AS=0.4851P AD=0.4356P
+ PS=2.96U PD=2.86U
* device instance $2619 r0 *1 139.465,47.875 nfet_03v3
M$2619 \$462 \$461 VSS VSS nfet_03v3 L=3.27U W=0.99U AS=0.4851P AD=0.4356P
+ PS=2.96U PD=2.86U
* device instance $2620 r0 *1 142.825,47.88 nfet_03v3
M$2620 \$464 \$463 VSS VSS nfet_03v3 L=1.03U W=1U AS=0.49P AD=0.44P PS=2.98U
+ PD=2.88U
* device instance $2621 r0 *1 145.625,46.205 nfet_03v3
M$2621 \$393 \$392 VSS VSS nfet_03v3 L=3.27U W=0.99U AS=0.4851P AD=0.4356P
+ PS=2.96U PD=2.86U
* device instance $2622 r0 *1 146.185,47.88 nfet_03v3
M$2622 \$466 \$465 VSS VSS nfet_03v3 L=1.03U W=1U AS=0.49P AD=0.44P PS=2.98U
+ PD=2.88U
* device instance $2623 r0 *1 149.2,47.88 nfet_03v3
M$2623 A|Y$44 B|Y$17 \$467 VSS nfet_03v3 L=0.28U W=2U AS=0.775P AD=0.52P
+ PS=4.55U PD=3.04U
* device instance $2625 r0 *1 150.8,47.88 nfet_03v3
M$2625 VSS \$469 \$467 VSS nfet_03v3 L=0.28U W=2U AS=0.52P AD=0.7P PS=3.04U
+ PD=4.4U
* device instance $2627 r0 *1 153.04,47.88 nfet_03v3
M$2627 VSS A|Y$43 \$469 VSS nfet_03v3 L=0.28U W=1U AS=0.44P AD=0.46P PS=2.88U
+ PD=2.92U
* device instance $2628 r0 *1 154.8,47.88 nfet_03v3
M$2628 B|Y$18 B|Y$15 \$471 VSS nfet_03v3 L=0.28U W=2U AS=0.775P AD=0.52P
+ PS=4.55U PD=3.04U
* device instance $2630 r0 *1 156.4,47.88 nfet_03v3
M$2630 VSS A|Y$44 \$471 VSS nfet_03v3 L=0.28U W=2U AS=0.52P AD=0.7P PS=3.04U
+ PD=4.4U
* device instance $2632 r0 *1 159.52,47.88 nfet_03v3
M$2632 A|Y$16 \$473 VSS VSS nfet_03v3 L=0.28U W=2U AS=1.02P AD=0.52P PS=5.04U
+ PD=3.04U
* device instance $2634 r0 *1 161.12,47.88 nfet_03v3
M$2634 \$473 A|COARSE_MUX[9] VSS VSS nfet_03v3 L=0.28U W=1U AS=0.26P AD=0.44P
+ PS=1.52U PD=2.88U
* device instance $2635 r0 *1 17.945,54.04 nfet_03v3
M$2635 \$479 \$478 VSS VSS nfet_03v3 L=1.03U W=1U AS=0.49P AD=0.44P PS=2.98U
+ PD=2.88U
* device instance $2636 r0 *1 21.76,54.04 nfet_03v3
M$2636 A|Y$45 \$529 VSS VSS nfet_03v3 L=0.28U W=2U AS=1.02P AD=0.52P PS=5.04U
+ PD=3.04U
* device instance $2638 r0 *1 23.36,54.04 nfet_03v3
M$2638 \$529 A|Y$46 VSS VSS nfet_03v3 L=0.28U W=1U AS=0.26P AD=0.44P PS=1.52U
+ PD=2.88U
* device instance $2639 r0 *1 25.12,54.04 nfet_03v3
M$2639 A|Y$46 \$530 VSS VSS nfet_03v3 L=0.28U W=2U AS=1.02P AD=0.52P PS=5.04U
+ PD=3.04U
* device instance $2641 r0 *1 26.72,54.04 nfet_03v3
M$2641 \$530 A|Y$47 VSS VSS nfet_03v3 L=0.28U W=1U AS=0.26P AD=0.44P PS=1.52U
+ PD=2.88U
* device instance $2642 r0 *1 28.48,54.04 nfet_03v3
M$2642 A|Y$47 \$531 VSS VSS nfet_03v3 L=0.28U W=2U AS=1.02P AD=0.52P PS=5.04U
+ PD=3.04U
* device instance $2644 r0 *1 30.08,54.04 nfet_03v3
M$2644 \$531 A|Y$48 VSS VSS nfet_03v3 L=0.28U W=1U AS=0.26P AD=0.44P PS=1.52U
+ PD=2.88U
* device instance $2645 r0 *1 31.52,54.04 nfet_03v3
M$2645 VSS A|Y$21 \$484 VSS nfet_03v3 L=0.28U W=1U AS=0.44P AD=0.26P PS=2.88U
+ PD=1.52U
* device instance $2646 r0 *1 32.32,54.04 nfet_03v3
M$2646 A|Y$24 \$484 VSS VSS nfet_03v3 L=0.28U W=2U AS=0.52P AD=1.02P PS=3.04U
+ PD=5.04U
* device instance $2648 r0 *1 40.24,54.04 nfet_03v3
M$2648 A|Y$49 \$532 VSS VSS nfet_03v3 L=0.28U W=2U AS=1.02P AD=0.52P PS=5.04U
+ PD=3.04U
* device instance $2650 r0 *1 41.84,54.04 nfet_03v3
M$2650 \$532 A|Y$29 VSS VSS nfet_03v3 L=0.28U W=1U AS=0.26P AD=0.44P PS=1.52U
+ PD=2.88U
* device instance $2651 r0 *1 43.6,54.04 nfet_03v3
M$2651 A|Y$50 \$533 VSS VSS nfet_03v3 L=0.28U W=2U AS=1.02P AD=0.52P PS=5.04U
+ PD=3.04U
* device instance $2653 r0 *1 45.2,54.04 nfet_03v3
M$2653 \$533 A|Y$30 VSS VSS nfet_03v3 L=0.28U W=1U AS=0.26P AD=0.44P PS=1.52U
+ PD=2.88U
* device instance $2654 r0 *1 48.08,54.04 nfet_03v3
M$2654 A|Y$51 \$534 VSS VSS nfet_03v3 L=0.28U W=2U AS=1.02P AD=0.52P PS=5.04U
+ PD=3.04U
* device instance $2656 r0 *1 49.68,54.04 nfet_03v3
M$2656 \$534 A|Y$31 VSS VSS nfet_03v3 L=0.28U W=1U AS=0.26P AD=0.44P PS=1.52U
+ PD=2.88U
* device instance $2657 r0 *1 51.44,54.04 nfet_03v3
M$2657 A|Y$33 \$535 VSS VSS nfet_03v3 L=0.28U W=2U AS=1.02P AD=0.52P PS=5.04U
+ PD=3.04U
* device instance $2659 r0 *1 53.04,54.04 nfet_03v3
M$2659 \$535 A|Y$52 VSS VSS nfet_03v3 L=0.28U W=1U AS=0.26P AD=0.44P PS=1.52U
+ PD=2.88U
* device instance $2660 r0 *1 54.8,54.04 nfet_03v3
M$2660 A|Y$53 \$536 VSS VSS nfet_03v3 L=0.28U W=2U AS=1.02P AD=0.52P PS=5.04U
+ PD=3.04U
* device instance $2662 r0 *1 56.4,54.04 nfet_03v3
M$2662 \$536 A|Y$54 VSS VSS nfet_03v3 L=0.28U W=1U AS=0.26P AD=0.44P PS=1.52U
+ PD=2.88U
* device instance $2663 r0 *1 58.16,54.04 nfet_03v3
M$2663 A|Y$55 \$537 VSS VSS nfet_03v3 L=0.28U W=2U AS=1.02P AD=0.52P PS=5.04U
+ PD=3.04U
* device instance $2665 r0 *1 59.76,54.04 nfet_03v3
M$2665 \$537 A|Y$35 VSS VSS nfet_03v3 L=0.28U W=1U AS=0.26P AD=0.44P PS=1.52U
+ PD=2.88U
* device instance $2666 r0 *1 61.2,54.04 nfet_03v3
M$2666 VSS A|Y$55 \$494 VSS nfet_03v3 L=0.28U W=1U AS=0.44P AD=0.26P PS=2.88U
+ PD=1.52U
* device instance $2667 r0 *1 62,54.04 nfet_03v3
M$2667 A|Y$56 \$494 VSS VSS nfet_03v3 L=0.28U W=2U AS=0.52P AD=1.02P PS=3.04U
+ PD=5.04U
* device instance $2669 r0 *1 64.56,54.04 nfet_03v3
M$2669 VSS A|Y$56 \$496 VSS nfet_03v3 L=0.28U W=1U AS=0.44P AD=0.26P PS=2.88U
+ PD=1.52U
* device instance $2670 r0 *1 65.36,54.04 nfet_03v3
M$2670 A|Y$57 \$496 VSS VSS nfet_03v3 L=0.28U W=2U AS=0.52P AD=1.02P PS=3.04U
+ PD=5.04U
* device instance $2672 r0 *1 67.92,54.04 nfet_03v3
M$2672 VSS A|Y$57 \$498 VSS nfet_03v3 L=0.28U W=1U AS=0.44P AD=0.26P PS=2.88U
+ PD=1.52U
* device instance $2673 r0 *1 68.72,54.04 nfet_03v3
M$2673 A|Y$58 \$498 VSS VSS nfet_03v3 L=0.28U W=2U AS=0.52P AD=1.02P PS=3.04U
+ PD=5.04U
* device instance $2675 r0 *1 71.84,54.04 nfet_03v3
M$2675 VSS A|Y$67 \$500 VSS nfet_03v3 L=0.28U W=1U AS=0.44P AD=0.26P PS=2.88U
+ PD=1.52U
* device instance $2676 r0 *1 72.64,54.04 nfet_03v3
M$2676 A|Y$59 \$500 VSS VSS nfet_03v3 L=0.28U W=2U AS=0.52P AD=1.02P PS=3.04U
+ PD=5.04U
* device instance $2678 r0 *1 97.36,54.04 nfet_03v3
M$2678 A|Y$60 \$539 VSS VSS nfet_03v3 L=0.28U W=2U AS=1.02P AD=0.52P PS=5.04U
+ PD=3.04U
* device instance $2680 r0 *1 98.96,54.04 nfet_03v3
M$2680 \$539 A|Y$61 VSS VSS nfet_03v3 L=0.28U W=1U AS=0.26P AD=0.44P PS=1.52U
+ PD=2.88U
* device instance $2681 r0 *1 100.4,54.04 nfet_03v3
M$2681 VSS A|Y$60 \$508 VSS nfet_03v3 L=0.28U W=1U AS=0.44P AD=0.26P PS=2.88U
+ PD=1.52U
* device instance $2682 r0 *1 101.2,54.04 nfet_03v3
M$2682 A|Y$37 \$508 VSS VSS nfet_03v3 L=0.28U W=2U AS=0.52P AD=1.02P PS=3.04U
+ PD=5.04U
* device instance $2684 r0 *1 103.76,54.04 nfet_03v3
M$2684 VSS A|Y$36 \$509 VSS nfet_03v3 L=0.28U W=1U AS=0.44P AD=0.26P PS=2.88U
+ PD=1.52U
* device instance $2685 r0 *1 104.56,54.04 nfet_03v3
M$2685 A|Y$62 \$509 VSS VSS nfet_03v3 L=0.28U W=2U AS=0.52P AD=1.02P PS=3.04U
+ PD=5.04U
* device instance $2687 r0 *1 107.12,54.04 nfet_03v3
M$2687 VSS A|Y$62 \$511 VSS nfet_03v3 L=0.28U W=1U AS=0.44P AD=0.26P PS=2.88U
+ PD=1.52U
* device instance $2688 r0 *1 107.92,54.04 nfet_03v3
M$2688 A|Y$39 \$511 VSS VSS nfet_03v3 L=0.28U W=2U AS=0.52P AD=1.02P PS=3.04U
+ PD=5.04U
* device instance $2690 r0 *1 110.905,54.04 nfet_03v3
M$2690 \$513 \$512 VSS VSS nfet_03v3 L=1.03U W=1U AS=0.49P AD=0.44P PS=2.98U
+ PD=2.88U
* device instance $2691 r0 *1 112.72,54.04 nfet_03v3
M$2691 VSS A|Y$23 \$514 VSS nfet_03v3 L=0.28U W=1U AS=0.44P AD=0.26P PS=2.88U
+ PD=1.52U
* device instance $2692 r0 *1 113.52,54.04 nfet_03v3
M$2692 A|Y$63 \$514 VSS VSS nfet_03v3 L=0.28U W=2U AS=0.52P AD=1.02P PS=3.04U
+ PD=5.04U
* device instance $2694 r0 *1 116.4,54.04 nfet_03v3
M$2694 A|Y$64 \$540 VSS VSS nfet_03v3 L=0.28U W=2U AS=1.02P AD=0.52P PS=5.04U
+ PD=3.04U
* device instance $2696 r0 *1 118,54.04 nfet_03v3
M$2696 \$540 A|Y$41 VSS VSS nfet_03v3 L=0.28U W=1U AS=0.26P AD=0.44P PS=1.52U
+ PD=2.88U
* device instance $2697 r0 *1 119.44,54.04 nfet_03v3
M$2697 VSS A|Y$63 \$517 VSS nfet_03v3 L=0.28U W=1U AS=0.44P AD=0.26P PS=2.88U
+ PD=1.52U
* device instance $2698 r0 *1 120.24,54.04 nfet_03v3
M$2698 A|Y$42 \$517 VSS VSS nfet_03v3 L=0.28U W=2U AS=0.52P AD=1.02P PS=3.04U
+ PD=5.04U
* device instance $2700 r0 *1 123.225,54.04 nfet_03v3
M$2700 \$519 \$518 VSS VSS nfet_03v3 L=1.03U W=1U AS=0.49P AD=0.44P PS=2.98U
+ PD=2.88U
* device instance $2701 r0 *1 145.2,54.04 nfet_03v3
M$2701 VSS A|Y$65 \$543 VSS nfet_03v3 L=0.28U W=2U AS=0.7P AD=0.52P PS=4.4U
+ PD=3.04U
* device instance $2703 r0 *1 146.8,54.04 nfet_03v3
M$2703 B|Y$19 B|Y$18 \$543 VSS nfet_03v3 L=0.28U W=2U AS=0.52P AD=0.775P
+ PS=3.04U PD=4.55U
* device instance $2705 r0 *1 149.2,54.04 nfet_03v3
M$2705 B|Y$17 B|Y$20 \$544 VSS nfet_03v3 L=0.28U W=2U AS=0.775P AD=0.52P
+ PS=4.55U PD=3.04U
* device instance $2707 r0 *1 150.8,54.04 nfet_03v3
M$2707 VSS A|Y$66 \$544 VSS nfet_03v3 L=0.28U W=2U AS=0.52P AD=0.7P PS=3.04U
+ PD=4.4U
* device instance $2709 r0 *1 153.04,54.04 nfet_03v3
M$2709 VSS A|Y$43 \$545 VSS nfet_03v3 L=0.28U W=2U AS=0.7P AD=0.52P PS=4.4U
+ PD=3.04U
* device instance $2711 r0 *1 154.64,54.04 nfet_03v3
M$2711 B|Y$16 B|Y$17 \$545 VSS nfet_03v3 L=0.28U W=2U AS=0.52P AD=0.775P
+ PS=3.04U PD=4.55U
* device instance $2713 r0 *1 157.385,54.04 nfet_03v3
M$2713 \$528 \$527 VSS VSS nfet_03v3 L=1.03U W=1U AS=0.49P AD=0.44P PS=2.98U
+ PD=2.88U
* device instance $2714 r0 *1 159.52,54.04 nfet_03v3
M$2714 A|Y$43 \$542 VSS VSS nfet_03v3 L=0.28U W=2U AS=1.02P AD=0.52P PS=5.04U
+ PD=3.04U
* device instance $2716 r0 *1 161.12,54.04 nfet_03v3
M$2716 \$542 A|COARSE_MUX[6] VSS VSS nfet_03v3 L=0.28U W=1U AS=0.26P AD=0.44P
+ PS=1.52U PD=2.88U
* device instance $2717 r0 *1 12.345,54.045 nfet_03v3
M$2717 \$477 \$476 VSS VSS nfet_03v3 L=7.75U W=0.99U AS=0.4851P AD=0.4356P
+ PS=2.96U PD=2.86U
* device instance $2718 r0 *1 12.345,55.715 nfet_03v3
M$2718 \$564 \$563 VSS VSS nfet_03v3 L=7.75U W=0.99U AS=0.4851P AD=0.4356P
+ PS=2.96U PD=2.86U
* device instance $2719 r0 *1 21.305,55.715 nfet_03v3
M$2719 \$566 \$565 VSS VSS nfet_03v3 L=7.75U W=0.99U AS=0.4851P AD=0.4356P
+ PS=2.96U PD=2.86U
* device instance $2720 r0 *1 28.72,55.72 nfet_03v3
M$2720 VSS A|Y$77 \$567 VSS nfet_03v3 L=0.28U W=1U AS=0.44P AD=0.26P PS=2.88U
+ PD=1.52U
* device instance $2721 r0 *1 29.52,55.72 nfet_03v3
M$2721 A|Y$48 \$567 VSS VSS nfet_03v3 L=0.28U W=2U AS=0.52P AD=1.02P PS=3.04U
+ PD=5.04U
* device instance $2723 r0 *1 35.865,55.715 nfet_03v3
M$2723 \$570 \$569 VSS VSS nfet_03v3 L=7.75U W=0.99U AS=0.4851P AD=0.4356P
+ PS=2.96U PD=2.86U
* device instance $2724 r0 *1 36.425,54.045 nfet_03v3
M$2724 \$486 \$485 VSS VSS nfet_03v3 L=3.27U W=0.99U AS=0.4851P AD=0.4356P
+ PS=2.96U PD=2.86U
* device instance $2725 r0 *1 42.585,55.715 nfet_03v3
M$2725 \$572 \$571 VSS VSS nfet_03v3 L=3.27U W=0.99U AS=0.4851P AD=0.4356P
+ PS=2.96U PD=2.86U
* device instance $2726 r0 *1 45.945,55.72 nfet_03v3
M$2726 \$546 \$573 VSS VSS nfet_03v3 L=1.03U W=1U AS=0.49P AD=0.44P PS=2.98U
+ PD=2.88U
* device instance $2727 r0 *1 48.32,55.72 nfet_03v3
M$2727 VSS A|Y$50 \$574 VSS nfet_03v3 L=0.28U W=1U AS=0.44P AD=0.26P PS=2.88U
+ PD=1.52U
* device instance $2728 r0 *1 49.12,55.72 nfet_03v3
M$2728 A|Y$32 \$574 VSS VSS nfet_03v3 L=0.28U W=2U AS=0.52P AD=1.02P PS=3.04U
+ PD=5.04U
* device instance $2730 r0 *1 51.68,55.72 nfet_03v3
M$2730 VSS A|Y$51 \$575 VSS nfet_03v3 L=0.28U W=1U AS=0.44P AD=0.26P PS=2.88U
+ PD=1.52U
* device instance $2731 r0 *1 52.48,55.72 nfet_03v3
M$2731 A|Y$52 \$575 VSS VSS nfet_03v3 L=0.28U W=2U AS=0.52P AD=1.02P PS=3.04U
+ PD=5.04U
* device instance $2733 r0 *1 55.465,55.72 nfet_03v3
M$2733 \$547 \$576 VSS VSS nfet_03v3 L=1.03U W=1U AS=0.49P AD=0.44P PS=2.98U
+ PD=2.88U
* device instance $2734 r0 *1 57.28,55.72 nfet_03v3
M$2734 VSS A|Y$34 \$577 VSS nfet_03v3 L=0.28U W=1U AS=0.44P AD=0.26P PS=2.88U
+ PD=1.52U
* device instance $2735 r0 *1 58.08,55.72 nfet_03v3
M$2735 A|Y$54 \$577 VSS VSS nfet_03v3 L=0.28U W=2U AS=0.52P AD=1.02P PS=3.04U
+ PD=5.04U
* device instance $2737 r0 *1 62.185,55.715 nfet_03v3
M$2737 \$579 \$578 VSS VSS nfet_03v3 L=3.27U W=0.99U AS=0.4851P AD=0.4356P
+ PS=2.96U PD=2.86U
* device instance $2738 r0 *1 67.785,55.72 nfet_03v3
M$2738 \$548 \$580 VSS VSS nfet_03v3 L=1.03U W=1U AS=0.49P AD=0.44P PS=2.98U
+ PD=2.88U
* device instance $2739 r0 *1 70.48,55.72 nfet_03v3
M$2739 A|Y$78 \$581 VSS VSS nfet_03v3 L=0.28U W=2U AS=1.02P AD=0.52P PS=5.04U
+ PD=3.04U
* device instance $2741 r0 *1 72.08,55.72 nfet_03v3
M$2741 \$581 A|Y$59 VSS VSS nfet_03v3 L=0.28U W=1U AS=0.26P AD=0.44P PS=1.52U
+ PD=2.88U
* device instance $2742 r0 *1 73.52,55.72 nfet_03v3
M$2742 VSS A|Y$78 \$582 VSS nfet_03v3 L=0.28U W=1U AS=0.44P AD=0.26P PS=2.88U
+ PD=1.52U
* device instance $2743 r0 *1 74.32,55.72 nfet_03v3
M$2743 A|Y$68 \$582 VSS VSS nfet_03v3 L=0.28U W=2U AS=0.52P AD=1.02P PS=3.04U
+ PD=5.04U
* device instance $2745 r0 *1 78.985,54.045 nfet_03v3
M$2745 \$503 \$502 VSS VSS nfet_03v3 L=7.75U W=0.99U AS=0.4851P AD=0.4356P
+ PS=2.96U PD=2.86U
* device instance $2746 r0 *1 76.88,55.72 nfet_03v3
M$2746 VSS A|Y$68 \$584 VSS nfet_03v3 L=0.28U W=1U AS=0.44P AD=0.26P PS=2.88U
+ PD=1.52U
* device instance $2747 r0 *1 77.68,55.72 nfet_03v3
M$2747 A|Y$69 \$584 VSS VSS nfet_03v3 L=0.28U W=2U AS=0.52P AD=1.02P PS=3.04U
+ PD=5.04U
* device instance $2749 r0 *1 80.24,55.72 nfet_03v3
M$2749 VSS A|Y$69 \$585 VSS nfet_03v3 L=0.28U W=1U AS=0.44P AD=0.26P PS=2.88U
+ PD=1.52U
* device instance $2750 r0 *1 81.04,55.72 nfet_03v3
M$2750 A|Y$70 \$585 VSS VSS nfet_03v3 L=0.28U W=2U AS=0.52P AD=1.02P PS=3.04U
+ PD=5.04U
* device instance $2752 r0 *1 84.16,55.72 nfet_03v3
M$2752 VSS A|Y$79 \$587 VSS nfet_03v3 L=0.28U W=1U AS=0.44P AD=0.26P PS=2.88U
+ PD=1.52U
* device instance $2753 r0 *1 84.96,55.72 nfet_03v3
M$2753 A|Y$71 \$587 VSS VSS nfet_03v3 L=0.28U W=2U AS=0.52P AD=1.02P PS=3.04U
+ PD=5.04U
* device instance $2755 r0 *1 90.745,54.045 nfet_03v3
M$2755 \$505 \$504 VSS VSS nfet_03v3 L=7.75U W=0.99U AS=0.4851P AD=0.4356P
+ PS=2.96U PD=2.86U
* device instance $2756 r0 *1 87.52,55.72 nfet_03v3
M$2756 VSS A|Y$85 \$588 VSS nfet_03v3 L=0.28U W=1U AS=0.44P AD=0.26P PS=2.88U
+ PD=1.52U
* device instance $2757 r0 *1 88.32,55.72 nfet_03v3
M$2757 A|Y$72 \$588 VSS VSS nfet_03v3 L=0.28U W=2U AS=0.52P AD=1.02P PS=3.04U
+ PD=5.04U
* device instance $2759 r0 *1 91.305,55.72 nfet_03v3
M$2759 \$554 \$589 VSS VSS nfet_03v3 L=1.03U W=1U AS=0.49P AD=0.44P PS=2.98U
+ PD=2.88U
* device instance $2760 r0 *1 93.12,55.72 nfet_03v3
M$2760 VSS A|Y$80 \$590 VSS nfet_03v3 L=0.28U W=1U AS=0.44P AD=0.26P PS=2.88U
+ PD=1.52U
* device instance $2761 r0 *1 93.92,55.72 nfet_03v3
M$2761 A|Y$73 \$590 VSS VSS nfet_03v3 L=0.28U W=2U AS=0.52P AD=1.02P PS=3.04U
+ PD=5.04U
* device instance $2763 r0 *1 96.48,55.72 nfet_03v3
M$2763 VSS A|Y$73 \$592 VSS nfet_03v3 L=0.28U W=1U AS=0.44P AD=0.26P PS=2.88U
+ PD=1.52U
* device instance $2764 r0 *1 97.28,55.72 nfet_03v3
M$2764 A|Y$74 \$592 VSS VSS nfet_03v3 L=0.28U W=2U AS=0.52P AD=1.02P PS=3.04U
+ PD=5.04U
* device instance $2766 r0 *1 99.84,55.72 nfet_03v3
M$2766 VSS A|Y$74 \$593 VSS nfet_03v3 L=0.28U W=1U AS=0.44P AD=0.26P PS=2.88U
+ PD=1.52U
* device instance $2767 r0 *1 100.64,55.72 nfet_03v3
M$2767 A|Y$61 \$593 VSS VSS nfet_03v3 L=0.28U W=2U AS=0.52P AD=1.02P PS=3.04U
+ PD=5.04U
* device instance $2769 r0 *1 103.625,55.72 nfet_03v3
M$2769 \$557 \$594 VSS VSS nfet_03v3 L=1.03U W=1U AS=0.49P AD=0.44P PS=2.98U
+ PD=2.88U
* device instance $2770 r0 *1 108.105,55.715 nfet_03v3
M$2770 \$596 \$595 VSS VSS nfet_03v3 L=3.27U W=0.99U AS=0.4851P AD=0.4356P
+ PS=2.96U PD=2.86U
* device instance $2771 r0 *1 111.465,55.72 nfet_03v3
M$2771 \$558 \$597 VSS VSS nfet_03v3 L=1.03U W=1U AS=0.49P AD=0.44P PS=2.98U
+ PD=2.88U
* device instance $2772 r0 *1 114.72,55.72 nfet_03v3
M$2772 A|Y$81 \$598 VSS VSS nfet_03v3 L=0.28U W=2U AS=1.02P AD=0.52P PS=5.04U
+ PD=3.04U
* device instance $2774 r0 *1 116.32,55.72 nfet_03v3
M$2774 \$598 A|Y$64 VSS VSS nfet_03v3 L=0.28U W=1U AS=0.26P AD=0.44P PS=1.52U
+ PD=2.88U
* device instance $2775 r0 *1 117.76,55.72 nfet_03v3
M$2775 VSS A|Y$81 \$599 VSS nfet_03v3 L=0.28U W=1U AS=0.44P AD=0.26P PS=2.88U
+ PD=1.52U
* device instance $2776 r0 *1 118.56,55.72 nfet_03v3
M$2776 A|Y$75 \$599 VSS VSS nfet_03v3 L=0.28U W=2U AS=0.52P AD=1.02P PS=3.04U
+ PD=5.04U
* device instance $2778 r0 *1 124.905,55.715 nfet_03v3
M$2778 \$602 \$601 VSS VSS nfet_03v3 L=7.75U W=0.99U AS=0.4851P AD=0.4356P
+ PS=2.96U PD=2.86U
* device instance $2779 r0 *1 129.945,54.045 nfet_03v3
M$2779 \$521 \$520 VSS VSS nfet_03v3 L=7.75U W=0.99U AS=0.4851P AD=0.4356P
+ PS=2.96U PD=2.86U
* device instance $2780 r0 *1 133.865,55.715 nfet_03v3
M$2780 \$604 \$603 VSS VSS nfet_03v3 L=7.75U W=0.99U AS=0.4851P AD=0.4356P
+ PS=2.96U PD=2.86U
* device instance $2781 r0 *1 138.905,54.045 nfet_03v3
M$2781 \$523 \$522 VSS VSS nfet_03v3 L=7.75U W=0.99U AS=0.4851P AD=0.4356P
+ PS=2.96U PD=2.86U
* device instance $2782 r0 *1 140.16,55.72 nfet_03v3
M$2782 VSS A|Y$82 \$560 VSS nfet_03v3 L=0.28U W=2U AS=0.7P AD=0.52P PS=4.4U
+ PD=3.04U
* device instance $2784 r0 *1 141.76,55.72 nfet_03v3
M$2784 B|Y$21 B|Y$19 \$560 VSS nfet_03v3 L=0.28U W=2U AS=0.52P AD=0.775P
+ PS=3.04U PD=4.55U
* device instance $2786 r0 *1 145.84,55.72 nfet_03v3
M$2786 A|Y$65 B|Y$20 \$561 VSS nfet_03v3 L=0.28U W=2U AS=0.775P AD=0.52P
+ PS=4.55U PD=3.04U
* device instance $2788 r0 *1 147.44,55.72 nfet_03v3
M$2788 VSS \$606 \$561 VSS nfet_03v3 L=0.28U W=2U AS=0.52P AD=0.7P PS=3.04U
+ PD=4.4U
* device instance $2790 r0 *1 149.68,55.72 nfet_03v3
M$2790 VSS A|Y$66 \$606 VSS nfet_03v3 L=0.28U W=1U AS=0.44P AD=0.46P PS=2.88U
+ PD=2.92U
* device instance $2791 r0 *1 152.905,55.715 nfet_03v3
M$2791 \$608 \$607 VSS VSS nfet_03v3 L=3.27U W=0.99U AS=0.4851P AD=0.4356P
+ PS=2.96U PD=2.86U
* device instance $2792 r0 *1 156.16,55.72 nfet_03v3
M$2792 A|Y$66 \$609 VSS VSS nfet_03v3 L=0.28U W=2U AS=1.02P AD=0.52P PS=5.04U
+ PD=3.04U
* device instance $2794 r0 *1 157.76,55.72 nfet_03v3
M$2794 \$609 A|COARSE_MUX[5] VSS VSS nfet_03v3 L=0.28U W=1U AS=0.26P AD=0.44P
+ PS=1.52U PD=2.88U
* device instance $2795 r0 *1 159.52,55.72 nfet_03v3
M$2795 A|Y$76 \$611 VSS VSS nfet_03v3 L=0.28U W=2U AS=1.02P AD=0.52P PS=5.04U
+ PD=3.04U
* device instance $2797 r0 *1 161.12,55.72 nfet_03v3
M$2797 \$611 A|COARSE_MUX[4] VSS VSS nfet_03v3 L=0.28U W=1U AS=0.26P AD=0.44P
+ PS=1.52U PD=2.88U
* device instance $2798 r0 *1 12.345,61.885 nfet_03v3
M$2798 \$644 \$614 VSS VSS nfet_03v3 L=7.75U W=0.99U AS=0.4851P AD=0.4356P
+ PS=2.96U PD=2.86U
* device instance $2799 r0 *1 12.345,63.555 nfet_03v3
M$2799 \$678 \$677 VSS VSS nfet_03v3 L=7.75U W=0.99U AS=0.4851P AD=0.4356P
+ PS=2.96U PD=2.86U
* device instance $2800 r0 *1 21.305,61.885 nfet_03v3
M$2800 \$645 \$615 VSS VSS nfet_03v3 L=7.75U W=0.99U AS=0.4851P AD=0.4356P
+ PS=2.96U PD=2.86U
* device instance $2801 r0 *1 21.305,63.555 nfet_03v3
M$2801 \$680 \$679 VSS VSS nfet_03v3 L=7.75U W=0.99U AS=0.4851P AD=0.4356P
+ PS=2.96U PD=2.86U
* device instance $2802 r0 *1 28.585,63.56 nfet_03v3
M$2802 \$682 \$681 VSS VSS nfet_03v3 L=1.03U W=1U AS=0.49P AD=0.44P PS=2.98U
+ PD=2.88U
* device instance $2803 r0 *1 28.48,61.88 nfet_03v3
M$2803 A|Y$77 \$646 VSS VSS nfet_03v3 L=0.28U W=2U AS=1.02P AD=0.52P PS=5.04U
+ PD=3.04U
* device instance $2805 r0 *1 30.08,61.88 nfet_03v3
M$2805 \$646 A|Y$83 VSS VSS nfet_03v3 L=0.28U W=1U AS=0.26P AD=0.44P PS=1.52U
+ PD=2.88U
* device instance $2806 r0 *1 31.28,63.56 nfet_03v3
M$2806 A|Y$89 \$725 VSS VSS nfet_03v3 L=0.28U W=2U AS=1.02P AD=0.52P PS=5.04U
+ PD=3.04U
* device instance $2808 r0 *1 32.88,63.56 nfet_03v3
M$2808 \$725 A|Y$84 VSS VSS nfet_03v3 L=0.28U W=1U AS=0.26P AD=0.44P PS=1.52U
+ PD=2.88U
* device instance $2809 r0 *1 31.52,61.88 nfet_03v3
M$2809 VSS A|Y$89 \$616 VSS nfet_03v3 L=0.28U W=1U AS=0.44P AD=0.26P PS=2.88U
+ PD=1.52U
* device instance $2810 r0 *1 32.32,61.88 nfet_03v3
M$2810 A|Y$83 \$616 VSS VSS nfet_03v3 L=0.28U W=2U AS=0.52P AD=1.02P PS=3.04U
+ PD=5.04U
* device instance $2812 r0 *1 34.64,63.56 nfet_03v3
M$2812 A|Y$90 \$726 VSS VSS nfet_03v3 L=0.28U W=2U AS=1.02P AD=0.52P PS=5.04U
+ PD=3.04U
* device instance $2814 r0 *1 36.24,63.56 nfet_03v3
M$2814 \$726 A|Y$92 VSS VSS nfet_03v3 L=0.28U W=1U AS=0.26P AD=0.44P PS=1.52U
+ PD=2.88U
* device instance $2815 r0 *1 35.2,61.88 nfet_03v3
M$2815 A|Y$84 \$648 VSS VSS nfet_03v3 L=0.28U W=2U AS=1.02P AD=0.52P PS=5.04U
+ PD=3.04U
* device instance $2817 r0 *1 36.8,61.88 nfet_03v3
M$2817 \$648 A|Y$90 VSS VSS nfet_03v3 L=0.28U W=1U AS=0.26P AD=0.44P PS=1.52U
+ PD=2.88U
* device instance $2818 r0 *1 37.68,63.56 nfet_03v3
M$2818 VSS A|Y$99 \$683 VSS nfet_03v3 L=0.28U W=1U AS=0.44P AD=0.26P PS=2.88U
+ PD=1.52U
* device instance $2819 r0 *1 38.48,63.56 nfet_03v3
M$2819 A|Y$92 \$683 VSS VSS nfet_03v3 L=0.28U W=2U AS=0.52P AD=1.02P PS=3.04U
+ PD=5.04U
* device instance $2821 r0 *1 39.785,61.885 nfet_03v3
M$2821 \$650 \$619 VSS VSS nfet_03v3 L=3.27U W=0.99U AS=0.4851P AD=0.4356P
+ PS=2.96U PD=2.86U
* device instance $2822 r0 *1 44.825,63.555 nfet_03v3
M$2822 \$686 \$685 VSS VSS nfet_03v3 L=7.75U W=0.99U AS=0.4851P AD=0.4356P
+ PS=2.96U PD=2.86U
* device instance $2823 r0 *1 43.145,61.88 nfet_03v3
M$2823 \$651 \$620 VSS VSS nfet_03v3 L=1.03U W=1U AS=0.49P AD=0.44P PS=2.98U
+ PD=2.88U
* device instance $2824 r0 *1 51.545,61.885 nfet_03v3
M$2824 \$652 \$621 VSS VSS nfet_03v3 L=7.75U W=0.99U AS=0.4851P AD=0.4356P
+ PS=2.96U PD=2.86U
* device instance $2825 r0 *1 50.32,63.56 nfet_03v3
M$2825 A|Y$93 \$728 VSS VSS nfet_03v3 L=0.28U W=2U AS=1.02P AD=0.52P PS=5.04U
+ PD=3.04U
* device instance $2827 r0 *1 51.92,63.56 nfet_03v3
M$2827 \$728 A|Y$94 VSS VSS nfet_03v3 L=0.28U W=1U AS=0.26P AD=0.44P PS=1.52U
+ PD=2.88U
* device instance $2828 r0 *1 54.905,63.555 nfet_03v3
M$2828 \$690 \$689 VSS VSS nfet_03v3 L=3.27U W=0.99U AS=0.4851P AD=0.4356P
+ PS=2.96U PD=2.86U
* device instance $2829 r0 *1 60.505,61.885 nfet_03v3
M$2829 \$653 \$622 VSS VSS nfet_03v3 L=7.75U W=0.99U AS=0.4851P AD=0.4356P
+ PS=2.96U PD=2.86U
* device instance $2830 r0 *1 58.265,63.56 nfet_03v3
M$2830 \$692 \$691 VSS VSS nfet_03v3 L=1.03U W=1U AS=0.49P AD=0.44P PS=2.98U
+ PD=2.88U
* device instance $2831 r0 *1 60.96,63.56 nfet_03v3
M$2831 A|Y$95 \$729 VSS VSS nfet_03v3 L=0.28U W=2U AS=1.02P AD=0.52P PS=5.04U
+ PD=3.04U
* device instance $2833 r0 *1 62.56,63.56 nfet_03v3
M$2833 \$729 A|Y$96 VSS VSS nfet_03v3 L=0.28U W=1U AS=0.26P AD=0.44P PS=1.52U
+ PD=2.88U
* device instance $2834 r0 *1 64.425,63.56 nfet_03v3
M$2834 \$696 \$695 VSS VSS nfet_03v3 L=1.03U W=1U AS=0.49P AD=0.44P PS=2.98U
+ PD=2.88U
* device instance $2835 r0 *1 66.105,61.88 nfet_03v3
M$2835 \$654 \$623 VSS VSS nfet_03v3 L=1.03U W=1U AS=0.49P AD=0.44P PS=2.98U
+ PD=2.88U
* device instance $2836 r0 *1 71.145,63.555 nfet_03v3
M$2836 \$698 \$697 VSS VSS nfet_03v3 L=7.75U W=0.99U AS=0.4851P AD=0.4356P
+ PS=2.96U PD=2.86U
* device instance $2837 r0 *1 69.04,61.88 nfet_03v3
M$2837 VSS A|Y$58 \$624 VSS nfet_03v3 L=0.28U W=1U AS=0.44P AD=0.26P PS=2.88U
+ PD=1.52U
* device instance $2838 r0 *1 69.84,61.88 nfet_03v3
M$2838 A|Y$67 \$624 VSS VSS nfet_03v3 L=0.28U W=2U AS=0.52P AD=1.02P PS=3.04U
+ PD=5.04U
* device instance $2840 r0 *1 73.945,61.885 nfet_03v3
M$2840 \$655 \$625 VSS VSS nfet_03v3 L=3.27U W=0.99U AS=0.4851P AD=0.4356P
+ PS=2.96U PD=2.86U
* device instance $2841 r0 *1 80.105,63.555 nfet_03v3
M$2841 \$700 \$699 VSS VSS nfet_03v3 L=7.75U W=0.99U AS=0.4851P AD=0.4356P
+ PS=2.96U PD=2.86U
* device instance $2842 r0 *1 77.305,61.88 nfet_03v3
M$2842 \$656 \$626 VSS VSS nfet_03v3 L=1.03U W=1U AS=0.49P AD=0.44P PS=2.98U
+ PD=2.88U
* device instance $2843 r0 *1 79.44,61.88 nfet_03v3
M$2843 A|Y$79 \$657 VSS VSS nfet_03v3 L=0.28U W=2U AS=1.02P AD=0.52P PS=5.04U
+ PD=3.04U
* device instance $2845 r0 *1 81.04,61.88 nfet_03v3
M$2845 \$657 A|Y$70 VSS VSS nfet_03v3 L=0.28U W=1U AS=0.26P AD=0.44P PS=1.52U
+ PD=2.88U
* device instance $2846 r0 *1 82.8,61.88 nfet_03v3
M$2846 A|Y$85 \$658 VSS VSS nfet_03v3 L=0.28U W=2U AS=1.02P AD=0.52P PS=5.04U
+ PD=3.04U
* device instance $2848 r0 *1 84.4,61.88 nfet_03v3
M$2848 \$658 A|Y$71 VSS VSS nfet_03v3 L=0.28U W=1U AS=0.26P AD=0.44P PS=1.52U
+ PD=2.88U
* device instance $2849 r0 *1 89.065,63.555 nfet_03v3
M$2849 \$702 \$701 VSS VSS nfet_03v3 L=7.75U W=0.99U AS=0.4851P AD=0.4356P
+ PS=2.96U PD=2.86U
* device instance $2850 r0 *1 88.08,61.88 nfet_03v3
M$2850 VSS A|Y$72 \$628 VSS nfet_03v3 L=0.28U W=1U AS=0.44P AD=0.26P PS=2.88U
+ PD=1.52U
* device instance $2851 r0 *1 88.88,61.88 nfet_03v3
M$2851 A|Y$86 \$628 VSS VSS nfet_03v3 L=0.28U W=2U AS=0.52P AD=1.02P PS=3.04U
+ PD=5.04U
* device instance $2853 r0 *1 91.44,61.88 nfet_03v3
M$2853 VSS A|Y$86 \$630 VSS nfet_03v3 L=0.28U W=1U AS=0.44P AD=0.26P PS=2.88U
+ PD=1.52U
* device instance $2854 r0 *1 92.24,61.88 nfet_03v3
M$2854 A|Y$80 \$630 VSS VSS nfet_03v3 L=0.28U W=2U AS=0.52P AD=1.02P PS=3.04U
+ PD=5.04U
* device instance $2856 r0 *1 98.025,63.555 nfet_03v3
M$2856 \$704 \$703 VSS VSS nfet_03v3 L=7.75U W=0.99U AS=0.4851P AD=0.4356P
+ PS=2.96U PD=2.86U
* device instance $2857 r0 *1 98.585,61.885 nfet_03v3
M$2857 \$659 \$631 VSS VSS nfet_03v3 L=7.75U W=0.99U AS=0.4851P AD=0.4356P
+ PS=2.96U PD=2.86U
* device instance $2858 r0 *1 103.625,63.56 nfet_03v3
M$2858 \$706 \$705 VSS VSS nfet_03v3 L=1.03U W=1U AS=0.49P AD=0.44P PS=2.98U
+ PD=2.88U
* device instance $2859 r0 *1 107.545,61.885 nfet_03v3
M$2859 \$660 \$632 VSS VSS nfet_03v3 L=7.75U W=0.99U AS=0.4851P AD=0.4356P
+ PS=2.96U PD=2.86U
* device instance $2860 r0 *1 110.345,63.555 nfet_03v3
M$2860 \$708 \$707 VSS VSS nfet_03v3 L=7.75U W=0.99U AS=0.4851P AD=0.4356P
+ PS=2.96U PD=2.86U
* device instance $2861 r0 *1 113.145,61.88 nfet_03v3
M$2861 \$661 \$633 VSS VSS nfet_03v3 L=1.03U W=1U AS=0.49P AD=0.44P PS=2.98U
+ PD=2.88U
* device instance $2862 r0 *1 115.28,61.88 nfet_03v3
M$2862 A|Y$87 \$662 VSS VSS nfet_03v3 L=0.28U W=2U AS=1.02P AD=0.52P PS=5.04U
+ PD=3.04U
* device instance $2864 r0 *1 116.88,61.88 nfet_03v3
M$2864 \$662 A|Y$75 VSS VSS nfet_03v3 L=0.28U W=1U AS=0.26P AD=0.44P PS=1.52U
+ PD=2.88U
* device instance $2865 r0 *1 117.52,63.56 nfet_03v3
M$2865 A|Y$97 \$730 VSS VSS nfet_03v3 L=0.28U W=2U AS=1.02P AD=0.52P PS=5.04U
+ PD=3.04U
* device instance $2867 r0 *1 119.12,63.56 nfet_03v3
M$2867 \$730 A|Y$98 VSS VSS nfet_03v3 L=0.28U W=1U AS=0.26P AD=0.44P PS=1.52U
+ PD=2.88U
* device instance $2868 r0 *1 118.32,61.88 nfet_03v3
M$2868 VSS A|Y$87 \$635 VSS nfet_03v3 L=0.28U W=1U AS=0.44P AD=0.26P PS=2.88U
+ PD=1.52U
* device instance $2869 r0 *1 119.12,61.88 nfet_03v3
M$2869 A|Y$88 \$635 VSS VSS nfet_03v3 L=0.28U W=2U AS=0.52P AD=1.02P PS=3.04U
+ PD=5.04U
* device instance $2871 r0 *1 120.56,63.56 nfet_03v3
M$2871 VSS A|Y$88 \$711 VSS nfet_03v3 L=0.28U W=1U AS=0.44P AD=0.26P PS=2.88U
+ PD=1.52U
* device instance $2872 r0 *1 121.36,63.56 nfet_03v3
M$2872 A|Y$98 \$711 VSS VSS nfet_03v3 L=0.28U W=2U AS=0.52P AD=1.02P PS=3.04U
+ PD=5.04U
* device instance $2874 r0 *1 122.105,61.88 nfet_03v3
M$2874 \$663 \$637 VSS VSS nfet_03v3 L=1.03U W=1U AS=0.49P AD=0.44P PS=2.98U
+ PD=2.88U
* device instance $2875 r0 *1 127.705,63.555 nfet_03v3
M$2875 \$713 \$712 VSS VSS nfet_03v3 L=7.75U W=0.99U AS=0.4851P AD=0.4356P
+ PS=2.96U PD=2.86U
* device instance $2876 r0 *1 129.945,61.885 nfet_03v3
M$2876 \$664 \$638 VSS VSS nfet_03v3 L=7.75U W=0.99U AS=0.4851P AD=0.4356P
+ PS=2.96U PD=2.86U
* device instance $2877 r0 *1 132.96,63.56 nfet_03v3
M$2877 B|Y$22 B|Y$24 \$714 VSS nfet_03v3 L=0.28U W=2U AS=0.775P AD=0.52P
+ PS=4.55U PD=3.04U
* device instance $2879 r0 *1 134.56,63.56 nfet_03v3
M$2879 VSS A|Y$100 \$714 VSS nfet_03v3 L=0.28U W=2U AS=0.52P AD=0.7P PS=3.04U
+ PD=4.4U
* device instance $2881 r0 *1 135.545,61.88 nfet_03v3
M$2881 \$665 \$639 VSS VSS nfet_03v3 L=1.03U W=1U AS=0.49P AD=0.44P PS=2.98U
+ PD=2.88U
* device instance $2882 r0 *1 136.8,63.56 nfet_03v3
M$2882 VSS A|Y$101 \$715 VSS nfet_03v3 L=0.28U W=2U AS=0.7P AD=0.52P PS=4.4U
+ PD=3.04U
* device instance $2884 r0 *1 138.4,63.56 nfet_03v3
M$2884 B|Y$23 B|Y$21 \$715 VSS nfet_03v3 L=0.28U W=2U AS=0.52P AD=0.775P
+ PS=3.04U PD=4.55U
* device instance $2886 r0 *1 138.56,61.88 nfet_03v3
M$2886 A|Y$82 B|Y$22 \$672 VSS nfet_03v3 L=0.28U W=2U AS=0.775P AD=0.52P
+ PS=4.55U PD=3.04U
* device instance $2888 r0 *1 140.16,61.88 nfet_03v3
M$2888 VSS \$667 \$672 VSS nfet_03v3 L=0.28U W=2U AS=0.52P AD=0.7P PS=3.04U
+ PD=4.4U
* device instance $2890 r0 *1 141.145,63.56 nfet_03v3
M$2890 \$718 \$717 VSS VSS nfet_03v3 L=1.03U W=1U AS=0.49P AD=0.44P PS=2.98U
+ PD=2.88U
* device instance $2891 r0 *1 142.4,61.88 nfet_03v3
M$2891 VSS A|Y$76 \$667 VSS nfet_03v3 L=0.28U W=1U AS=0.44P AD=0.46P PS=2.88U
+ PD=2.92U
* device instance $2892 r0 *1 144.08,61.88 nfet_03v3
M$2892 VSS A|Y$76 \$673 VSS nfet_03v3 L=0.28U W=2U AS=0.7P AD=0.52P PS=4.4U
+ PD=3.04U
* device instance $2894 r0 *1 145.68,61.88 nfet_03v3
M$2894 B|Y$20 B|Y$22 \$673 VSS nfet_03v3 L=0.28U W=2U AS=0.52P AD=0.775P
+ PS=3.04U PD=4.55U
* device instance $2896 r0 *1 146.185,63.56 nfet_03v3
M$2896 \$720 \$719 VSS VSS nfet_03v3 L=1.03U W=1U AS=0.49P AD=0.44P PS=2.98U
+ PD=2.88U
* device instance $2897 r0 *1 149.545,61.885 nfet_03v3
M$2897 \$669 \$640 VSS VSS nfet_03v3 L=3.27U W=0.99U AS=0.4851P AD=0.4356P
+ PS=2.96U PD=2.86U
* device instance $2898 r0 *1 148.56,63.56 nfet_03v3
M$2898 C|Y$4 A|Y$91 VSS VSS nfet_03v3 L=0.28U W=2U AS=0.7P AD=0.7P PS=4.4U
+ PD=4.4U
* device instance $2900 r0 *1 150.8,63.56 nfet_03v3
M$2900 C|Y$5 A|Y$102 VSS VSS nfet_03v3 L=0.28U W=2U AS=0.7P AD=0.7P PS=4.4U
+ PD=4.4U
* device instance $2902 r0 *1 153.12,63.56 nfet_03v3
M$2902 Y$5 C|Y$5 \$721 VSS nfet_03v3 L=0.28U W=2U AS=0.71P AD=0.7P PS=4.42U
+ PD=4.4U
* device instance $2904 r0 *1 153.6,61.88 nfet_03v3
M$2904 VSS A|Y$91 \$674 VSS nfet_03v3 L=0.28U W=2U AS=0.7P AD=0.52P PS=4.4U
+ PD=3.04U
* device instance $2906 r0 *1 155.2,61.88 nfet_03v3
M$2906 \$675 A|B|Y \$674 VSS nfet_03v3 L=0.28U W=2U AS=0.52P AD=0.7P PS=3.04U
+ PD=4.4U
* device instance $2908 r0 *1 155.36,63.56 nfet_03v3
M$2908 \$721 A|B|Y \$723 VSS nfet_03v3 L=0.28U W=2U AS=0.7P AD=0.52P PS=4.4U
+ PD=3.04U
* device instance $2910 r0 *1 156.96,63.56 nfet_03v3
M$2910 VSS A|Y$102 \$723 VSS nfet_03v3 L=0.28U W=2U AS=0.52P AD=0.7P PS=3.04U
+ PD=4.4U
* device instance $2912 r0 *1 157.44,61.88 nfet_03v3
M$2912 Y$4 C|Y$4 \$675 VSS nfet_03v3 L=0.28U W=2U AS=0.7P AD=0.71P PS=4.4U
+ PD=4.42U
* device instance $2914 r0 *1 159.52,63.56 nfet_03v3
M$2914 A|Y$102 \$736 VSS VSS nfet_03v3 L=0.28U W=2U AS=1.02P AD=0.52P PS=5.04U
+ PD=3.04U
* device instance $2916 r0 *1 161.12,63.56 nfet_03v3
M$2916 \$736 A|MID_MUX[9] VSS VSS nfet_03v3 L=0.28U W=1U AS=0.26P AD=0.44P
+ PS=1.52U PD=2.88U
* device instance $2917 r0 *1 160.185,61.88 nfet_03v3
M$2917 \$671 \$642 VSS VSS nfet_03v3 L=1.03U W=1U AS=0.49P AD=0.44P PS=2.98U
+ PD=2.88U
* device instance $2918 r0 *1 8.985,69.72 nfet_03v3
M$2918 \$764 \$737 VSS VSS nfet_03v3 L=1.03U W=1U AS=0.49P AD=0.44P PS=2.98U
+ PD=2.88U
* device instance $2919 r0 *1 12.8,69.72 nfet_03v3
M$2919 A|Y$103 \$765 VSS VSS nfet_03v3 L=0.28U W=2U AS=1.02P AD=0.52P PS=5.04U
+ PD=3.04U
* device instance $2921 r0 *1 14.4,69.72 nfet_03v3
M$2921 \$765 A|Q VSS VSS nfet_03v3 L=0.28U W=1U AS=0.26P AD=0.44P PS=1.52U
+ PD=2.88U
* device instance $2922 r0 *1 16.265,69.72 nfet_03v3
M$2922 \$767 \$739 VSS VSS nfet_03v3 L=1.03U W=1U AS=0.49P AD=0.44P PS=2.98U
+ PD=2.88U
* device instance $2923 r0 *1 18.08,69.72 nfet_03v3
M$2923 VSS A|CLK|REF \$740 VSS nfet_03v3 L=0.28U W=1U AS=0.44P AD=0.26P
+ PS=2.88U PD=1.52U
* device instance $2924 r0 *1 18.88,69.72 nfet_03v3
M$2924 \$741 \$740 VSS VSS nfet_03v3 L=0.28U W=1U AS=0.26P AD=0.485P PS=1.52U
+ PD=2.97U
* device instance $2925 r0 *1 20.365,69.72 nfet_03v3
M$2925 \$823 \$741 VSS VSS nfet_03v3 L=0.28U W=1U AS=0.44P AD=0.42P PS=2.88U
+ PD=1.84U
* device instance $2926 r0 *1 21.485,69.72 nfet_03v3
M$2926 \$770 D|Y \$823 VSS nfet_03v3 L=0.28U W=1U AS=0.42P AD=0.875P PS=1.84U
+ PD=2.75U
* device instance $2927 r0 *1 23.515,69.72 nfet_03v3
M$2927 \$824 \$740 \$770 VSS nfet_03v3 L=0.28U W=1U AS=0.875P AD=0.14P PS=2.75U
+ PD=1.28U
* device instance $2928 r0 *1 24.075,69.72 nfet_03v3
M$2928 VSS \$771 \$824 VSS nfet_03v3 L=0.28U W=1U AS=0.14P AD=0.26P PS=1.28U
+ PD=1.52U
* device instance $2929 r0 *1 24.875,69.72 nfet_03v3
M$2929 \$771 \$770 VSS VSS nfet_03v3 L=0.28U W=1U AS=0.26P AD=0.305P PS=1.52U
+ PD=1.61U
* device instance $2930 r0 *1 25.765,69.72 nfet_03v3
M$2930 \$772 \$740 \$771 VSS nfet_03v3 L=0.28U W=1U AS=0.305P AD=0.625P
+ PS=1.61U PD=2.25U
* device instance $2931 r0 *1 27.295,69.72 nfet_03v3
M$2931 \$825 \$741 \$772 VSS nfet_03v3 L=0.28U W=1U AS=0.625P AD=0.43P PS=2.25U
+ PD=1.86U
* device instance $2932 r0 *1 28.435,69.72 nfet_03v3
M$2932 VSS \$773 \$825 VSS nfet_03v3 L=0.28U W=1U AS=0.43P AD=0.26P PS=1.86U
+ PD=1.52U
* device instance $2933 r0 *1 29.235,69.72 nfet_03v3
M$2933 \$773 \$772 VSS VSS nfet_03v3 L=0.28U W=1U AS=0.26P AD=0.55P PS=1.52U
+ PD=3.1U
* device instance $2934 r0 *1 30.785,69.72 nfet_03v3
M$2934 A|Q$1 \$773 VSS VSS nfet_03v3 L=0.28U W=2U AS=0.7P AD=0.875P PS=4.4U
+ PD=4.75U
* device instance $2936 r0 *1 33.625,69.72 nfet_03v3
M$2936 \$775 \$742 VSS VSS nfet_03v3 L=1.03U W=1U AS=0.49P AD=0.44P PS=2.98U
+ PD=2.88U
* device instance $2937 r0 *1 36.32,69.72 nfet_03v3
M$2937 A|Y$99 \$776 VSS VSS nfet_03v3 L=0.28U W=2U AS=1.02P AD=0.52P PS=5.04U
+ PD=3.04U
* device instance $2939 r0 *1 37.92,69.72 nfet_03v3
M$2939 \$776 A|Y$110 VSS VSS nfet_03v3 L=0.28U W=1U AS=0.26P AD=0.44P PS=1.52U
+ PD=2.88U
* device instance $2940 r0 *1 39.68,69.72 nfet_03v3
M$2940 A|Y$110 \$778 VSS VSS nfet_03v3 L=0.28U W=2U AS=1.02P AD=0.52P PS=5.04U
+ PD=3.04U
* device instance $2942 r0 *1 41.28,69.72 nfet_03v3
M$2942 \$778 A|Y$111 VSS VSS nfet_03v3 L=0.28U W=1U AS=0.26P AD=0.44P PS=1.52U
+ PD=2.88U
* device instance $2943 r0 *1 42.72,69.72 nfet_03v3
M$2943 VSS A|Y$112 \$743 VSS nfet_03v3 L=0.28U W=1U AS=0.44P AD=0.26P PS=2.88U
+ PD=1.52U
* device instance $2944 r0 *1 43.52,69.72 nfet_03v3
M$2944 A|Y$104 \$743 VSS VSS nfet_03v3 L=0.28U W=2U AS=0.52P AD=1.02P PS=3.04U
+ PD=5.04U
* device instance $2946 r0 *1 48.185,69.72 nfet_03v3
M$2946 \$781 \$745 VSS VSS nfet_03v3 L=1.03U W=1U AS=0.49P AD=0.44P PS=2.98U
+ PD=2.88U
* device instance $2947 r0 *1 50.32,69.72 nfet_03v3
M$2947 A|Y$94 \$782 VSS VSS nfet_03v3 L=0.28U W=2U AS=1.02P AD=0.52P PS=5.04U
+ PD=3.04U
* device instance $2949 r0 *1 51.92,69.72 nfet_03v3
M$2949 \$782 A|Y$113 VSS VSS nfet_03v3 L=0.28U W=1U AS=0.26P AD=0.44P PS=1.52U
+ PD=2.88U
* device instance $2950 r0 *1 53.68,69.72 nfet_03v3
M$2950 A|Y$113 \$784 VSS VSS nfet_03v3 L=0.28U W=2U AS=1.02P AD=0.52P PS=5.04U
+ PD=3.04U
* device instance $2952 r0 *1 55.28,69.72 nfet_03v3
M$2952 \$784 A|Y$114 VSS VSS nfet_03v3 L=0.28U W=1U AS=0.26P AD=0.44P PS=1.52U
+ PD=2.88U
* device instance $2953 r0 *1 57.04,69.72 nfet_03v3
M$2953 A|Y$114 \$786 VSS VSS nfet_03v3 L=0.28U W=2U AS=1.02P AD=0.52P PS=5.04U
+ PD=3.04U
* device instance $2955 r0 *1 58.64,69.72 nfet_03v3
M$2955 \$786 A|Y$95 VSS VSS nfet_03v3 L=0.28U W=1U AS=0.26P AD=0.44P PS=1.52U
+ PD=2.88U
* device instance $2956 r0 *1 60.4,69.72 nfet_03v3
M$2956 A|Y$96 \$787 VSS VSS nfet_03v3 L=0.28U W=2U AS=1.02P AD=0.52P PS=5.04U
+ PD=3.04U
* device instance $2958 r0 *1 62,69.72 nfet_03v3
M$2958 \$787 A|Y$115 VSS VSS nfet_03v3 L=0.28U W=1U AS=0.26P AD=0.44P PS=1.52U
+ PD=2.88U
* device instance $2959 r0 *1 63.76,69.72 nfet_03v3
M$2959 A|Y$115 \$789 VSS VSS nfet_03v3 L=0.28U W=2U AS=1.02P AD=0.52P PS=5.04U
+ PD=3.04U
* device instance $2961 r0 *1 65.36,69.72 nfet_03v3
M$2961 \$789 A|Y$116 VSS VSS nfet_03v3 L=0.28U W=1U AS=0.26P AD=0.44P PS=1.52U
+ PD=2.88U
* device instance $2962 r0 *1 96.345,69.72 nfet_03v3
M$2962 \$794 \$749 VSS VSS nfet_03v3 L=1.03U W=1U AS=0.49P AD=0.44P PS=2.98U
+ PD=2.88U
* device instance $2963 r0 *1 99.04,69.72 nfet_03v3
M$2963 A|Y$105 \$795 VSS VSS nfet_03v3 L=0.28U W=2U AS=1.02P AD=0.52P PS=5.04U
+ PD=3.04U
* device instance $2965 r0 *1 100.64,69.72 nfet_03v3
M$2965 \$795 A|Y$117 VSS VSS nfet_03v3 L=0.28U W=1U AS=0.26P AD=0.44P PS=1.52U
+ PD=2.88U
* device instance $2966 r0 *1 102.4,69.72 nfet_03v3
M$2966 A|Y$106 \$797 VSS VSS nfet_03v3 L=0.28U W=2U AS=1.02P AD=0.52P PS=5.04U
+ PD=3.04U
* device instance $2968 r0 *1 104,69.72 nfet_03v3
M$2968 \$797 A|Y$118 VSS VSS nfet_03v3 L=0.28U W=1U AS=0.26P AD=0.44P PS=1.52U
+ PD=2.88U
* device instance $2969 r0 *1 106.32,69.72 nfet_03v3
M$2969 A|Y$107 \$799 VSS VSS nfet_03v3 L=0.28U W=2U AS=1.02P AD=0.52P PS=5.04U
+ PD=3.04U
* device instance $2971 r0 *1 107.92,69.72 nfet_03v3
M$2971 \$799 A|Y$119 VSS VSS nfet_03v3 L=0.28U W=1U AS=0.26P AD=0.44P PS=1.52U
+ PD=2.88U
* device instance $2972 r0 *1 115.28,69.72 nfet_03v3
M$2972 A|Y$108 \$802 VSS VSS nfet_03v3 L=0.28U W=2U AS=1.02P AD=0.52P PS=5.04U
+ PD=3.04U
* device instance $2974 r0 *1 116.88,69.72 nfet_03v3
M$2974 \$802 A|Y$120 VSS VSS nfet_03v3 L=0.28U W=1U AS=0.26P AD=0.44P PS=1.52U
+ PD=2.88U
* device instance $2975 r0 *1 118.32,69.72 nfet_03v3
M$2975 VSS A|Y$97 \$755 VSS nfet_03v3 L=0.28U W=1U AS=0.44P AD=0.26P PS=2.88U
+ PD=1.52U
* device instance $2976 r0 *1 119.12,69.72 nfet_03v3
M$2976 A|Y$120 \$755 VSS VSS nfet_03v3 L=0.28U W=2U AS=0.52P AD=1.02P PS=3.04U
+ PD=5.04U
* device instance $2978 r0 *1 122.105,69.72 nfet_03v3
M$2978 \$804 \$756 VSS VSS nfet_03v3 L=1.03U W=1U AS=0.49P AD=0.44P PS=2.98U
+ PD=2.88U
* device instance $2979 r0 *1 131.065,69.72 nfet_03v3
M$2979 \$806 \$758 VSS VSS nfet_03v3 L=1.03U W=1U AS=0.49P AD=0.44P PS=2.98U
+ PD=2.88U
* device instance $2980 r0 *1 134.64,69.72 nfet_03v3
M$2980 A|Y$101 B|Y$24 \$819 VSS nfet_03v3 L=0.28U W=2U AS=0.775P AD=0.52P
+ PS=4.55U PD=3.04U
* device instance $2982 r0 *1 136.24,69.72 nfet_03v3
M$2982 VSS \$807 \$819 VSS nfet_03v3 L=0.28U W=2U AS=0.52P AD=0.7P PS=3.04U
+ PD=4.4U
* device instance $2984 r0 *1 138.48,69.72 nfet_03v3
M$2984 VSS A|Y$100 \$807 VSS nfet_03v3 L=0.28U W=1U AS=0.44P AD=0.46P PS=2.88U
+ PD=2.92U
* device instance $2985 r0 *1 145.065,69.72 nfet_03v3
M$2985 \$809 \$760 VSS VSS nfet_03v3 L=1.03U W=1U AS=0.49P AD=0.44P PS=2.98U
+ PD=2.88U
* device instance $2986 r0 *1 148,69.72 nfet_03v3
M$2986 C|Y$7 A|Y$121 VSS VSS nfet_03v3 L=0.28U W=2U AS=0.7P AD=0.7P PS=4.4U
+ PD=4.4U
* device instance $2988 r0 *1 150.24,69.72 nfet_03v3
M$2988 C|Y$6 A|Y$109 VSS VSS nfet_03v3 L=0.28U W=2U AS=0.7P AD=0.7P PS=4.4U
+ PD=4.4U
* device instance $2990 r0 *1 152.48,69.72 nfet_03v3
M$2990 VSS A|Y$121 \$821 VSS nfet_03v3 L=0.28U W=2U AS=0.7P AD=0.52P PS=4.4U
+ PD=3.04U
* device instance $2992 r0 *1 154.08,69.72 nfet_03v3
M$2992 \$822 A|B|Y \$821 VSS nfet_03v3 L=0.28U W=2U AS=0.52P AD=0.7P PS=3.04U
+ PD=4.4U
* device instance $2994 r0 *1 156.32,69.72 nfet_03v3
M$2994 Y$6 C|Y$7 \$822 VSS nfet_03v3 L=0.28U W=2U AS=0.7P AD=0.71P PS=4.4U
+ PD=4.42U
* device instance $2996 r0 *1 159.52,69.72 nfet_03v3
M$2996 A|Y$109 \$813 VSS VSS nfet_03v3 L=0.28U W=2U AS=1.02P AD=0.52P PS=5.04U
+ PD=3.04U
* device instance $2998 r0 *1 161.12,69.72 nfet_03v3
M$2998 \$813 A|MID_MUX[2] VSS VSS nfet_03v3 L=0.28U W=1U AS=0.26P AD=0.44P
+ PS=1.52U PD=2.88U
* device instance $2999 r0 *1 8.735,71.4 nfet_03v3
M$2999 A|Q \$826 VSS VSS nfet_03v3 L=0.28U W=2U AS=0.875P AD=0.7P PS=4.75U
+ PD=4.4U
* device instance $3001 r0 *1 11.085,71.4 nfet_03v3
M$3001 VSS \$827 \$826 VSS nfet_03v3 L=0.28U W=1U AS=0.55P AD=0.26P PS=3.1U
+ PD=1.52U
* device instance $3002 r0 *1 11.885,71.4 nfet_03v3
M$3002 \$877 \$826 VSS VSS nfet_03v3 L=0.28U W=1U AS=0.26P AD=0.43P PS=1.52U
+ PD=1.86U
* device instance $3003 r0 *1 13.025,71.4 nfet_03v3
M$3003 \$827 \$828 \$877 VSS nfet_03v3 L=0.28U W=1U AS=0.43P AD=0.625P PS=1.86U
+ PD=2.25U
* device instance $3004 r0 *1 14.555,71.4 nfet_03v3
M$3004 \$829 \$880 \$827 VSS nfet_03v3 L=0.28U W=1U AS=0.625P AD=0.305P
+ PS=2.25U PD=1.61U
* device instance $3005 r0 *1 15.445,71.4 nfet_03v3
M$3005 VSS \$830 \$829 VSS nfet_03v3 L=0.28U W=1U AS=0.305P AD=0.26P PS=1.61U
+ PD=1.52U
* device instance $3006 r0 *1 16.245,71.4 nfet_03v3
M$3006 \$878 \$829 VSS VSS nfet_03v3 L=0.28U W=1U AS=0.26P AD=0.14P PS=1.52U
+ PD=1.28U
* device instance $3007 r0 *1 16.805,71.4 nfet_03v3
M$3007 \$830 \$880 \$878 VSS nfet_03v3 L=0.28U W=1U AS=0.14P AD=0.875P PS=1.28U
+ PD=2.75U
* device instance $3008 r0 *1 18.835,71.4 nfet_03v3
M$3008 \$879 D|Y$1 \$830 VSS nfet_03v3 L=0.28U W=1U AS=0.875P AD=0.42P PS=2.75U
+ PD=1.84U
* device instance $3009 r0 *1 19.955,71.4 nfet_03v3
M$3009 VSS \$828 \$879 VSS nfet_03v3 L=0.28U W=1U AS=0.42P AD=0.44P PS=1.84U
+ PD=2.88U
* device instance $3010 r0 *1 21.44,71.4 nfet_03v3
M$3010 VSS \$880 \$828 VSS nfet_03v3 L=0.28U W=1U AS=0.485P AD=0.26P PS=2.97U
+ PD=1.52U
* device instance $3011 r0 *1 22.24,71.4 nfet_03v3
M$3011 \$880 A|CLK|REF VSS VSS nfet_03v3 L=0.28U W=1U AS=0.26P AD=0.44P
+ PS=1.52U PD=2.88U
* device instance $3012 r0 *1 24.105,71.4 nfet_03v3
M$3012 \$832 \$831 VSS VSS nfet_03v3 L=1.03U W=1U AS=0.49P AD=0.44P PS=2.98U
+ PD=2.88U
* device instance $3013 r0 *1 31.945,71.395 nfet_03v3
M$3013 \$834 \$833 VSS VSS nfet_03v3 L=7.75U W=0.99U AS=0.4851P AD=0.4356P
+ PS=2.96U PD=2.86U
* device instance $3014 r0 *1 37.545,71.4 nfet_03v3
M$3014 \$836 \$835 VSS VSS nfet_03v3 L=1.03U W=1U AS=0.49P AD=0.44P PS=2.98U
+ PD=2.88U
* device instance $3015 r0 *1 41.36,71.4 nfet_03v3
M$3015 A|Y$112 \$882 VSS VSS nfet_03v3 L=0.28U W=2U AS=1.02P AD=0.52P PS=5.04U
+ PD=3.04U
* device instance $3017 r0 *1 42.96,71.4 nfet_03v3
M$3017 \$882 A|Y$122 VSS VSS nfet_03v3 L=0.28U W=1U AS=0.26P AD=0.44P PS=1.52U
+ PD=2.88U
* device instance $3018 r0 *1 44.72,71.4 nfet_03v3
M$3018 A|Y$122 \$883 VSS VSS nfet_03v3 L=0.28U W=2U AS=1.02P AD=0.52P PS=5.04U
+ PD=3.04U
* device instance $3020 r0 *1 46.32,71.4 nfet_03v3
M$3020 \$883 A|Y$123 VSS VSS nfet_03v3 L=0.28U W=1U AS=0.26P AD=0.44P PS=1.52U
+ PD=2.88U
* device instance $3021 r0 *1 48.08,71.4 nfet_03v3
M$3021 A|Y$123 \$884 VSS VSS nfet_03v3 L=0.28U W=2U AS=1.02P AD=0.52P PS=5.04U
+ PD=3.04U
* device instance $3023 r0 *1 49.68,71.4 nfet_03v3
M$3023 \$884 A|Y$93 VSS VSS nfet_03v3 L=0.28U W=1U AS=0.26P AD=0.44P PS=1.52U
+ PD=2.88U
* device instance $3024 r0 *1 54.905,71.395 nfet_03v3
M$3024 \$840 \$839 VSS VSS nfet_03v3 L=7.75U W=0.99U AS=0.4851P AD=0.4356P
+ PS=2.96U PD=2.86U
* device instance $3025 r0 *1 60.505,71.4 nfet_03v3
M$3025 \$842 \$841 VSS VSS nfet_03v3 L=1.03U W=1U AS=0.49P AD=0.44P PS=2.98U
+ PD=2.88U
* device instance $3026 r0 *1 63.2,71.4 nfet_03v3
M$3026 A|Y$124 \$885 VSS VSS nfet_03v3 L=0.28U W=2U AS=1.02P AD=0.52P PS=5.04U
+ PD=3.04U
* device instance $3028 r0 *1 64.8,71.4 nfet_03v3
M$3028 \$885 A|Y$125 VSS VSS nfet_03v3 L=0.28U W=1U AS=0.26P AD=0.44P PS=1.52U
+ PD=2.88U
* device instance $3029 r0 *1 70.585,69.725 nfet_03v3
M$3029 \$791 \$746 VSS VSS nfet_03v3 L=7.75U W=0.99U AS=0.4851P AD=0.4356P
+ PS=2.96U PD=2.86U
* device instance $3030 r0 *1 67.36,71.4 nfet_03v3
M$3030 VSS A|Y$124 \$845 VSS nfet_03v3 L=0.28U W=1U AS=0.44P AD=0.26P PS=2.88U
+ PD=1.52U
* device instance $3031 r0 *1 68.16,71.4 nfet_03v3
M$3031 A|Y$116 \$845 VSS VSS nfet_03v3 L=0.28U W=2U AS=0.52P AD=1.02P PS=3.04U
+ PD=5.04U
* device instance $3033 r0 *1 74.505,71.395 nfet_03v3
M$3033 \$847 \$846 VSS VSS nfet_03v3 L=7.75U W=0.99U AS=0.4851P AD=0.4356P
+ PS=2.96U PD=2.86U
* device instance $3034 r0 *1 79.545,69.725 nfet_03v3
M$3034 \$792 \$747 VSS VSS nfet_03v3 L=7.75U W=0.99U AS=0.4851P AD=0.4356P
+ PS=2.96U PD=2.86U
* device instance $3035 r0 *1 80.8,71.4 nfet_03v3
M$3035 VSS A|Y$126 \$848 VSS nfet_03v3 L=0.28U W=1U AS=0.44P AD=0.26P PS=2.88U
+ PD=1.52U
* device instance $3036 r0 *1 81.6,71.4 nfet_03v3
M$3036 A|Y$127 \$848 VSS VSS nfet_03v3 L=0.28U W=2U AS=0.52P AD=1.02P PS=3.04U
+ PD=5.04U
* device instance $3038 r0 *1 87.945,71.395 nfet_03v3
M$3038 \$852 \$851 VSS VSS nfet_03v3 L=7.75U W=0.99U AS=0.4851P AD=0.4356P
+ PS=2.96U PD=2.86U
* device instance $3039 r0 *1 90.745,69.725 nfet_03v3
M$3039 \$793 \$748 VSS VSS nfet_03v3 L=7.75U W=0.99U AS=0.4851P AD=0.4356P
+ PS=2.96U PD=2.86U
* device instance $3040 r0 *1 94.665,71.395 nfet_03v3
M$3040 \$854 \$853 VSS VSS nfet_03v3 L=3.27U W=0.99U AS=0.4851P AD=0.4356P
+ PS=2.96U PD=2.86U
* device instance $3041 r0 *1 97.92,71.4 nfet_03v3
M$3041 A|Y$128 \$886 VSS VSS nfet_03v3 L=0.28U W=2U AS=1.02P AD=0.52P PS=5.04U
+ PD=3.04U
* device instance $3043 r0 *1 99.52,71.4 nfet_03v3
M$3043 \$886 A|Y$129 VSS VSS nfet_03v3 L=0.28U W=1U AS=0.26P AD=0.44P PS=1.52U
+ PD=2.88U
* device instance $3044 r0 *1 100.96,71.4 nfet_03v3
M$3044 VSS A|Y$105 \$857 VSS nfet_03v3 L=0.28U W=1U AS=0.44P AD=0.26P PS=2.88U
+ PD=1.52U
* device instance $3045 r0 *1 101.76,71.4 nfet_03v3
M$3045 A|Y$129 \$857 VSS VSS nfet_03v3 L=0.28U W=2U AS=0.52P AD=1.02P PS=3.04U
+ PD=5.04U
* device instance $3047 r0 *1 106.88,71.4 nfet_03v3
M$3047 A|Y$118 \$887 VSS VSS nfet_03v3 L=0.28U W=2U AS=1.02P AD=0.52P PS=5.04U
+ PD=3.04U
* device instance $3049 r0 *1 108.48,71.4 nfet_03v3
M$3049 \$887 A|Y$107 VSS VSS nfet_03v3 L=0.28U W=1U AS=0.26P AD=0.44P PS=1.52U
+ PD=2.88U
* device instance $3050 r0 *1 110.905,69.725 nfet_03v3
M$3050 \$801 \$753 VSS VSS nfet_03v3 L=3.27U W=0.99U AS=0.4851P AD=0.4356P
+ PS=2.96U PD=2.86U
* device instance $3051 r0 *1 110.24,71.4 nfet_03v3
M$3051 A|Y$119 \$888 VSS VSS nfet_03v3 L=0.28U W=2U AS=1.02P AD=0.52P PS=5.04U
+ PD=3.04U
* device instance $3053 r0 *1 111.84,71.4 nfet_03v3
M$3053 \$888 A|Y$130 VSS VSS nfet_03v3 L=0.28U W=1U AS=0.26P AD=0.44P PS=1.52U
+ PD=2.88U
* device instance $3054 r0 *1 113.6,71.4 nfet_03v3
M$3054 A|Y$130 \$889 VSS VSS nfet_03v3 L=0.28U W=2U AS=1.02P AD=0.52P PS=5.04U
+ PD=3.04U
* device instance $3056 r0 *1 115.2,71.4 nfet_03v3
M$3056 \$889 A|Y$131 VSS VSS nfet_03v3 L=0.28U W=1U AS=0.26P AD=0.44P PS=1.52U
+ PD=2.88U
* device instance $3057 r0 *1 116.64,71.4 nfet_03v3
M$3057 VSS A|Y$108 \$860 VSS nfet_03v3 L=0.28U W=1U AS=0.44P AD=0.26P PS=2.88U
+ PD=1.52U
* device instance $3058 r0 *1 117.44,71.4 nfet_03v3
M$3058 A|Y$131 \$860 VSS VSS nfet_03v3 L=0.28U W=2U AS=0.52P AD=1.02P PS=3.04U
+ PD=5.04U
* device instance $3060 r0 *1 123.785,71.395 nfet_03v3
M$3060 \$862 \$861 VSS VSS nfet_03v3 L=7.75U W=0.99U AS=0.4851P AD=0.4356P
+ PS=2.96U PD=2.86U
* device instance $3061 r0 *1 127.705,69.725 nfet_03v3
M$3061 \$805 \$757 VSS VSS nfet_03v3 L=3.27U W=0.99U AS=0.4851P AD=0.4356P
+ PS=2.96U PD=2.86U
* device instance $3062 r0 *1 128.96,71.4 nfet_03v3
M$3062 VSS A|Y$132 \$863 VSS nfet_03v3 L=0.28U W=2U AS=0.7P AD=0.52P PS=4.4U
+ PD=3.04U
* device instance $3064 r0 *1 130.56,71.4 nfet_03v3
M$3064 B|Y$24 B|Y$25 \$863 VSS nfet_03v3 L=0.28U W=2U AS=0.52P AD=0.775P
+ PS=3.04U PD=4.55U
* device instance $3066 r0 *1 133.12,71.4 nfet_03v3
M$3066 \$867 A|Y$132 VSS VSS nfet_03v3 L=0.28U W=1U AS=0.46P AD=0.44P PS=2.92U
+ PD=2.88U
* device instance $3067 r0 *1 134.56,71.4 nfet_03v3
M$3067 VSS \$867 \$866 VSS nfet_03v3 L=0.28U W=2U AS=0.7P AD=0.52P PS=4.4U
+ PD=3.04U
* device instance $3069 r0 *1 136.16,71.4 nfet_03v3
M$3069 A|Y$134 B|Y$25 \$866 VSS nfet_03v3 L=0.28U W=2U AS=0.52P AD=0.775P
+ PS=3.04U PD=4.55U
* device instance $3071 r0 *1 138.56,71.4 nfet_03v3
M$3071 B|Y$26 B|Y$23 \$868 VSS nfet_03v3 L=0.28U W=2U AS=0.775P AD=0.52P
+ PS=4.55U PD=3.04U
* device instance $3073 r0 *1 140.16,71.4 nfet_03v3
M$3073 VSS A|Y$134 \$868 VSS nfet_03v3 L=0.28U W=2U AS=0.52P AD=0.7P PS=3.04U
+ PD=4.4U
* device instance $3075 r0 *1 141.705,69.725 nfet_03v3
M$3075 \$808 \$759 VSS VSS nfet_03v3 L=3.27U W=0.99U AS=0.4851P AD=0.4356P
+ PS=2.96U PD=2.86U
* device instance $3076 r0 *1 142.825,71.4 nfet_03v3
M$3076 \$871 \$870 VSS VSS nfet_03v3 L=1.03U W=1U AS=0.49P AD=0.44P PS=2.98U
+ PD=2.88U
* device instance $3077 r0 *1 146.08,71.4 nfet_03v3
M$3077 A|Y$100 \$891 VSS VSS nfet_03v3 L=0.28U W=2U AS=1.02P AD=0.52P PS=5.04U
+ PD=3.04U
* device instance $3079 r0 *1 147.68,71.4 nfet_03v3
M$3079 \$891 A|COARSE_MUX[3] VSS VSS nfet_03v3 L=0.28U W=1U AS=0.26P AD=0.44P
+ PS=1.52U PD=2.88U
* device instance $3080 r0 *1 149.44,71.4 nfet_03v3
M$3080 A|Y$91 \$892 VSS VSS nfet_03v3 L=0.28U W=2U AS=1.02P AD=0.52P PS=5.04U
+ PD=3.04U
* device instance $3082 r0 *1 151.04,71.4 nfet_03v3
M$3082 \$892 A|MID_MUX[3] VSS VSS nfet_03v3 L=0.28U W=1U AS=0.26P AD=0.44P
+ PS=1.52U PD=2.88U
* device instance $3083 r0 *1 152.56,71.4 nfet_03v3
M$3083 Y$7 C|Y$6 \$872 VSS nfet_03v3 L=0.28U W=2U AS=0.71P AD=0.7P PS=4.42U
+ PD=4.4U
* device instance $3085 r0 *1 154.8,71.4 nfet_03v3
M$3085 \$872 A|B|Y \$874 VSS nfet_03v3 L=0.28U W=2U AS=0.7P AD=0.52P PS=4.4U
+ PD=3.04U
* device instance $3087 r0 *1 156.4,71.4 nfet_03v3
M$3087 VSS A|Y$109 \$874 VSS nfet_03v3 L=0.28U W=2U AS=0.52P AD=0.7P PS=3.04U
+ PD=4.4U
* device instance $3089 r0 *1 159.52,71.4 nfet_03v3
M$3089 A|Y$133 \$893 VSS VSS nfet_03v3 L=0.28U W=2U AS=1.02P AD=0.52P PS=5.04U
+ PD=3.04U
* device instance $3091 r0 *1 161.12,71.4 nfet_03v3
M$3091 \$893 A|COARSE_MUX[1] VSS VSS nfet_03v3 L=0.28U W=1U AS=0.26P AD=0.44P
+ PS=1.52U PD=2.88U
* device instance $3092 r0 *1 8.88,79.24 nfet_03v3
M$3092 INJ_EDGE|Y \$965 VSS VSS nfet_03v3 L=0.28U W=2U AS=1.02P AD=0.52P
+ PS=5.04U PD=3.04U
* device instance $3094 r0 *1 10.48,79.24 nfet_03v3
M$3094 \$965 A|Y$135 VSS VSS nfet_03v3 L=0.28U W=1U AS=0.26P AD=0.44P PS=1.52U
+ PD=2.88U
* device instance $3095 r0 *1 8.88,77.56 nfet_03v3
M$3095 SS_BBPD[1]|Y \$898 VSS VSS nfet_03v3 L=0.28U W=2U AS=1.02P AD=0.52P
+ PS=5.04U PD=3.04U
* device instance $3097 r0 *1 10.48,77.56 nfet_03v3
M$3097 \$898 A|Y$103 VSS VSS nfet_03v3 L=0.28U W=1U AS=0.26P AD=0.44P PS=1.52U
+ PD=2.88U
* device instance $3098 r0 *1 12.24,79.24 nfet_03v3
M$3098 SS_BBPD[0]|Y \$966 VSS VSS nfet_03v3 L=0.28U W=2U AS=1.02P AD=0.52P
+ PS=5.04U PD=3.04U
* device instance $3100 r0 *1 13.84,79.24 nfet_03v3
M$3100 \$966 A|Y$145 VSS VSS nfet_03v3 L=0.28U W=1U AS=0.26P AD=0.44P PS=1.52U
+ PD=2.88U
* device instance $3101 r0 *1 12.8,77.56 nfet_03v3
M$3101 A|Y$135 \$900 VSS VSS nfet_03v3 L=0.28U W=2U AS=1.02P AD=0.52P PS=5.04U
+ PD=3.04U
* device instance $3103 r0 *1 14.4,77.56 nfet_03v3
M$3103 \$900 A|CLK|REF VSS VSS nfet_03v3 L=0.28U W=1U AS=0.26P AD=0.44P
+ PS=1.52U PD=2.88U
* device instance $3104 r0 *1 15.28,79.24 nfet_03v3
M$3104 VSS A|Y$146 \$968 VSS nfet_03v3 L=0.28U W=2U AS=0.7P AD=0.52P PS=4.4U
+ PD=3.04U
* device instance $3106 r0 *1 16.88,79.24 nfet_03v3
M$3106 A|B|Y$2 A|B|Y$1 \$968 VSS nfet_03v3 L=0.28U W=2U AS=0.52P AD=0.775P
+ PS=3.04U PD=4.55U
* device instance $3108 r0 *1 16.16,77.56 nfet_03v3
M$3108 D|Y$1 \$902 VSS VSS nfet_03v3 L=0.28U W=2U AS=1.02P AD=0.52P PS=5.04U
+ PD=3.04U
* device instance $3110 r0 *1 17.76,77.56 nfet_03v3
M$3110 \$902 A|B|Y$1 VSS VSS nfet_03v3 L=0.28U W=1U AS=0.26P AD=0.44P PS=1.52U
+ PD=2.88U
* device instance $3111 r0 *1 19.28,79.24 nfet_03v3
M$3111 A|B|Y$1 A|B|Y$2 \$970 VSS nfet_03v3 L=0.28U W=2U AS=0.775P AD=0.52P
+ PS=4.55U PD=3.04U
* device instance $3113 r0 *1 20.88,79.24 nfet_03v3
M$3113 VSS A|Y$147 \$970 VSS nfet_03v3 L=0.28U W=2U AS=0.52P AD=0.7P PS=3.04U
+ PD=4.4U
* device instance $3115 r0 *1 20.88,77.56 nfet_03v3
M$3115 VSS A|B|Y$2 \$904 VSS nfet_03v3 L=0.28U W=1U AS=0.44P AD=0.26P PS=2.88U
+ PD=1.52U
* device instance $3116 r0 *1 21.68,77.56 nfet_03v3
M$3116 D|Y \$904 VSS VSS nfet_03v3 L=0.28U W=2U AS=0.52P AD=1.02P PS=3.04U
+ PD=5.04U
* device instance $3118 r0 *1 23.545,79.24 nfet_03v3
M$3118 \$973 \$972 VSS VSS nfet_03v3 L=1.03U W=1U AS=0.49P AD=0.44P PS=2.98U
+ PD=2.88U
* device instance $3119 r0 *1 24.665,77.56 nfet_03v3
M$3119 \$906 \$905 VSS VSS nfet_03v3 L=1.03U W=1U AS=0.49P AD=0.44P PS=2.98U
+ PD=2.88U
* device instance $3120 r0 *1 31.945,79.235 nfet_03v3
M$3120 \$975 \$974 VSS VSS nfet_03v3 L=7.75U W=0.99U AS=0.4851P AD=0.4356P
+ PS=2.96U PD=2.86U
* device instance $3121 r0 *1 28.48,77.56 nfet_03v3
M$3121 A|Y$145 \$907 VSS VSS nfet_03v3 L=0.28U W=2U AS=1.02P AD=0.52P PS=5.04U
+ PD=3.04U
* device instance $3123 r0 *1 30.08,77.56 nfet_03v3
M$3123 \$907 A|Q$1 VSS VSS nfet_03v3 L=0.28U W=1U AS=0.26P AD=0.44P PS=1.52U
+ PD=2.88U
* device instance $3124 r0 *1 35.305,77.565 nfet_03v3
M$3124 \$909 \$908 VSS VSS nfet_03v3 L=7.75U W=0.99U AS=0.4851P AD=0.4356P
+ PS=2.96U PD=2.86U
* device instance $3125 r0 *1 40.905,79.235 nfet_03v3
M$3125 \$977 \$976 VSS VSS nfet_03v3 L=7.75U W=0.99U AS=0.4851P AD=0.4356P
+ PS=2.96U PD=2.86U
* device instance $3126 r0 *1 41.92,77.56 nfet_03v3
M$3126 A|Y$111 \$910 VSS VSS nfet_03v3 L=0.28U W=2U AS=1.02P AD=0.52P PS=5.04U
+ PD=3.04U
* device instance $3128 r0 *1 43.52,77.56 nfet_03v3
M$3128 \$910 A|Y$104 VSS VSS nfet_03v3 L=0.28U W=1U AS=0.26P AD=0.44P PS=1.52U
+ PD=2.88U
* device instance $3129 r0 *1 47.2,79.24 nfet_03v3
M$3129 VSS A|Y$148 \$978 VSS nfet_03v3 L=0.28U W=1U AS=0.44P AD=0.26P PS=2.88U
+ PD=1.52U
* device instance $3130 r0 *1 48,79.24 nfet_03v3
M$3130 A|Y$149 \$978 VSS VSS nfet_03v3 L=0.28U W=2U AS=0.52P AD=1.02P PS=3.04U
+ PD=5.04U
* device instance $3132 r0 *1 51.545,77.565 nfet_03v3
M$3132 \$912 \$911 VSS VSS nfet_03v3 L=7.75U W=0.99U AS=0.4851P AD=0.4356P
+ PS=2.96U PD=2.86U
* device instance $3133 r0 *1 50.985,79.24 nfet_03v3
M$3133 \$982 \$981 VSS VSS nfet_03v3 L=1.03U W=1U AS=0.49P AD=0.44P PS=2.98U
+ PD=2.88U
* device instance $3134 r0 *1 52.8,79.24 nfet_03v3
M$3134 VSS A|Y$150 \$983 VSS nfet_03v3 L=0.28U W=1U AS=0.44P AD=0.26P PS=2.88U
+ PD=1.52U
* device instance $3135 r0 *1 53.6,79.24 nfet_03v3
M$3135 A|Y$151 \$983 VSS VSS nfet_03v3 L=0.28U W=2U AS=0.52P AD=1.02P PS=3.04U
+ PD=5.04U
* device instance $3137 r0 *1 56.585,79.24 nfet_03v3
M$3137 \$987 \$986 VSS VSS nfet_03v3 L=1.03U W=1U AS=0.49P AD=0.44P PS=2.98U
+ PD=2.88U
* device instance $3138 r0 *1 58.265,77.565 nfet_03v3
M$3138 \$914 \$913 VSS VSS nfet_03v3 L=3.27U W=0.99U AS=0.4851P AD=0.4356P
+ PS=2.96U PD=2.86U
* device instance $3139 r0 *1 60.08,79.24 nfet_03v3
M$3139 VSS A|Y$152 \$988 VSS nfet_03v3 L=0.28U W=1U AS=0.44P AD=0.26P PS=2.88U
+ PD=1.52U
* device instance $3140 r0 *1 60.88,79.24 nfet_03v3
M$3140 A|Y$144 \$988 VSS VSS nfet_03v3 L=0.28U W=2U AS=0.52P AD=1.02P PS=3.04U
+ PD=5.04U
* device instance $3142 r0 *1 61.76,77.56 nfet_03v3
M$3142 VSS A|Y$144 \$915 VSS nfet_03v3 L=0.28U W=1U AS=0.44P AD=0.26P PS=2.88U
+ PD=1.52U
* device instance $3143 r0 *1 62.56,77.56 nfet_03v3
M$3143 A|Y$136 \$915 VSS VSS nfet_03v3 L=0.28U W=2U AS=0.52P AD=1.02P PS=3.04U
+ PD=5.04U
* device instance $3145 r0 *1 63.865,79.24 nfet_03v3
M$3145 \$991 \$990 VSS VSS nfet_03v3 L=1.03U W=1U AS=0.49P AD=0.44P PS=2.98U
+ PD=2.88U
* device instance $3146 r0 *1 65.12,77.56 nfet_03v3
M$3146 VSS A|Y$136 \$917 VSS nfet_03v3 L=0.28U W=1U AS=0.44P AD=0.26P PS=2.88U
+ PD=1.52U
* device instance $3147 r0 *1 65.92,77.56 nfet_03v3
M$3147 A|Y$137 \$917 VSS VSS nfet_03v3 L=0.28U W=2U AS=0.52P AD=1.02P PS=3.04U
+ PD=5.04U
* device instance $3149 r0 *1 68.905,79.235 nfet_03v3
M$3149 \$993 \$992 VSS VSS nfet_03v3 L=3.27U W=0.99U AS=0.4851P AD=0.4356P
+ PS=2.96U PD=2.86U
* device instance $3150 r0 *1 68.48,77.56 nfet_03v3
M$3150 VSS A|Y$137 \$919 VSS nfet_03v3 L=0.28U W=1U AS=0.44P AD=0.26P PS=2.88U
+ PD=1.52U
* device instance $3151 r0 *1 69.28,77.56 nfet_03v3
M$3151 A|Y$125 \$919 VSS VSS nfet_03v3 L=0.28U W=2U AS=0.52P AD=1.02P PS=3.04U
+ PD=5.04U
* device instance $3153 r0 *1 72.265,77.56 nfet_03v3
M$3153 \$921 \$920 VSS VSS nfet_03v3 L=1.03U W=1U AS=0.49P AD=0.44P PS=2.98U
+ PD=2.88U
* device instance $3154 r0 *1 72.265,79.24 nfet_03v3
M$3154 \$995 \$994 VSS VSS nfet_03v3 L=1.03U W=1U AS=0.49P AD=0.44P PS=2.98U
+ PD=2.88U
* device instance $3155 r0 *1 74.4,79.24 nfet_03v3
M$3155 A|Y$153 \$996 VSS VSS nfet_03v3 L=0.28U W=2U AS=1.02P AD=0.52P PS=5.04U
+ PD=3.04U
* device instance $3157 r0 *1 76,79.24 nfet_03v3
M$3157 \$996 A|Y$154 VSS VSS nfet_03v3 L=0.28U W=1U AS=0.26P AD=0.44P PS=1.52U
+ PD=2.88U
* device instance $3158 r0 *1 76.08,77.56 nfet_03v3
M$3158 A|Y$138 \$922 VSS VSS nfet_03v3 L=0.28U W=2U AS=1.02P AD=0.52P PS=5.04U
+ PD=3.04U
* device instance $3160 r0 *1 77.68,77.56 nfet_03v3
M$3160 \$922 A|Y$127 VSS VSS nfet_03v3 L=0.28U W=1U AS=0.26P AD=0.44P PS=1.52U
+ PD=2.88U
* device instance $3161 r0 *1 77.44,79.24 nfet_03v3
M$3161 VSS A|Y$138 \$999 VSS nfet_03v3 L=0.28U W=1U AS=0.44P AD=0.26P PS=2.88U
+ PD=1.52U
* device instance $3162 r0 *1 78.24,79.24 nfet_03v3
M$3162 A|Y$154 \$999 VSS VSS nfet_03v3 L=0.28U W=2U AS=0.52P AD=1.02P PS=3.04U
+ PD=5.04U
* device instance $3164 r0 *1 79.44,77.56 nfet_03v3
M$3164 A|Y$126 \$924 VSS VSS nfet_03v3 L=0.28U W=2U AS=1.02P AD=0.52P PS=5.04U
+ PD=3.04U
* device instance $3166 r0 *1 81.04,77.56 nfet_03v3
M$3166 \$924 A|Y$139 VSS VSS nfet_03v3 L=0.28U W=1U AS=0.26P AD=0.44P PS=1.52U
+ PD=2.88U
* device instance $3167 r0 *1 81.225,79.24 nfet_03v3
M$3167 \$1001 \$1000 VSS VSS nfet_03v3 L=1.03U W=1U AS=0.49P AD=0.44P PS=2.98U
+ PD=2.88U
* device instance $3168 r0 *1 82.8,77.56 nfet_03v3
M$3168 A|Y$139 \$926 VSS VSS nfet_03v3 L=0.28U W=2U AS=1.02P AD=0.52P PS=5.04U
+ PD=3.04U
* device instance $3170 r0 *1 84.4,77.56 nfet_03v3
M$3170 \$926 A|Y$140 VSS VSS nfet_03v3 L=0.28U W=1U AS=0.26P AD=0.44P PS=1.52U
+ PD=2.88U
* device instance $3171 r0 *1 83.6,79.24 nfet_03v3
M$3171 VSS A|Y$155 \$1002 VSS nfet_03v3 L=0.28U W=1U AS=0.44P AD=0.26P PS=2.88U
+ PD=1.52U
* device instance $3172 r0 *1 84.4,79.24 nfet_03v3
M$3172 A|Y$140 \$1002 VSS VSS nfet_03v3 L=0.28U W=2U AS=0.52P AD=1.02P PS=3.04U
+ PD=5.04U
* device instance $3174 r0 *1 90.745,77.565 nfet_03v3
M$3174 \$929 \$928 VSS VSS nfet_03v3 L=7.75U W=0.99U AS=0.4851P AD=0.4356P
+ PS=2.96U PD=2.86U
* device instance $3175 r0 *1 88.505,79.235 nfet_03v3
M$3175 \$1005 \$1004 VSS VSS nfet_03v3 L=3.27U W=0.99U AS=0.4851P AD=0.4356P
+ PS=2.96U PD=2.86U
* device instance $3176 r0 *1 91.865,79.24 nfet_03v3
M$3176 \$1007 \$1006 VSS VSS nfet_03v3 L=1.03U W=1U AS=0.49P AD=0.44P PS=2.98U
+ PD=2.88U
* device instance $3177 r0 *1 95.68,79.24 nfet_03v3
M$3177 A|Y$156 \$1008 VSS VSS nfet_03v3 L=0.28U W=2U AS=1.02P AD=0.52P PS=5.04U
+ PD=3.04U
* device instance $3179 r0 *1 97.28,79.24 nfet_03v3
M$3179 \$1008 A|Y$141 VSS VSS nfet_03v3 L=0.28U W=1U AS=0.26P AD=0.44P PS=1.52U
+ PD=2.88U
* device instance $3180 r0 *1 96.345,77.56 nfet_03v3
M$3180 \$931 \$930 VSS VSS nfet_03v3 L=1.03U W=1U AS=0.49P AD=0.44P PS=2.98U
+ PD=2.88U
* device instance $3181 r0 *1 98.48,77.56 nfet_03v3
M$3181 A|Y$141 \$932 VSS VSS nfet_03v3 L=0.28U W=2U AS=1.02P AD=0.52P PS=5.04U
+ PD=3.04U
* device instance $3183 r0 *1 100.08,77.56 nfet_03v3
M$3183 \$932 A|Y$128 VSS VSS nfet_03v3 L=0.28U W=1U AS=0.26P AD=0.44P PS=1.52U
+ PD=2.88U
* device instance $3184 r0 *1 98.72,79.24 nfet_03v3
M$3184 VSS A|Y$156 \$1010 VSS nfet_03v3 L=0.28U W=1U AS=0.44P AD=0.26P PS=2.88U
+ PD=1.52U
* device instance $3185 r0 *1 99.52,79.24 nfet_03v3
M$3185 A|Y$157 \$1010 VSS VSS nfet_03v3 L=0.28U W=2U AS=0.52P AD=1.02P PS=3.04U
+ PD=5.04U
* device instance $3187 r0 *1 101.84,77.56 nfet_03v3
M$3187 A|Y$117 \$934 VSS VSS nfet_03v3 L=0.28U W=2U AS=1.02P AD=0.52P PS=5.04U
+ PD=3.04U
* device instance $3189 r0 *1 103.44,77.56 nfet_03v3
M$3189 \$934 A|Y$106 VSS VSS nfet_03v3 L=0.28U W=1U AS=0.26P AD=0.44P PS=1.52U
+ PD=2.88U
* device instance $3190 r0 *1 102.505,79.24 nfet_03v3
M$3190 \$1013 \$1012 VSS VSS nfet_03v3 L=1.03U W=1U AS=0.49P AD=0.44P PS=2.98U
+ PD=2.88U
* device instance $3191 r0 *1 108.665,77.565 nfet_03v3
M$3191 \$936 \$935 VSS VSS nfet_03v3 L=7.75U W=0.99U AS=0.4851P AD=0.4356P
+ PS=2.96U PD=2.86U
* device instance $3192 r0 *1 110.345,79.235 nfet_03v3
M$3192 \$1015 \$1014 VSS VSS nfet_03v3 L=7.75U W=0.99U AS=0.4851P AD=0.4356P
+ PS=2.96U PD=2.86U
* device instance $3193 r0 *1 117.625,77.565 nfet_03v3
M$3193 \$938 \$937 VSS VSS nfet_03v3 L=7.75U W=0.99U AS=0.4851P AD=0.4356P
+ PS=2.96U PD=2.86U
* device instance $3194 r0 *1 119.305,79.235 nfet_03v3
M$3194 \$1017 \$1016 VSS VSS nfet_03v3 L=7.75U W=0.99U AS=0.4851P AD=0.4356P
+ PS=2.96U PD=2.86U
* device instance $3195 r0 *1 123.225,77.56 nfet_03v3
M$3195 \$940 \$939 VSS VSS nfet_03v3 L=1.03U W=1U AS=0.49P AD=0.44P PS=2.98U
+ PD=2.88U
* device instance $3196 r0 *1 126.025,79.235 nfet_03v3
M$3196 \$1019 \$1018 VSS VSS nfet_03v3 L=3.27U W=0.99U AS=0.4851P AD=0.4356P
+ PS=2.96U PD=2.86U
* device instance $3197 r0 *1 127.705,77.565 nfet_03v3
M$3197 \$942 \$941 VSS VSS nfet_03v3 L=3.27U W=0.99U AS=0.4851P AD=0.4356P
+ PS=2.96U PD=2.86U
* device instance $3198 r0 *1 129.385,79.24 nfet_03v3
M$3198 \$1021 \$1020 VSS VSS nfet_03v3 L=1.03U W=1U AS=0.49P AD=0.44P PS=2.98U
+ PD=2.88U
* device instance $3199 r0 *1 131.065,77.56 nfet_03v3
M$3199 \$944 \$943 VSS VSS nfet_03v3 L=1.03U W=1U AS=0.49P AD=0.44P PS=2.98U
+ PD=2.88U
* device instance $3200 r0 *1 132.4,79.24 nfet_03v3
M$3200 A|Y$142 B|Y$28 \$1022 VSS nfet_03v3 L=0.28U W=2U AS=0.775P AD=0.52P
+ PS=4.55U PD=3.04U
* device instance $3202 r0 *1 134,79.24 nfet_03v3
M$3202 VSS \$1024 \$1022 VSS nfet_03v3 L=0.28U W=2U AS=0.52P AD=0.7P PS=3.04U
+ PD=4.4U
* device instance $3204 r0 *1 134,77.56 nfet_03v3
M$3204 VSS A|Y$142 \$963 VSS nfet_03v3 L=0.28U W=2U AS=0.7P AD=0.52P PS=4.4U
+ PD=3.04U
* device instance $3206 r0 *1 135.6,77.56 nfet_03v3
M$3206 B|Y$27 B|Y$26 \$963 VSS nfet_03v3 L=0.28U W=2U AS=0.52P AD=0.775P
+ PS=3.04U PD=4.55U
* device instance $3208 r0 *1 136.24,79.24 nfet_03v3
M$3208 VSS A|Y$133 \$1024 VSS nfet_03v3 L=0.28U W=1U AS=0.44P AD=0.46P PS=2.88U
+ PD=2.92U
* device instance $3209 r0 *1 141.705,77.565 nfet_03v3
M$3209 \$948 \$947 VSS VSS nfet_03v3 L=7.75U W=0.99U AS=0.4851P AD=0.4356P
+ PS=2.96U PD=2.86U
* device instance $3210 r0 *1 138,79.24 nfet_03v3
M$3210 B|Y$25 B|Y$28 \$1025 VSS nfet_03v3 L=0.28U W=2U AS=0.775P AD=0.52P
+ PS=4.55U PD=3.04U
* device instance $3212 r0 *1 139.6,79.24 nfet_03v3
M$3212 VSS A|Y$133 \$1025 VSS nfet_03v3 L=0.28U W=2U AS=0.52P AD=0.7P PS=3.04U
+ PD=4.4U
* device instance $3214 r0 *1 142.265,79.24 nfet_03v3
M$3214 \$1027 \$1026 VSS VSS nfet_03v3 L=1.03U W=1U AS=0.49P AD=0.44P PS=2.98U
+ PD=2.88U
* device instance $3215 r0 *1 146.185,79.24 nfet_03v3
M$3215 \$1029 \$1028 VSS VSS nfet_03v3 L=1.03U W=1U AS=0.49P AD=0.44P PS=2.98U
+ PD=2.88U
* device instance $3216 r0 *1 147.305,77.56 nfet_03v3
M$3216 \$950 \$949 VSS VSS nfet_03v3 L=1.03U W=1U AS=0.49P AD=0.44P PS=2.98U
+ PD=2.88U
* device instance $3217 r0 *1 149.12,79.24 nfet_03v3
M$3217 C|Y$8 A|Y$158 VSS VSS nfet_03v3 L=0.28U W=2U AS=0.7P AD=0.7P PS=4.4U
+ PD=4.4U
* device instance $3219 r0 *1 149.44,77.56 nfet_03v3
M$3219 A|Y$121 \$951 VSS VSS nfet_03v3 L=0.28U W=2U AS=1.02P AD=0.52P PS=5.04U
+ PD=3.04U
* device instance $3221 r0 *1 151.04,77.56 nfet_03v3
M$3221 \$951 A|MID_MUX[0] VSS VSS nfet_03v3 L=0.28U W=1U AS=0.26P AD=0.44P
+ PS=1.52U PD=2.88U
* device instance $3222 r0 *1 151.44,79.24 nfet_03v3
M$3222 Y$8 C|Y$9 \$1032 VSS nfet_03v3 L=0.28U W=2U AS=0.71P AD=0.7P PS=4.42U
+ PD=4.4U
* device instance $3224 r0 *1 152.8,77.56 nfet_03v3
M$3224 A|Y$132 \$953 VSS VSS nfet_03v3 L=0.28U W=2U AS=1.02P AD=0.52P PS=5.04U
+ PD=3.04U
* device instance $3226 r0 *1 154.4,77.56 nfet_03v3
M$3226 \$953 A|COARSE_MUX[2] VSS VSS nfet_03v3 L=0.28U W=1U AS=0.26P AD=0.44P
+ PS=1.52U PD=2.88U
* device instance $3227 r0 *1 153.68,79.24 nfet_03v3
M$3227 \$1032 A|B|Y \$1035 VSS nfet_03v3 L=0.28U W=2U AS=0.7P AD=0.52P PS=4.4U
+ PD=3.04U
* device instance $3229 r0 *1 155.28,79.24 nfet_03v3
M$3229 VSS A|Y$143 \$1035 VSS nfet_03v3 L=0.28U W=2U AS=0.52P AD=0.7P PS=3.04U
+ PD=4.4U
* device instance $3231 r0 *1 156.16,77.56 nfet_03v3
M$3231 A|Y$143 \$955 VSS VSS nfet_03v3 L=0.28U W=2U AS=1.02P AD=0.52P PS=5.04U
+ PD=3.04U
* device instance $3233 r0 *1 157.76,77.56 nfet_03v3
M$3233 \$955 A|MID_MUX[7] VSS VSS nfet_03v3 L=0.28U W=1U AS=0.26P AD=0.44P
+ PS=1.52U PD=2.88U
* device instance $3234 r0 *1 159.52,79.24 nfet_03v3
M$3234 A|Y$175 \$1036 VSS VSS nfet_03v3 L=0.28U W=2U AS=1.02P AD=0.52P PS=5.04U
+ PD=3.04U
* device instance $3236 r0 *1 161.12,79.24 nfet_03v3
M$3236 \$1036 A|COARSE_MUX[0] VSS VSS nfet_03v3 L=0.28U W=1U AS=0.26P AD=0.44P
+ PS=1.52U PD=2.88U
* device instance $3237 r0 *1 159.52,77.56 nfet_03v3
M$3237 A|Y$176 \$958 VSS VSS nfet_03v3 L=0.28U W=2U AS=1.02P AD=0.52P PS=5.04U
+ PD=3.04U
* device instance $3239 r0 *1 161.12,77.56 nfet_03v3
M$3239 \$958 A|MID_MUX[1] VSS VSS nfet_03v3 L=0.28U W=1U AS=0.26P AD=0.44P
+ PS=1.52U PD=2.88U
* device instance $3240 r0 *1 10.105,85.405 nfet_03v3
M$3240 \$1074 \$1040 VSS VSS nfet_03v3 L=3.27U W=0.99U AS=0.4851P AD=0.4356P
+ PS=2.96U PD=2.86U
* device instance $3241 r0 *1 13.465,85.4 nfet_03v3
M$3241 \$1075 \$1041 VSS VSS nfet_03v3 L=1.03U W=1U AS=0.49P AD=0.44P PS=2.98U
+ PD=2.88U
* device instance $3242 r0 *1 16.4,85.4 nfet_03v3
M$3242 A|Y$146 A|CLK|REF VSS VSS nfet_03v3 L=0.28U W=2U AS=0.7P AD=0.7P PS=4.4U
+ PD=4.4U
* device instance $3244 r0 *1 18.64,85.4 nfet_03v3
M$3244 Y$9 A|Y$146 VSS VSS nfet_03v3 L=0.28U W=2U AS=0.7P AD=0.7P PS=4.4U
+ PD=4.4U
* device instance $3246 r0 *1 21.305,85.4 nfet_03v3
M$3246 \$1076 \$1043 VSS VSS nfet_03v3 L=1.03U W=1U AS=0.49P AD=0.44P PS=2.98U
+ PD=2.88U
* device instance $3247 r0 *1 23.68,85.4 nfet_03v3
M$3247 Y$10 A|Y$147 VSS VSS nfet_03v3 L=0.28U W=2U AS=0.7P AD=0.7P PS=4.4U
+ PD=4.4U
* device instance $3249 r0 *1 27.465,85.405 nfet_03v3
M$3249 \$1077 \$1045 VSS VSS nfet_03v3 L=3.27U W=0.99U AS=0.4851P AD=0.4356P
+ PS=2.96U PD=2.86U
* device instance $3250 r0 *1 30.825,85.4 nfet_03v3
M$3250 \$1078 \$1046 VSS VSS nfet_03v3 L=1.03U W=1U AS=0.49P AD=0.44P PS=2.98U
+ PD=2.88U
* device instance $3251 r0 *1 34.32,85.4 nfet_03v3
M$3251 VSS A|Y$166 \$1047 VSS nfet_03v3 L=0.28U W=1U AS=0.44P AD=0.26P PS=2.88U
+ PD=1.52U
* device instance $3252 r0 *1 35.12,85.4 nfet_03v3
M$3252 A|Y$159 \$1047 VSS VSS nfet_03v3 L=0.28U W=2U AS=0.52P AD=1.02P PS=3.04U
+ PD=5.04U
* device instance $3254 r0 *1 37.68,85.4 nfet_03v3
M$3254 VSS A|Y$179 \$1049 VSS nfet_03v3 L=0.28U W=1U AS=0.44P AD=0.26P PS=2.88U
+ PD=1.52U
* device instance $3255 r0 *1 38.48,85.4 nfet_03v3
M$3255 A|Y$160 \$1049 VSS VSS nfet_03v3 L=0.28U W=2U AS=0.52P AD=1.02P PS=3.04U
+ PD=5.04U
* device instance $3257 r0 *1 41.465,85.4 nfet_03v3
M$3257 \$1080 \$1051 VSS VSS nfet_03v3 L=1.03U W=1U AS=0.49P AD=0.44P PS=2.98U
+ PD=2.88U
* device instance $3258 r0 *1 43.28,85.4 nfet_03v3
M$3258 VSS A|Y$167 \$1052 VSS nfet_03v3 L=0.28U W=1U AS=0.44P AD=0.26P PS=2.88U
+ PD=1.52U
* device instance $3259 r0 *1 44.08,85.4 nfet_03v3
M$3259 A|Y$161 \$1052 VSS VSS nfet_03v3 L=0.28U W=2U AS=0.52P AD=1.02P PS=3.04U
+ PD=5.04U
* device instance $3261 r0 *1 48.88,85.4 nfet_03v3
M$3261 VSS A|Y$168 \$1054 VSS nfet_03v3 L=0.28U W=1U AS=0.44P AD=0.26P PS=2.88U
+ PD=1.52U
* device instance $3262 r0 *1 49.68,85.4 nfet_03v3
M$3262 A|Y$150 \$1054 VSS VSS nfet_03v3 L=0.28U W=2U AS=0.52P AD=1.02P PS=3.04U
+ PD=5.04U
* device instance $3264 r0 *1 52.56,85.4 nfet_03v3
M$3264 A|Y$169 \$1083 VSS VSS nfet_03v3 L=0.28U W=2U AS=1.02P AD=0.52P PS=5.04U
+ PD=3.04U
* device instance $3266 r0 *1 54.16,85.4 nfet_03v3
M$3266 \$1083 A|Y$151 VSS VSS nfet_03v3 L=0.28U W=1U AS=0.26P AD=0.44P PS=1.52U
+ PD=2.88U
* device instance $3267 r0 *1 55.6,85.4 nfet_03v3
M$3267 VSS A|Y$169 \$1055 VSS nfet_03v3 L=0.28U W=1U AS=0.44P AD=0.26P PS=2.88U
+ PD=1.52U
* device instance $3268 r0 *1 56.4,85.4 nfet_03v3
M$3268 A|Y$162 \$1055 VSS VSS nfet_03v3 L=0.28U W=2U AS=0.52P AD=1.02P PS=3.04U
+ PD=5.04U
* device instance $3270 r0 *1 58.96,85.4 nfet_03v3
M$3270 VSS A|Y$162 \$1057 VSS nfet_03v3 L=0.28U W=1U AS=0.44P AD=0.26P PS=2.88U
+ PD=1.52U
* device instance $3271 r0 *1 59.76,85.4 nfet_03v3
M$3271 A|Y$152 \$1057 VSS VSS nfet_03v3 L=0.28U W=2U AS=0.52P AD=1.02P PS=3.04U
+ PD=5.04U
* device instance $3273 r0 *1 66.105,85.405 nfet_03v3
M$3273 \$1085 \$1058 VSS VSS nfet_03v3 L=7.75U W=0.99U AS=0.4851P AD=0.4356P
+ PS=2.96U PD=2.86U
* device instance $3274 r0 *1 72.72,85.4 nfet_03v3
M$3274 A|Y$163 \$1086 VSS VSS nfet_03v3 L=0.28U W=2U AS=1.02P AD=0.52P PS=5.04U
+ PD=3.04U
* device instance $3276 r0 *1 74.32,85.4 nfet_03v3
M$3276 \$1086 A|Y$170 VSS VSS nfet_03v3 L=0.28U W=1U AS=0.26P AD=0.44P PS=1.52U
+ PD=2.88U
* device instance $3277 r0 *1 75.76,85.4 nfet_03v3
M$3277 VSS A|Y$153 \$1060 VSS nfet_03v3 L=0.28U W=1U AS=0.44P AD=0.26P PS=2.88U
+ PD=1.52U
* device instance $3278 r0 *1 76.56,85.4 nfet_03v3
M$3278 A|Y$170 \$1060 VSS VSS nfet_03v3 L=0.28U W=2U AS=0.52P AD=1.02P PS=3.04U
+ PD=5.04U
* device instance $3280 r0 *1 79.545,85.4 nfet_03v3
M$3280 \$1088 \$1061 VSS VSS nfet_03v3 L=1.03U W=1U AS=0.49P AD=0.44P PS=2.98U
+ PD=2.88U
* device instance $3281 r0 *1 82.8,85.4 nfet_03v3
M$3281 A|Y$155 \$1089 VSS VSS nfet_03v3 L=0.28U W=2U AS=1.02P AD=0.52P PS=5.04U
+ PD=3.04U
* device instance $3283 r0 *1 84.4,85.4 nfet_03v3
M$3283 \$1089 A|Y$172 VSS VSS nfet_03v3 L=0.28U W=1U AS=0.26P AD=0.44P PS=1.52U
+ PD=2.88U
* device instance $3284 r0 *1 86.96,85.4 nfet_03v3
M$3284 VSS A|Y$171 \$1062 VSS nfet_03v3 L=0.28U W=1U AS=0.44P AD=0.26P PS=2.88U
+ PD=1.52U
* device instance $3285 r0 *1 87.76,85.4 nfet_03v3
M$3285 A|Y$172 \$1062 VSS VSS nfet_03v3 L=0.28U W=2U AS=0.52P AD=1.02P PS=3.04U
+ PD=5.04U
* device instance $3287 r0 *1 94.105,85.405 nfet_03v3
M$3287 \$1092 \$1063 VSS VSS nfet_03v3 L=7.75U W=0.99U AS=0.4851P AD=0.4356P
+ PS=2.96U PD=2.86U
* device instance $3288 r0 *1 99.28,85.4 nfet_03v3
M$3288 VSS A|Y$157 \$1064 VSS nfet_03v3 L=0.28U W=1U AS=0.44P AD=0.26P PS=2.88U
+ PD=1.52U
* device instance $3289 r0 *1 100.08,85.4 nfet_03v3
M$3289 A|Y$164 \$1064 VSS VSS nfet_03v3 L=0.28U W=2U AS=0.52P AD=1.02P PS=3.04U
+ PD=5.04U
* device instance $3291 r0 *1 106.425,85.405 nfet_03v3
M$3291 \$1093 \$1066 VSS VSS nfet_03v3 L=7.75U W=0.99U AS=0.4851P AD=0.4356P
+ PS=2.96U PD=2.86U
* device instance $3292 r0 *1 115.385,85.405 nfet_03v3
M$3292 \$1094 \$1067 VSS VSS nfet_03v3 L=7.75U W=0.99U AS=0.4851P AD=0.4356P
+ PS=2.96U PD=2.86U
* device instance $3293 r0 *1 122.105,85.405 nfet_03v3
M$3293 \$1095 \$1068 VSS VSS nfet_03v3 L=3.27U W=0.99U AS=0.4851P AD=0.4356P
+ PS=2.96U PD=2.86U
* device instance $3294 r0 *1 127.705,85.405 nfet_03v3
M$3294 \$1096 \$1069 VSS VSS nfet_03v3 L=3.27U W=0.99U AS=0.4851P AD=0.4356P
+ PS=2.96U PD=2.86U
* device instance $3295 r0 *1 131.065,85.4 nfet_03v3
M$3295 \$1097 \$1070 VSS VSS nfet_03v3 L=1.03U W=1U AS=0.49P AD=0.44P PS=2.98U
+ PD=2.88U
* device instance $3296 r0 *1 133.44,85.4 nfet_03v3
M$3296 VSS A|Y$173 \$1108 VSS nfet_03v3 L=0.28U W=2U AS=0.7P AD=0.52P PS=4.4U
+ PD=3.04U
* device instance $3298 r0 *1 135.04,85.4 nfet_03v3
M$3298 A|Y$174 B|Y$27 \$1108 VSS nfet_03v3 L=0.28U W=2U AS=0.52P AD=0.775P
+ PS=3.04U PD=4.55U
* device instance $3300 r0 *1 137.44,85.4 nfet_03v3
M$3300 B|Y$28 B|Y$29 \$1109 VSS nfet_03v3 L=0.28U W=2U AS=0.775P AD=0.52P
+ PS=4.55U PD=3.04U
* device instance $3302 r0 *1 139.04,85.4 nfet_03v3
M$3302 VSS A|Y$175 \$1109 VSS nfet_03v3 L=0.28U W=2U AS=0.52P AD=0.7P PS=3.04U
+ PD=4.4U
* device instance $3304 r0 *1 142.825,85.405 nfet_03v3
M$3304 \$1101 \$1071 VSS VSS nfet_03v3 L=3.27U W=0.99U AS=0.4851P AD=0.4356P
+ PS=2.96U PD=2.86U
* device instance $3305 r0 *1 145.76,85.4 nfet_03v3
M$3305 C|Y$9 A|Y$143 VSS VSS nfet_03v3 L=0.28U W=2U AS=0.7P AD=0.7P PS=4.4U
+ PD=4.4U
* device instance $3307 r0 *1 148.32,85.4 nfet_03v3
M$3307 A|Y$158 \$1102 VSS VSS nfet_03v3 L=0.28U W=2U AS=1.02P AD=0.52P PS=5.04U
+ PD=3.04U
* device instance $3309 r0 *1 149.92,85.4 nfet_03v3
M$3309 \$1102 A|MID_MUX[12] VSS VSS nfet_03v3 L=0.28U W=1U AS=0.26P AD=0.44P
+ PS=1.52U PD=2.88U
* device instance $3310 r0 *1 151.44,85.4 nfet_03v3
M$3310 Y$11 C|Y$10 \$1110 VSS nfet_03v3 L=0.28U W=2U AS=0.71P AD=0.7P PS=4.42U
+ PD=4.4U
* device instance $3312 r0 *1 153.68,85.4 nfet_03v3
M$3312 \$1110 A|B|Y \$1111 VSS nfet_03v3 L=0.28U W=2U AS=0.7P AD=0.52P PS=4.4U
+ PD=3.04U
* device instance $3314 r0 *1 155.28,85.4 nfet_03v3
M$3314 VSS A|Y$176 \$1111 VSS nfet_03v3 L=0.28U W=2U AS=0.52P AD=0.7P PS=3.04U
+ PD=4.4U
* device instance $3316 r0 *1 159.52,85.4 nfet_03v3
M$3316 A|Y$165 \$1106 VSS VSS nfet_03v3 L=0.28U W=2U AS=1.02P AD=0.52P PS=5.04U
+ PD=3.04U
* device instance $3318 r0 *1 161.12,85.4 nfet_03v3
M$3318 \$1106 A|MID_MUX[13] VSS VSS nfet_03v3 L=0.28U W=1U AS=0.26P AD=0.44P
+ PS=1.52U PD=2.88U
* device instance $3319 r0 *1 8.56,87.08 nfet_03v3
M$3319 VSS A|DCO_EN \$1113 VSS nfet_03v3 L=0.28U W=1U AS=0.44P AD=0.26P
+ PS=2.88U PD=1.52U
* device instance $3320 r0 *1 9.36,87.08 nfet_03v3
M$3320 A|Y$177 \$1113 VSS VSS nfet_03v3 L=0.28U W=2U AS=0.52P AD=1.02P PS=3.04U
+ PD=5.04U
* device instance $3322 r0 *1 12.24,87.08 nfet_03v3
M$3322 OUT|Y \$1115 VSS VSS nfet_03v3 L=0.28U W=2U AS=1.02P AD=0.52P PS=5.04U
+ PD=3.04U
* device instance $3324 r0 *1 13.84,87.08 nfet_03v3
M$3324 \$1115 A|Y$178 VSS VSS nfet_03v3 L=0.28U W=1U AS=0.26P AD=0.44P PS=1.52U
+ PD=2.88U
* device instance $3325 r0 *1 15.705,87.08 nfet_03v3
M$3325 \$1119 \$1118 VSS VSS nfet_03v3 L=1.03U W=1U AS=0.49P AD=0.44P PS=2.98U
+ PD=2.88U
* device instance $3326 r0 *1 19.44,87.08 nfet_03v3
M$3326 \$1121 A|Y$146 VSS VSS nfet_03v3 L=0.28U W=1U AS=0.46P AD=0.44P PS=2.92U
+ PD=2.88U
* device instance $3327 r0 *1 20.88,87.08 nfet_03v3
M$3327 VSS \$1121 \$1120 VSS nfet_03v3 L=0.28U W=2U AS=0.7P AD=0.52P PS=4.4U
+ PD=3.04U
* device instance $3329 r0 *1 22.48,87.08 nfet_03v3
M$3329 A|Y$189 B|ZERO \$1120 VSS nfet_03v3 L=0.28U W=2U AS=0.52P AD=0.775P
+ PS=3.04U PD=4.55U
* device instance $3331 r0 *1 24.8,87.08 nfet_03v3
M$3331 B|ZERO \$1123 VSS VSS nfet_03v3 L=0.28U W=1U AS=0.44P AD=0.44P PS=2.88U
+ PD=2.88U
* device instance $3332 r0 *1 29.705,87.075 nfet_03v3
M$3332 \$1125 \$1124 VSS VSS nfet_03v3 L=3.27U W=0.99U AS=0.4851P AD=0.4356P
+ PS=2.96U PD=2.86U
* device instance $3333 r0 *1 34.08,87.08 nfet_03v3
M$3333 A|Y$179 \$1126 VSS VSS nfet_03v3 L=0.28U W=2U AS=1.02P AD=0.52P PS=5.04U
+ PD=3.04U
* device instance $3335 r0 *1 35.68,87.08 nfet_03v3
M$3335 \$1126 A|Y$159 VSS VSS nfet_03v3 L=0.28U W=1U AS=0.26P AD=0.44P PS=1.52U
+ PD=2.88U
* device instance $3336 r0 *1 37.44,87.08 nfet_03v3
M$3336 A|Y$180 \$1128 VSS VSS nfet_03v3 L=0.28U W=2U AS=1.02P AD=0.52P PS=5.04U
+ PD=3.04U
* device instance $3338 r0 *1 39.04,87.08 nfet_03v3
M$3338 \$1128 A|Y$160 VSS VSS nfet_03v3 L=0.28U W=1U AS=0.26P AD=0.44P PS=1.52U
+ PD=2.88U
* device instance $3339 r0 *1 40.48,87.08 nfet_03v3
M$3339 VSS A|Y$180 \$1130 VSS nfet_03v3 L=0.28U W=1U AS=0.44P AD=0.26P PS=2.88U
+ PD=1.52U
* device instance $3340 r0 *1 41.28,87.08 nfet_03v3
M$3340 A|Y$167 \$1130 VSS VSS nfet_03v3 L=0.28U W=2U AS=0.52P AD=1.02P PS=3.04U
+ PD=5.04U
* device instance $3342 r0 *1 44.4,87.08 nfet_03v3
M$3342 VSS A|Y$161 \$1131 VSS nfet_03v3 L=0.28U W=1U AS=0.44P AD=0.26P PS=2.88U
+ PD=1.52U
* device instance $3343 r0 *1 45.2,87.08 nfet_03v3
M$3343 A|Y$148 \$1131 VSS VSS nfet_03v3 L=0.28U W=2U AS=0.52P AD=1.02P PS=3.04U
+ PD=5.04U
* device instance $3345 r0 *1 48.32,87.08 nfet_03v3
M$3345 VSS A|Y$149 \$1132 VSS nfet_03v3 L=0.28U W=1U AS=0.44P AD=0.26P PS=2.88U
+ PD=1.52U
* device instance $3346 r0 *1 49.12,87.08 nfet_03v3
M$3346 A|Y$168 \$1132 VSS VSS nfet_03v3 L=0.28U W=2U AS=0.52P AD=1.02P PS=3.04U
+ PD=5.04U
* device instance $3348 r0 *1 55.465,87.075 nfet_03v3
M$3348 \$1134 \$1133 VSS VSS nfet_03v3 L=7.75U W=0.99U AS=0.4851P AD=0.4356P
+ PS=2.96U PD=2.86U
* device instance $3349 r0 *1 62.185,87.075 nfet_03v3
M$3349 \$1136 \$1135 VSS VSS nfet_03v3 L=3.27U W=0.99U AS=0.4851P AD=0.4356P
+ PS=2.96U PD=2.86U
* device instance $3350 r0 *1 67.785,87.08 nfet_03v3
M$3350 \$1138 \$1137 VSS VSS nfet_03v3 L=1.03U W=1U AS=0.49P AD=0.44P PS=2.98U
+ PD=2.88U
* device instance $3351 r0 *1 70.48,87.08 nfet_03v3
M$3351 A|Y$181 \$1139 VSS VSS nfet_03v3 L=0.28U W=2U AS=1.02P AD=0.52P PS=5.04U
+ PD=3.04U
* device instance $3353 r0 *1 72.08,87.08 nfet_03v3
M$3353 \$1139 A|Y$182 VSS VSS nfet_03v3 L=0.28U W=1U AS=0.26P AD=0.44P PS=1.52U
+ PD=2.88U
* device instance $3354 r0 *1 73.52,87.08 nfet_03v3
M$3354 VSS A|Y$163 \$1142 VSS nfet_03v3 L=0.28U W=1U AS=0.44P AD=0.26P PS=2.88U
+ PD=1.52U
* device instance $3355 r0 *1 74.32,87.08 nfet_03v3
M$3355 A|Y$182 \$1142 VSS VSS nfet_03v3 L=0.28U W=2U AS=0.52P AD=1.02P PS=3.04U
+ PD=5.04U
* device instance $3357 r0 *1 78.425,87.075 nfet_03v3
M$3357 \$1144 \$1143 VSS VSS nfet_03v3 L=3.27U W=0.99U AS=0.4851P AD=0.4356P
+ PS=2.96U PD=2.86U
* device instance $3358 r0 *1 82.8,87.08 nfet_03v3
M$3358 A|Y$171 \$1145 VSS VSS nfet_03v3 L=0.28U W=2U AS=1.02P AD=0.52P PS=5.04U
+ PD=3.04U
* device instance $3360 r0 *1 84.4,87.08 nfet_03v3
M$3360 \$1145 A|Y$183 VSS VSS nfet_03v3 L=0.28U W=1U AS=0.26P AD=0.44P PS=1.52U
+ PD=2.88U
* device instance $3361 r0 *1 86.16,87.08 nfet_03v3
M$3361 A|Y$183 \$1147 VSS VSS nfet_03v3 L=0.28U W=2U AS=1.02P AD=0.52P PS=5.04U
+ PD=3.04U
* device instance $3363 r0 *1 87.76,87.08 nfet_03v3
M$3363 \$1147 A|Y$184 VSS VSS nfet_03v3 L=0.28U W=1U AS=0.26P AD=0.44P PS=1.52U
+ PD=2.88U
* device instance $3364 r0 *1 89.52,87.08 nfet_03v3
M$3364 A|Y$184 \$1149 VSS VSS nfet_03v3 L=0.28U W=2U AS=1.02P AD=0.52P PS=5.04U
+ PD=3.04U
* device instance $3366 r0 *1 91.12,87.08 nfet_03v3
M$3366 \$1149 A|Y$185 VSS VSS nfet_03v3 L=0.28U W=1U AS=0.26P AD=0.44P PS=1.52U
+ PD=2.88U
* device instance $3367 r0 *1 94.105,87.075 nfet_03v3
M$3367 \$1152 \$1151 VSS VSS nfet_03v3 L=3.27U W=0.99U AS=0.4851P AD=0.4356P
+ PS=2.96U PD=2.86U
* device instance $3368 r0 *1 99.04,87.08 nfet_03v3
M$3368 A|Y$186 \$1153 VSS VSS nfet_03v3 L=0.28U W=2U AS=1.02P AD=0.52P PS=5.04U
+ PD=3.04U
* device instance $3370 r0 *1 100.64,87.08 nfet_03v3
M$3370 \$1153 A|Y$187 VSS VSS nfet_03v3 L=0.28U W=1U AS=0.26P AD=0.44P PS=1.52U
+ PD=2.88U
* device instance $3371 r0 *1 102.08,87.08 nfet_03v3
M$3371 VSS A|Y$164 \$1156 VSS nfet_03v3 L=0.28U W=1U AS=0.44P AD=0.26P PS=2.88U
+ PD=1.52U
* device instance $3372 r0 *1 102.88,87.08 nfet_03v3
M$3372 A|Y$187 \$1156 VSS VSS nfet_03v3 L=0.28U W=2U AS=0.52P AD=1.02P PS=3.04U
+ PD=5.04U
* device instance $3374 r0 *1 110.345,87.075 nfet_03v3
M$3374 \$1158 \$1157 VSS VSS nfet_03v3 L=7.75U W=0.99U AS=0.4851P AD=0.4356P
+ PS=2.96U PD=2.86U
* device instance $3375 r0 *1 119.305,87.075 nfet_03v3
M$3375 \$1160 \$1159 VSS VSS nfet_03v3 L=7.75U W=0.99U AS=0.4851P AD=0.4356P
+ PS=2.96U PD=2.86U
* device instance $3376 r0 *1 126.025,87.075 nfet_03v3
M$3376 \$1162 \$1161 VSS VSS nfet_03v3 L=3.27U W=0.99U AS=0.4851P AD=0.4356P
+ PS=2.96U PD=2.86U
* device instance $3377 r0 *1 129.385,87.08 nfet_03v3
M$3377 \$1164 \$1163 VSS VSS nfet_03v3 L=1.03U W=1U AS=0.49P AD=0.44P PS=2.98U
+ PD=2.88U
* device instance $3378 r0 *1 132.4,87.08 nfet_03v3
M$3378 A|Y$173 B|Y$29 \$1165 VSS nfet_03v3 L=0.28U W=2U AS=0.775P AD=0.52P
+ PS=4.55U PD=3.04U
* device instance $3380 r0 *1 134,87.08 nfet_03v3
M$3380 VSS \$1167 \$1165 VSS nfet_03v3 L=0.28U W=2U AS=0.52P AD=0.7P PS=3.04U
+ PD=4.4U
* device instance $3382 r0 *1 136.24,87.08 nfet_03v3
M$3382 VSS A|Y$175 \$1167 VSS nfet_03v3 L=0.28U W=1U AS=0.44P AD=0.46P PS=2.88U
+ PD=2.92U
* device instance $3383 r0 *1 137.92,87.08 nfet_03v3
M$3383 A|B|Y A|Y$174 VSS VSS nfet_03v3 L=0.28U W=4U AS=1.22P AD=1.3P PS=7.44U
+ PD=7.6U
* device instance $3387 r0 *1 142.265,87.08 nfet_03v3
M$3387 \$1169 \$1168 VSS VSS nfet_03v3 L=1.03U W=1U AS=0.49P AD=0.44P PS=2.98U
+ PD=2.88U
* device instance $3388 r0 *1 146.185,87.08 nfet_03v3
M$3388 \$1171 \$1170 VSS VSS nfet_03v3 L=1.03U W=1U AS=0.49P AD=0.44P PS=2.98U
+ PD=2.88U
* device instance $3389 r0 *1 149.68,87.08 nfet_03v3
M$3389 C|Y$10 A|Y$176 VSS VSS nfet_03v3 L=0.28U W=2U AS=0.7P AD=0.7P PS=4.4U
+ PD=4.4U
* device instance $3391 r0 *1 151.92,87.08 nfet_03v3
M$3391 VSS A|Y$158 \$1172 VSS nfet_03v3 L=0.28U W=2U AS=0.7P AD=0.52P PS=4.4U
+ PD=3.04U
* device instance $3393 r0 *1 153.52,87.08 nfet_03v3
M$3393 \$1173 A|B|Y \$1172 VSS nfet_03v3 L=0.28U W=2U AS=0.52P AD=0.7P PS=3.04U
+ PD=4.4U
* device instance $3395 r0 *1 155.76,87.08 nfet_03v3
M$3395 Y$12 C|Y$8 \$1173 VSS nfet_03v3 L=0.28U W=2U AS=0.7P AD=0.71P PS=4.4U
+ PD=4.42U
* device instance $3397 r0 *1 159.52,87.08 nfet_03v3
M$3397 A|Y$188 \$1174 VSS VSS nfet_03v3 L=0.28U W=2U AS=1.02P AD=0.52P PS=5.04U
+ PD=3.04U
* device instance $3399 r0 *1 161.12,87.08 nfet_03v3
M$3399 \$1174 A|MID_MUX[5] VSS VSS nfet_03v3 L=0.28U W=1U AS=0.26P AD=0.44P
+ PS=1.52U PD=2.88U
* device instance $3400 r0 *1 8.56,93.24 nfet_03v3
M$3400 VSS A|FINE_MUX[8] \$1180 VSS nfet_03v3 L=0.28U W=1U AS=0.44P AD=0.26P
+ PS=2.88U PD=1.52U
* device instance $3401 r0 *1 9.36,93.24 nfet_03v3
M$3401 A|Y$190 \$1180 VSS VSS nfet_03v3 L=0.28U W=2U AS=0.52P AD=1.02P PS=3.04U
+ PD=5.04U
* device instance $3403 r0 *1 8.985,94.92 nfet_03v3
M$3403 \$1248 \$1247 VSS VSS nfet_03v3 L=1.03U W=1U AS=0.49P AD=0.44P PS=2.98U
+ PD=2.88U
* device instance $3404 r0 *1 11.36,94.92 nfet_03v3
M$3404 VSS A|Y$190 \$1249 VSS nfet_03v3 L=0.28U W=2U AS=0.7P AD=0.52P PS=4.4U
+ PD=3.04U
* device instance $3406 r0 *1 12.96,94.92 nfet_03v3
M$3406 \$1250 A|B|Y$3 \$1249 VSS nfet_03v3 L=0.28U W=2U AS=0.52P AD=0.7P
+ PS=3.04U PD=4.4U
* device instance $3408 r0 *1 12.16,93.24 nfet_03v3
M$3408 \$1182 A|Y$177 VSS VSS nfet_03v3 L=0.28U W=1U AS=0.445P AD=0.44P
+ PS=2.89U PD=2.88U
* device instance $3409 r0 *1 13.6,93.24 nfet_03v3
M$3409 B|Y$30 \$1182 VSS VSS nfet_03v3 L=0.28U W=2U AS=0.7P AD=0.52P PS=4.4U
+ PD=3.04U
* device instance $3411 r0 *1 15.2,93.24 nfet_03v3
M$3411 B|Y$30 B|ZERO$1 VSS VSS nfet_03v3 L=0.28U W=2U AS=0.52P AD=0.775P
+ PS=3.04U PD=4.55U
* device instance $3413 r0 *1 15.2,94.92 nfet_03v3
M$3413 Y$15 C|Y$13 \$1250 VSS nfet_03v3 L=0.28U W=2U AS=0.7P AD=0.71P PS=4.4U
+ PD=4.42U
* device instance $3415 r0 *1 17.52,93.24 nfet_03v3
M$3415 B|ZERO$1 \$1240 VSS VSS nfet_03v3 L=0.28U W=1U AS=0.44P AD=0.44P
+ PS=2.88U PD=2.88U
* device instance $3416 r0 *1 19.2,94.92 nfet_03v3
M$3416 VSS A|Y$147 \$1252 VSS nfet_03v3 L=0.28U W=2U AS=0.7P AD=0.52P PS=4.4U
+ PD=3.04U
* device instance $3418 r0 *1 20.8,94.92 nfet_03v3
M$3418 B|Y$31 B|Y$30 \$1252 VSS nfet_03v3 L=0.28U W=2U AS=0.52P AD=0.775P
+ PS=3.04U PD=4.55U
* device instance $3420 r0 *1 20.96,93.24 nfet_03v3
M$3420 A|Y$178 B|Y$31 \$1243 VSS nfet_03v3 L=0.28U W=2U AS=0.775P AD=0.52P
+ PS=4.55U PD=3.04U
* device instance $3422 r0 *1 22.56,93.24 nfet_03v3
M$3422 VSS A|Y$189 \$1243 VSS nfet_03v3 L=0.28U W=2U AS=0.52P AD=0.7P PS=3.04U
+ PD=4.4U
* device instance $3424 r0 *1 24.8,94.92 nfet_03v3
M$3424 A|Y$147 A|Y$200 VSS VSS nfet_03v3 L=0.28U W=2U AS=0.7P AD=0.7P PS=4.4U
+ PD=4.4U
* device instance $3426 r0 *1 25.225,93.24 nfet_03v3
M$3426 \$1188 \$1187 VSS VSS nfet_03v3 L=1.03U W=1U AS=0.49P AD=0.44P PS=2.98U
+ PD=2.88U
* device instance $3427 r0 *1 27.6,93.24 nfet_03v3
M$3427 VSS A|Y$178 \$1189 VSS nfet_03v3 L=0.28U W=1U AS=0.44P AD=0.26P PS=2.88U
+ PD=1.52U
* device instance $3428 r0 *1 28.4,93.24 nfet_03v3
M$3428 A|Y$191 \$1189 VSS VSS nfet_03v3 L=0.28U W=2U AS=0.52P AD=1.02P PS=3.04U
+ PD=5.04U
* device instance $3430 r0 *1 28.16,94.92 nfet_03v3
M$3430 A|Y$200 A|B|Y$3 VSS VSS nfet_03v3 L=0.28U W=6U AS=1.74P AD=1.9P
+ PS=10.48U PD=10.8U
* device instance $3436 r0 *1 32.08,93.24 nfet_03v3
M$3436 VSS A|Y$191 \$1191 VSS nfet_03v3 L=0.28U W=1U AS=0.44P AD=0.26P PS=2.88U
+ PD=1.52U
* device instance $3437 r0 *1 32.88,93.24 nfet_03v3
M$3437 A|Y$166 \$1191 VSS VSS nfet_03v3 L=0.28U W=2U AS=0.52P AD=1.02P PS=3.04U
+ PD=5.04U
* device instance $3439 r0 *1 37.545,94.915 nfet_03v3
M$3439 \$1256 \$1255 VSS VSS nfet_03v3 L=7.75U W=0.99U AS=0.4851P AD=0.4356P
+ PS=2.96U PD=2.86U
* device instance $3440 r0 *1 39.225,93.245 nfet_03v3
M$3440 \$1193 \$1192 VSS VSS nfet_03v3 L=7.75U W=0.99U AS=0.4851P AD=0.4356P
+ PS=2.96U PD=2.86U
* device instance $3441 r0 *1 46.505,94.915 nfet_03v3
M$3441 \$1258 \$1257 VSS VSS nfet_03v3 L=7.75U W=0.99U AS=0.4851P AD=0.4356P
+ PS=2.96U PD=2.86U
* device instance $3442 r0 *1 44.825,93.24 nfet_03v3
M$3442 \$1195 \$1194 VSS VSS nfet_03v3 L=1.03U W=1U AS=0.49P AD=0.44P PS=2.98U
+ PD=2.88U
* device instance $3443 r0 *1 51.545,93.245 nfet_03v3
M$3443 \$1197 \$1196 VSS VSS nfet_03v3 L=7.75U W=0.99U AS=0.4851P AD=0.4356P
+ PS=2.96U PD=2.86U
* device instance $3444 r0 *1 55.465,94.915 nfet_03v3
M$3444 \$1260 \$1259 VSS VSS nfet_03v3 L=7.75U W=0.99U AS=0.4851P AD=0.4356P
+ PS=2.96U PD=2.86U
* device instance $3445 r0 *1 60.505,93.245 nfet_03v3
M$3445 \$1199 \$1198 VSS VSS nfet_03v3 L=7.75U W=0.99U AS=0.4851P AD=0.4356P
+ PS=2.96U PD=2.86U
* device instance $3446 r0 *1 62.185,94.915 nfet_03v3
M$3446 \$1262 \$1261 VSS VSS nfet_03v3 L=3.27U W=0.99U AS=0.4851P AD=0.4356P
+ PS=2.96U PD=2.86U
* device instance $3447 r0 *1 66,93.24 nfet_03v3
M$3447 A|Y$192 \$1200 VSS VSS nfet_03v3 L=0.28U W=2U AS=1.02P AD=0.52P PS=5.04U
+ PD=3.04U
* device instance $3449 r0 *1 67.6,93.24 nfet_03v3
M$3449 \$1200 A|Y$193 VSS VSS nfet_03v3 L=0.28U W=1U AS=0.26P AD=0.44P PS=1.52U
+ PD=2.88U
* device instance $3450 r0 *1 67.785,94.92 nfet_03v3
M$3450 \$1264 \$1263 VSS VSS nfet_03v3 L=1.03U W=1U AS=0.49P AD=0.44P PS=2.98U
+ PD=2.88U
* device instance $3451 r0 *1 69.04,93.24 nfet_03v3
M$3451 VSS A|Y$192 \$1203 VSS nfet_03v3 L=0.28U W=1U AS=0.44P AD=0.26P PS=2.88U
+ PD=1.52U
* device instance $3452 r0 *1 69.84,93.24 nfet_03v3
M$3452 A|Y$194 \$1203 VSS VSS nfet_03v3 L=0.28U W=2U AS=0.52P AD=1.02P PS=3.04U
+ PD=5.04U
* device instance $3454 r0 *1 69.92,94.92 nfet_03v3
M$3454 A|Y$201 \$1265 VSS VSS nfet_03v3 L=0.28U W=2U AS=1.02P AD=0.52P PS=5.04U
+ PD=3.04U
* device instance $3456 r0 *1 71.52,94.92 nfet_03v3
M$3456 \$1265 A|Y$202 VSS VSS nfet_03v3 L=0.28U W=1U AS=0.26P AD=0.44P PS=1.52U
+ PD=2.88U
* device instance $3457 r0 *1 72.4,93.24 nfet_03v3
M$3457 VSS A|Y$181 \$1205 VSS nfet_03v3 L=0.28U W=1U AS=0.44P AD=0.26P PS=2.88U
+ PD=1.52U
* device instance $3458 r0 *1 73.2,93.24 nfet_03v3
M$3458 A|Y$193 \$1205 VSS VSS nfet_03v3 L=0.28U W=2U AS=0.52P AD=1.02P PS=3.04U
+ PD=5.04U
* device instance $3460 r0 *1 72.96,94.92 nfet_03v3
M$3460 VSS A|Y$194 \$1268 VSS nfet_03v3 L=0.28U W=1U AS=0.44P AD=0.26P PS=2.88U
+ PD=1.52U
* device instance $3461 r0 *1 73.76,94.92 nfet_03v3
M$3461 A|Y$202 \$1268 VSS VSS nfet_03v3 L=0.28U W=2U AS=0.52P AD=1.02P PS=3.04U
+ PD=5.04U
* device instance $3463 r0 *1 79.545,93.245 nfet_03v3
M$3463 \$1207 \$1206 VSS VSS nfet_03v3 L=7.75U W=0.99U AS=0.4851P AD=0.4356P
+ PS=2.96U PD=2.86U
* device instance $3464 r0 *1 80.105,94.915 nfet_03v3
M$3464 \$1270 \$1269 VSS VSS nfet_03v3 L=7.75U W=0.99U AS=0.4851P AD=0.4356P
+ PS=2.96U PD=2.86U
* device instance $3465 r0 *1 89.065,94.915 nfet_03v3
M$3465 \$1272 \$1271 VSS VSS nfet_03v3 L=7.75U W=0.99U AS=0.4851P AD=0.4356P
+ PS=2.96U PD=2.86U
* device instance $3466 r0 *1 87.385,93.24 nfet_03v3
M$3466 \$1209 \$1208 VSS VSS nfet_03v3 L=1.03U W=1U AS=0.49P AD=0.44P PS=2.98U
+ PD=2.88U
* device instance $3467 r0 *1 90.08,93.24 nfet_03v3
M$3467 A|Y$185 \$1210 VSS VSS nfet_03v3 L=0.28U W=2U AS=1.02P AD=0.52P PS=5.04U
+ PD=3.04U
* device instance $3469 r0 *1 91.68,93.24 nfet_03v3
M$3469 \$1210 A|Y$195 VSS VSS nfet_03v3 L=0.28U W=1U AS=0.26P AD=0.44P PS=1.52U
+ PD=2.88U
* device instance $3470 r0 *1 93.44,93.24 nfet_03v3
M$3470 A|Y$195 \$1212 VSS VSS nfet_03v3 L=0.28U W=2U AS=1.02P AD=0.52P PS=5.04U
+ PD=3.04U
* device instance $3472 r0 *1 95.04,93.24 nfet_03v3
M$3472 \$1212 A|Y$196 VSS VSS nfet_03v3 L=0.28U W=1U AS=0.26P AD=0.44P PS=1.52U
+ PD=2.88U
* device instance $3473 r0 *1 95.785,94.915 nfet_03v3
M$3473 \$1274 \$1273 VSS VSS nfet_03v3 L=3.27U W=0.99U AS=0.4851P AD=0.4356P
+ PS=2.96U PD=2.86U
* device instance $3474 r0 *1 96.8,93.24 nfet_03v3
M$3474 A|Y$196 \$1214 VSS VSS nfet_03v3 L=0.28U W=2U AS=1.02P AD=0.52P PS=5.04U
+ PD=3.04U
* device instance $3476 r0 *1 98.4,93.24 nfet_03v3
M$3476 \$1214 A|Y$197 VSS VSS nfet_03v3 L=0.28U W=1U AS=0.26P AD=0.44P PS=1.52U
+ PD=2.88U
* device instance $3477 r0 *1 99.36,94.92 nfet_03v3
M$3477 A|Y$211 A|B|Y VSS VSS nfet_03v3 L=0.28U W=4U AS=1.3P AD=1.22P PS=7.6U
+ PD=7.44U
* device instance $3481 r0 *1 99.84,93.24 nfet_03v3
M$3481 VSS A|Y$186 \$1216 VSS nfet_03v3 L=0.28U W=1U AS=0.44P AD=0.26P PS=2.88U
+ PD=1.52U
* device instance $3482 r0 *1 100.64,93.24 nfet_03v3
M$3482 A|Y$197 \$1216 VSS VSS nfet_03v3 L=0.28U W=2U AS=0.52P AD=1.02P PS=3.04U
+ PD=5.04U
* device instance $3484 r0 *1 103.625,94.92 nfet_03v3
M$3484 \$1276 \$1275 VSS VSS nfet_03v3 L=1.03U W=1U AS=0.49P AD=0.44P PS=2.98U
+ PD=2.88U
* device instance $3485 r0 *1 106.985,93.245 nfet_03v3
M$3485 \$1218 \$1217 VSS VSS nfet_03v3 L=7.75U W=0.99U AS=0.4851P AD=0.4356P
+ PS=2.96U PD=2.86U
* device instance $3486 r0 *1 110.345,94.915 nfet_03v3
M$3486 \$1278 \$1277 VSS VSS nfet_03v3 L=7.75U W=0.99U AS=0.4851P AD=0.4356P
+ PS=2.96U PD=2.86U
* device instance $3487 r0 *1 115.945,93.245 nfet_03v3
M$3487 \$1220 \$1219 VSS VSS nfet_03v3 L=7.75U W=0.99U AS=0.4851P AD=0.4356P
+ PS=2.96U PD=2.86U
* device instance $3488 r0 *1 119.305,94.915 nfet_03v3
M$3488 \$1280 \$1279 VSS VSS nfet_03v3 L=7.75U W=0.99U AS=0.4851P AD=0.4356P
+ PS=2.96U PD=2.86U
* device instance $3489 r0 *1 121.545,93.24 nfet_03v3
M$3489 \$1222 \$1221 VSS VSS nfet_03v3 L=1.03U W=1U AS=0.49P AD=0.44P PS=2.98U
+ PD=2.88U
* device instance $3490 r0 *1 126.025,94.915 nfet_03v3
M$3490 \$1282 \$1281 VSS VSS nfet_03v3 L=3.27U W=0.99U AS=0.4851P AD=0.4356P
+ PS=2.96U PD=2.86U
* device instance $3491 r0 *1 127.705,93.245 nfet_03v3
M$3491 \$1224 \$1223 VSS VSS nfet_03v3 L=3.27U W=0.99U AS=0.4851P AD=0.4356P
+ PS=2.96U PD=2.86U
* device instance $3492 r0 *1 130.4,94.92 nfet_03v3
M$3492 A|Y$199 \$1283 VSS VSS nfet_03v3 L=0.28U W=2U AS=1.02P AD=0.52P PS=5.04U
+ PD=3.04U
* device instance $3494 r0 *1 132,94.92 nfet_03v3
M$3494 \$1283 A|Y$203 VSS VSS nfet_03v3 L=0.28U W=1U AS=0.26P AD=0.44P PS=1.52U
+ PD=2.88U
* device instance $3495 r0 *1 131.065,93.24 nfet_03v3
M$3495 \$1226 \$1225 VSS VSS nfet_03v3 L=1.03U W=1U AS=0.49P AD=0.44P PS=2.98U
+ PD=2.88U
* device instance $3496 r0 *1 133.44,94.92 nfet_03v3
M$3496 VSS A|Y$204 \$1285 VSS nfet_03v3 L=0.28U W=1U AS=0.44P AD=0.26P PS=2.88U
+ PD=1.52U
* device instance $3497 r0 *1 134.24,94.92 nfet_03v3
M$3497 A|Y$205 \$1285 VSS VSS nfet_03v3 L=0.28U W=2U AS=0.52P AD=1.02P PS=3.04U
+ PD=5.04U
* device instance $3499 r0 *1 134,93.24 nfet_03v3
M$3499 VSS A|Y$199 \$1227 VSS nfet_03v3 L=0.28U W=1U AS=0.44P AD=0.26P PS=2.88U
+ PD=1.52U
* device instance $3500 r0 *1 134.8,93.24 nfet_03v3
M$3500 A|Y$198 \$1227 VSS VSS nfet_03v3 L=0.28U W=2U AS=0.52P AD=1.02P PS=3.04U
+ PD=5.04U
* device instance $3502 r0 *1 138.345,94.915 nfet_03v3
M$3502 \$1289 \$1288 VSS VSS nfet_03v3 L=3.27U W=0.99U AS=0.4851P AD=0.4356P
+ PS=2.96U PD=2.86U
* device instance $3503 r0 *1 137.36,93.24 nfet_03v3
M$3503 VSS A|Y$198 \$1229 VSS nfet_03v3 L=0.28U W=1U AS=0.44P AD=0.26P PS=2.88U
+ PD=1.52U
* device instance $3504 r0 *1 138.16,93.24 nfet_03v3
M$3504 B|Y$29 \$1229 VSS VSS nfet_03v3 L=0.28U W=2U AS=0.52P AD=1.02P PS=3.04U
+ PD=5.04U
* device instance $3506 r0 *1 142.265,93.245 nfet_03v3
M$3506 \$1231 \$1230 VSS VSS nfet_03v3 L=3.27U W=0.99U AS=0.4851P AD=0.4356P
+ PS=2.96U PD=2.86U
* device instance $3507 r0 *1 141.705,94.92 nfet_03v3
M$3507 \$1291 \$1290 VSS VSS nfet_03v3 L=1.03U W=1U AS=0.49P AD=0.44P PS=2.98U
+ PD=2.88U
* device instance $3508 r0 *1 145.625,93.24 nfet_03v3
M$3508 \$1233 \$1232 VSS VSS nfet_03v3 L=1.03U W=1U AS=0.49P AD=0.44P PS=2.98U
+ PD=2.88U
* device instance $3509 r0 *1 147.305,94.915 nfet_03v3
M$3509 \$1293 \$1292 VSS VSS nfet_03v3 L=3.27U W=0.99U AS=0.4851P AD=0.4356P
+ PS=2.96U PD=2.86U
* device instance $3510 r0 *1 148.56,93.24 nfet_03v3
M$3510 C|Y$11 A|Y$165 VSS VSS nfet_03v3 L=0.28U W=2U AS=0.7P AD=0.7P PS=4.4U
+ PD=4.4U
* device instance $3512 r0 *1 150.665,94.92 nfet_03v3
M$3512 \$1295 \$1294 VSS VSS nfet_03v3 L=1.03U W=1U AS=0.49P AD=0.44P PS=2.98U
+ PD=2.88U
* device instance $3513 r0 *1 150.88,93.24 nfet_03v3
M$3513 Y$13 C|Y$11 \$1244 VSS nfet_03v3 L=0.28U W=2U AS=0.71P AD=0.7P PS=4.42U
+ PD=4.4U
* device instance $3515 r0 *1 152.56,94.92 nfet_03v3
M$3515 Y$14 C|Y$14 \$1296 VSS nfet_03v3 L=0.28U W=2U AS=0.71P AD=0.7P PS=4.42U
+ PD=4.4U
* device instance $3517 r0 *1 153.12,93.24 nfet_03v3
M$3517 \$1244 A|B|Y \$1245 VSS nfet_03v3 L=0.28U W=2U AS=0.7P AD=0.52P PS=4.4U
+ PD=3.04U
* device instance $3519 r0 *1 154.72,93.24 nfet_03v3
M$3519 VSS A|Y$165 \$1245 VSS nfet_03v3 L=0.28U W=2U AS=0.52P AD=0.7P PS=3.04U
+ PD=4.4U
* device instance $3521 r0 *1 154.8,94.92 nfet_03v3
M$3521 \$1296 A|B|Y \$1299 VSS nfet_03v3 L=0.28U W=2U AS=0.7P AD=0.52P PS=4.4U
+ PD=3.04U
* device instance $3523 r0 *1 156.4,94.92 nfet_03v3
M$3523 VSS A|Y$206 \$1299 VSS nfet_03v3 L=0.28U W=2U AS=0.52P AD=0.7P PS=3.04U
+ PD=4.4U
* device instance $3525 r0 *1 156.96,93.24 nfet_03v3
M$3525 C|Y$12 A|Y$188 VSS VSS nfet_03v3 L=0.28U W=2U AS=0.7P AD=0.7P PS=4.4U
+ PD=4.4U
* device instance $3527 r0 *1 159.52,93.24 nfet_03v3
M$3527 A|Y$206 \$1237 VSS VSS nfet_03v3 L=0.28U W=2U AS=1.02P AD=0.52P PS=5.04U
+ PD=3.04U
* device instance $3529 r0 *1 161.12,93.24 nfet_03v3
M$3529 \$1237 A|MID_MUX[4] VSS VSS nfet_03v3 L=0.28U W=1U AS=0.26P AD=0.44P
+ PS=1.52U PD=2.88U
* device instance $3530 r0 *1 159.52,94.92 nfet_03v3
M$3530 A|Y$214 \$1301 VSS VSS nfet_03v3 L=0.28U W=2U AS=1.02P AD=0.52P PS=5.04U
+ PD=3.04U
* device instance $3532 r0 *1 161.12,94.92 nfet_03v3
M$3532 \$1301 A|MID_MUX[10] VSS VSS nfet_03v3 L=0.28U W=1U AS=0.26P AD=0.44P
+ PS=1.52U PD=2.88U
* device instance $3533 r0 *1 9.12,101.08 nfet_03v3
M$3533 C|Y$13 A|Y$190 VSS VSS nfet_03v3 L=0.28U W=2U AS=0.7P AD=0.7P PS=4.4U
+ PD=4.4U
* device instance $3535 r0 *1 11.44,101.08 nfet_03v3
M$3535 Y$16 C|Y$15 \$1361 VSS nfet_03v3 L=0.28U W=2U AS=0.71P AD=0.7P PS=4.42U
+ PD=4.4U
* device instance $3537 r0 *1 13.68,101.08 nfet_03v3
M$3537 \$1361 A|B|Y$3 \$1362 VSS nfet_03v3 L=0.28U W=2U AS=0.7P AD=0.52P
+ PS=4.4U PD=3.04U
* device instance $3539 r0 *1 15.28,101.08 nfet_03v3
M$3539 VSS A|Y$218 \$1362 VSS nfet_03v3 L=0.28U W=2U AS=0.52P AD=0.7P PS=3.04U
+ PD=4.4U
* device instance $3541 r0 *1 21.305,101.085 nfet_03v3
M$3541 \$1334 \$1306 VSS VSS nfet_03v3 L=7.75U W=0.99U AS=0.4851P AD=0.4356P
+ PS=2.96U PD=2.86U
* device instance $3542 r0 *1 30.265,101.085 nfet_03v3
M$3542 \$1335 \$1307 VSS VSS nfet_03v3 L=7.75U W=0.99U AS=0.4851P AD=0.4356P
+ PS=2.96U PD=2.86U
* device instance $3543 r0 *1 39.225,101.085 nfet_03v3
M$3543 \$1336 \$1308 VSS VSS nfet_03v3 L=7.75U W=0.99U AS=0.4851P AD=0.4356P
+ PS=2.96U PD=2.86U
* device instance $3544 r0 *1 44.825,101.08 nfet_03v3
M$3544 \$1337 \$1309 VSS VSS nfet_03v3 L=1.03U W=1U AS=0.49P AD=0.44P PS=2.98U
+ PD=2.88U
* device instance $3545 r0 *1 51.545,101.085 nfet_03v3
M$3545 \$1338 \$1310 VSS VSS nfet_03v3 L=7.75U W=0.99U AS=0.4851P AD=0.4356P
+ PS=2.96U PD=2.86U
* device instance $3546 r0 *1 60.505,101.085 nfet_03v3
M$3546 \$1339 \$1311 VSS VSS nfet_03v3 L=7.75U W=0.99U AS=0.4851P AD=0.4356P
+ PS=2.96U PD=2.86U
* device instance $3547 r0 *1 66.105,101.08 nfet_03v3
M$3547 \$1340 \$1312 VSS VSS nfet_03v3 L=1.03U W=1U AS=0.49P AD=0.44P PS=2.98U
+ PD=2.88U
* device instance $3548 r0 *1 68.24,101.08 nfet_03v3
M$3548 A|Y$209 \$1341 VSS VSS nfet_03v3 L=0.28U W=2U AS=1.02P AD=0.52P PS=5.04U
+ PD=3.04U
* device instance $3550 r0 *1 69.84,101.08 nfet_03v3
M$3550 \$1341 A|Y$201 VSS VSS nfet_03v3 L=0.28U W=1U AS=0.26P AD=0.44P PS=1.52U
+ PD=2.88U
* device instance $3551 r0 *1 71.28,101.08 nfet_03v3
M$3551 VSS A|Y$209 \$1313 VSS nfet_03v3 L=0.28U W=1U AS=0.44P AD=0.26P PS=2.88U
+ PD=1.52U
* device instance $3552 r0 *1 72.08,101.08 nfet_03v3
M$3552 A|Y$207 \$1313 VSS VSS nfet_03v3 L=0.28U W=2U AS=0.52P AD=1.02P PS=3.04U
+ PD=5.04U
* device instance $3554 r0 *1 75.76,101.08 nfet_03v3
M$3554 VSS A|Y$210 \$1315 VSS nfet_03v3 L=0.28U W=1U AS=0.44P AD=0.26P PS=2.88U
+ PD=1.52U
* device instance $3555 r0 *1 76.56,101.08 nfet_03v3
M$3555 A|Y$208 \$1315 VSS VSS nfet_03v3 L=0.28U W=2U AS=0.52P AD=1.02P PS=3.04U
+ PD=5.04U
* device instance $3557 r0 *1 80.665,101.085 nfet_03v3
M$3557 \$1344 \$1317 VSS VSS nfet_03v3 L=3.27U W=0.99U AS=0.4851P AD=0.4356P
+ PS=2.96U PD=2.86U
* device instance $3558 r0 *1 84.025,101.08 nfet_03v3
M$3558 \$1345 \$1318 VSS VSS nfet_03v3 L=1.03U W=1U AS=0.49P AD=0.44P PS=2.98U
+ PD=2.88U
* device instance $3559 r0 *1 88.505,101.085 nfet_03v3
M$3559 \$1346 \$1319 VSS VSS nfet_03v3 L=3.27U W=0.99U AS=0.4851P AD=0.4356P
+ PS=2.96U PD=2.86U
* device instance $3560 r0 *1 91.865,101.08 nfet_03v3
M$3560 \$1347 \$1320 VSS VSS nfet_03v3 L=1.03U W=1U AS=0.49P AD=0.44P PS=2.98U
+ PD=2.88U
* device instance $3561 r0 *1 93.84,101.08 nfet_03v3
M$3561 A|B|Y$3 A|Y$211 VSS VSS nfet_03v3 L=0.28U W=6U AS=1.9P AD=1.74P PS=10.8U
+ PD=10.48U
* device instance $3567 r0 *1 103.065,101.085 nfet_03v3
M$3567 \$1349 \$1321 VSS VSS nfet_03v3 L=7.75U W=0.99U AS=0.4851P AD=0.4356P
+ PS=2.96U PD=2.86U
* device instance $3568 r0 *1 112.025,101.085 nfet_03v3
M$3568 \$1350 \$1322 VSS VSS nfet_03v3 L=7.75U W=0.99U AS=0.4851P AD=0.4356P
+ PS=2.96U PD=2.86U
* device instance $3569 r0 *1 118.745,101.085 nfet_03v3
M$3569 \$1351 \$1323 VSS VSS nfet_03v3 L=3.27U W=0.99U AS=0.4851P AD=0.4356P
+ PS=2.96U PD=2.86U
* device instance $3570 r0 *1 122.105,101.08 nfet_03v3
M$3570 \$1352 \$1324 VSS VSS nfet_03v3 L=1.03U W=1U AS=0.49P AD=0.44P PS=2.98U
+ PD=2.88U
* device instance $3571 r0 *1 127.705,101.085 nfet_03v3
M$3571 \$1353 \$1325 VSS VSS nfet_03v3 L=3.27U W=0.99U AS=0.4851P AD=0.4356P
+ PS=2.96U PD=2.86U
* device instance $3572 r0 *1 131.52,101.08 nfet_03v3
M$3572 A|Y$204 \$1354 VSS VSS nfet_03v3 L=0.28U W=2U AS=1.02P AD=0.52P PS=5.04U
+ PD=3.04U
* device instance $3574 r0 *1 133.12,101.08 nfet_03v3
M$3574 \$1354 A|Y$212 VSS VSS nfet_03v3 L=0.28U W=1U AS=0.26P AD=0.44P PS=1.52U
+ PD=2.88U
* device instance $3575 r0 *1 134.56,101.08 nfet_03v3
M$3575 VSS A|Y$213 \$1326 VSS nfet_03v3 L=0.28U W=1U AS=0.44P AD=0.26P PS=2.88U
+ PD=1.52U
* device instance $3576 r0 *1 135.36,101.08 nfet_03v3
M$3576 A|Y$212 \$1326 VSS VSS nfet_03v3 L=0.28U W=2U AS=0.52P AD=1.02P PS=3.04U
+ PD=5.04U
* device instance $3578 r0 *1 137.92,101.08 nfet_03v3
M$3578 VSS A|Y$205 \$1327 VSS nfet_03v3 L=0.28U W=1U AS=0.44P AD=0.26P PS=2.88U
+ PD=1.52U
* device instance $3579 r0 *1 138.72,101.08 nfet_03v3
M$3579 A|Y$203 \$1327 VSS VSS nfet_03v3 L=0.28U W=2U AS=0.52P AD=1.02P PS=3.04U
+ PD=5.04U
* device instance $3581 r0 *1 145.065,101.085 nfet_03v3
M$3581 \$1357 \$1328 VSS VSS nfet_03v3 L=7.75U W=0.99U AS=0.4851P AD=0.4356P
+ PS=2.96U PD=2.86U
* device instance $3582 r0 *1 150.24,101.08 nfet_03v3
M$3582 C|Y$16 A|Y$214 VSS VSS nfet_03v3 L=0.28U W=2U AS=0.7P AD=0.7P PS=4.4U
+ PD=4.4U
* device instance $3584 r0 *1 152.56,101.08 nfet_03v3
M$3584 Y$17 C|Y$16 \$1363 VSS nfet_03v3 L=0.28U W=2U AS=0.71P AD=0.7P PS=4.42U
+ PD=4.4U
* device instance $3586 r0 *1 154.8,101.08 nfet_03v3
M$3586 \$1363 A|B|Y \$1364 VSS nfet_03v3 L=0.28U W=2U AS=0.7P AD=0.52P PS=4.4U
+ PD=3.04U
* device instance $3588 r0 *1 156.4,101.08 nfet_03v3
M$3588 VSS A|Y$214 \$1364 VSS nfet_03v3 L=0.28U W=2U AS=0.52P AD=0.7P PS=3.04U
+ PD=4.4U
* device instance $3590 r0 *1 159.2,101.08 nfet_03v3
M$3590 VSS A|Y$211 \$1330 VSS nfet_03v3 L=0.28U W=1U AS=0.44P AD=0.26P PS=2.88U
+ PD=1.52U
* device instance $3591 r0 *1 160,101.08 nfet_03v3
M$3591 MID_OUT|Y \$1330 VSS VSS nfet_03v3 L=0.28U W=2U AS=0.52P AD=1.02P
+ PS=3.04U PD=5.04U
* device instance $3593 r0 *1 9.12,102.76 nfet_03v3
M$3593 C|Y$15 A|Y$218 VSS VSS nfet_03v3 L=0.28U W=2U AS=0.7P AD=0.7P PS=4.4U
+ PD=4.4U
* device instance $3595 r0 *1 9.12,108.92 nfet_03v3
M$3595 C|Y$18 A|Y$233 VSS VSS nfet_03v3 L=0.28U W=2U AS=0.7P AD=0.7P PS=4.4U
+ PD=4.4U
* device instance $3597 r0 *1 11.36,102.76 nfet_03v3
M$3597 VSS A|Y$219 \$1365 VSS nfet_03v3 L=0.28U W=2U AS=0.7P AD=0.52P PS=4.4U
+ PD=3.04U
* device instance $3599 r0 *1 12.96,102.76 nfet_03v3
M$3599 \$1367 A|B|Y$3 \$1365 VSS nfet_03v3 L=0.28U W=2U AS=0.52P AD=0.7P
+ PS=3.04U PD=4.4U
* device instance $3601 r0 *1 11.36,108.92 nfet_03v3
M$3601 VSS A|Y$233 \$1494 VSS nfet_03v3 L=0.28U W=2U AS=0.7P AD=0.52P PS=4.4U
+ PD=3.04U
* device instance $3603 r0 *1 12.96,108.92 nfet_03v3
M$3603 \$1495 A|B|Y$3 \$1494 VSS nfet_03v3 L=0.28U W=2U AS=0.52P AD=0.7P
+ PS=3.04U PD=4.4U
* device instance $3605 r0 *1 15.2,102.76 nfet_03v3
M$3605 Y$19 C|Y$17 \$1367 VSS nfet_03v3 L=0.28U W=2U AS=0.7P AD=0.71P PS=4.4U
+ PD=4.42U
* device instance $3607 r0 *1 15.2,108.92 nfet_03v3
M$3607 Y$20 C|Y$18 \$1495 VSS nfet_03v3 L=0.28U W=2U AS=0.7P AD=0.71P PS=4.4U
+ PD=4.42U
* device instance $3609 r0 *1 17.52,102.76 nfet_03v3
M$3609 VSS A|FINE_MUX[19] \$1368 VSS nfet_03v3 L=0.28U W=1U AS=0.44P AD=0.26P
+ PS=2.88U PD=1.52U
* device instance $3610 r0 *1 18.32,102.76 nfet_03v3
M$3610 A|Y$218 \$1368 VSS VSS nfet_03v3 L=0.28U W=2U AS=0.52P AD=1.02P PS=3.04U
+ PD=5.04U
* device instance $3612 r0 *1 17.52,108.92 nfet_03v3
M$3612 C|Y$17 A|Y$219 VSS VSS nfet_03v3 L=0.28U W=2U AS=0.7P AD=0.7P PS=4.4U
+ PD=4.4U
* device instance $3614 r0 *1 20.185,108.92 nfet_03v3
M$3614 \$1459 \$1427 VSS VSS nfet_03v3 L=1.03U W=1U AS=0.49P AD=0.44P PS=2.98U
+ PD=2.88U
* device instance $3615 r0 *1 22.425,102.755 nfet_03v3
M$3615 \$1387 \$1386 VSS VSS nfet_03v3 L=3.27U W=0.99U AS=0.4851P AD=0.4356P
+ PS=2.96U PD=2.86U
* device instance $3616 r0 *1 22.56,108.92 nfet_03v3
M$3616 C|Y$19 A|Y$234 VSS VSS nfet_03v3 L=0.28U W=2U AS=0.7P AD=0.7P PS=4.4U
+ PD=4.4U
* device instance $3618 r0 *1 24.8,108.92 nfet_03v3
M$3618 VSS A|Y$234 \$1496 VSS nfet_03v3 L=0.28U W=2U AS=0.7P AD=0.52P PS=4.4U
+ PD=3.04U
* device instance $3620 r0 *1 26.4,108.92 nfet_03v3
M$3620 \$1497 A|B|Y$3 \$1496 VSS nfet_03v3 L=0.28U W=2U AS=0.52P AD=0.7P
+ PS=3.04U PD=4.4U
* device instance $3622 r0 *1 31.945,102.755 nfet_03v3
M$3622 \$1389 \$1388 VSS VSS nfet_03v3 L=7.75U W=0.99U AS=0.4851P AD=0.4356P
+ PS=2.96U PD=2.86U
* device instance $3623 r0 *1 28.64,108.92 nfet_03v3
M$3623 Y$21 C|Y$19 \$1497 VSS nfet_03v3 L=0.28U W=2U AS=0.7P AD=0.71P PS=4.4U
+ PD=4.42U
* device instance $3625 r0 *1 40.905,102.755 nfet_03v3
M$3625 \$1391 \$1390 VSS VSS nfet_03v3 L=7.75U W=0.99U AS=0.4851P AD=0.4356P
+ PS=2.96U PD=2.86U
* device instance $3626 r0 *1 44.825,108.92 nfet_03v3
M$3626 \$1464 \$1431 VSS VSS nfet_03v3 L=1.03U W=1U AS=0.49P AD=0.44P PS=2.98U
+ PD=2.88U
* device instance $3627 r0 *1 49.865,102.755 nfet_03v3
M$3627 \$1393 \$1392 VSS VSS nfet_03v3 L=7.75U W=0.99U AS=0.4851P AD=0.4356P
+ PS=2.96U PD=2.86U
* device instance $3628 r0 *1 58.825,102.755 nfet_03v3
M$3628 \$1395 \$1394 VSS VSS nfet_03v3 L=7.75U W=0.99U AS=0.4851P AD=0.4356P
+ PS=2.96U PD=2.86U
* device instance $3629 r0 *1 64.425,102.76 nfet_03v3
M$3629 \$1369 \$1396 VSS VSS nfet_03v3 L=1.03U W=1U AS=0.49P AD=0.44P PS=2.98U
+ PD=2.88U
* device instance $3630 r0 *1 67.785,102.76 nfet_03v3
M$3630 \$1370 \$1397 VSS VSS nfet_03v3 L=1.03U W=1U AS=0.49P AD=0.44P PS=2.98U
+ PD=2.88U
* device instance $3631 r0 *1 70.585,108.92 nfet_03v3
M$3631 \$1468 \$1435 VSS VSS nfet_03v3 L=1.03U W=1U AS=0.49P AD=0.44P PS=2.98U
+ PD=2.88U
* device instance $3632 r0 *1 70.48,102.76 nfet_03v3
M$3632 A|Y$210 \$1398 VSS VSS nfet_03v3 L=0.28U W=2U AS=1.02P AD=0.52P PS=5.04U
+ PD=3.04U
* device instance $3634 r0 *1 72.08,102.76 nfet_03v3
M$3634 \$1398 A|Y$220 VSS VSS nfet_03v3 L=0.28U W=1U AS=0.26P AD=0.44P PS=1.52U
+ PD=2.88U
* device instance $3635 r0 *1 72.96,108.92 nfet_03v3
M$3635 VSS A|Y$207 \$1436 VSS nfet_03v3 L=0.28U W=1U AS=0.44P AD=0.26P PS=2.88U
+ PD=1.52U
* device instance $3636 r0 *1 73.76,108.92 nfet_03v3
M$3636 A|Y$220 \$1436 VSS VSS nfet_03v3 L=0.28U W=2U AS=0.52P AD=1.02P PS=3.04U
+ PD=5.04U
* device instance $3638 r0 *1 73.84,102.76 nfet_03v3
M$3638 A|Y$215 \$1400 VSS VSS nfet_03v3 L=0.28U W=2U AS=1.02P AD=0.52P PS=5.04U
+ PD=3.04U
* device instance $3640 r0 *1 75.44,102.76 nfet_03v3
M$3640 \$1400 A|Y$208 VSS VSS nfet_03v3 L=0.28U W=1U AS=0.26P AD=0.44P PS=1.52U
+ PD=2.88U
* device instance $3641 r0 *1 76.745,108.92 nfet_03v3
M$3641 \$1469 \$1437 VSS VSS nfet_03v3 L=1.03U W=1U AS=0.49P AD=0.44P PS=2.98U
+ PD=2.88U
* device instance $3642 r0 *1 76.88,102.76 nfet_03v3
M$3642 VSS A|Y$215 \$1372 VSS nfet_03v3 L=0.28U W=1U AS=0.44P AD=0.26P PS=2.88U
+ PD=1.52U
* device instance $3643 r0 *1 77.68,102.76 nfet_03v3
M$3643 A|Y$216 \$1372 VSS VSS nfet_03v3 L=0.28U W=2U AS=0.52P AD=1.02P PS=3.04U
+ PD=5.04U
* device instance $3645 r0 *1 79.44,108.92 nfet_03v3
M$3645 A|Y$223 \$1470 VSS VSS nfet_03v3 L=0.28U W=2U AS=1.02P AD=0.52P PS=5.04U
+ PD=3.04U
* device instance $3647 r0 *1 81.04,108.92 nfet_03v3
M$3647 \$1470 A|Y$217 VSS VSS nfet_03v3 L=0.28U W=1U AS=0.26P AD=0.44P PS=1.52U
+ PD=2.88U
* device instance $3648 r0 *1 80.24,102.76 nfet_03v3
M$3648 VSS A|Y$216 \$1374 VSS nfet_03v3 L=0.28U W=1U AS=0.44P AD=0.26P PS=2.88U
+ PD=1.52U
* device instance $3649 r0 *1 81.04,102.76 nfet_03v3
M$3649 A|Y$217 \$1374 VSS VSS nfet_03v3 L=0.28U W=2U AS=0.52P AD=1.02P PS=3.04U
+ PD=5.04U
* device instance $3651 r0 *1 82.48,108.92 nfet_03v3
M$3651 VSS A|Y$223 \$1439 VSS nfet_03v3 L=0.28U W=1U AS=0.44P AD=0.26P PS=2.88U
+ PD=1.52U
* device instance $3652 r0 *1 83.28,108.92 nfet_03v3
M$3652 A|Y$224 \$1439 VSS VSS nfet_03v3 L=0.28U W=2U AS=0.52P AD=1.02P PS=3.04U
+ PD=5.04U
* device instance $3654 r0 *1 87.385,102.755 nfet_03v3
M$3654 \$1402 \$1401 VSS VSS nfet_03v3 L=7.75U W=0.99U AS=0.4851P AD=0.4356P
+ PS=2.96U PD=2.86U
* device instance $3655 r0 *1 86.96,108.92 nfet_03v3
M$3655 VSS A|Y$224 \$1441 VSS nfet_03v3 L=0.28U W=1U AS=0.44P AD=0.26P PS=2.88U
+ PD=1.52U
* device instance $3656 r0 *1 87.76,108.92 nfet_03v3
M$3656 A|Y$225 \$1441 VSS VSS nfet_03v3 L=0.28U W=2U AS=0.52P AD=1.02P PS=3.04U
+ PD=5.04U
* device instance $3658 r0 *1 90.32,108.92 nfet_03v3
M$3658 VSS A|Y$235 \$1443 VSS nfet_03v3 L=0.28U W=1U AS=0.44P AD=0.26P PS=2.88U
+ PD=1.52U
* device instance $3659 r0 *1 91.12,108.92 nfet_03v3
M$3659 A|Y$226 \$1443 VSS VSS nfet_03v3 L=0.28U W=2U AS=0.52P AD=1.02P PS=3.04U
+ PD=5.04U
* device instance $3661 r0 *1 96.345,102.755 nfet_03v3
M$3661 \$1404 \$1403 VSS VSS nfet_03v3 L=7.75U W=0.99U AS=0.4851P AD=0.4356P
+ PS=2.96U PD=2.86U
* device instance $3662 r0 *1 95.68,108.92 nfet_03v3
M$3662 A|Y$227 \$1472 VSS VSS nfet_03v3 L=0.28U W=2U AS=1.02P AD=0.52P PS=5.04U
+ PD=3.04U
* device instance $3664 r0 *1 97.28,108.92 nfet_03v3
M$3664 \$1472 A|Y$236 VSS VSS nfet_03v3 L=0.28U W=1U AS=0.26P AD=0.44P PS=1.52U
+ PD=2.88U
* device instance $3665 r0 *1 99.04,108.92 nfet_03v3
M$3665 A|Y$228 \$1474 VSS VSS nfet_03v3 L=0.28U W=2U AS=1.02P AD=0.52P PS=5.04U
+ PD=3.04U
* device instance $3667 r0 *1 100.64,108.92 nfet_03v3
M$3667 \$1474 A|Y$237 VSS VSS nfet_03v3 L=0.28U W=1U AS=0.26P AD=0.44P PS=1.52U
+ PD=2.88U
* device instance $3668 r0 *1 101.945,102.76 nfet_03v3
M$3668 \$1376 \$1405 VSS VSS nfet_03v3 L=1.03U W=1U AS=0.49P AD=0.44P PS=2.98U
+ PD=2.88U
* device instance $3669 r0 *1 102.4,108.92 nfet_03v3
M$3669 A|Y$229 \$1476 VSS VSS nfet_03v3 L=0.28U W=2U AS=1.02P AD=0.52P PS=5.04U
+ PD=3.04U
* device instance $3671 r0 *1 104,108.92 nfet_03v3
M$3671 \$1476 A|Y$238 VSS VSS nfet_03v3 L=0.28U W=1U AS=0.26P AD=0.44P PS=1.52U
+ PD=2.88U
* device instance $3672 r0 *1 106.32,108.92 nfet_03v3
M$3672 A|Y$230 \$1478 VSS VSS nfet_03v3 L=0.28U W=2U AS=1.02P AD=0.52P PS=5.04U
+ PD=3.04U
* device instance $3674 r0 *1 107.92,108.92 nfet_03v3
M$3674 \$1478 A|Y$239 VSS VSS nfet_03v3 L=0.28U W=1U AS=0.26P AD=0.44P PS=1.52U
+ PD=2.88U
* device instance $3675 r0 *1 110.345,102.755 nfet_03v3
M$3675 \$1407 \$1406 VSS VSS nfet_03v3 L=7.75U W=0.99U AS=0.4851P AD=0.4356P
+ PS=2.96U PD=2.86U
* device instance $3676 r0 *1 109.785,108.92 nfet_03v3
M$3676 \$1480 \$1449 VSS VSS nfet_03v3 L=1.03U W=1U AS=0.49P AD=0.44P PS=2.98U
+ PD=2.88U
* device instance $3677 r0 *1 113.04,108.92 nfet_03v3
M$3677 A|Y$231 \$1481 VSS VSS nfet_03v3 L=0.28U W=2U AS=1.02P AD=0.52P PS=5.04U
+ PD=3.04U
* device instance $3679 r0 *1 114.64,108.92 nfet_03v3
M$3679 \$1481 A|Y$240 VSS VSS nfet_03v3 L=0.28U W=1U AS=0.26P AD=0.44P PS=1.52U
+ PD=2.88U
* device instance $3680 r0 *1 119.305,102.755 nfet_03v3
M$3680 \$1409 \$1408 VSS VSS nfet_03v3 L=7.75U W=0.99U AS=0.4851P AD=0.4356P
+ PS=2.96U PD=2.86U
* device instance $3681 r0 *1 116.4,108.92 nfet_03v3
M$3681 A|Y$232 \$1483 VSS VSS nfet_03v3 L=0.28U W=2U AS=1.02P AD=0.52P PS=5.04U
+ PD=3.04U
* device instance $3683 r0 *1 118,108.92 nfet_03v3
M$3683 \$1483 A|Y$241 VSS VSS nfet_03v3 L=0.28U W=1U AS=0.26P AD=0.44P PS=1.52U
+ PD=2.88U
* device instance $3684 r0 *1 126.025,102.755 nfet_03v3
M$3684 \$1411 \$1410 VSS VSS nfet_03v3 L=3.27U W=0.99U AS=0.4851P AD=0.4356P
+ PS=2.96U PD=2.86U
* device instance $3685 r0 *1 129.385,102.76 nfet_03v3
M$3685 \$1377 \$1412 VSS VSS nfet_03v3 L=1.03U W=1U AS=0.49P AD=0.44P PS=2.98U
+ PD=2.88U
* device instance $3686 r0 *1 132.08,102.76 nfet_03v3
M$3686 A|Y$213 \$1413 VSS VSS nfet_03v3 L=0.28U W=2U AS=1.02P AD=0.52P PS=5.04U
+ PD=3.04U
* device instance $3688 r0 *1 133.68,102.76 nfet_03v3
M$3688 \$1413 A|Y$221 VSS VSS nfet_03v3 L=0.28U W=1U AS=0.26P AD=0.44P PS=1.52U
+ PD=2.88U
* device instance $3689 r0 *1 132.64,108.92 nfet_03v3
M$3689 A|Y$222 \$1487 VSS VSS nfet_03v3 L=0.28U W=2U AS=1.02P AD=0.52P PS=5.04U
+ PD=3.04U
* device instance $3691 r0 *1 134.24,108.92 nfet_03v3
M$3691 \$1487 A|Y$242 VSS VSS nfet_03v3 L=0.28U W=1U AS=0.26P AD=0.44P PS=1.52U
+ PD=2.88U
* device instance $3692 r0 *1 135.12,102.76 nfet_03v3
M$3692 VSS A|Y$222 \$1378 VSS nfet_03v3 L=0.28U W=1U AS=0.44P AD=0.26P PS=2.88U
+ PD=1.52U
* device instance $3693 r0 *1 135.92,102.76 nfet_03v3
M$3693 A|Y$221 \$1378 VSS VSS nfet_03v3 L=0.28U W=2U AS=0.52P AD=1.02P PS=3.04U
+ PD=5.04U
* device instance $3695 r0 *1 136,108.92 nfet_03v3
M$3695 A|Y$242 \$1489 VSS VSS nfet_03v3 L=0.28U W=2U AS=1.02P AD=0.52P PS=5.04U
+ PD=3.04U
* device instance $3697 r0 *1 137.6,108.92 nfet_03v3
M$3697 \$1489 A|Y$243 VSS VSS nfet_03v3 L=0.28U W=1U AS=0.26P AD=0.44P PS=1.52U
+ PD=2.88U
* device instance $3698 r0 *1 140.025,102.755 nfet_03v3
M$3698 \$1417 \$1416 VSS VSS nfet_03v3 L=3.27U W=0.99U AS=0.4851P AD=0.4356P
+ PS=2.96U PD=2.86U
* device instance $3699 r0 *1 147.305,102.755 nfet_03v3
M$3699 \$1419 \$1418 VSS VSS nfet_03v3 L=3.27U W=0.99U AS=0.4851P AD=0.4356P
+ PS=2.96U PD=2.86U
* device instance $3700 r0 *1 150.665,102.76 nfet_03v3
M$3700 \$1379 \$1420 VSS VSS nfet_03v3 L=1.03U W=1U AS=0.49P AD=0.44P PS=2.98U
+ PD=2.88U
* device instance $3701 r0 *1 152.56,102.76 nfet_03v3
M$3701 Y$18 C|Y$12 \$1380 VSS nfet_03v3 L=0.28U W=2U AS=0.71P AD=0.7P PS=4.42U
+ PD=4.4U
* device instance $3703 r0 *1 154.8,102.76 nfet_03v3
M$3703 \$1380 A|B|Y \$1381 VSS nfet_03v3 L=0.28U W=2U AS=0.7P AD=0.52P PS=4.4U
+ PD=3.04U
* device instance $3705 r0 *1 156.4,102.76 nfet_03v3
M$3705 VSS A|Y$188 \$1381 VSS nfet_03v3 L=0.28U W=2U AS=0.52P AD=0.7P PS=3.04U
+ PD=4.4U
* device instance $3707 r0 *1 158.64,102.76 nfet_03v3
M$3707 C|Y$14 A|Y$206 VSS VSS nfet_03v3 L=0.28U W=2U AS=0.7P AD=0.7P PS=4.4U
+ PD=4.4U
* device instance $3709 r0 *1 8.56,110.6 nfet_03v3
M$3709 VSS A|FINE_MUX[0] \$1498 VSS nfet_03v3 L=0.28U W=1U AS=0.44P AD=0.26P
+ PS=2.88U PD=1.52U
* device instance $3710 r0 *1 9.36,110.6 nfet_03v3
M$3710 A|Y$234 \$1498 VSS VSS nfet_03v3 L=0.28U W=2U AS=0.52P AD=1.02P PS=3.04U
+ PD=5.04U
* device instance $3712 r0 *1 11.92,110.6 nfet_03v3
M$3712 VSS A|FINE_MUX[26] \$1499 VSS nfet_03v3 L=0.28U W=1U AS=0.44P AD=0.26P
+ PS=2.88U PD=1.52U
* device instance $3713 r0 *1 12.72,110.6 nfet_03v3
M$3713 A|Y$233 \$1499 VSS VSS nfet_03v3 L=0.28U W=2U AS=0.52P AD=1.02P PS=3.04U
+ PD=5.04U
* device instance $3715 r0 *1 19.065,110.595 nfet_03v3
M$3715 \$1501 \$1500 VSS VSS nfet_03v3 L=7.75U W=0.99U AS=0.4851P AD=0.4356P
+ PS=2.96U PD=2.86U
* device instance $3716 r0 *1 24.8,110.6 nfet_03v3
M$3716 C|Y$20 A|Y$255 VSS VSS nfet_03v3 L=0.28U W=2U AS=0.7P AD=0.7P PS=4.4U
+ PD=4.4U
* device instance $3718 r0 *1 31.945,110.595 nfet_03v3
M$3718 \$1504 \$1503 VSS VSS nfet_03v3 L=7.75U W=0.99U AS=0.4851P AD=0.4356P
+ PS=2.96U PD=2.86U
* device instance $3719 r0 *1 34.745,108.925 nfet_03v3
M$3719 \$1462 \$1429 VSS VSS nfet_03v3 L=7.75U W=0.99U AS=0.4851P AD=0.4356P
+ PS=2.96U PD=2.86U
* device instance $3720 r0 *1 40.905,110.595 nfet_03v3
M$3720 \$1506 \$1505 VSS VSS nfet_03v3 L=7.75U W=0.99U AS=0.4851P AD=0.4356P
+ PS=2.96U PD=2.86U
* device instance $3721 r0 *1 41.465,108.925 nfet_03v3
M$3721 \$1463 \$1430 VSS VSS nfet_03v3 L=3.27U W=0.99U AS=0.4851P AD=0.4356P
+ PS=2.96U PD=2.86U
* device instance $3722 r0 *1 49.865,110.595 nfet_03v3
M$3722 \$1508 \$1507 VSS VSS nfet_03v3 L=7.75U W=0.99U AS=0.4851P AD=0.4356P
+ PS=2.96U PD=2.86U
* device instance $3723 r0 *1 51.545,108.925 nfet_03v3
M$3723 \$1465 \$1432 VSS VSS nfet_03v3 L=7.75U W=0.99U AS=0.4851P AD=0.4356P
+ PS=2.96U PD=2.86U
* device instance $3724 r0 *1 58.825,110.595 nfet_03v3
M$3724 \$1510 \$1509 VSS VSS nfet_03v3 L=7.75U W=0.99U AS=0.4851P AD=0.4356P
+ PS=2.96U PD=2.86U
* device instance $3725 r0 *1 60.505,108.925 nfet_03v3
M$3725 \$1466 \$1433 VSS VSS nfet_03v3 L=7.75U W=0.99U AS=0.4851P AD=0.4356P
+ PS=2.96U PD=2.86U
* device instance $3726 r0 *1 64.425,110.6 nfet_03v3
M$3726 \$1512 \$1511 VSS VSS nfet_03v3 L=1.03U W=1U AS=0.49P AD=0.44P PS=2.98U
+ PD=2.88U
* device instance $3727 r0 *1 67.225,108.925 nfet_03v3
M$3727 \$1467 \$1434 VSS VSS nfet_03v3 L=3.27U W=0.99U AS=0.4851P AD=0.4356P
+ PS=2.96U PD=2.86U
* device instance $3728 r0 *1 71.145,110.595 nfet_03v3
M$3728 \$1514 \$1513 VSS VSS nfet_03v3 L=7.75U W=0.99U AS=0.4851P AD=0.4356P
+ PS=2.96U PD=2.86U
* device instance $3729 r0 *1 80.105,110.595 nfet_03v3
M$3729 \$1516 \$1515 VSS VSS nfet_03v3 L=7.75U W=0.99U AS=0.4851P AD=0.4356P
+ PS=2.96U PD=2.86U
* device instance $3730 r0 *1 86.16,110.6 nfet_03v3
M$3730 A|Y$244 \$1517 VSS VSS nfet_03v3 L=0.28U W=2U AS=1.02P AD=0.52P PS=5.04U
+ PD=3.04U
* device instance $3732 r0 *1 87.76,110.6 nfet_03v3
M$3732 \$1517 A|Y$225 VSS VSS nfet_03v3 L=0.28U W=1U AS=0.26P AD=0.44P PS=1.52U
+ PD=2.88U
* device instance $3733 r0 *1 89.2,110.6 nfet_03v3
M$3733 VSS A|Y$244 \$1518 VSS nfet_03v3 L=0.28U W=1U AS=0.44P AD=0.26P PS=2.88U
+ PD=1.52U
* device instance $3734 r0 *1 90,110.6 nfet_03v3
M$3734 A|Y$235 \$1518 VSS VSS nfet_03v3 L=0.28U W=2U AS=0.52P AD=1.02P PS=3.04U
+ PD=5.04U
* device instance $3736 r0 *1 92.56,110.6 nfet_03v3
M$3736 VSS A|Y$226 \$1520 VSS nfet_03v3 L=0.28U W=1U AS=0.44P AD=0.26P PS=2.88U
+ PD=1.52U
* device instance $3737 r0 *1 93.36,110.6 nfet_03v3
M$3737 A|Y$245 \$1520 VSS VSS nfet_03v3 L=0.28U W=2U AS=0.52P AD=1.02P PS=3.04U
+ PD=5.04U
* device instance $3739 r0 *1 95.92,110.6 nfet_03v3
M$3739 VSS A|Y$245 \$1522 VSS nfet_03v3 L=0.28U W=1U AS=0.44P AD=0.26P PS=2.88U
+ PD=1.52U
* device instance $3740 r0 *1 96.72,110.6 nfet_03v3
M$3740 A|Y$236 \$1522 VSS VSS nfet_03v3 L=0.28U W=2U AS=0.52P AD=1.02P PS=3.04U
+ PD=5.04U
* device instance $3742 r0 *1 99.28,110.6 nfet_03v3
M$3742 VSS A|Y$227 \$1523 VSS nfet_03v3 L=0.28U W=1U AS=0.44P AD=0.26P PS=2.88U
+ PD=1.52U
* device instance $3743 r0 *1 100.08,110.6 nfet_03v3
M$3743 A|Y$246 \$1523 VSS VSS nfet_03v3 L=0.28U W=2U AS=0.52P AD=1.02P PS=3.04U
+ PD=5.04U
* device instance $3745 r0 *1 103.065,110.6 nfet_03v3
M$3745 \$1526 \$1525 VSS VSS nfet_03v3 L=1.03U W=1U AS=0.49P AD=0.44P PS=2.98U
+ PD=2.88U
* device instance $3746 r0 *1 106.56,110.6 nfet_03v3
M$3746 VSS A|Y$229 \$1527 VSS nfet_03v3 L=0.28U W=1U AS=0.44P AD=0.26P PS=2.88U
+ PD=1.52U
* device instance $3747 r0 *1 107.36,110.6 nfet_03v3
M$3747 A|Y$239 \$1527 VSS VSS nfet_03v3 L=0.28U W=2U AS=0.52P AD=1.02P PS=3.04U
+ PD=5.04U
* device instance $3749 r0 *1 109.92,110.6 nfet_03v3
M$3749 VSS A|Y$230 \$1528 VSS nfet_03v3 L=0.28U W=1U AS=0.44P AD=0.26P PS=2.88U
+ PD=1.52U
* device instance $3750 r0 *1 110.72,110.6 nfet_03v3
M$3750 A|Y$247 \$1528 VSS VSS nfet_03v3 L=0.28U W=2U AS=0.52P AD=1.02P PS=3.04U
+ PD=5.04U
* device instance $3752 r0 *1 113.28,110.6 nfet_03v3
M$3752 VSS A|Y$247 \$1530 VSS nfet_03v3 L=0.28U W=1U AS=0.44P AD=0.26P PS=2.88U
+ PD=1.52U
* device instance $3753 r0 *1 114.08,110.6 nfet_03v3
M$3753 A|Y$240 \$1530 VSS VSS nfet_03v3 L=0.28U W=2U AS=0.52P AD=1.02P PS=3.04U
+ PD=5.04U
* device instance $3755 r0 *1 116.64,110.6 nfet_03v3
M$3755 VSS A|Y$231 \$1531 VSS nfet_03v3 L=0.28U W=1U AS=0.44P AD=0.26P PS=2.88U
+ PD=1.52U
* device instance $3756 r0 *1 117.44,110.6 nfet_03v3
M$3756 A|Y$241 \$1531 VSS VSS nfet_03v3 L=0.28U W=2U AS=0.52P AD=1.02P PS=3.04U
+ PD=5.04U
* device instance $3758 r0 *1 120.985,108.925 nfet_03v3
M$3758 \$1485 \$1452 VSS VSS nfet_03v3 L=3.27U W=0.99U AS=0.4851P AD=0.4356P
+ PS=2.96U PD=2.86U
* device instance $3759 r0 *1 123.785,110.595 nfet_03v3
M$3759 \$1533 \$1532 VSS VSS nfet_03v3 L=7.75U W=0.99U AS=0.4851P AD=0.4356P
+ PS=2.96U PD=2.86U
* device instance $3760 r0 *1 127.705,108.925 nfet_03v3
M$3760 \$1486 \$1453 VSS VSS nfet_03v3 L=3.27U W=0.99U AS=0.4851P AD=0.4356P
+ PS=2.96U PD=2.86U
* device instance $3761 r0 *1 129.385,110.6 nfet_03v3
M$3761 \$1535 \$1534 VSS VSS nfet_03v3 L=1.03U W=1U AS=0.49P AD=0.44P PS=2.98U
+ PD=2.88U
* device instance $3762 r0 *1 132.64,110.6 nfet_03v3
M$3762 A|Y$248 \$1536 VSS VSS nfet_03v3 L=0.28U W=2U AS=1.02P AD=0.52P PS=5.04U
+ PD=3.04U
* device instance $3764 r0 *1 134.24,110.6 nfet_03v3
M$3764 \$1536 A|Y$249 VSS VSS nfet_03v3 L=0.28U W=1U AS=0.26P AD=0.44P PS=1.52U
+ PD=2.88U
* device instance $3765 r0 *1 135.68,110.6 nfet_03v3
M$3765 VSS A|Y$248 \$1539 VSS nfet_03v3 L=0.28U W=1U AS=0.44P AD=0.26P PS=2.88U
+ PD=1.52U
* device instance $3766 r0 *1 136.48,110.6 nfet_03v3
M$3766 A|Y$243 \$1539 VSS VSS nfet_03v3 L=0.28U W=2U AS=0.52P AD=1.02P PS=3.04U
+ PD=5.04U
* device instance $3768 r0 *1 142.825,108.925 nfet_03v3
M$3768 \$1491 \$1454 VSS VSS nfet_03v3 L=7.75U W=0.99U AS=0.4851P AD=0.4356P
+ PS=2.96U PD=2.86U
* device instance $3769 r0 *1 140.585,110.595 nfet_03v3
M$3769 \$1541 \$1540 VSS VSS nfet_03v3 L=3.27U W=0.99U AS=0.4851P AD=0.4356P
+ PS=2.96U PD=2.86U
* device instance $3770 r0 *1 149.545,110.595 nfet_03v3
M$3770 \$1543 \$1542 VSS VSS nfet_03v3 L=7.75U W=0.99U AS=0.4851P AD=0.4356P
+ PS=2.96U PD=2.86U
* device instance $3771 r0 *1 151.785,108.925 nfet_03v3
M$3771 \$1492 \$1455 VSS VSS nfet_03v3 L=7.75U W=0.99U AS=0.4851P AD=0.4356P
+ PS=2.96U PD=2.86U
* device instance $3772 r0 *1 156.265,110.595 nfet_03v3
M$3772 \$1545 \$1544 VSS VSS nfet_03v3 L=3.27U W=0.99U AS=0.4851P AD=0.4356P
+ PS=2.96U PD=2.86U
* device instance $3773 r0 *1 158.505,108.925 nfet_03v3
M$3773 \$1493 \$1456 VSS VSS nfet_03v3 L=3.27U W=0.99U AS=0.4851P AD=0.4356P
+ PS=2.96U PD=2.86U
* device instance $3774 r0 *1 159.625,110.6 nfet_03v3
M$3774 \$1547 \$1546 VSS VSS nfet_03v3 L=1.03U W=1U AS=0.49P AD=0.44P PS=2.98U
+ PD=2.88U
* device instance $3775 r0 *1 8.56,118.44 nfet_03v3
M$3775 VSS A|FINE_MUX[7] \$1605 VSS nfet_03v3 L=0.28U W=1U AS=0.44P AD=0.26P
+ PS=2.88U PD=1.52U
* device instance $3776 r0 *1 9.36,118.44 nfet_03v3
M$3776 A|Y$255 \$1605 VSS VSS nfet_03v3 L=0.28U W=2U AS=0.52P AD=1.02P PS=3.04U
+ PD=5.04U
* device instance $3778 r0 *1 8.56,116.76 nfet_03v3
M$3778 VSS A|FINE_MUX[22] \$1548 VSS nfet_03v3 L=0.28U W=1U AS=0.44P AD=0.26P
+ PS=2.88U PD=1.52U
* device instance $3779 r0 *1 9.36,116.76 nfet_03v3
M$3779 A|Y$219 \$1548 VSS VSS nfet_03v3 L=0.28U W=2U AS=0.52P AD=1.02P PS=3.04U
+ PD=5.04U
* device instance $3781 r0 *1 11.92,118.44 nfet_03v3
M$3781 VSS A|FINE_MUX[4] \$1606 VSS nfet_03v3 L=0.28U W=1U AS=0.44P AD=0.26P
+ PS=2.88U PD=1.52U
* device instance $3782 r0 *1 12.72,118.44 nfet_03v3
M$3782 A|Y$254 \$1606 VSS VSS nfet_03v3 L=0.28U W=2U AS=0.52P AD=1.02P PS=3.04U
+ PD=5.04U
* device instance $3784 r0 *1 11.92,116.76 nfet_03v3
M$3784 VSS A|FINE_MUX[28] \$1549 VSS nfet_03v3 L=0.28U W=1U AS=0.44P AD=0.26P
+ PS=2.88U PD=1.52U
* device instance $3785 r0 *1 12.72,116.76 nfet_03v3
M$3785 A|Y$250 \$1549 VSS VSS nfet_03v3 L=0.28U W=2U AS=0.52P AD=1.02P PS=3.04U
+ PD=5.04U
* device instance $3787 r0 *1 15.705,116.76 nfet_03v3
M$3787 \$1580 \$1551 VSS VSS nfet_03v3 L=1.03U W=1U AS=0.49P AD=0.44P PS=2.98U
+ PD=2.88U
* device instance $3788 r0 *1 15.84,118.44 nfet_03v3
M$3788 VSS A|Y$254 \$1607 VSS nfet_03v3 L=0.28U W=2U AS=0.7P AD=0.52P PS=4.4U
+ PD=3.04U
* device instance $3790 r0 *1 17.44,118.44 nfet_03v3
M$3790 \$1608 A|B|Y$3 \$1607 VSS nfet_03v3 L=0.28U W=2U AS=0.52P AD=0.7P
+ PS=3.04U PD=4.4U
* device instance $3792 r0 *1 17.52,116.76 nfet_03v3
M$3792 C|Y$21 A|Y$254 VSS VSS nfet_03v3 L=0.28U W=2U AS=0.7P AD=0.7P PS=4.4U
+ PD=4.4U
* device instance $3794 r0 *1 19.68,118.44 nfet_03v3
M$3794 Y$23 C|Y$21 \$1608 VSS nfet_03v3 L=0.28U W=2U AS=0.7P AD=0.71P PS=4.4U
+ PD=4.42U
* device instance $3796 r0 *1 20.185,116.76 nfet_03v3
M$3796 \$1581 \$1553 VSS VSS nfet_03v3 L=1.03U W=1U AS=0.49P AD=0.44P PS=2.98U
+ PD=2.88U
* device instance $3797 r0 *1 23.545,118.435 nfet_03v3
M$3797 \$1610 \$1609 VSS VSS nfet_03v3 L=3.27U W=0.99U AS=0.4851P AD=0.4356P
+ PS=2.96U PD=2.86U
* device instance $3798 r0 *1 23.12,116.76 nfet_03v3
M$3798 VSS A|Y$255 \$1602 VSS nfet_03v3 L=0.28U W=2U AS=0.7P AD=0.52P PS=4.4U
+ PD=3.04U
* device instance $3800 r0 *1 24.72,116.76 nfet_03v3
M$3800 \$1603 A|B|Y$3 \$1602 VSS nfet_03v3 L=0.28U W=2U AS=0.52P AD=0.7P
+ PS=3.04U PD=4.4U
* device instance $3802 r0 *1 26.96,116.76 nfet_03v3
M$3802 Y$22 C|Y$20 \$1603 VSS nfet_03v3 L=0.28U W=2U AS=0.7P AD=0.71P PS=4.4U
+ PD=4.42U
* device instance $3804 r0 *1 28.16,118.44 nfet_03v3
M$3804 VSS A|Y$250 \$1611 VSS nfet_03v3 L=0.28U W=2U AS=0.7P AD=0.52P PS=4.4U
+ PD=3.04U
* device instance $3806 r0 *1 29.76,118.44 nfet_03v3
M$3806 \$1612 A|B|Y$3 \$1611 VSS nfet_03v3 L=0.28U W=2U AS=0.52P AD=0.7P
+ PS=3.04U PD=4.4U
* device instance $3808 r0 *1 29.28,116.76 nfet_03v3
M$3808 C|Y$22 A|Y$250 VSS VSS nfet_03v3 L=0.28U W=2U AS=0.7P AD=0.7P PS=4.4U
+ PD=4.4U
* device instance $3810 r0 *1 35.305,116.765 nfet_03v3
M$3810 \$1583 \$1556 VSS VSS nfet_03v3 L=7.75U W=0.99U AS=0.4851P AD=0.4356P
+ PS=2.96U PD=2.86U
* device instance $3811 r0 *1 32,118.44 nfet_03v3
M$3811 Y$24 C|Y$22 \$1612 VSS nfet_03v3 L=0.28U W=2U AS=0.7P AD=0.71P PS=4.4U
+ PD=4.42U
* device instance $3813 r0 *1 38.105,118.435 nfet_03v3
M$3813 \$1614 \$1613 VSS VSS nfet_03v3 L=7.75U W=0.99U AS=0.4851P AD=0.4356P
+ PS=2.96U PD=2.86U
* device instance $3814 r0 *1 42.025,116.765 nfet_03v3
M$3814 \$1584 \$1557 VSS VSS nfet_03v3 L=3.27U W=0.99U AS=0.4851P AD=0.4356P
+ PS=2.96U PD=2.86U
* device instance $3815 r0 *1 47.065,118.435 nfet_03v3
M$3815 \$1616 \$1615 VSS VSS nfet_03v3 L=7.75U W=0.99U AS=0.4851P AD=0.4356P
+ PS=2.96U PD=2.86U
* device instance $3816 r0 *1 51.545,116.765 nfet_03v3
M$3816 \$1585 \$1558 VSS VSS nfet_03v3 L=7.75U W=0.99U AS=0.4851P AD=0.4356P
+ PS=2.96U PD=2.86U
* device instance $3817 r0 *1 56.025,118.435 nfet_03v3
M$3817 \$1618 \$1617 VSS VSS nfet_03v3 L=7.75U W=0.99U AS=0.4851P AD=0.4356P
+ PS=2.96U PD=2.86U
* device instance $3818 r0 *1 60.505,116.765 nfet_03v3
M$3818 \$1586 \$1559 VSS VSS nfet_03v3 L=7.75U W=0.99U AS=0.4851P AD=0.4356P
+ PS=2.96U PD=2.86U
* device instance $3819 r0 *1 62.745,118.435 nfet_03v3
M$3819 \$1620 \$1619 VSS VSS nfet_03v3 L=3.27U W=0.99U AS=0.4851P AD=0.4356P
+ PS=2.96U PD=2.86U
* device instance $3820 r0 *1 69.465,116.765 nfet_03v3
M$3820 \$1587 \$1560 VSS VSS nfet_03v3 L=7.75U W=0.99U AS=0.4851P AD=0.4356P
+ PS=2.96U PD=2.86U
* device instance $3821 r0 *1 71.145,118.435 nfet_03v3
M$3821 \$1622 \$1621 VSS VSS nfet_03v3 L=7.75U W=0.99U AS=0.4851P AD=0.4356P
+ PS=2.96U PD=2.86U
* device instance $3822 r0 *1 78.425,116.765 nfet_03v3
M$3822 \$1588 \$1561 VSS VSS nfet_03v3 L=7.75U W=0.99U AS=0.4851P AD=0.4356P
+ PS=2.96U PD=2.86U
* device instance $3823 r0 *1 80.105,118.435 nfet_03v3
M$3823 \$1624 \$1623 VSS VSS nfet_03v3 L=7.75U W=0.99U AS=0.4851P AD=0.4356P
+ PS=2.96U PD=2.86U
* device instance $3824 r0 *1 84.025,116.76 nfet_03v3
M$3824 \$1589 \$1562 VSS VSS nfet_03v3 L=1.03U W=1U AS=0.49P AD=0.44P PS=2.98U
+ PD=2.88U
* device instance $3825 r0 *1 89.065,118.435 nfet_03v3
M$3825 \$1626 \$1625 VSS VSS nfet_03v3 L=7.75U W=0.99U AS=0.4851P AD=0.4356P
+ PS=2.96U PD=2.86U
* device instance $3826 r0 *1 90.745,116.765 nfet_03v3
M$3826 \$1590 \$1563 VSS VSS nfet_03v3 L=7.75U W=0.99U AS=0.4851P AD=0.4356P
+ PS=2.96U PD=2.86U
* device instance $3827 r0 *1 98.025,118.435 nfet_03v3
M$3827 \$1628 \$1627 VSS VSS nfet_03v3 L=7.75U W=0.99U AS=0.4851P AD=0.4356P
+ PS=2.96U PD=2.86U
* device instance $3828 r0 *1 96.345,116.76 nfet_03v3
M$3828 \$1591 \$1564 VSS VSS nfet_03v3 L=1.03U W=1U AS=0.49P AD=0.44P PS=2.98U
+ PD=2.88U
* device instance $3829 r0 *1 99.04,116.76 nfet_03v3
M$3829 A|Y$237 \$1592 VSS VSS nfet_03v3 L=0.28U W=2U AS=1.02P AD=0.52P PS=5.04U
+ PD=3.04U
* device instance $3831 r0 *1 100.64,116.76 nfet_03v3
M$3831 \$1592 A|Y$246 VSS VSS nfet_03v3 L=0.28U W=1U AS=0.26P AD=0.44P PS=1.52U
+ PD=2.88U
* device instance $3832 r0 *1 102.08,116.76 nfet_03v3
M$3832 VSS A|Y$228 \$1565 VSS nfet_03v3 L=0.28U W=1U AS=0.44P AD=0.26P PS=2.88U
+ PD=1.52U
* device instance $3833 r0 *1 102.88,116.76 nfet_03v3
M$3833 A|Y$238 \$1565 VSS VSS nfet_03v3 L=0.28U W=2U AS=0.52P AD=1.02P PS=3.04U
+ PD=5.04U
* device instance $3835 r0 *1 103.625,118.44 nfet_03v3
M$3835 \$1630 \$1629 VSS VSS nfet_03v3 L=1.03U W=1U AS=0.49P AD=0.44P PS=2.98U
+ PD=2.88U
* device instance $3836 r0 *1 109.225,116.765 nfet_03v3
M$3836 \$1593 \$1566 VSS VSS nfet_03v3 L=7.75U W=0.99U AS=0.4851P AD=0.4356P
+ PS=2.96U PD=2.86U
* device instance $3837 r0 *1 110.345,118.435 nfet_03v3
M$3837 \$1632 \$1631 VSS VSS nfet_03v3 L=7.75U W=0.99U AS=0.4851P AD=0.4356P
+ PS=2.96U PD=2.86U
* device instance $3838 r0 *1 114.825,116.76 nfet_03v3
M$3838 \$1594 \$1567 VSS VSS nfet_03v3 L=1.03U W=1U AS=0.49P AD=0.44P PS=2.98U
+ PD=2.88U
* device instance $3839 r0 *1 115.945,118.44 nfet_03v3
M$3839 \$1634 \$1633 VSS VSS nfet_03v3 L=1.03U W=1U AS=0.49P AD=0.44P PS=2.98U
+ PD=2.88U
* device instance $3840 r0 *1 116.64,116.76 nfet_03v3
M$3840 VSS A|Y$232 \$1568 VSS nfet_03v3 L=0.28U W=1U AS=0.44P AD=0.26P PS=2.88U
+ PD=1.52U
* device instance $3841 r0 *1 117.44,116.76 nfet_03v3
M$3841 A|Y$251 \$1568 VSS VSS nfet_03v3 L=0.28U W=2U AS=0.52P AD=1.02P PS=3.04U
+ PD=5.04U
* device instance $3843 r0 *1 118.64,118.44 nfet_03v3
M$3843 A|Y$257 \$1635 VSS VSS nfet_03v3 L=0.28U W=2U AS=1.02P AD=0.52P PS=5.04U
+ PD=3.04U
* device instance $3845 r0 *1 120.24,118.44 nfet_03v3
M$3845 \$1635 A|Y$252 VSS VSS nfet_03v3 L=0.28U W=1U AS=0.26P AD=0.44P PS=1.52U
+ PD=2.88U
* device instance $3846 r0 *1 120,116.76 nfet_03v3
M$3846 VSS A|Y$251 \$1570 VSS nfet_03v3 L=0.28U W=1U AS=0.44P AD=0.26P PS=2.88U
+ PD=1.52U
* device instance $3847 r0 *1 120.8,116.76 nfet_03v3
M$3847 A|Y$252 \$1570 VSS VSS nfet_03v3 L=0.28U W=2U AS=0.52P AD=1.02P PS=3.04U
+ PD=5.04U
* device instance $3849 r0 *1 125.465,118.435 nfet_03v3
M$3849 \$1638 \$1637 VSS VSS nfet_03v3 L=7.75U W=0.99U AS=0.4851P AD=0.4356P
+ PS=2.96U PD=2.86U
* device instance $3850 r0 *1 127.705,116.765 nfet_03v3
M$3850 \$1595 \$1572 VSS VSS nfet_03v3 L=3.27U W=0.99U AS=0.4851P AD=0.4356P
+ PS=2.96U PD=2.86U
* device instance $3851 r0 *1 131.52,118.44 nfet_03v3
M$3851 A|Y$258 \$1639 VSS VSS nfet_03v3 L=0.28U W=2U AS=1.02P AD=0.52P PS=5.04U
+ PD=3.04U
* device instance $3853 r0 *1 133.12,118.44 nfet_03v3
M$3853 \$1639 A|Y$259 VSS VSS nfet_03v3 L=0.28U W=1U AS=0.26P AD=0.44P PS=1.52U
+ PD=2.88U
* device instance $3854 r0 *1 132.08,116.76 nfet_03v3
M$3854 A|Y$253 \$1596 VSS VSS nfet_03v3 L=0.28U W=2U AS=1.02P AD=0.52P PS=5.04U
+ PD=3.04U
* device instance $3856 r0 *1 133.68,116.76 nfet_03v3
M$3856 \$1596 A|Y$256 VSS VSS nfet_03v3 L=0.28U W=1U AS=0.26P AD=0.44P PS=1.52U
+ PD=2.88U
* device instance $3857 r0 *1 134.56,118.44 nfet_03v3
M$3857 VSS A|Y$258 \$1642 VSS nfet_03v3 L=0.28U W=1U AS=0.44P AD=0.26P PS=2.88U
+ PD=1.52U
* device instance $3858 r0 *1 135.36,118.44 nfet_03v3
M$3858 A|Y$256 \$1642 VSS VSS nfet_03v3 L=0.28U W=2U AS=0.52P AD=1.02P PS=3.04U
+ PD=5.04U
* device instance $3860 r0 *1 135.12,116.76 nfet_03v3
M$3860 VSS A|Y$253 \$1574 VSS nfet_03v3 L=0.28U W=1U AS=0.44P AD=0.26P PS=2.88U
+ PD=1.52U
* device instance $3861 r0 *1 135.92,116.76 nfet_03v3
M$3861 A|Y$249 \$1574 VSS VSS nfet_03v3 L=0.28U W=2U AS=0.52P AD=1.02P PS=3.04U
+ PD=5.04U
* device instance $3863 r0 *1 137.92,118.44 nfet_03v3
M$3863 VSS A|Y$260 \$1643 VSS nfet_03v3 L=0.28U W=1U AS=0.44P AD=0.26P PS=2.88U
+ PD=1.52U
* device instance $3864 r0 *1 138.72,118.44 nfet_03v3
M$3864 A|Y$259 \$1643 VSS VSS nfet_03v3 L=0.28U W=2U AS=0.52P AD=1.02P PS=3.04U
+ PD=5.04U
* device instance $3866 r0 *1 142.265,116.765 nfet_03v3
M$3866 \$1598 \$1575 VSS VSS nfet_03v3 L=7.75U W=0.99U AS=0.4851P AD=0.4356P
+ PS=2.96U PD=2.86U
* device instance $3867 r0 *1 141.705,118.44 nfet_03v3
M$3867 \$1646 \$1645 VSS VSS nfet_03v3 L=1.03U W=1U AS=0.49P AD=0.44P PS=2.98U
+ PD=2.88U
* device instance $3868 r0 *1 149.545,118.435 nfet_03v3
M$3868 \$1648 \$1647 VSS VSS nfet_03v3 L=7.75U W=0.99U AS=0.4851P AD=0.4356P
+ PS=2.96U PD=2.86U
* device instance $3869 r0 *1 151.225,116.765 nfet_03v3
M$3869 \$1599 \$1576 VSS VSS nfet_03v3 L=7.75U W=0.99U AS=0.4851P AD=0.4356P
+ PS=2.96U PD=2.86U
* device instance $3870 r0 *1 156.265,118.435 nfet_03v3
M$3870 \$1650 \$1649 VSS VSS nfet_03v3 L=3.27U W=0.99U AS=0.4851P AD=0.4356P
+ PS=2.96U PD=2.86U
* device instance $3871 r0 *1 157.945,116.765 nfet_03v3
M$3871 \$1600 \$1577 VSS VSS nfet_03v3 L=3.27U W=0.99U AS=0.4851P AD=0.4356P
+ PS=2.96U PD=2.86U
* device instance $3872 r0 *1 159.625,118.44 nfet_03v3
M$3872 \$1652 \$1651 VSS VSS nfet_03v3 L=1.03U W=1U AS=0.49P AD=0.44P PS=2.98U
+ PD=2.88U
* device instance $3873 r0 *1 9.12,124.6 nfet_03v3
M$3873 C|Y$23 A|Y$266 VSS VSS nfet_03v3 L=0.28U W=2U AS=0.7P AD=0.7P PS=4.4U
+ PD=4.4U
* device instance $3875 r0 *1 11.44,124.6 nfet_03v3
M$3875 Y$25 C|Y$23 \$1716 VSS nfet_03v3 L=0.28U W=2U AS=0.71P AD=0.7P PS=4.42U
+ PD=4.4U
* device instance $3877 r0 *1 13.68,124.6 nfet_03v3
M$3877 \$1716 A|B|Y$3 \$1717 VSS nfet_03v3 L=0.28U W=2U AS=0.7P AD=0.52P
+ PS=4.4U PD=3.04U
* device instance $3879 r0 *1 15.28,124.6 nfet_03v3
M$3879 VSS A|Y$266 \$1717 VSS nfet_03v3 L=0.28U W=2U AS=0.52P AD=0.7P PS=3.04U
+ PD=4.4U
* device instance $3881 r0 *1 21.305,124.605 nfet_03v3
M$3881 \$1688 \$1658 VSS VSS nfet_03v3 L=7.75U W=0.99U AS=0.4851P AD=0.4356P
+ PS=2.96U PD=2.86U
* device instance $3882 r0 *1 30.265,124.605 nfet_03v3
M$3882 \$1689 \$1659 VSS VSS nfet_03v3 L=7.75U W=0.99U AS=0.4851P AD=0.4356P
+ PS=2.96U PD=2.86U
* device instance $3883 r0 *1 39.225,124.605 nfet_03v3
M$3883 \$1690 \$1660 VSS VSS nfet_03v3 L=7.75U W=0.99U AS=0.4851P AD=0.4356P
+ PS=2.96U PD=2.86U
* device instance $3884 r0 *1 44.825,124.6 nfet_03v3
M$3884 \$1691 \$1661 VSS VSS nfet_03v3 L=1.03U W=1U AS=0.49P AD=0.44P PS=2.98U
+ PD=2.88U
* device instance $3885 r0 *1 51.545,124.605 nfet_03v3
M$3885 \$1692 \$1662 VSS VSS nfet_03v3 L=7.75U W=0.99U AS=0.4851P AD=0.4356P
+ PS=2.96U PD=2.86U
* device instance $3886 r0 *1 60.505,124.605 nfet_03v3
M$3886 \$1693 \$1663 VSS VSS nfet_03v3 L=7.75U W=0.99U AS=0.4851P AD=0.4356P
+ PS=2.96U PD=2.86U
* device instance $3887 r0 *1 69.465,124.605 nfet_03v3
M$3887 \$1694 \$1664 VSS VSS nfet_03v3 L=7.75U W=0.99U AS=0.4851P AD=0.4356P
+ PS=2.96U PD=2.86U
* device instance $3888 r0 *1 78.425,124.605 nfet_03v3
M$3888 \$1695 \$1665 VSS VSS nfet_03v3 L=7.75U W=0.99U AS=0.4851P AD=0.4356P
+ PS=2.96U PD=2.86U
* device instance $3889 r0 *1 84.025,124.6 nfet_03v3
M$3889 \$1696 \$1666 VSS VSS nfet_03v3 L=1.03U W=1U AS=0.49P AD=0.44P PS=2.98U
+ PD=2.88U
* device instance $3890 r0 *1 90.745,124.605 nfet_03v3
M$3890 \$1697 \$1667 VSS VSS nfet_03v3 L=7.75U W=0.99U AS=0.4851P AD=0.4356P
+ PS=2.96U PD=2.86U
* device instance $3891 r0 *1 97.465,124.605 nfet_03v3
M$3891 \$1698 \$1668 VSS VSS nfet_03v3 L=3.27U W=0.99U AS=0.4851P AD=0.4356P
+ PS=2.96U PD=2.86U
* device instance $3892 r0 *1 100.825,124.6 nfet_03v3
M$3892 \$1699 \$1669 VSS VSS nfet_03v3 L=1.03U W=1U AS=0.49P AD=0.44P PS=2.98U
+ PD=2.88U
* device instance $3893 r0 *1 102.96,124.6 nfet_03v3
M$3893 A|Y$261 \$1700 VSS VSS nfet_03v3 L=0.28U W=2U AS=1.02P AD=0.52P PS=5.04U
+ PD=3.04U
* device instance $3895 r0 *1 104.56,124.6 nfet_03v3
M$3895 \$1700 A|Y$267 VSS VSS nfet_03v3 L=0.28U W=1U AS=0.26P AD=0.44P PS=1.52U
+ PD=2.88U
* device instance $3896 r0 *1 107.545,124.605 nfet_03v3
M$3896 \$1702 \$1671 VSS VSS nfet_03v3 L=3.27U W=0.99U AS=0.4851P AD=0.4356P
+ PS=2.96U PD=2.86U
* device instance $3897 r0 *1 110.905,124.6 nfet_03v3
M$3897 \$1703 \$1672 VSS VSS nfet_03v3 L=1.03U W=1U AS=0.49P AD=0.44P PS=2.98U
+ PD=2.88U
* device instance $3898 r0 *1 113.04,124.6 nfet_03v3
M$3898 A|Y$262 \$1704 VSS VSS nfet_03v3 L=0.28U W=2U AS=1.02P AD=0.52P PS=5.04U
+ PD=3.04U
* device instance $3900 r0 *1 114.64,124.6 nfet_03v3
M$3900 \$1704 A|Y$268 VSS VSS nfet_03v3 L=0.28U W=1U AS=0.26P AD=0.44P PS=1.52U
+ PD=2.88U
* device instance $3901 r0 *1 116.505,124.6 nfet_03v3
M$3901 \$1706 \$1674 VSS VSS nfet_03v3 L=1.03U W=1U AS=0.49P AD=0.44P PS=2.98U
+ PD=2.88U
* device instance $3902 r0 *1 118.32,124.6 nfet_03v3
M$3902 VSS A|Y$257 \$1675 VSS nfet_03v3 L=0.28U W=1U AS=0.44P AD=0.26P PS=2.88U
+ PD=1.52U
* device instance $3903 r0 *1 119.12,124.6 nfet_03v3
M$3903 A|Y$263 \$1675 VSS VSS nfet_03v3 L=0.28U W=2U AS=0.52P AD=1.02P PS=3.04U
+ PD=5.04U
* device instance $3905 r0 *1 121.68,124.6 nfet_03v3
M$3905 VSS A|Y$263 \$1677 VSS nfet_03v3 L=0.28U W=1U AS=0.44P AD=0.26P PS=2.88U
+ PD=1.52U
* device instance $3906 r0 *1 122.48,124.6 nfet_03v3
M$3906 A|Y$264 \$1677 VSS VSS nfet_03v3 L=0.28U W=2U AS=0.52P AD=1.02P PS=3.04U
+ PD=5.04U
* device instance $3908 r0 *1 127.705,124.605 nfet_03v3
M$3908 \$1707 \$1679 VSS VSS nfet_03v3 L=3.27U W=0.99U AS=0.4851P AD=0.4356P
+ PS=2.96U PD=2.86U
* device instance $3909 r0 *1 131.52,124.6 nfet_03v3
M$3909 A|Y$265 \$1708 VSS VSS nfet_03v3 L=0.28U W=2U AS=1.02P AD=0.52P PS=5.04U
+ PD=3.04U
* device instance $3911 r0 *1 133.12,124.6 nfet_03v3
M$3911 \$1708 A|Y$269 VSS VSS nfet_03v3 L=0.28U W=1U AS=0.26P AD=0.44P PS=1.52U
+ PD=2.88U
* device instance $3912 r0 *1 134.56,124.6 nfet_03v3
M$3912 VSS A|Y$265 \$1681 VSS nfet_03v3 L=0.28U W=1U AS=0.44P AD=0.26P PS=2.88U
+ PD=1.52U
* device instance $3913 r0 *1 135.36,124.6 nfet_03v3
M$3913 A|Y$260 \$1681 VSS VSS nfet_03v3 L=0.28U W=2U AS=0.52P AD=1.02P PS=3.04U
+ PD=5.04U
* device instance $3915 r0 *1 137.92,124.6 nfet_03v3
M$3915 VSS A|Y$270 \$1682 VSS nfet_03v3 L=0.28U W=1U AS=0.44P AD=0.26P PS=2.88U
+ PD=1.52U
* device instance $3916 r0 *1 138.72,124.6 nfet_03v3
M$3916 A|Y$269 \$1682 VSS VSS nfet_03v3 L=0.28U W=2U AS=0.52P AD=1.02P PS=3.04U
+ PD=5.04U
* device instance $3918 r0 *1 145.065,124.605 nfet_03v3
M$3918 \$1711 \$1683 VSS VSS nfet_03v3 L=7.75U W=0.99U AS=0.4851P AD=0.4356P
+ PS=2.96U PD=2.86U
* device instance $3919 r0 *1 154.025,124.605 nfet_03v3
M$3919 \$1712 \$1684 VSS VSS nfet_03v3 L=7.75U W=0.99U AS=0.4851P AD=0.4356P
+ PS=2.96U PD=2.86U
* device instance $3920 r0 *1 159.625,124.6 nfet_03v3
M$3920 \$1713 \$1685 VSS VSS nfet_03v3 L=1.03U W=1U AS=0.49P AD=0.44P PS=2.98U
+ PD=2.88U
* device instance $3921 r0 *1 9.12,126.28 nfet_03v3
M$3921 C|Y$24 A|Y$271 VSS VSS nfet_03v3 L=0.28U W=2U AS=0.7P AD=0.7P PS=4.4U
+ PD=4.4U
* device instance $3923 r0 *1 11.36,126.28 nfet_03v3
M$3923 VSS A|Y$271 \$1720 VSS nfet_03v3 L=0.28U W=2U AS=0.7P AD=0.52P PS=4.4U
+ PD=3.04U
* device instance $3925 r0 *1 12.96,126.28 nfet_03v3
M$3925 \$1721 A|B|Y$3 \$1720 VSS nfet_03v3 L=0.28U W=2U AS=0.52P AD=0.7P
+ PS=3.04U PD=4.4U
* device instance $3927 r0 *1 15.2,126.28 nfet_03v3
M$3927 Y$26 C|Y$24 \$1721 VSS nfet_03v3 L=0.28U W=2U AS=0.7P AD=0.71P PS=4.4U
+ PD=4.42U
* device instance $3929 r0 *1 17.52,126.28 nfet_03v3
M$3929 VSS A|FINE_MUX[1] \$1723 VSS nfet_03v3 L=0.28U W=1U AS=0.44P AD=0.26P
+ PS=2.88U PD=1.52U
* device instance $3930 r0 *1 18.32,126.28 nfet_03v3
M$3930 A|Y$266 \$1723 VSS VSS nfet_03v3 L=0.28U W=2U AS=0.52P AD=1.02P PS=3.04U
+ PD=5.04U
* device instance $3932 r0 *1 20.88,126.28 nfet_03v3
M$3932 VSS A|Y$272 \$1724 VSS nfet_03v3 L=0.28U W=2U AS=0.7P AD=0.52P PS=4.4U
+ PD=3.04U
* device instance $3934 r0 *1 22.48,126.28 nfet_03v3
M$3934 \$1726 A|B|Y$3 \$1724 VSS nfet_03v3 L=0.28U W=2U AS=0.52P AD=0.7P
+ PS=3.04U PD=4.4U
* device instance $3936 r0 *1 24.72,126.28 nfet_03v3
M$3936 Y$27 C|Y$25 \$1726 VSS nfet_03v3 L=0.28U W=2U AS=0.7P AD=0.71P PS=4.4U
+ PD=4.42U
* device instance $3938 r0 *1 28.16,126.28 nfet_03v3
M$3938 C|Y$25 A|Y$272 VSS VSS nfet_03v3 L=0.28U W=2U AS=0.7P AD=0.7P PS=4.4U
+ PD=4.4U
* device instance $3940 r0 *1 34.185,126.275 nfet_03v3
M$3940 \$1729 \$1728 VSS VSS nfet_03v3 L=7.75U W=0.99U AS=0.4851P AD=0.4356P
+ PS=2.96U PD=2.86U
* device instance $3941 r0 *1 43.145,126.275 nfet_03v3
M$3941 \$1731 \$1730 VSS VSS nfet_03v3 L=7.75U W=0.99U AS=0.4851P AD=0.4356P
+ PS=2.96U PD=2.86U
* device instance $3942 r0 *1 52.105,126.275 nfet_03v3
M$3942 \$1733 \$1732 VSS VSS nfet_03v3 L=7.75U W=0.99U AS=0.4851P AD=0.4356P
+ PS=2.96U PD=2.86U
* device instance $3943 r0 *1 61.065,126.275 nfet_03v3
M$3943 \$1735 \$1734 VSS VSS nfet_03v3 L=7.75U W=0.99U AS=0.4851P AD=0.4356P
+ PS=2.96U PD=2.86U
* device instance $3944 r0 *1 71.145,126.275 nfet_03v3
M$3944 \$1737 \$1736 VSS VSS nfet_03v3 L=7.75U W=0.99U AS=0.4851P AD=0.4356P
+ PS=2.96U PD=2.86U
* device instance $3945 r0 *1 80.105,126.275 nfet_03v3
M$3945 \$1739 \$1738 VSS VSS nfet_03v3 L=7.75U W=0.99U AS=0.4851P AD=0.4356P
+ PS=2.96U PD=2.86U
* device instance $3946 r0 *1 89.065,126.275 nfet_03v3
M$3946 \$1741 \$1740 VSS VSS nfet_03v3 L=7.75U W=0.99U AS=0.4851P AD=0.4356P
+ PS=2.96U PD=2.86U
* device instance $3947 r0 *1 95.68,126.28 nfet_03v3
M$3947 A|Y$273 \$1742 VSS VSS nfet_03v3 L=0.28U W=2U AS=1.02P AD=0.52P PS=5.04U
+ PD=3.04U
* device instance $3949 r0 *1 97.28,126.28 nfet_03v3
M$3949 \$1742 A|Y$274 VSS VSS nfet_03v3 L=0.28U W=1U AS=0.26P AD=0.44P PS=1.52U
+ PD=2.88U
* device instance $3950 r0 *1 99.04,126.28 nfet_03v3
M$3950 A|Y$275 \$1745 VSS VSS nfet_03v3 L=0.28U W=2U AS=1.02P AD=0.52P PS=5.04U
+ PD=3.04U
* device instance $3952 r0 *1 100.64,126.28 nfet_03v3
M$3952 \$1745 A|Y$276 VSS VSS nfet_03v3 L=0.28U W=1U AS=0.26P AD=0.44P PS=1.52U
+ PD=2.88U
* device instance $3953 r0 *1 102.4,126.28 nfet_03v3
M$3953 A|Y$276 \$1748 VSS VSS nfet_03v3 L=0.28U W=2U AS=1.02P AD=0.52P PS=5.04U
+ PD=3.04U
* device instance $3955 r0 *1 104,126.28 nfet_03v3
M$3955 \$1748 A|Y$261 VSS VSS nfet_03v3 L=0.28U W=1U AS=0.26P AD=0.44P PS=1.52U
+ PD=2.88U
* device instance $3956 r0 *1 106.88,126.28 nfet_03v3
M$3956 A|Y$267 \$1749 VSS VSS nfet_03v3 L=0.28U W=2U AS=1.02P AD=0.52P PS=5.04U
+ PD=3.04U
* device instance $3958 r0 *1 108.48,126.28 nfet_03v3
M$3958 \$1749 A|Y$277 VSS VSS nfet_03v3 L=0.28U W=1U AS=0.26P AD=0.44P PS=1.52U
+ PD=2.88U
* device instance $3959 r0 *1 110.24,126.28 nfet_03v3
M$3959 A|Y$277 \$1751 VSS VSS nfet_03v3 L=0.28U W=2U AS=1.02P AD=0.52P PS=5.04U
+ PD=3.04U
* device instance $3961 r0 *1 111.84,126.28 nfet_03v3
M$3961 \$1751 A|Y$278 VSS VSS nfet_03v3 L=0.28U W=1U AS=0.26P AD=0.44P PS=1.52U
+ PD=2.88U
* device instance $3962 r0 *1 113.28,126.28 nfet_03v3
M$3962 VSS A|Y$262 \$1753 VSS nfet_03v3 L=0.28U W=1U AS=0.44P AD=0.26P PS=2.88U
+ PD=1.52U
* device instance $3963 r0 *1 114.08,126.28 nfet_03v3
M$3963 A|Y$278 \$1753 VSS VSS nfet_03v3 L=0.28U W=2U AS=0.52P AD=1.02P PS=3.04U
+ PD=5.04U
* device instance $3965 r0 *1 116.96,126.28 nfet_03v3
M$3965 A|Y$268 \$1754 VSS VSS nfet_03v3 L=0.28U W=2U AS=1.02P AD=0.52P PS=5.04U
+ PD=3.04U
* device instance $3967 r0 *1 118.56,126.28 nfet_03v3
M$3967 \$1754 A|Y$279 VSS VSS nfet_03v3 L=0.28U W=1U AS=0.26P AD=0.44P PS=1.52U
+ PD=2.88U
* device instance $3968 r0 *1 120.32,126.28 nfet_03v3
M$3968 A|Y$280 \$1756 VSS VSS nfet_03v3 L=0.28U W=2U AS=1.02P AD=0.52P PS=5.04U
+ PD=3.04U
* device instance $3970 r0 *1 121.92,126.28 nfet_03v3
M$3970 \$1756 A|Y$264 VSS VSS nfet_03v3 L=0.28U W=1U AS=0.26P AD=0.44P PS=1.52U
+ PD=2.88U
* device instance $3971 r0 *1 127.145,126.275 nfet_03v3
M$3971 \$1759 \$1758 VSS VSS nfet_03v3 L=7.75U W=0.99U AS=0.4851P AD=0.4356P
+ PS=2.96U PD=2.86U
* device instance $3972 r0 *1 132.745,126.28 nfet_03v3
M$3972 \$1761 \$1760 VSS VSS nfet_03v3 L=1.03U W=1U AS=0.49P AD=0.44P PS=2.98U
+ PD=2.88U
* device instance $3973 r0 *1 134.88,126.28 nfet_03v3
M$3973 A|Y$270 \$1762 VSS VSS nfet_03v3 L=0.28U W=2U AS=1.02P AD=0.52P PS=5.04U
+ PD=3.04U
* device instance $3975 r0 *1 136.48,126.28 nfet_03v3
M$3975 \$1762 A|Y$281 VSS VSS nfet_03v3 L=0.28U W=1U AS=0.26P AD=0.44P PS=1.52U
+ PD=2.88U
* device instance $3976 r0 *1 137.92,126.28 nfet_03v3
M$3976 VSS A|Y$282 \$1765 VSS nfet_03v3 L=0.28U W=1U AS=0.44P AD=0.26P PS=2.88U
+ PD=1.52U
* device instance $3977 r0 *1 138.72,126.28 nfet_03v3
M$3977 A|Y$281 \$1765 VSS VSS nfet_03v3 L=0.28U W=2U AS=0.52P AD=1.02P PS=3.04U
+ PD=5.04U
* device instance $3979 r0 *1 141.705,126.28 nfet_03v3
M$3979 \$1767 \$1766 VSS VSS nfet_03v3 L=1.03U W=1U AS=0.49P AD=0.44P PS=2.98U
+ PD=2.88U
* device instance $3980 r0 *1 149.545,126.275 nfet_03v3
M$3980 \$1769 \$1768 VSS VSS nfet_03v3 L=7.75U W=0.99U AS=0.4851P AD=0.4356P
+ PS=2.96U PD=2.86U
* device instance $3981 r0 *1 156.265,126.275 nfet_03v3
M$3981 \$1771 \$1770 VSS VSS nfet_03v3 L=3.27U W=0.99U AS=0.4851P AD=0.4356P
+ PS=2.96U PD=2.86U
* device instance $3982 r0 *1 159.625,126.28 nfet_03v3
M$3982 \$1773 \$1772 VSS VSS nfet_03v3 L=1.03U W=1U AS=0.49P AD=0.44P PS=2.98U
+ PD=2.88U
* device instance $3983 r0 *1 8.56,134.12 nfet_03v3
M$3983 VSS A|FINE_MUX[3] \$1830 VSS nfet_03v3 L=0.28U W=1U AS=0.44P AD=0.26P
+ PS=2.88U PD=1.52U
* device instance $3984 r0 *1 9.36,134.12 nfet_03v3
M$3984 A|Y$272 \$1830 VSS VSS nfet_03v3 L=0.28U W=2U AS=0.52P AD=1.02P PS=3.04U
+ PD=5.04U
* device instance $3986 r0 *1 9.12,132.44 nfet_03v3
M$3986 C|Y$26 A|Y$288 VSS VSS nfet_03v3 L=0.28U W=2U AS=0.7P AD=0.7P PS=4.4U
+ PD=4.4U
* device instance $3988 r0 *1 11.36,132.44 nfet_03v3
M$3988 VSS A|Y$288 \$1828 VSS nfet_03v3 L=0.28U W=2U AS=0.7P AD=0.52P PS=4.4U
+ PD=3.04U
* device instance $3990 r0 *1 12.96,132.44 nfet_03v3
M$3990 \$1829 A|B|Y$3 \$1828 VSS nfet_03v3 L=0.28U W=2U AS=0.52P AD=0.7P
+ PS=3.04U PD=4.4U
* device instance $3992 r0 *1 11.92,134.12 nfet_03v3
M$3992 VSS A|FINE_MUX[15] \$1831 VSS nfet_03v3 L=0.28U W=1U AS=0.44P AD=0.26P
+ PS=2.88U PD=1.52U
* device instance $3993 r0 *1 12.72,134.12 nfet_03v3
M$3993 A|Y$271 \$1831 VSS VSS nfet_03v3 L=0.28U W=2U AS=0.52P AD=1.02P PS=3.04U
+ PD=5.04U
* device instance $3995 r0 *1 15.2,132.44 nfet_03v3
M$3995 Y$28 C|Y$26 \$1829 VSS nfet_03v3 L=0.28U W=2U AS=0.7P AD=0.71P PS=4.4U
+ PD=4.42U
* device instance $3997 r0 *1 15.28,134.12 nfet_03v3
M$3997 C|Y$27 A|Y$320 VSS VSS nfet_03v3 L=0.28U W=2U AS=0.7P AD=0.7P PS=4.4U
+ PD=4.4U
* device instance $3999 r0 *1 21.305,132.445 nfet_03v3
M$3999 \$1780 \$1779 VSS VSS nfet_03v3 L=7.75U W=0.99U AS=0.4851P AD=0.4356P
+ PS=2.96U PD=2.86U
* device instance $4000 r0 *1 21.305,134.115 nfet_03v3
M$4000 \$1834 \$1833 VSS VSS nfet_03v3 L=7.75U W=0.99U AS=0.4851P AD=0.4356P
+ PS=2.96U PD=2.86U
* device instance $4001 r0 *1 30.265,132.445 nfet_03v3
M$4001 \$1782 \$1781 VSS VSS nfet_03v3 L=7.75U W=0.99U AS=0.4851P AD=0.4356P
+ PS=2.96U PD=2.86U
* device instance $4002 r0 *1 31.945,134.115 nfet_03v3
M$4002 \$1836 \$1835 VSS VSS nfet_03v3 L=7.75U W=0.99U AS=0.4851P AD=0.4356P
+ PS=2.96U PD=2.86U
* device instance $4003 r0 *1 39.225,132.445 nfet_03v3
M$4003 \$1784 \$1783 VSS VSS nfet_03v3 L=7.75U W=0.99U AS=0.4851P AD=0.4356P
+ PS=2.96U PD=2.86U
* device instance $4004 r0 *1 40.905,134.115 nfet_03v3
M$4004 \$1838 \$1837 VSS VSS nfet_03v3 L=7.75U W=0.99U AS=0.4851P AD=0.4356P
+ PS=2.96U PD=2.86U
* device instance $4005 r0 *1 44.825,132.44 nfet_03v3
M$4005 \$1786 \$1785 VSS VSS nfet_03v3 L=1.03U W=1U AS=0.49P AD=0.44P PS=2.98U
+ PD=2.88U
* device instance $4006 r0 *1 49.865,134.115 nfet_03v3
M$4006 \$1840 \$1839 VSS VSS nfet_03v3 L=7.75U W=0.99U AS=0.4851P AD=0.4356P
+ PS=2.96U PD=2.86U
* device instance $4007 r0 *1 51.545,132.445 nfet_03v3
M$4007 \$1788 \$1787 VSS VSS nfet_03v3 L=7.75U W=0.99U AS=0.4851P AD=0.4356P
+ PS=2.96U PD=2.86U
* device instance $4008 r0 *1 58.825,134.115 nfet_03v3
M$4008 \$1842 \$1841 VSS VSS nfet_03v3 L=7.75U W=0.99U AS=0.4851P AD=0.4356P
+ PS=2.96U PD=2.86U
* device instance $4009 r0 *1 60.505,132.445 nfet_03v3
M$4009 \$1790 \$1789 VSS VSS nfet_03v3 L=7.75U W=0.99U AS=0.4851P AD=0.4356P
+ PS=2.96U PD=2.86U
* device instance $4010 r0 *1 64.425,134.12 nfet_03v3
M$4010 \$1844 \$1843 VSS VSS nfet_03v3 L=1.03U W=1U AS=0.49P AD=0.44P PS=2.98U
+ PD=2.88U
* device instance $4011 r0 *1 69.465,132.445 nfet_03v3
M$4011 \$1792 \$1791 VSS VSS nfet_03v3 L=7.75U W=0.99U AS=0.4851P AD=0.4356P
+ PS=2.96U PD=2.86U
* device instance $4012 r0 *1 71.145,134.115 nfet_03v3
M$4012 \$1846 \$1845 VSS VSS nfet_03v3 L=7.75U W=0.99U AS=0.4851P AD=0.4356P
+ PS=2.96U PD=2.86U
* device instance $4013 r0 *1 78.425,132.445 nfet_03v3
M$4013 \$1794 \$1793 VSS VSS nfet_03v3 L=7.75U W=0.99U AS=0.4851P AD=0.4356P
+ PS=2.96U PD=2.86U
* device instance $4014 r0 *1 80.105,134.115 nfet_03v3
M$4014 \$1848 \$1847 VSS VSS nfet_03v3 L=7.75U W=0.99U AS=0.4851P AD=0.4356P
+ PS=2.96U PD=2.86U
* device instance $4015 r0 *1 84.025,132.44 nfet_03v3
M$4015 \$1796 \$1795 VSS VSS nfet_03v3 L=1.03U W=1U AS=0.49P AD=0.44P PS=2.98U
+ PD=2.88U
* device instance $4016 r0 *1 85.705,134.12 nfet_03v3
M$4016 \$1850 \$1849 VSS VSS nfet_03v3 L=1.03U W=1U AS=0.49P AD=0.44P PS=2.98U
+ PD=2.88U
* device instance $4017 r0 *1 87.385,132.44 nfet_03v3
M$4017 \$1798 \$1797 VSS VSS nfet_03v3 L=1.03U W=1U AS=0.49P AD=0.44P PS=2.98U
+ PD=2.88U
* device instance $4018 r0 *1 88.4,134.12 nfet_03v3
M$4018 A|Y$290 \$1871 VSS VSS nfet_03v3 L=0.28U W=2U AS=1.02P AD=0.52P PS=5.04U
+ PD=3.04U
* device instance $4020 r0 *1 90,134.12 nfet_03v3
M$4020 \$1871 A|Y$292 VSS VSS nfet_03v3 L=0.28U W=1U AS=0.26P AD=0.44P PS=1.52U
+ PD=2.88U
* device instance $4021 r0 *1 90.08,132.44 nfet_03v3
M$4021 A|Y$283 \$1799 VSS VSS nfet_03v3 L=0.28U W=2U AS=1.02P AD=0.52P PS=5.04U
+ PD=3.04U
* device instance $4023 r0 *1 91.68,132.44 nfet_03v3
M$4023 \$1799 A|Y$284 VSS VSS nfet_03v3 L=0.28U W=1U AS=0.26P AD=0.44P PS=1.52U
+ PD=2.88U
* device instance $4024 r0 *1 91.44,134.12 nfet_03v3
M$4024 VSS A|Y$283 \$1852 VSS nfet_03v3 L=0.28U W=1U AS=0.44P AD=0.26P PS=2.88U
+ PD=1.52U
* device instance $4025 r0 *1 92.24,134.12 nfet_03v3
M$4025 A|Y$292 \$1852 VSS VSS nfet_03v3 L=0.28U W=2U AS=0.52P AD=1.02P PS=3.04U
+ PD=5.04U
* device instance $4027 r0 *1 93.44,132.44 nfet_03v3
M$4027 A|Y$284 \$1802 VSS VSS nfet_03v3 L=0.28U W=2U AS=1.02P AD=0.52P PS=5.04U
+ PD=3.04U
* device instance $4029 r0 *1 95.04,132.44 nfet_03v3
M$4029 \$1802 A|Y$285 VSS VSS nfet_03v3 L=0.28U W=1U AS=0.26P AD=0.44P PS=1.52U
+ PD=2.88U
* device instance $4030 r0 *1 98.585,134.115 nfet_03v3
M$4030 \$1854 \$1853 VSS VSS nfet_03v3 L=7.75U W=0.99U AS=0.4851P AD=0.4356P
+ PS=2.96U PD=2.86U
* device instance $4031 r0 *1 96.48,132.44 nfet_03v3
M$4031 VSS A|Y$273 \$1804 VSS nfet_03v3 L=0.28U W=1U AS=0.44P AD=0.26P PS=2.88U
+ PD=1.52U
* device instance $4032 r0 *1 97.28,132.44 nfet_03v3
M$4032 A|Y$285 \$1804 VSS VSS nfet_03v3 L=0.28U W=2U AS=0.52P AD=1.02P PS=3.04U
+ PD=5.04U
* device instance $4034 r0 *1 99.84,132.44 nfet_03v3
M$4034 VSS A|Y$275 \$1805 VSS nfet_03v3 L=0.28U W=1U AS=0.44P AD=0.26P PS=2.88U
+ PD=1.52U
* device instance $4035 r0 *1 100.64,132.44 nfet_03v3
M$4035 A|Y$274 \$1805 VSS VSS nfet_03v3 L=0.28U W=2U AS=0.52P AD=1.02P PS=3.04U
+ PD=5.04U
* device instance $4037 r0 *1 106.985,132.445 nfet_03v3
M$4037 \$1807 \$1806 VSS VSS nfet_03v3 L=7.75U W=0.99U AS=0.4851P AD=0.4356P
+ PS=2.96U PD=2.86U
* device instance $4038 r0 *1 110.345,134.115 nfet_03v3
M$4038 \$1856 \$1855 VSS VSS nfet_03v3 L=7.75U W=0.99U AS=0.4851P AD=0.4356P
+ PS=2.96U PD=2.86U
* device instance $4039 r0 *1 112.585,132.44 nfet_03v3
M$4039 \$1809 \$1808 VSS VSS nfet_03v3 L=1.03U W=1U AS=0.49P AD=0.44P PS=2.98U
+ PD=2.88U
* device instance $4040 r0 *1 119.305,134.115 nfet_03v3
M$4040 \$1858 \$1857 VSS VSS nfet_03v3 L=7.75U W=0.99U AS=0.4851P AD=0.4356P
+ PS=2.96U PD=2.86U
* device instance $4041 r0 *1 116.4,132.44 nfet_03v3
M$4041 A|Y$279 \$1810 VSS VSS nfet_03v3 L=0.28U W=2U AS=1.02P AD=0.52P PS=5.04U
+ PD=3.04U
* device instance $4043 r0 *1 118,132.44 nfet_03v3
M$4043 \$1810 A|Y$286 VSS VSS nfet_03v3 L=0.28U W=1U AS=0.26P AD=0.44P PS=1.52U
+ PD=2.88U
* device instance $4044 r0 *1 119.76,132.44 nfet_03v3
M$4044 A|Y$286 \$1812 VSS VSS nfet_03v3 L=0.28U W=2U AS=1.02P AD=0.52P PS=5.04U
+ PD=3.04U
* device instance $4046 r0 *1 121.36,132.44 nfet_03v3
M$4046 \$1812 A|Y$280 VSS VSS nfet_03v3 L=0.28U W=1U AS=0.26P AD=0.44P PS=1.52U
+ PD=2.88U
* device instance $4047 r0 *1 123.225,132.44 nfet_03v3
M$4047 \$1814 \$1813 VSS VSS nfet_03v3 L=1.03U W=1U AS=0.49P AD=0.44P PS=2.98U
+ PD=2.88U
* device instance $4048 r0 *1 128.265,134.115 nfet_03v3
M$4048 \$1860 \$1859 VSS VSS nfet_03v3 L=7.75U W=0.99U AS=0.4851P AD=0.4356P
+ PS=2.96U PD=2.86U
* device instance $4049 r0 *1 129.945,132.445 nfet_03v3
M$4049 \$1816 \$1815 VSS VSS nfet_03v3 L=7.75U W=0.99U AS=0.4851P AD=0.4356P
+ PS=2.96U PD=2.86U
* device instance $4050 r0 *1 133.865,134.12 nfet_03v3
M$4050 \$1862 \$1861 VSS VSS nfet_03v3 L=1.03U W=1U AS=0.49P AD=0.44P PS=2.98U
+ PD=2.88U
* device instance $4051 r0 *1 136,132.44 nfet_03v3
M$4051 A|Y$282 \$1817 VSS VSS nfet_03v3 L=0.28U W=2U AS=1.02P AD=0.52P PS=5.04U
+ PD=3.04U
* device instance $4053 r0 *1 137.6,132.44 nfet_03v3
M$4053 \$1817 A|Y$287 VSS VSS nfet_03v3 L=0.28U W=1U AS=0.26P AD=0.44P PS=1.52U
+ PD=2.88U
* device instance $4054 r0 *1 137.68,134.12 nfet_03v3
M$4054 A|Y$289 \$1873 VSS VSS nfet_03v3 L=0.28U W=2U AS=1.02P AD=0.52P PS=5.04U
+ PD=3.04U
* device instance $4056 r0 *1 139.28,134.12 nfet_03v3
M$4056 \$1873 A|Y$291 VSS VSS nfet_03v3 L=0.28U W=1U AS=0.26P AD=0.44P PS=1.52U
+ PD=2.88U
* device instance $4057 r0 *1 139.04,132.44 nfet_03v3
M$4057 VSS A|Y$289 \$1819 VSS nfet_03v3 L=0.28U W=1U AS=0.44P AD=0.26P PS=2.88U
+ PD=1.52U
* device instance $4058 r0 *1 139.84,132.44 nfet_03v3
M$4058 A|Y$287 \$1819 VSS VSS nfet_03v3 L=0.28U W=2U AS=0.52P AD=1.02P PS=3.04U
+ PD=5.04U
* device instance $4060 r0 *1 140.72,134.12 nfet_03v3
M$4060 VSS A|Y$293 \$1863 VSS nfet_03v3 L=0.28U W=1U AS=0.44P AD=0.26P PS=2.88U
+ PD=1.52U
* device instance $4061 r0 *1 141.52,134.12 nfet_03v3
M$4061 A|Y$291 \$1863 VSS VSS nfet_03v3 L=0.28U W=2U AS=0.52P AD=1.02P PS=3.04U
+ PD=5.04U
* device instance $4063 r0 *1 146.185,132.445 nfet_03v3
M$4063 \$1821 \$1820 VSS VSS nfet_03v3 L=7.75U W=0.99U AS=0.4851P AD=0.4356P
+ PS=2.96U PD=2.86U
* device instance $4064 r0 *1 149.545,134.115 nfet_03v3
M$4064 \$1866 \$1865 VSS VSS nfet_03v3 L=7.75U W=0.99U AS=0.4851P AD=0.4356P
+ PS=2.96U PD=2.86U
* device instance $4065 r0 *1 155.145,132.445 nfet_03v3
M$4065 \$1823 \$1822 VSS VSS nfet_03v3 L=7.75U W=0.99U AS=0.4851P AD=0.4356P
+ PS=2.96U PD=2.86U
* device instance $4066 r0 *1 156.265,134.115 nfet_03v3
M$4066 \$1868 \$1867 VSS VSS nfet_03v3 L=3.27U W=0.99U AS=0.4851P AD=0.4356P
+ PS=2.96U PD=2.86U
* device instance $4067 r0 *1 159.625,134.12 nfet_03v3
M$4067 \$1870 \$1869 VSS VSS nfet_03v3 L=1.03U W=1U AS=0.49P AD=0.44P PS=2.98U
+ PD=2.88U
* device instance $4068 r0 *1 160.745,132.44 nfet_03v3
M$4068 \$1825 \$1824 VSS VSS nfet_03v3 L=1.03U W=1U AS=0.49P AD=0.44P PS=2.98U
+ PD=2.88U
* device instance $4069 r0 *1 8.56,140.28 nfet_03v3
M$4069 VSS A|FINE_MUX[25] \$1877 VSS nfet_03v3 L=0.28U W=1U AS=0.44P AD=0.26P
+ PS=2.88U PD=1.52U
* device instance $4070 r0 *1 9.36,140.28 nfet_03v3
M$4070 A|Y$288 \$1877 VSS VSS nfet_03v3 L=0.28U W=2U AS=0.52P AD=1.02P PS=3.04U
+ PD=5.04U
* device instance $4072 r0 *1 11.92,140.28 nfet_03v3
M$4072 VSS A|Y$294 \$1938 VSS nfet_03v3 L=0.28U W=2U AS=0.7P AD=0.52P PS=4.4U
+ PD=3.04U
* device instance $4074 r0 *1 13.52,140.28 nfet_03v3
M$4074 \$1939 A|B|Y$3 \$1938 VSS nfet_03v3 L=0.28U W=2U AS=0.52P AD=0.7P
+ PS=3.04U PD=4.4U
* device instance $4076 r0 *1 15.76,140.28 nfet_03v3
M$4076 Y$29 C|Y$28 \$1939 VSS nfet_03v3 L=0.28U W=2U AS=0.7P AD=0.71P PS=4.4U
+ PD=4.42U
* device instance $4078 r0 *1 18.08,140.28 nfet_03v3
M$4078 C|Y$28 A|Y$294 VSS VSS nfet_03v3 L=0.28U W=2U AS=0.7P AD=0.7P PS=4.4U
+ PD=4.4U
* device instance $4080 r0 *1 24.105,140.285 nfet_03v3
M$4080 \$1883 \$1882 VSS VSS nfet_03v3 L=7.75U W=0.99U AS=0.4851P AD=0.4356P
+ PS=2.96U PD=2.86U
* device instance $4081 r0 *1 33.065,140.285 nfet_03v3
M$4081 \$1885 \$1884 VSS VSS nfet_03v3 L=7.75U W=0.99U AS=0.4851P AD=0.4356P
+ PS=2.96U PD=2.86U
* device instance $4082 r0 *1 39.785,140.285 nfet_03v3
M$4082 \$1887 \$1886 VSS VSS nfet_03v3 L=3.27U W=0.99U AS=0.4851P AD=0.4356P
+ PS=2.96U PD=2.86U
* device instance $4083 r0 *1 43.145,140.28 nfet_03v3
M$4083 \$1889 \$1888 VSS VSS nfet_03v3 L=1.03U W=1U AS=0.49P AD=0.44P PS=2.98U
+ PD=2.88U
* device instance $4084 r0 *1 51.545,140.285 nfet_03v3
M$4084 \$1891 \$1890 VSS VSS nfet_03v3 L=7.75U W=0.99U AS=0.4851P AD=0.4356P
+ PS=2.96U PD=2.86U
* device instance $4085 r0 *1 60.505,140.285 nfet_03v3
M$4085 \$1893 \$1892 VSS VSS nfet_03v3 L=7.75U W=0.99U AS=0.4851P AD=0.4356P
+ PS=2.96U PD=2.86U
* device instance $4086 r0 *1 69.465,140.285 nfet_03v3
M$4086 \$1895 \$1894 VSS VSS nfet_03v3 L=7.75U W=0.99U AS=0.4851P AD=0.4356P
+ PS=2.96U PD=2.86U
* device instance $4087 r0 *1 78.425,140.285 nfet_03v3
M$4087 \$1897 \$1896 VSS VSS nfet_03v3 L=7.75U W=0.99U AS=0.4851P AD=0.4356P
+ PS=2.96U PD=2.86U
* device instance $4088 r0 *1 84.025,140.28 nfet_03v3
M$4088 \$1899 \$1898 VSS VSS nfet_03v3 L=1.03U W=1U AS=0.49P AD=0.44P PS=2.98U
+ PD=2.88U
* device instance $4089 r0 *1 88.505,140.285 nfet_03v3
M$4089 \$1901 \$1900 VSS VSS nfet_03v3 L=3.27U W=0.99U AS=0.4851P AD=0.4356P
+ PS=2.96U PD=2.86U
* device instance $4090 r0 *1 91.44,140.28 nfet_03v3
M$4090 VSS A|Y$290 \$1902 VSS nfet_03v3 L=0.28U W=1U AS=0.44P AD=0.26P PS=2.88U
+ PD=1.52U
* device instance $4091 r0 *1 92.24,140.28 nfet_03v3
M$4091 A|Y$295 \$1902 VSS VSS nfet_03v3 L=0.28U W=2U AS=0.52P AD=1.02P PS=3.04U
+ PD=5.04U
* device instance $4093 r0 *1 98.585,140.285 nfet_03v3
M$4093 \$1905 \$1904 VSS VSS nfet_03v3 L=7.75U W=0.99U AS=0.4851P AD=0.4356P
+ PS=2.96U PD=2.86U
* device instance $4094 r0 *1 107.545,140.285 nfet_03v3
M$4094 \$1907 \$1906 VSS VSS nfet_03v3 L=7.75U W=0.99U AS=0.4851P AD=0.4356P
+ PS=2.96U PD=2.86U
* device instance $4095 r0 *1 114.16,140.28 nfet_03v3
M$4095 A|Y$296 \$1908 VSS VSS nfet_03v3 L=0.28U W=2U AS=1.02P AD=0.52P PS=5.04U
+ PD=3.04U
* device instance $4097 r0 *1 115.76,140.28 nfet_03v3
M$4097 \$1908 A|Y$297 VSS VSS nfet_03v3 L=0.28U W=1U AS=0.26P AD=0.44P PS=1.52U
+ PD=2.88U
* device instance $4098 r0 *1 117.52,140.28 nfet_03v3
M$4098 A|Y$298 \$1911 VSS VSS nfet_03v3 L=0.28U W=2U AS=1.02P AD=0.52P PS=5.04U
+ PD=3.04U
* device instance $4100 r0 *1 119.12,140.28 nfet_03v3
M$4100 \$1911 A|Y$299 VSS VSS nfet_03v3 L=0.28U W=1U AS=0.26P AD=0.44P PS=1.52U
+ PD=2.88U
* device instance $4101 r0 *1 120.88,140.28 nfet_03v3
M$4101 A|Y$300 \$1914 VSS VSS nfet_03v3 L=0.28U W=2U AS=1.02P AD=0.52P PS=5.04U
+ PD=3.04U
* device instance $4103 r0 *1 122.48,140.28 nfet_03v3
M$4103 \$1914 A|Y$301 VSS VSS nfet_03v3 L=0.28U W=1U AS=0.26P AD=0.44P PS=1.52U
+ PD=2.88U
* device instance $4104 r0 *1 126.48,140.28 nfet_03v3
M$4104 A|Y$302 \$1917 VSS VSS nfet_03v3 L=0.28U W=2U AS=1.02P AD=0.52P PS=5.04U
+ PD=3.04U
* device instance $4106 r0 *1 128.08,140.28 nfet_03v3
M$4106 \$1917 A|Y$303 VSS VSS nfet_03v3 L=0.28U W=1U AS=0.26P AD=0.44P PS=1.52U
+ PD=2.88U
* device instance $4107 r0 *1 129.945,140.28 nfet_03v3
M$4107 \$1921 \$1920 VSS VSS nfet_03v3 L=1.03U W=1U AS=0.49P AD=0.44P PS=2.98U
+ PD=2.88U
* device instance $4108 r0 *1 133.76,140.28 nfet_03v3
M$4108 A|Y$304 \$1922 VSS VSS nfet_03v3 L=0.28U W=2U AS=1.02P AD=0.52P PS=5.04U
+ PD=3.04U
* device instance $4110 r0 *1 135.36,140.28 nfet_03v3
M$4110 \$1922 A|Y$305 VSS VSS nfet_03v3 L=0.28U W=1U AS=0.26P AD=0.44P PS=1.52U
+ PD=2.88U
* device instance $4111 r0 *1 137.225,140.28 nfet_03v3
M$4111 \$1926 \$1925 VSS VSS nfet_03v3 L=1.03U W=1U AS=0.49P AD=0.44P PS=2.98U
+ PD=2.88U
* device instance $4112 r0 *1 139.36,140.28 nfet_03v3
M$4112 A|Y$293 \$1927 VSS VSS nfet_03v3 L=0.28U W=2U AS=1.02P AD=0.52P PS=5.04U
+ PD=3.04U
* device instance $4114 r0 *1 140.96,140.28 nfet_03v3
M$4114 \$1927 A|Y$306 VSS VSS nfet_03v3 L=0.28U W=1U AS=0.26P AD=0.44P PS=1.52U
+ PD=2.88U
* device instance $4115 r0 *1 142.4,140.28 nfet_03v3
M$4115 VSS A|Y$307 \$1929 VSS nfet_03v3 L=0.28U W=1U AS=0.44P AD=0.26P PS=2.88U
+ PD=1.52U
* device instance $4116 r0 *1 143.2,140.28 nfet_03v3
M$4116 A|Y$306 \$1929 VSS VSS nfet_03v3 L=0.28U W=2U AS=0.52P AD=1.02P PS=3.04U
+ PD=5.04U
* device instance $4118 r0 *1 149.545,140.285 nfet_03v3
M$4118 \$1931 \$1930 VSS VSS nfet_03v3 L=7.75U W=0.99U AS=0.4851P AD=0.4356P
+ PS=2.96U PD=2.86U
* device instance $4119 r0 *1 156.265,140.285 nfet_03v3
M$4119 \$1933 \$1932 VSS VSS nfet_03v3 L=3.27U W=0.99U AS=0.4851P AD=0.4356P
+ PS=2.96U PD=2.86U
* device instance $4120 r0 *1 159.625,140.28 nfet_03v3
M$4120 \$1935 \$1934 VSS VSS nfet_03v3 L=1.03U W=1U AS=0.49P AD=0.44P PS=2.98U
+ PD=2.88U
* device instance $4121 r0 *1 8.56,141.96 nfet_03v3
M$4121 VSS A|FINE_MUX[10] \$1941 VSS nfet_03v3 L=0.28U W=1U AS=0.44P AD=0.26P
+ PS=2.88U PD=1.52U
* device instance $4122 r0 *1 9.36,141.96 nfet_03v3
M$4122 A|Y$294 \$1941 VSS VSS nfet_03v3 L=0.28U W=2U AS=0.52P AD=1.02P PS=3.04U
+ PD=5.04U
* device instance $4124 r0 *1 11.92,141.96 nfet_03v3
M$4124 VSS A|Y$320 \$1942 VSS nfet_03v3 L=0.28U W=2U AS=0.7P AD=0.52P PS=4.4U
+ PD=3.04U
* device instance $4126 r0 *1 13.52,141.96 nfet_03v3
M$4126 \$1944 A|B|Y$3 \$1942 VSS nfet_03v3 L=0.28U W=2U AS=0.52P AD=0.7P
+ PS=3.04U PD=4.4U
* device instance $4128 r0 *1 15.76,141.96 nfet_03v3
M$4128 Y$30 C|Y$27 \$1944 VSS nfet_03v3 L=0.28U W=2U AS=0.7P AD=0.71P PS=4.4U
+ PD=4.42U
* device instance $4130 r0 *1 18.08,141.96 nfet_03v3
M$4130 VSS A|FINE_MUX[20] \$1945 VSS nfet_03v3 L=0.28U W=1U AS=0.44P AD=0.26P
+ PS=2.88U PD=1.52U
* device instance $4131 r0 *1 18.88,141.96 nfet_03v3
M$4131 A|Y$308 \$1945 VSS VSS nfet_03v3 L=0.28U W=2U AS=0.52P AD=1.02P PS=3.04U
+ PD=5.04U
* device instance $4133 r0 *1 21.44,141.96 nfet_03v3
M$4133 C|Y$29 A|Y$308 VSS VSS nfet_03v3 L=0.28U W=2U AS=0.7P AD=0.7P PS=4.4U
+ PD=4.4U
* device instance $4135 r0 *1 24.105,141.96 nfet_03v3
M$4135 \$1949 \$1948 VSS VSS nfet_03v3 L=1.03U W=1U AS=0.49P AD=0.44P PS=2.98U
+ PD=2.88U
* device instance $4136 r0 *1 31.945,141.955 nfet_03v3
M$4136 \$1951 \$1950 VSS VSS nfet_03v3 L=7.75U W=0.99U AS=0.4851P AD=0.4356P
+ PS=2.96U PD=2.86U
* device instance $4137 r0 *1 40.905,141.955 nfet_03v3
M$4137 \$1953 \$1952 VSS VSS nfet_03v3 L=7.75U W=0.99U AS=0.4851P AD=0.4356P
+ PS=2.96U PD=2.86U
* device instance $4138 r0 *1 49.865,141.955 nfet_03v3
M$4138 \$1955 \$1954 VSS VSS nfet_03v3 L=7.75U W=0.99U AS=0.4851P AD=0.4356P
+ PS=2.96U PD=2.86U
* device instance $4139 r0 *1 58.825,141.955 nfet_03v3
M$4139 \$1957 \$1956 VSS VSS nfet_03v3 L=7.75U W=0.99U AS=0.4851P AD=0.4356P
+ PS=2.96U PD=2.86U
* device instance $4140 r0 *1 64.425,141.96 nfet_03v3
M$4140 \$1959 \$1958 VSS VSS nfet_03v3 L=1.03U W=1U AS=0.49P AD=0.44P PS=2.98U
+ PD=2.88U
* device instance $4141 r0 *1 68.905,141.955 nfet_03v3
M$4141 \$1961 \$1960 VSS VSS nfet_03v3 L=3.27U W=0.99U AS=0.4851P AD=0.4356P
+ PS=2.96U PD=2.86U
* device instance $4142 r0 *1 72.96,141.96 nfet_03v3
M$4142 C|Y$30 A|Y$321 VSS VSS nfet_03v3 L=0.28U W=2U AS=0.7P AD=0.7P PS=4.4U
+ PD=4.4U
* device instance $4144 r0 *1 75.625,141.96 nfet_03v3
M$4144 \$1964 \$1963 VSS VSS nfet_03v3 L=1.03U W=1U AS=0.49P AD=0.44P PS=2.98U
+ PD=2.88U
* device instance $4145 r0 *1 77.44,141.96 nfet_03v3
M$4145 C|Y$31 A|Y$322 VSS VSS nfet_03v3 L=0.28U W=2U AS=0.7P AD=0.7P PS=4.4U
+ PD=4.4U
* device instance $4147 r0 *1 83.465,141.955 nfet_03v3
M$4147 \$1967 \$1966 VSS VSS nfet_03v3 L=7.75U W=0.99U AS=0.4851P AD=0.4356P
+ PS=2.96U PD=2.86U
* device instance $4148 r0 *1 89.065,141.96 nfet_03v3
M$4148 \$1969 \$1968 VSS VSS nfet_03v3 L=1.03U W=1U AS=0.49P AD=0.44P PS=2.98U
+ PD=2.88U
* device instance $4149 r0 *1 92,141.96 nfet_03v3
M$4149 VSS A|Y$295 \$1970 VSS nfet_03v3 L=0.28U W=1U AS=0.44P AD=0.26P PS=2.88U
+ PD=1.52U
* device instance $4150 r0 *1 92.8,141.96 nfet_03v3
M$4150 A|Y$309 \$1970 VSS VSS nfet_03v3 L=0.28U W=2U AS=0.52P AD=1.02P PS=3.04U
+ PD=5.04U
* device instance $4152 r0 *1 95.36,141.96 nfet_03v3
M$4152 VSS A|Y$309 \$1972 VSS nfet_03v3 L=0.28U W=1U AS=0.44P AD=0.26P PS=2.88U
+ PD=1.52U
* device instance $4153 r0 *1 96.16,141.96 nfet_03v3
M$4153 A|Y$310 \$1972 VSS VSS nfet_03v3 L=0.28U W=2U AS=0.52P AD=1.02P PS=3.04U
+ PD=5.04U
* device instance $4155 r0 *1 99.04,141.96 nfet_03v3
M$4155 A|Y$311 \$2003 VSS VSS nfet_03v3 L=0.28U W=2U AS=1.02P AD=0.52P PS=5.04U
+ PD=3.04U
* device instance $4157 r0 *1 100.64,141.96 nfet_03v3
M$4157 \$2003 A|Y$312 VSS VSS nfet_03v3 L=0.28U W=1U AS=0.26P AD=0.44P PS=1.52U
+ PD=2.88U
* device instance $4158 r0 *1 102.4,141.96 nfet_03v3
M$4158 A|Y$313 \$2004 VSS VSS nfet_03v3 L=0.28U W=2U AS=1.02P AD=0.52P PS=5.04U
+ PD=3.04U
* device instance $4160 r0 *1 104,141.96 nfet_03v3
M$4160 \$2004 A|Y$314 VSS VSS nfet_03v3 L=0.28U W=1U AS=0.26P AD=0.44P PS=1.52U
+ PD=2.88U
* device instance $4161 r0 *1 107.68,141.96 nfet_03v3
M$4161 VSS A|Y$323 \$1978 VSS nfet_03v3 L=0.28U W=1U AS=0.44P AD=0.26P PS=2.88U
+ PD=1.52U
* device instance $4162 r0 *1 108.48,141.96 nfet_03v3
M$4162 A|Y$315 \$1978 VSS VSS nfet_03v3 L=0.28U W=2U AS=0.52P AD=1.02P PS=3.04U
+ PD=5.04U
* device instance $4164 r0 *1 111.04,141.96 nfet_03v3
M$4164 VSS A|Y$315 \$1980 VSS nfet_03v3 L=0.28U W=1U AS=0.44P AD=0.26P PS=2.88U
+ PD=1.52U
* device instance $4165 r0 *1 111.84,141.96 nfet_03v3
M$4165 A|Y$316 \$1980 VSS VSS nfet_03v3 L=0.28U W=2U AS=0.52P AD=1.02P PS=3.04U
+ PD=5.04U
* device instance $4167 r0 *1 114.4,141.96 nfet_03v3
M$4167 VSS A|Y$316 \$1982 VSS nfet_03v3 L=0.28U W=1U AS=0.44P AD=0.26P PS=2.88U
+ PD=1.52U
* device instance $4168 r0 *1 115.2,141.96 nfet_03v3
M$4168 A|Y$297 \$1982 VSS VSS nfet_03v3 L=0.28U W=2U AS=0.52P AD=1.02P PS=3.04U
+ PD=5.04U
* device instance $4170 r0 *1 117.76,141.96 nfet_03v3
M$4170 VSS A|Y$296 \$1983 VSS nfet_03v3 L=0.28U W=1U AS=0.44P AD=0.26P PS=2.88U
+ PD=1.52U
* device instance $4171 r0 *1 118.56,141.96 nfet_03v3
M$4171 A|Y$299 \$1983 VSS VSS nfet_03v3 L=0.28U W=2U AS=0.52P AD=1.02P PS=3.04U
+ PD=5.04U
* device instance $4173 r0 *1 121.12,141.96 nfet_03v3
M$4173 VSS A|Y$298 \$1984 VSS nfet_03v3 L=0.28U W=1U AS=0.44P AD=0.26P PS=2.88U
+ PD=1.52U
* device instance $4174 r0 *1 121.92,141.96 nfet_03v3
M$4174 A|Y$301 \$1984 VSS VSS nfet_03v3 L=0.28U W=2U AS=0.52P AD=1.02P PS=3.04U
+ PD=5.04U
* device instance $4176 r0 *1 124.48,141.96 nfet_03v3
M$4176 VSS A|Y$300 \$1985 VSS nfet_03v3 L=0.28U W=1U AS=0.44P AD=0.26P PS=2.88U
+ PD=1.52U
* device instance $4177 r0 *1 125.28,141.96 nfet_03v3
M$4177 A|Y$317 \$1985 VSS VSS nfet_03v3 L=0.28U W=2U AS=0.52P AD=1.02P PS=3.04U
+ PD=5.04U
* device instance $4179 r0 *1 127.84,141.96 nfet_03v3
M$4179 VSS A|Y$317 \$1987 VSS nfet_03v3 L=0.28U W=1U AS=0.44P AD=0.26P PS=2.88U
+ PD=1.52U
* device instance $4180 r0 *1 128.64,141.96 nfet_03v3
M$4180 A|Y$303 \$1987 VSS VSS nfet_03v3 L=0.28U W=2U AS=0.52P AD=1.02P PS=3.04U
+ PD=5.04U
* device instance $4182 r0 *1 131.2,141.96 nfet_03v3
M$4182 VSS A|Y$324 \$1988 VSS nfet_03v3 L=0.28U W=1U AS=0.44P AD=0.26P PS=2.88U
+ PD=1.52U
* device instance $4183 r0 *1 132,141.96 nfet_03v3
M$4183 A|Y$318 \$1988 VSS VSS nfet_03v3 L=0.28U W=2U AS=0.52P AD=1.02P PS=3.04U
+ PD=5.04U
* device instance $4185 r0 *1 134.56,141.96 nfet_03v3
M$4185 VSS A|Y$318 \$1990 VSS nfet_03v3 L=0.28U W=1U AS=0.44P AD=0.26P PS=2.88U
+ PD=1.52U
* device instance $4186 r0 *1 135.36,141.96 nfet_03v3
M$4186 A|Y$305 \$1990 VSS VSS nfet_03v3 L=0.28U W=2U AS=0.52P AD=1.02P PS=3.04U
+ PD=5.04U
* device instance $4188 r0 *1 137.92,141.96 nfet_03v3
M$4188 VSS A|Y$304 \$1991 VSS nfet_03v3 L=0.28U W=1U AS=0.44P AD=0.26P PS=2.88U
+ PD=1.52U
* device instance $4189 r0 *1 138.72,141.96 nfet_03v3
M$4189 A|Y$319 \$1991 VSS VSS nfet_03v3 L=0.28U W=2U AS=0.52P AD=1.02P PS=3.04U
+ PD=5.04U
* device instance $4191 r0 *1 141.28,141.96 nfet_03v3
M$4191 VSS A|Y$325 \$1993 VSS nfet_03v3 L=0.28U W=1U AS=0.44P AD=0.26P PS=2.88U
+ PD=1.52U
* device instance $4192 r0 *1 142.08,141.96 nfet_03v3
M$4192 A|Y$307 \$1993 VSS VSS nfet_03v3 L=0.28U W=2U AS=0.52P AD=1.02P PS=3.04U
+ PD=5.04U
* device instance $4194 r0 *1 149.545,141.955 nfet_03v3
M$4194 \$1995 \$1994 VSS VSS nfet_03v3 L=7.75U W=0.99U AS=0.4851P AD=0.4356P
+ PS=2.96U PD=2.86U
* device instance $4195 r0 *1 156.265,141.955 nfet_03v3
M$4195 \$1997 \$1996 VSS VSS nfet_03v3 L=3.27U W=0.99U AS=0.4851P AD=0.4356P
+ PS=2.96U PD=2.86U
* device instance $4196 r0 *1 159.625,141.96 nfet_03v3
M$4196 \$1999 \$1998 VSS VSS nfet_03v3 L=1.03U W=1U AS=0.49P AD=0.44P PS=2.98U
+ PD=2.88U
* device instance $4197 r0 *1 8.56,148.12 nfet_03v3
M$4197 VSS A|FINE_MUX[24] \$2009 VSS nfet_03v3 L=0.28U W=1U AS=0.44P AD=0.26P
+ PS=2.88U PD=1.52U
* device instance $4198 r0 *1 9.36,148.12 nfet_03v3
M$4198 A|Y$320 \$2009 VSS VSS nfet_03v3 L=0.28U W=2U AS=0.52P AD=1.02P PS=3.04U
+ PD=5.04U
* device instance $4200 r0 *1 8.985,149.8 nfet_03v3
M$4200 \$2063 \$2062 VSS VSS nfet_03v3 L=1.03U W=1U AS=0.49P AD=0.44P PS=2.98U
+ PD=2.88U
* device instance $4201 r0 *1 11.36,149.8 nfet_03v3
M$4201 VSS A|Y$326 \$2064 VSS nfet_03v3 L=0.28U W=2U AS=0.7P AD=0.52P PS=4.4U
+ PD=3.04U
* device instance $4203 r0 *1 12.96,149.8 nfet_03v3
M$4203 \$2065 A|B|Y$3 \$2064 VSS nfet_03v3 L=0.28U W=2U AS=0.52P AD=0.7P
+ PS=3.04U PD=4.4U
* device instance $4205 r0 *1 12,148.12 nfet_03v3
M$4205 Y$31 C|Y$29 \$2055 VSS nfet_03v3 L=0.28U W=2U AS=0.71P AD=0.7P PS=4.42U
+ PD=4.4U
* device instance $4207 r0 *1 14.24,148.12 nfet_03v3
M$4207 \$2055 A|B|Y$3 \$2056 VSS nfet_03v3 L=0.28U W=2U AS=0.7P AD=0.52P
+ PS=4.4U PD=3.04U
* device instance $4209 r0 *1 15.84,148.12 nfet_03v3
M$4209 VSS A|Y$308 \$2056 VSS nfet_03v3 L=0.28U W=2U AS=0.52P AD=0.7P PS=3.04U
+ PD=4.4U
* device instance $4211 r0 *1 15.2,149.8 nfet_03v3
M$4211 Y$35 C|Y$32 \$2065 VSS nfet_03v3 L=0.28U W=2U AS=0.7P AD=0.71P PS=4.4U
+ PD=4.42U
* device instance $4213 r0 *1 21.305,149.795 nfet_03v3
M$4213 \$2067 \$2066 VSS VSS nfet_03v3 L=7.75U W=0.99U AS=0.4851P AD=0.4356P
+ PS=2.96U PD=2.86U
* device instance $4214 r0 *1 18.08,148.12 nfet_03v3
M$4214 C|Y$32 A|Y$326 VSS VSS nfet_03v3 L=0.28U W=2U AS=0.7P AD=0.7P PS=4.4U
+ PD=4.4U
* device instance $4216 r0 *1 24.105,148.125 nfet_03v3
M$4216 \$2013 \$2012 VSS VSS nfet_03v3 L=7.75U W=0.99U AS=0.4851P AD=0.4356P
+ PS=2.96U PD=2.86U
* device instance $4217 r0 *1 31.945,149.795 nfet_03v3
M$4217 \$2069 \$2068 VSS VSS nfet_03v3 L=7.75U W=0.99U AS=0.4851P AD=0.4356P
+ PS=2.96U PD=2.86U
* device instance $4218 r0 *1 33.065,148.125 nfet_03v3
M$4218 \$2015 \$2014 VSS VSS nfet_03v3 L=7.75U W=0.99U AS=0.4851P AD=0.4356P
+ PS=2.96U PD=2.86U
* device instance $4219 r0 *1 40.905,149.795 nfet_03v3
M$4219 \$2071 \$2070 VSS VSS nfet_03v3 L=7.75U W=0.99U AS=0.4851P AD=0.4356P
+ PS=2.96U PD=2.86U
* device instance $4220 r0 *1 39.785,148.125 nfet_03v3
M$4220 \$2017 \$2016 VSS VSS nfet_03v3 L=3.27U W=0.99U AS=0.4851P AD=0.4356P
+ PS=2.96U PD=2.86U
* device instance $4221 r0 *1 43.145,148.12 nfet_03v3
M$4221 \$2019 \$2018 VSS VSS nfet_03v3 L=1.03U W=1U AS=0.49P AD=0.44P PS=2.98U
+ PD=2.88U
* device instance $4222 r0 *1 49.865,149.795 nfet_03v3
M$4222 \$2073 \$2072 VSS VSS nfet_03v3 L=7.75U W=0.99U AS=0.4851P AD=0.4356P
+ PS=2.96U PD=2.86U
* device instance $4223 r0 *1 51.545,148.125 nfet_03v3
M$4223 \$2021 \$2020 VSS VSS nfet_03v3 L=7.75U W=0.99U AS=0.4851P AD=0.4356P
+ PS=2.96U PD=2.86U
* device instance $4224 r0 *1 58.825,149.795 nfet_03v3
M$4224 \$2075 \$2074 VSS VSS nfet_03v3 L=7.75U W=0.99U AS=0.4851P AD=0.4356P
+ PS=2.96U PD=2.86U
* device instance $4225 r0 *1 60.505,148.125 nfet_03v3
M$4225 \$2023 \$2022 VSS VSS nfet_03v3 L=7.75U W=0.99U AS=0.4851P AD=0.4356P
+ PS=2.96U PD=2.86U
* device instance $4226 r0 *1 64.425,149.8 nfet_03v3
M$4226 \$2077 \$2076 VSS VSS nfet_03v3 L=1.03U W=1U AS=0.49P AD=0.44P PS=2.98U
+ PD=2.88U
* device instance $4227 r0 *1 66.105,148.12 nfet_03v3
M$4227 \$2025 \$2024 VSS VSS nfet_03v3 L=1.03U W=1U AS=0.49P AD=0.44P PS=2.98U
+ PD=2.88U
* device instance $4228 r0 *1 69.04,148.12 nfet_03v3
M$4228 VSS A|Y$321 \$2058 VSS nfet_03v3 L=0.28U W=2U AS=0.7P AD=0.52P PS=4.4U
+ PD=3.04U
* device instance $4230 r0 *1 70.64,148.12 nfet_03v3
M$4230 \$2059 A|B|Y$3 \$2058 VSS nfet_03v3 L=0.28U W=2U AS=0.52P AD=0.7P
+ PS=3.04U PD=4.4U
* device instance $4232 r0 *1 69.12,149.8 nfet_03v3
M$4232 Y$34 C|Y$33 \$2078 VSS nfet_03v3 L=0.28U W=2U AS=0.71P AD=0.7P PS=4.42U
+ PD=4.4U
* device instance $4234 r0 *1 71.36,149.8 nfet_03v3
M$4234 \$2078 A|B|Y$3 \$2081 VSS nfet_03v3 L=0.28U W=2U AS=0.7P AD=0.52P
+ PS=4.4U PD=3.04U
* device instance $4236 r0 *1 72.96,149.8 nfet_03v3
M$4236 VSS A|Y$330 \$2081 VSS nfet_03v3 L=0.28U W=2U AS=0.52P AD=0.7P PS=3.04U
+ PD=4.4U
* device instance $4238 r0 *1 72.88,148.12 nfet_03v3
M$4238 Y$32 C|Y$30 \$2059 VSS nfet_03v3 L=0.28U W=2U AS=0.7P AD=0.71P PS=4.4U
+ PD=4.42U
* device instance $4240 r0 *1 75.2,148.12 nfet_03v3
M$4240 VSS A|Y$322 \$2060 VSS nfet_03v3 L=0.28U W=2U AS=0.7P AD=0.52P PS=4.4U
+ PD=3.04U
* device instance $4242 r0 *1 76.8,148.12 nfet_03v3
M$4242 \$2061 A|B|Y$3 \$2060 VSS nfet_03v3 L=0.28U W=2U AS=0.52P AD=0.7P
+ PS=3.04U PD=4.4U
* device instance $4244 r0 *1 78.985,149.795 nfet_03v3
M$4244 \$2084 \$2083 VSS VSS nfet_03v3 L=7.75U W=0.99U AS=0.4851P AD=0.4356P
+ PS=2.96U PD=2.86U
* device instance $4245 r0 *1 79.04,148.12 nfet_03v3
M$4245 Y$33 C|Y$31 \$2061 VSS nfet_03v3 L=0.28U W=2U AS=0.7P AD=0.71P PS=4.4U
+ PD=4.42U
* device instance $4247 r0 *1 82.905,148.125 nfet_03v3
M$4247 \$2029 \$2028 VSS VSS nfet_03v3 L=3.27U W=0.99U AS=0.4851P AD=0.4356P
+ PS=2.96U PD=2.86U
* device instance $4248 r0 *1 87.945,149.795 nfet_03v3
M$4248 \$2086 \$2085 VSS VSS nfet_03v3 L=7.75U W=0.99U AS=0.4851P AD=0.4356P
+ PS=2.96U PD=2.86U
* device instance $4249 r0 *1 88.505,148.125 nfet_03v3
M$4249 \$2031 \$2030 VSS VSS nfet_03v3 L=3.27U W=0.99U AS=0.4851P AD=0.4356P
+ PS=2.96U PD=2.86U
* device instance $4250 r0 *1 91.865,148.12 nfet_03v3
M$4250 \$2033 \$2032 VSS VSS nfet_03v3 L=1.03U W=1U AS=0.49P AD=0.44P PS=2.98U
+ PD=2.88U
* device instance $4251 r0 *1 96.905,149.795 nfet_03v3
M$4251 \$2088 \$2087 VSS VSS nfet_03v3 L=7.75U W=0.99U AS=0.4851P AD=0.4356P
+ PS=2.96U PD=2.86U
* device instance $4252 r0 *1 94,148.12 nfet_03v3
M$4252 A|Y$327 \$2034 VSS VSS nfet_03v3 L=0.28U W=2U AS=1.02P AD=0.52P PS=5.04U
+ PD=3.04U
* device instance $4254 r0 *1 95.6,148.12 nfet_03v3
M$4254 \$2034 A|Y$310 VSS VSS nfet_03v3 L=0.28U W=1U AS=0.26P AD=0.44P PS=1.52U
+ PD=2.88U
* device instance $4255 r0 *1 97.04,148.12 nfet_03v3
M$4255 VSS A|Y$327 \$2036 VSS nfet_03v3 L=0.28U W=1U AS=0.44P AD=0.26P PS=2.88U
+ PD=1.52U
* device instance $4256 r0 *1 97.84,148.12 nfet_03v3
M$4256 A|Y$328 \$2036 VSS VSS nfet_03v3 L=0.28U W=2U AS=0.52P AD=1.02P PS=3.04U
+ PD=5.04U
* device instance $4258 r0 *1 100.4,148.12 nfet_03v3
M$4258 VSS A|Y$328 \$2038 VSS nfet_03v3 L=0.28U W=1U AS=0.44P AD=0.26P PS=2.88U
+ PD=1.52U
* device instance $4259 r0 *1 101.2,148.12 nfet_03v3
M$4259 A|Y$312 \$2038 VSS VSS nfet_03v3 L=0.28U W=2U AS=0.52P AD=1.02P PS=3.04U
+ PD=5.04U
* device instance $4261 r0 *1 102.505,149.8 nfet_03v3
M$4261 \$2090 \$2089 VSS VSS nfet_03v3 L=1.03U W=1U AS=0.49P AD=0.44P PS=2.98U
+ PD=2.88U
* device instance $4262 r0 *1 103.76,148.12 nfet_03v3
M$4262 VSS A|Y$311 \$2039 VSS nfet_03v3 L=0.28U W=1U AS=0.44P AD=0.26P PS=2.88U
+ PD=1.52U
* device instance $4263 r0 *1 104.56,148.12 nfet_03v3
M$4263 A|Y$314 \$2039 VSS VSS nfet_03v3 L=0.28U W=2U AS=0.52P AD=1.02P PS=3.04U
+ PD=5.04U
* device instance $4265 r0 *1 110.345,149.795 nfet_03v3
M$4265 \$2092 \$2091 VSS VSS nfet_03v3 L=7.75U W=0.99U AS=0.4851P AD=0.4356P
+ PS=2.96U PD=2.86U
* device instance $4266 r0 *1 107.12,148.12 nfet_03v3
M$4266 VSS A|Y$313 \$2040 VSS nfet_03v3 L=0.28U W=1U AS=0.44P AD=0.26P PS=2.88U
+ PD=1.52U
* device instance $4267 r0 *1 107.92,148.12 nfet_03v3
M$4267 A|Y$323 \$2040 VSS VSS nfet_03v3 L=0.28U W=2U AS=0.52P AD=1.02P PS=3.04U
+ PD=5.04U
* device instance $4269 r0 *1 114.265,148.125 nfet_03v3
M$4269 \$2042 \$2041 VSS VSS nfet_03v3 L=7.75U W=0.99U AS=0.4851P AD=0.4356P
+ PS=2.96U PD=2.86U
* device instance $4270 r0 *1 119.305,149.795 nfet_03v3
M$4270 \$2094 \$2093 VSS VSS nfet_03v3 L=7.75U W=0.99U AS=0.4851P AD=0.4356P
+ PS=2.96U PD=2.86U
* device instance $4271 r0 *1 120.985,148.125 nfet_03v3
M$4271 \$2044 \$2043 VSS VSS nfet_03v3 L=3.27U W=0.99U AS=0.4851P AD=0.4356P
+ PS=2.96U PD=2.86U
* device instance $4272 r0 *1 128.265,149.795 nfet_03v3
M$4272 \$2096 \$2095 VSS VSS nfet_03v3 L=7.75U W=0.99U AS=0.4851P AD=0.4356P
+ PS=2.96U PD=2.86U
* device instance $4273 r0 *1 127.28,148.12 nfet_03v3
M$4273 VSS A|Y$302 \$2045 VSS nfet_03v3 L=0.28U W=1U AS=0.44P AD=0.26P PS=2.88U
+ PD=1.52U
* device instance $4274 r0 *1 128.08,148.12 nfet_03v3
M$4274 A|Y$324 \$2045 VSS VSS nfet_03v3 L=0.28U W=2U AS=0.52P AD=1.02P PS=3.04U
+ PD=5.04U
* device instance $4276 r0 *1 132.185,148.125 nfet_03v3
M$4276 \$2047 \$2046 VSS VSS nfet_03v3 L=3.27U W=0.99U AS=0.4851P AD=0.4356P
+ PS=2.96U PD=2.86U
* device instance $4277 r0 *1 137.225,149.795 nfet_03v3
M$4277 \$2098 \$2097 VSS VSS nfet_03v3 L=7.75U W=0.99U AS=0.4851P AD=0.4356P
+ PS=2.96U PD=2.86U
* device instance $4278 r0 *1 137.12,148.12 nfet_03v3
M$4278 A|Y$329 \$2048 VSS VSS nfet_03v3 L=0.28U W=2U AS=1.02P AD=0.52P PS=5.04U
+ PD=3.04U
* device instance $4280 r0 *1 138.72,148.12 nfet_03v3
M$4280 \$2048 A|Y$319 VSS VSS nfet_03v3 L=0.28U W=1U AS=0.26P AD=0.44P PS=1.52U
+ PD=2.88U
* device instance $4281 r0 *1 140.16,148.12 nfet_03v3
M$4281 VSS A|Y$329 \$2050 VSS nfet_03v3 L=0.28U W=1U AS=0.44P AD=0.26P PS=2.88U
+ PD=1.52U
* device instance $4282 r0 *1 140.96,148.12 nfet_03v3
M$4282 A|Y$325 \$2050 VSS VSS nfet_03v3 L=0.28U W=2U AS=0.52P AD=1.02P PS=3.04U
+ PD=5.04U
* device instance $4284 r0 *1 142.825,149.8 nfet_03v3
M$4284 \$2100 \$2099 VSS VSS nfet_03v3 L=1.03U W=1U AS=0.49P AD=0.44P PS=2.98U
+ PD=2.88U
* device instance $4285 r0 *1 147.305,148.125 nfet_03v3
M$4285 \$2052 \$2051 VSS VSS nfet_03v3 L=7.75U W=0.99U AS=0.4851P AD=0.4356P
+ PS=2.96U PD=2.86U
* device instance $4286 r0 *1 149.545,149.795 nfet_03v3
M$4286 \$2102 \$2101 VSS VSS nfet_03v3 L=7.75U W=0.99U AS=0.4851P AD=0.4356P
+ PS=2.96U PD=2.86U
* device instance $4287 r0 *1 156.265,148.125 nfet_03v3
M$4287 \$2054 \$2053 VSS VSS nfet_03v3 L=7.75U W=0.99U AS=0.4851P AD=0.4356P
+ PS=2.96U PD=2.86U
* device instance $4288 r0 *1 156.265,149.795 nfet_03v3
M$4288 \$2104 \$2103 VSS VSS nfet_03v3 L=3.27U W=0.99U AS=0.4851P AD=0.4356P
+ PS=2.96U PD=2.86U
* device instance $4289 r0 *1 159.625,149.8 nfet_03v3
M$4289 \$2106 \$2105 VSS VSS nfet_03v3 L=1.03U W=1U AS=0.49P AD=0.44P PS=2.98U
+ PD=2.88U
* device instance $4290 r0 *1 8.56,155.96 nfet_03v3
M$4290 VSS A|FINE_MUX[18] \$2108 VSS nfet_03v3 L=0.28U W=1U AS=0.44P AD=0.26P
+ PS=2.88U PD=1.52U
* device instance $4291 r0 *1 9.36,155.96 nfet_03v3
M$4291 A|Y$326 \$2108 VSS VSS nfet_03v3 L=0.28U W=2U AS=0.52P AD=1.02P PS=3.04U
+ PD=5.04U
* device instance $4293 r0 *1 15.705,155.965 nfet_03v3
M$4293 \$2110 \$2109 VSS VSS nfet_03v3 L=7.75U W=0.99U AS=0.4851P AD=0.4356P
+ PS=2.96U PD=2.86U
* device instance $4294 r0 *1 24.665,155.965 nfet_03v3
M$4294 \$2112 \$2111 VSS VSS nfet_03v3 L=7.75U W=0.99U AS=0.4851P AD=0.4356P
+ PS=2.96U PD=2.86U
* device instance $4295 r0 *1 33.625,155.965 nfet_03v3
M$4295 \$2114 \$2113 VSS VSS nfet_03v3 L=7.75U W=0.99U AS=0.4851P AD=0.4356P
+ PS=2.96U PD=2.86U
* device instance $4296 r0 *1 40.345,155.965 nfet_03v3
M$4296 \$2116 \$2115 VSS VSS nfet_03v3 L=3.27U W=0.99U AS=0.4851P AD=0.4356P
+ PS=2.96U PD=2.86U
* device instance $4297 r0 *1 43.705,155.96 nfet_03v3
M$4297 \$2118 \$2117 VSS VSS nfet_03v3 L=1.03U W=1U AS=0.49P AD=0.44P PS=2.98U
+ PD=2.88U
* device instance $4298 r0 *1 48.185,155.96 nfet_03v3
M$4298 \$2120 \$2119 VSS VSS nfet_03v3 L=1.03U W=1U AS=0.49P AD=0.44P PS=2.98U
+ PD=2.88U
* device instance $4299 r0 *1 51.2,155.96 nfet_03v3
M$4299 Y$36 C|Y$37 \$2155 VSS nfet_03v3 L=0.28U W=2U AS=0.71P AD=0.7P PS=4.42U
+ PD=4.4U
* device instance $4301 r0 *1 53.44,155.96 nfet_03v3
M$4301 \$2155 A|B|Y$3 \$2156 VSS nfet_03v3 L=0.28U W=2U AS=0.7P AD=0.52P
+ PS=4.4U PD=3.04U
* device instance $4303 r0 *1 55.04,155.96 nfet_03v3
M$4303 VSS A|Y$331 \$2156 VSS nfet_03v3 L=0.28U W=2U AS=0.52P AD=0.7P PS=3.04U
+ PD=4.4U
* device instance $4305 r0 *1 57.28,155.96 nfet_03v3
M$4305 VSS A|FINE_MUX[9] \$2122 VSS nfet_03v3 L=0.28U W=1U AS=0.44P AD=0.26P
+ PS=2.88U PD=1.52U
* device instance $4306 r0 *1 58.08,155.96 nfet_03v3
M$4306 A|Y$331 \$2122 VSS VSS nfet_03v3 L=0.28U W=2U AS=0.52P AD=1.02P PS=3.04U
+ PD=5.04U
* device instance $4308 r0 *1 61.065,155.96 nfet_03v3
M$4308 \$2124 \$2123 VSS VSS nfet_03v3 L=1.03U W=1U AS=0.49P AD=0.44P PS=2.98U
+ PD=2.88U
* device instance $4309 r0 *1 63.44,155.96 nfet_03v3
M$4309 C|Y$34 A|Y$332 VSS VSS nfet_03v3 L=0.28U W=2U AS=0.7P AD=0.7P PS=4.4U
+ PD=4.4U
* device instance $4311 r0 *1 67.225,155.965 nfet_03v3
M$4311 \$2127 \$2126 VSS VSS nfet_03v3 L=3.27U W=0.99U AS=0.4851P AD=0.4356P
+ PS=2.96U PD=2.86U
* device instance $4312 r0 *1 71.28,155.96 nfet_03v3
M$4312 C|Y$33 A|Y$330 VSS VSS nfet_03v3 L=0.28U W=2U AS=0.7P AD=0.7P PS=4.4U
+ PD=4.4U
* device instance $4314 r0 *1 75.065,155.965 nfet_03v3
M$4314 \$2129 \$2128 VSS VSS nfet_03v3 L=3.27U W=0.99U AS=0.4851P AD=0.4356P
+ PS=2.96U PD=2.86U
* device instance $4315 r0 *1 78.56,155.96 nfet_03v3
M$4315 C|Y$35 A|Y$340 VSS VSS nfet_03v3 L=0.28U W=2U AS=0.7P AD=0.7P PS=4.4U
+ PD=4.4U
* device instance $4317 r0 *1 81.225,155.96 nfet_03v3
M$4317 \$2132 \$2131 VSS VSS nfet_03v3 L=1.03U W=1U AS=0.49P AD=0.44P PS=2.98U
+ PD=2.88U
* device instance $4318 r0 *1 83.04,155.96 nfet_03v3
M$4318 C|Y$36 A|Y$341 VSS VSS nfet_03v3 L=0.28U W=2U AS=0.7P AD=0.7P PS=4.4U
+ PD=4.4U
* device instance $4320 r0 *1 86.96,155.96 nfet_03v3
M$4320 C|Y$41 A|Y$333 VSS VSS nfet_03v3 L=0.28U W=2U AS=0.7P AD=0.7P PS=4.4U
+ PD=4.4U
* device instance $4322 r0 *1 92.985,155.965 nfet_03v3
M$4322 \$2135 \$2134 VSS VSS nfet_03v3 L=7.75U W=0.99U AS=0.4851P AD=0.4356P
+ PS=2.96U PD=2.86U
* device instance $4323 r0 *1 101.945,155.965 nfet_03v3
M$4323 \$2137 \$2136 VSS VSS nfet_03v3 L=7.75U W=0.99U AS=0.4851P AD=0.4356P
+ PS=2.96U PD=2.86U
* device instance $4324 r0 *1 110.905,155.965 nfet_03v3
M$4324 \$2139 \$2138 VSS VSS nfet_03v3 L=7.75U W=0.99U AS=0.4851P AD=0.4356P
+ PS=2.96U PD=2.86U
* device instance $4325 r0 *1 119.865,155.965 nfet_03v3
M$4325 \$2141 \$2140 VSS VSS nfet_03v3 L=7.75U W=0.99U AS=0.4851P AD=0.4356P
+ PS=2.96U PD=2.86U
* device instance $4326 r0 *1 129.945,155.965 nfet_03v3
M$4326 \$2143 \$2142 VSS VSS nfet_03v3 L=7.75U W=0.99U AS=0.4851P AD=0.4356P
+ PS=2.96U PD=2.86U
* device instance $4327 r0 *1 138.905,155.965 nfet_03v3
M$4327 \$2145 \$2144 VSS VSS nfet_03v3 L=7.75U W=0.99U AS=0.4851P AD=0.4356P
+ PS=2.96U PD=2.86U
* device instance $4328 r0 *1 147.865,155.965 nfet_03v3
M$4328 \$2147 \$2146 VSS VSS nfet_03v3 L=7.75U W=0.99U AS=0.4851P AD=0.4356P
+ PS=2.96U PD=2.86U
* device instance $4329 r0 *1 156.825,155.965 nfet_03v3
M$4329 \$2149 \$2148 VSS VSS nfet_03v3 L=7.75U W=0.99U AS=0.4851P AD=0.4356P
+ PS=2.96U PD=2.86U
* device instance $4330 r0 *1 12.345,157.635 nfet_03v3
M$4330 \$2158 \$2157 VSS VSS nfet_03v3 L=7.75U W=0.99U AS=0.4851P AD=0.4356P
+ PS=2.96U PD=2.86U
* device instance $4331 r0 *1 21.305,157.635 nfet_03v3
M$4331 \$2160 \$2159 VSS VSS nfet_03v3 L=7.75U W=0.99U AS=0.4851P AD=0.4356P
+ PS=2.96U PD=2.86U
* device instance $4332 r0 *1 31.945,157.635 nfet_03v3
M$4332 \$2162 \$2161 VSS VSS nfet_03v3 L=7.75U W=0.99U AS=0.4851P AD=0.4356P
+ PS=2.96U PD=2.86U
* device instance $4333 r0 *1 40.905,157.635 nfet_03v3
M$4333 \$2164 \$2163 VSS VSS nfet_03v3 L=7.75U W=0.99U AS=0.4851P AD=0.4356P
+ PS=2.96U PD=2.86U
* device instance $4334 r0 *1 47.76,157.64 nfet_03v3
M$4334 C|Y$37 A|Y$331 VSS VSS nfet_03v3 L=0.28U W=2U AS=0.7P AD=0.7P PS=4.4U
+ PD=4.4U
* device instance $4336 r0 *1 50.32,157.64 nfet_03v3
M$4336 A|Y$338 \$2165 VSS VSS nfet_03v3 L=0.28U W=2U AS=1.02P AD=0.52P PS=5.04U
+ PD=3.04U
* device instance $4338 r0 *1 51.92,157.64 nfet_03v3
M$4338 \$2165 A|FINE_MUX[17] VSS VSS nfet_03v3 L=0.28U W=1U AS=0.26P AD=0.44P
+ PS=1.52U PD=2.88U
* device instance $4339 r0 *1 53.44,157.64 nfet_03v3
M$4339 Y$37 C|Y$38 \$2167 VSS nfet_03v3 L=0.28U W=2U AS=0.71P AD=0.7P PS=4.42U
+ PD=4.4U
* device instance $4341 r0 *1 55.68,157.64 nfet_03v3
M$4341 \$2167 A|B|Y$3 \$2170 VSS nfet_03v3 L=0.28U W=2U AS=0.7P AD=0.52P
+ PS=4.4U PD=3.04U
* device instance $4343 r0 *1 57.28,157.64 nfet_03v3
M$4343 VSS A|Y$339 \$2170 VSS nfet_03v3 L=0.28U W=2U AS=0.52P AD=0.7P PS=3.04U
+ PD=4.4U
* device instance $4345 r0 *1 60.08,157.64 nfet_03v3
M$4345 VSS A|Y$332 \$2171 VSS nfet_03v3 L=0.28U W=2U AS=0.7P AD=0.52P PS=4.4U
+ PD=3.04U
* device instance $4347 r0 *1 61.68,157.64 nfet_03v3
M$4347 \$2172 A|B|Y$3 \$2171 VSS nfet_03v3 L=0.28U W=2U AS=0.52P AD=0.7P
+ PS=3.04U PD=4.4U
* device instance $4349 r0 *1 63.92,157.64 nfet_03v3
M$4349 Y$38 C|Y$34 \$2172 VSS nfet_03v3 L=0.28U W=2U AS=0.7P AD=0.71P PS=4.4U
+ PD=4.42U
* device instance $4351 r0 *1 67.36,157.64 nfet_03v3
M$4351 C|Y$39 A|Y$334 VSS VSS nfet_03v3 L=0.28U W=2U AS=0.7P AD=0.7P PS=4.4U
+ PD=4.4U
* device instance $4353 r0 *1 69.6,157.64 nfet_03v3
M$4353 C|Y$40 A|Y$335 VSS VSS nfet_03v3 L=0.28U W=2U AS=0.7P AD=0.7P PS=4.4U
+ PD=4.4U
* device instance $4355 r0 *1 71.84,157.64 nfet_03v3
M$4355 VSS A|FINE_MUX[29] \$2177 VSS nfet_03v3 L=0.28U W=1U AS=0.44P AD=0.26P
+ PS=2.88U PD=1.52U
* device instance $4356 r0 *1 72.64,157.64 nfet_03v3
M$4356 A|Y$330 \$2177 VSS VSS nfet_03v3 L=0.28U W=2U AS=0.52P AD=1.02P PS=3.04U
+ PD=5.04U
* device instance $4358 r0 *1 76.32,157.64 nfet_03v3
M$4358 VSS A|FINE_MUX[2] \$2179 VSS nfet_03v3 L=0.28U W=1U AS=0.44P AD=0.26P
+ PS=2.88U PD=1.52U
* device instance $4359 r0 *1 77.12,157.64 nfet_03v3
M$4359 A|Y$322 \$2179 VSS VSS nfet_03v3 L=0.28U W=2U AS=0.52P AD=1.02P PS=3.04U
+ PD=5.04U
* device instance $4361 r0 *1 80.24,157.64 nfet_03v3
M$4361 VSS A|Y$333 \$2181 VSS nfet_03v3 L=0.28U W=2U AS=0.7P AD=0.52P PS=4.4U
+ PD=3.04U
* device instance $4363 r0 *1 81.84,157.64 nfet_03v3
M$4363 \$2182 A|B|Y$3 \$2181 VSS nfet_03v3 L=0.28U W=2U AS=0.52P AD=0.7P
+ PS=3.04U PD=4.4U
* device instance $4365 r0 *1 84.08,157.64 nfet_03v3
M$4365 Y$39 C|Y$41 \$2182 VSS nfet_03v3 L=0.28U W=2U AS=0.7P AD=0.71P PS=4.4U
+ PD=4.42U
* device instance $4367 r0 *1 86.4,157.64 nfet_03v3
M$4367 VSS A|Y$336 \$2184 VSS nfet_03v3 L=0.28U W=2U AS=0.7P AD=0.52P PS=4.4U
+ PD=3.04U
* device instance $4369 r0 *1 88,157.64 nfet_03v3
M$4369 \$2186 A|B|Y$3 \$2184 VSS nfet_03v3 L=0.28U W=2U AS=0.52P AD=0.7P
+ PS=3.04U PD=4.4U
* device instance $4371 r0 *1 90.24,157.64 nfet_03v3
M$4371 Y$40 C|Y$42 \$2186 VSS nfet_03v3 L=0.28U W=2U AS=0.7P AD=0.71P PS=4.4U
+ PD=4.42U
* device instance $4373 r0 *1 96.345,157.635 nfet_03v3
M$4373 \$2189 \$2188 VSS VSS nfet_03v3 L=7.75U W=0.99U AS=0.4851P AD=0.4356P
+ PS=2.96U PD=2.86U
* device instance $4374 r0 *1 101.945,157.64 nfet_03v3
M$4374 \$2191 \$2190 VSS VSS nfet_03v3 L=1.03U W=1U AS=0.49P AD=0.44P PS=2.98U
+ PD=2.88U
* device instance $4375 r0 *1 110.345,157.635 nfet_03v3
M$4375 \$2193 \$2192 VSS VSS nfet_03v3 L=7.75U W=0.99U AS=0.4851P AD=0.4356P
+ PS=2.96U PD=2.86U
* device instance $4376 r0 *1 119.305,157.635 nfet_03v3
M$4376 \$2195 \$2194 VSS VSS nfet_03v3 L=7.75U W=0.99U AS=0.4851P AD=0.4356P
+ PS=2.96U PD=2.86U
* device instance $4377 r0 *1 128.265,157.635 nfet_03v3
M$4377 \$2197 \$2196 VSS VSS nfet_03v3 L=7.75U W=0.99U AS=0.4851P AD=0.4356P
+ PS=2.96U PD=2.86U
* device instance $4378 r0 *1 137.225,157.635 nfet_03v3
M$4378 \$2199 \$2198 VSS VSS nfet_03v3 L=7.75U W=0.99U AS=0.4851P AD=0.4356P
+ PS=2.96U PD=2.86U
* device instance $4379 r0 *1 142.825,157.64 nfet_03v3
M$4379 \$2201 \$2200 VSS VSS nfet_03v3 L=1.03U W=1U AS=0.49P AD=0.44P PS=2.98U
+ PD=2.88U
* device instance $4380 r0 *1 149.545,157.635 nfet_03v3
M$4380 \$2203 \$2202 VSS VSS nfet_03v3 L=7.75U W=0.99U AS=0.4851P AD=0.4356P
+ PS=2.96U PD=2.86U
* device instance $4381 r0 *1 156.265,157.635 nfet_03v3
M$4381 \$2205 \$2204 VSS VSS nfet_03v3 L=3.27U W=0.99U AS=0.4851P AD=0.4356P
+ PS=2.96U PD=2.86U
* device instance $4382 r0 *1 159.625,157.64 nfet_03v3
M$4382 \$2207 \$2206 VSS VSS nfet_03v3 L=1.03U W=1U AS=0.49P AD=0.44P PS=2.98U
+ PD=2.88U
* device instance $4383 r0 *1 12.345,163.805 nfet_03v3
M$4383 \$2226 \$2212 VSS VSS nfet_03v3 L=7.75U W=0.99U AS=0.4851P AD=0.4356P
+ PS=2.96U PD=2.86U
* device instance $4384 r0 *1 21.305,163.805 nfet_03v3
M$4384 \$2227 \$2213 VSS VSS nfet_03v3 L=7.75U W=0.99U AS=0.4851P AD=0.4356P
+ PS=2.96U PD=2.86U
* device instance $4385 r0 *1 30.265,163.805 nfet_03v3
M$4385 \$2228 \$2214 VSS VSS nfet_03v3 L=7.75U W=0.99U AS=0.4851P AD=0.4356P
+ PS=2.96U PD=2.86U
* device instance $4386 r0 *1 36.985,163.805 nfet_03v3
M$4386 \$2229 \$2215 VSS VSS nfet_03v3 L=3.27U W=0.99U AS=0.4851P AD=0.4356P
+ PS=2.96U PD=2.86U
* device instance $4387 r0 *1 40.345,163.8 nfet_03v3
M$4387 \$2230 \$2216 VSS VSS nfet_03v3 L=1.03U W=1U AS=0.49P AD=0.44P PS=2.98U
+ PD=2.88U
* device instance $4388 r0 *1 42.16,163.8 nfet_03v3
M$4388 C|Y$43 A|Y$337 VSS VSS nfet_03v3 L=0.28U W=2U AS=0.7P AD=0.7P PS=4.4U
+ PD=4.4U
* device instance $4390 r0 *1 44.4,163.8 nfet_03v3
M$4390 C|Y$44 A|Y$338 VSS VSS nfet_03v3 L=0.28U W=2U AS=0.7P AD=0.7P PS=4.4U
+ PD=4.4U
* device instance $4392 r0 *1 49.44,163.8 nfet_03v3
M$4392 VSS A|Y$338 \$2256 VSS nfet_03v3 L=0.28U W=2U AS=0.7P AD=0.52P PS=4.4U
+ PD=3.04U
* device instance $4394 r0 *1 51.04,163.8 nfet_03v3
M$4394 \$2257 A|B|Y$3 \$2256 VSS nfet_03v3 L=0.28U W=2U AS=0.52P AD=0.7P
+ PS=3.04U PD=4.4U
* device instance $4396 r0 *1 53.28,163.8 nfet_03v3
M$4396 Y$41 C|Y$44 \$2257 VSS nfet_03v3 L=0.28U W=2U AS=0.7P AD=0.71P PS=4.4U
+ PD=4.42U
* device instance $4398 r0 *1 55.6,163.8 nfet_03v3
M$4398 C|Y$38 A|Y$339 VSS VSS nfet_03v3 L=0.28U W=2U AS=0.7P AD=0.7P PS=4.4U
+ PD=4.4U
* device instance $4400 r0 *1 57.84,163.8 nfet_03v3
M$4400 VSS A|FINE_MUX[27] \$2237 VSS nfet_03v3 L=0.28U W=1U AS=0.44P AD=0.26P
+ PS=2.88U PD=1.52U
* device instance $4401 r0 *1 58.64,163.8 nfet_03v3
M$4401 A|Y$339 \$2237 VSS VSS nfet_03v3 L=0.28U W=2U AS=0.52P AD=1.02P PS=3.04U
+ PD=5.04U
* device instance $4403 r0 *1 61.2,163.8 nfet_03v3
M$4403 VSS A|Y$334 \$2258 VSS nfet_03v3 L=0.28U W=2U AS=0.7P AD=0.52P PS=4.4U
+ PD=3.04U
* device instance $4405 r0 *1 62.8,163.8 nfet_03v3
M$4405 \$2259 A|B|Y$3 \$2258 VSS nfet_03v3 L=0.28U W=2U AS=0.52P AD=0.7P
+ PS=3.04U PD=4.4U
* device instance $4407 r0 *1 65.04,163.8 nfet_03v3
M$4407 Y$42 C|Y$39 \$2259 VSS nfet_03v3 L=0.28U W=2U AS=0.7P AD=0.71P PS=4.4U
+ PD=4.42U
* device instance $4409 r0 *1 67.36,163.8 nfet_03v3
M$4409 VSS A|Y$335 \$2260 VSS nfet_03v3 L=0.28U W=2U AS=0.7P AD=0.52P PS=4.4U
+ PD=3.04U
* device instance $4411 r0 *1 68.96,163.8 nfet_03v3
M$4411 \$2261 A|B|Y$3 \$2260 VSS nfet_03v3 L=0.28U W=2U AS=0.52P AD=0.7P
+ PS=3.04U PD=4.4U
* device instance $4413 r0 *1 71.2,163.8 nfet_03v3
M$4413 Y$43 C|Y$40 \$2261 VSS nfet_03v3 L=0.28U W=2U AS=0.7P AD=0.71P PS=4.4U
+ PD=4.42U
* device instance $4415 r0 *1 73.52,163.8 nfet_03v3
M$4415 VSS A|Y$340 \$2262 VSS nfet_03v3 L=0.28U W=2U AS=0.7P AD=0.52P PS=4.4U
+ PD=3.04U
* device instance $4417 r0 *1 75.12,163.8 nfet_03v3
M$4417 \$2263 A|B|Y$3 \$2262 VSS nfet_03v3 L=0.28U W=2U AS=0.52P AD=0.7P
+ PS=3.04U PD=4.4U
* device instance $4419 r0 *1 77.36,163.8 nfet_03v3
M$4419 Y$44 C|Y$35 \$2263 VSS nfet_03v3 L=0.28U W=2U AS=0.7P AD=0.71P PS=4.4U
+ PD=4.42U
* device instance $4421 r0 *1 79.68,163.8 nfet_03v3
M$4421 VSS A|Y$341 \$2264 VSS nfet_03v3 L=0.28U W=2U AS=0.7P AD=0.52P PS=4.4U
+ PD=3.04U
* device instance $4423 r0 *1 81.28,163.8 nfet_03v3
M$4423 \$2265 A|B|Y$3 \$2264 VSS nfet_03v3 L=0.28U W=2U AS=0.52P AD=0.7P
+ PS=3.04U PD=4.4U
* device instance $4425 r0 *1 83.52,163.8 nfet_03v3
M$4425 Y$45 C|Y$36 \$2265 VSS nfet_03v3 L=0.28U W=2U AS=0.7P AD=0.71P PS=4.4U
+ PD=4.42U
* device instance $4427 r0 *1 87.52,163.8 nfet_03v3
M$4427 VSS A|Y$342 \$2266 VSS nfet_03v3 L=0.28U W=2U AS=0.7P AD=0.52P PS=4.4U
+ PD=3.04U
* device instance $4429 r0 *1 89.12,163.8 nfet_03v3
M$4429 \$2267 A|B|Y$3 \$2266 VSS nfet_03v3 L=0.28U W=2U AS=0.52P AD=0.7P
+ PS=3.04U PD=4.4U
* device instance $4431 r0 *1 91.36,163.8 nfet_03v3
M$4431 Y$46 C|Y$45 \$2267 VSS nfet_03v3 L=0.28U W=2U AS=0.7P AD=0.71P PS=4.4U
+ PD=4.42U
* device instance $4433 r0 *1 93.68,163.8 nfet_03v3
M$4433 C|Y$42 A|Y$336 VSS VSS nfet_03v3 L=0.28U W=2U AS=0.7P AD=0.7P PS=4.4U
+ PD=4.4U
* device instance $4435 r0 *1 99.705,163.805 nfet_03v3
M$4435 \$2248 \$2217 VSS VSS nfet_03v3 L=7.75U W=0.99U AS=0.4851P AD=0.4356P
+ PS=2.96U PD=2.86U
* device instance $4436 r0 *1 108.665,163.805 nfet_03v3
M$4436 \$2249 \$2218 VSS VSS nfet_03v3 L=7.75U W=0.99U AS=0.4851P AD=0.4356P
+ PS=2.96U PD=2.86U
* device instance $4437 r0 *1 117.625,163.805 nfet_03v3
M$4437 \$2250 \$2219 VSS VSS nfet_03v3 L=7.75U W=0.99U AS=0.4851P AD=0.4356P
+ PS=2.96U PD=2.86U
* device instance $4438 r0 *1 123.225,163.8 nfet_03v3
M$4438 \$2251 \$2220 VSS VSS nfet_03v3 L=1.03U W=1U AS=0.49P AD=0.44P PS=2.98U
+ PD=2.88U
* device instance $4439 r0 *1 129.945,163.805 nfet_03v3
M$4439 \$2252 \$2221 VSS VSS nfet_03v3 L=7.75U W=0.99U AS=0.4851P AD=0.4356P
+ PS=2.96U PD=2.86U
* device instance $4440 r0 *1 138.905,163.805 nfet_03v3
M$4440 \$2253 \$2222 VSS VSS nfet_03v3 L=7.75U W=0.99U AS=0.4851P AD=0.4356P
+ PS=2.96U PD=2.86U
* device instance $4441 r0 *1 147.865,163.805 nfet_03v3
M$4441 \$2254 \$2223 VSS VSS nfet_03v3 L=7.75U W=0.99U AS=0.4851P AD=0.4356P
+ PS=2.96U PD=2.86U
* device instance $4442 r0 *1 156.825,163.805 nfet_03v3
M$4442 \$2255 \$2224 VSS VSS nfet_03v3 L=7.75U W=0.99U AS=0.4851P AD=0.4356P
+ PS=2.96U PD=2.86U
* device instance $4443 r0 *1 12.345,165.475 nfet_03v3
M$4443 \$2273 \$2272 VSS VSS nfet_03v3 L=7.75U W=0.99U AS=0.4851P AD=0.4356P
+ PS=2.96U PD=2.86U
* device instance $4444 r0 *1 21.305,165.475 nfet_03v3
M$4444 \$2275 \$2274 VSS VSS nfet_03v3 L=7.75U W=0.99U AS=0.4851P AD=0.4356P
+ PS=2.96U PD=2.86U
* device instance $4445 r0 *1 31.385,165.475 nfet_03v3
M$4445 \$2277 \$2276 VSS VSS nfet_03v3 L=7.75U W=0.99U AS=0.4851P AD=0.4356P
+ PS=2.96U PD=2.86U
* device instance $4446 r0 *1 38.105,165.475 nfet_03v3
M$4446 \$2279 \$2278 VSS VSS nfet_03v3 L=3.27U W=0.99U AS=0.4851P AD=0.4356P
+ PS=2.96U PD=2.86U
* device instance $4447 r0 *1 42.48,165.48 nfet_03v3
M$4447 A|Y$337 \$2280 VSS VSS nfet_03v3 L=0.28U W=2U AS=1.02P AD=0.52P PS=5.04U
+ PD=3.04U
* device instance $4449 r0 *1 44.08,165.48 nfet_03v3
M$4449 \$2280 A|FINE_MUX[23] VSS VSS nfet_03v3 L=0.28U W=1U AS=0.26P AD=0.44P
+ PS=1.52U PD=2.88U
* device instance $4450 r0 *1 47.76,165.48 nfet_03v3
M$4450 VSS A|Y$337 \$2268 VSS nfet_03v3 L=0.28U W=2U AS=0.7P AD=0.52P PS=4.4U
+ PD=3.04U
* device instance $4452 r0 *1 49.36,165.48 nfet_03v3
M$4452 \$2269 A|B|Y$3 \$2268 VSS nfet_03v3 L=0.28U W=2U AS=0.52P AD=0.7P
+ PS=3.04U PD=4.4U
* device instance $4454 r0 *1 51.6,165.48 nfet_03v3
M$4454 Y$47 C|Y$43 \$2269 VSS nfet_03v3 L=0.28U W=2U AS=0.7P AD=0.71P PS=4.4U
+ PD=4.42U
* device instance $4456 r0 *1 54.8,165.48 nfet_03v3
M$4456 A|Y$332 \$2282 VSS VSS nfet_03v3 L=0.28U W=2U AS=1.02P AD=0.52P PS=5.04U
+ PD=3.04U
* device instance $4458 r0 *1 56.4,165.48 nfet_03v3
M$4458 \$2282 A|FINE_MUX[30] VSS VSS nfet_03v3 L=0.28U W=1U AS=0.26P AD=0.44P
+ PS=1.52U PD=2.88U
* device instance $4459 r0 *1 58.16,165.48 nfet_03v3
M$4459 A|Y$334 \$2284 VSS VSS nfet_03v3 L=0.28U W=2U AS=1.02P AD=0.52P PS=5.04U
+ PD=3.04U
* device instance $4461 r0 *1 59.76,165.48 nfet_03v3
M$4461 \$2284 A|FINE_MUX[6] VSS VSS nfet_03v3 L=0.28U W=1U AS=0.26P AD=0.44P
+ PS=1.52U PD=2.88U
* device instance $4462 r0 *1 61.52,165.48 nfet_03v3
M$4462 A|Y$335 \$2286 VSS VSS nfet_03v3 L=0.28U W=2U AS=1.02P AD=0.52P PS=5.04U
+ PD=3.04U
* device instance $4464 r0 *1 63.12,165.48 nfet_03v3
M$4464 \$2286 A|FINE_MUX[13] VSS VSS nfet_03v3 L=0.28U W=1U AS=0.26P AD=0.44P
+ PS=1.52U PD=2.88U
* device instance $4465 r0 *1 67.12,165.48 nfet_03v3
M$4465 A|Y$321 \$2288 VSS VSS nfet_03v3 L=0.28U W=2U AS=1.02P AD=0.52P PS=5.04U
+ PD=3.04U
* device instance $4467 r0 *1 68.72,165.48 nfet_03v3
M$4467 \$2288 A|FINE_MUX[12] VSS VSS nfet_03v3 L=0.28U W=1U AS=0.26P AD=0.44P
+ PS=1.52U PD=2.88U
* device instance $4468 r0 *1 70.48,165.48 nfet_03v3
M$4468 A|Y$340 \$2290 VSS VSS nfet_03v3 L=0.28U W=2U AS=1.02P AD=0.52P PS=5.04U
+ PD=3.04U
* device instance $4470 r0 *1 72.08,165.48 nfet_03v3
M$4470 \$2290 A|FINE_MUX[14] VSS VSS nfet_03v3 L=0.28U W=1U AS=0.26P AD=0.44P
+ PS=1.52U PD=2.88U
* device instance $4471 r0 *1 73.84,165.48 nfet_03v3
M$4471 A|Y$341 \$2292 VSS VSS nfet_03v3 L=0.28U W=2U AS=1.02P AD=0.52P PS=5.04U
+ PD=3.04U
* device instance $4473 r0 *1 75.44,165.48 nfet_03v3
M$4473 \$2292 A|FINE_MUX[16] VSS VSS nfet_03v3 L=0.28U W=1U AS=0.26P AD=0.44P
+ PS=1.52U PD=2.88U
* device instance $4474 r0 *1 77.2,165.48 nfet_03v3
M$4474 A|Y$333 \$2294 VSS VSS nfet_03v3 L=0.28U W=2U AS=1.02P AD=0.52P PS=5.04U
+ PD=3.04U
* device instance $4476 r0 *1 78.8,165.48 nfet_03v3
M$4476 \$2294 A|FINE_MUX[21] VSS VSS nfet_03v3 L=0.28U W=1U AS=0.26P AD=0.44P
+ PS=1.52U PD=2.88U
* device instance $4477 r0 *1 80.56,165.48 nfet_03v3
M$4477 A|Y$336 \$2296 VSS VSS nfet_03v3 L=0.28U W=2U AS=1.02P AD=0.52P PS=5.04U
+ PD=3.04U
* device instance $4479 r0 *1 82.16,165.48 nfet_03v3
M$4479 \$2296 A|FINE_MUX[11] VSS VSS nfet_03v3 L=0.28U W=1U AS=0.26P AD=0.44P
+ PS=1.52U PD=2.88U
* device instance $4480 r0 *1 84.72,165.48 nfet_03v3
M$4480 VSS A|FINE_MUX[5] \$2270 VSS nfet_03v3 L=0.28U W=1U AS=0.44P AD=0.26P
+ PS=2.88U PD=1.52U
* device instance $4481 r0 *1 85.52,165.48 nfet_03v3
M$4481 A|Y$342 \$2270 VSS VSS nfet_03v3 L=0.28U W=2U AS=0.52P AD=1.02P PS=3.04U
+ PD=5.04U
* device instance $4483 r0 *1 89.2,165.48 nfet_03v3
M$4483 C|Y$45 A|Y$342 VSS VSS nfet_03v3 L=0.28U W=2U AS=0.7P AD=0.7P PS=4.4U
+ PD=4.4U
* device instance $4485 r0 *1 95.225,165.475 nfet_03v3
M$4485 \$2300 \$2299 VSS VSS nfet_03v3 L=7.75U W=0.99U AS=0.4851P AD=0.4356P
+ PS=2.96U PD=2.86U
* device instance $4486 r0 *1 100.825,165.48 nfet_03v3
M$4486 \$2271 \$2301 VSS VSS nfet_03v3 L=1.03U W=1U AS=0.49P AD=0.44P PS=2.98U
+ PD=2.88U
* device instance $4487 r0 *1 107.545,165.475 nfet_03v3
M$4487 \$2303 \$2302 VSS VSS nfet_03v3 L=7.75U W=0.99U AS=0.4851P AD=0.4356P
+ PS=2.96U PD=2.86U
* device instance $4488 r0 *1 116.505,165.475 nfet_03v3
M$4488 \$2305 \$2304 VSS VSS nfet_03v3 L=7.75U W=0.99U AS=0.4851P AD=0.4356P
+ PS=2.96U PD=2.86U
* device instance $4489 r0 *1 126.585,165.475 nfet_03v3
M$4489 \$2307 \$2306 VSS VSS nfet_03v3 L=7.75U W=0.99U AS=0.4851P AD=0.4356P
+ PS=2.96U PD=2.86U
* device instance $4490 r0 *1 135.545,165.475 nfet_03v3
M$4490 \$2309 \$2308 VSS VSS nfet_03v3 L=7.75U W=0.99U AS=0.4851P AD=0.4356P
+ PS=2.96U PD=2.86U
* device instance $4491 r0 *1 145.625,165.475 nfet_03v3
M$4491 \$2311 \$2310 VSS VSS nfet_03v3 L=7.75U W=0.99U AS=0.4851P AD=0.4356P
+ PS=2.96U PD=2.86U
* device instance $4492 r0 *1 154.585,165.475 nfet_03v3
M$4492 \$2313 \$2312 VSS VSS nfet_03v3 L=7.75U W=0.99U AS=0.4851P AD=0.4356P
+ PS=2.96U PD=2.86U
.ENDS PLL_RING_DCO_PHYS
