* NGSPICE file created from gf180mcu_as_sc_mcu7t3v3__and2_2.ext - technology: gf180mcuD

.subckt gf180mcu_as_sc_mcu7t3v3__and2_2 VDD VNW VPW VSS B A Y
M_M0 VDD B a_28_68# VNW pfet_03v3 ad=0.3588p pd=1.9u as=0.3588p ps=1.9u w=1.38u l=0.28u
M_M1 a_172_68# A a_28_68# VPW nfet_03v3 ad=0.26p pd=1.52u as=0.44p ps=2.88u w=1u l=0.28u
M_M2 Y a_28_68# VDD VNW pfet_03v3 ad=0.3588p pd=1.9u as=0.3588p ps=1.9u w=1.38u l=0.28u
M_M3 VSS a_28_68# Y VPW nfet_03v3 ad=0.52p pd=3.04u as=0.26p ps=1.52u w=1u l=0.28u
M_M4 VDD a_28_68# Y VNW pfet_03v3 ad=0.7176p pd=3.8u as=0.3588p ps=1.9u w=1.38u l=0.28u
M_M5 Y a_28_68# VSS VPW nfet_03v3 ad=0.26p pd=1.52u as=0.26p ps=1.52u w=1u l=0.28u
M_M6 a_28_68# A VDD VNW pfet_03v3 ad=0.3588p pd=1.9u as=0.6072p ps=3.64u w=1.38u l=0.28u
M_M7 VSS B a_172_68# VPW nfet_03v3 ad=0.26p pd=1.52u as=0.26p ps=1.52u w=1u l=0.28u
.ends

* NGSPICE file created from gf180mcu_as_sc_mcu7t3v3__and2_4.ext - technology: gf180mcuD

.subckt gf180mcu_as_sc_mcu7t3v3__and2_4 VDD VNW VPW VSS B A Y
M_M0 VSS a_28_68# Y VPW nfet_03v3 ad=0.6p pd=3.2u as=0.26p ps=1.52u w=1u l=0.28u
M_M1 VDD B a_28_68# VNW pfet_03v3 ad=0.3588p pd=1.9u as=0.3588p ps=1.9u w=1.38u l=0.28u
M_M2 Y a_28_68# VDD VNW pfet_03v3 ad=0.3588p pd=1.9u as=0.3588p ps=1.9u w=1.38u l=0.28u
M_M3 a_172_68# A a_28_68# VPW nfet_03v3 ad=0.26p pd=1.52u as=0.44p ps=2.88u w=1u l=0.28u
M_M4 Y a_28_68# VSS VPW nfet_03v3 ad=0.26p pd=1.52u as=0.26p ps=1.52u w=1u l=0.28u
M_M5 Y a_28_68# VDD VNW pfet_03v3 ad=0.3588p pd=1.9u as=0.3588p ps=1.9u w=1.38u l=0.28u
M_M6 VDD a_28_68# Y VNW pfet_03v3 ad=0.828p pd=3.96u as=0.3588p ps=1.9u w=1.38u l=0.28u
M_M7 VSS a_28_68# Y VPW nfet_03v3 ad=0.26p pd=1.52u as=0.26p ps=1.52u w=1u l=0.28u
M_M8 VDD a_28_68# Y VNW pfet_03v3 ad=0.3588p pd=1.9u as=0.3588p ps=1.9u w=1.38u l=0.28u
M_M9 Y a_28_68# VSS VPW nfet_03v3 ad=0.26p pd=1.52u as=0.26p ps=1.52u w=1u l=0.28u
M_M10 a_28_68# A VDD VNW pfet_03v3 ad=0.3588p pd=1.9u as=0.6072p ps=3.64u w=1.38u l=0.28u
M_M11 VSS B a_172_68# VPW nfet_03v3 ad=0.26p pd=1.52u as=0.26p ps=1.52u w=1u l=0.28u
.ends

* NGSPICE file created from gf180mcu_as_sc_mcu7t3v3__and3_2.ext - technology: gf180mcuD

.subckt gf180mcu_as_sc_mcu7t3v3__and3_2 VDD VNW VPW VSS Y C B A
M_M0 a_28_68# B VDD VNW pfet_03v3 ad=0.3588p pd=1.9u as=0.3588p ps=1.9u w=1.38u l=0.28u
M_M1 VDD a_28_68# Y VNW pfet_03v3 ad=1.1592p pd=4.44u as=0.3588p ps=1.9u w=1.38u l=0.28u
M_M2 a_172_68# A a_28_68# VPW nfet_03v3 ad=0.26p pd=1.52u as=0.44p ps=2.88u w=1u l=0.28u
M_M3 VSS a_28_68# Y VPW nfet_03v3 ad=0.84p pd=3.68u as=0.26p ps=1.52u w=1u l=0.28u
M_M4 VDD C a_28_68# VNW pfet_03v3 ad=0.3588p pd=1.9u as=0.3588p ps=1.9u w=1.38u l=0.28u
M_M5 Y a_28_68# VSS VPW nfet_03v3 ad=0.26p pd=1.52u as=0.26p ps=1.52u w=1u l=0.28u
M_M6 Y a_28_68# VDD VNW pfet_03v3 ad=0.3588p pd=1.9u as=0.3588p ps=1.9u w=1.38u l=0.28u
M_M7 VSS C a_332_68# VPW nfet_03v3 ad=0.26p pd=1.52u as=0.26p ps=1.52u w=1u l=0.28u
M_M8 VDD A a_28_68# VNW pfet_03v3 ad=0.3588p pd=1.9u as=0.6072p ps=3.64u w=1.38u l=0.28u
M_M9 a_332_68# B a_172_68# VPW nfet_03v3 ad=0.26p pd=1.52u as=0.26p ps=1.52u w=1u l=0.28u
.ends

* NGSPICE file created from gf180mcu_as_sc_mcu7t3v3__and3_4.ext - technology: gf180mcuD

.subckt gf180mcu_as_sc_mcu7t3v3__and3_4 VDD VNW VPW VSS Y C B A
M_M0 Y a_28_68# VSS VPW nfet_03v3 ad=0.26p pd=1.52u as=0.26p ps=1.52u w=1u l=0.28u
M_M1 a_28_68# B VDD VNW pfet_03v3 ad=0.3588p pd=1.9u as=0.3588p ps=1.9u w=1.38u l=0.28u
M_M2 VDD a_28_68# Y VNW pfet_03v3 ad=0.3588p pd=1.9u as=0.3588p ps=1.9u w=1.38u l=0.28u
M_M3 a_172_68# A a_28_68# VPW nfet_03v3 ad=0.26p pd=1.52u as=0.44p ps=2.88u w=1u l=0.28u
M_M4 VSS a_28_68# Y VPW nfet_03v3 ad=0.26p pd=1.52u as=0.26p ps=1.52u w=1u l=0.28u
M_M5 VDD C a_28_68# VNW pfet_03v3 ad=0.3588p pd=1.9u as=0.3588p ps=1.9u w=1.38u l=0.28u
M_M6 Y a_28_68# VDD VNW pfet_03v3 ad=0.3588p pd=1.9u as=0.3588p ps=1.9u w=1.38u l=0.28u
M_M7 Y a_28_68# VSS VPW nfet_03v3 ad=0.26p pd=1.52u as=0.26p ps=1.52u w=1u l=0.28u
M_M8 Y a_28_68# VDD VNW pfet_03v3 ad=0.3588p pd=1.9u as=0.3588p ps=1.9u w=1.38u l=0.28u
M_M9 VSS C a_332_68# VPW nfet_03v3 ad=0.26p pd=1.52u as=0.26p ps=1.52u w=1u l=0.28u
M_M10 VDD a_28_68# Y VNW pfet_03v3 ad=0.6072p pd=3.64u as=0.3588p ps=1.9u w=1.38u l=0.28u
M_M11 VSS a_28_68# Y VPW nfet_03v3 ad=0.44p pd=2.88u as=0.26p ps=1.52u w=1u l=0.28u
M_M12 VDD A a_28_68# VNW pfet_03v3 ad=0.3588p pd=1.9u as=0.6072p ps=3.64u w=1.38u l=0.28u
M_M13 a_332_68# B a_172_68# VPW nfet_03v3 ad=0.26p pd=1.52u as=0.26p ps=1.52u w=1u l=0.28u
.ends

* NGSPICE file created from gf180mcu_as_sc_mcu7t3v3__and4_2.ext - technology: gf180mcuD

.subckt gf180mcu_as_sc_mcu7t3v3__and4_2 VDD VNW VPW VSS A C B D Y
M_M0 VSS a_28_68# Y VPW nfet_03v3 ad=0.6p pd=3.2u as=0.26p ps=1.52u w=1u l=0.28u
M_M1 VDD B a_28_68# VNW pfet_03v3 ad=0.3588p pd=1.9u as=0.3588p ps=1.9u w=1.38u l=0.28u
M_M2 Y a_28_68# VDD VNW pfet_03v3 ad=0.3588p pd=1.9u as=0.3588p ps=1.9u w=1.38u l=0.28u
M_M3 a_172_68# A a_28_68# VPW nfet_03v3 ad=0.26p pd=1.52u as=0.44p ps=2.88u w=1u l=0.28u
M_M4 Y a_28_68# VSS VPW nfet_03v3 ad=0.26p pd=1.52u as=0.26p ps=1.52u w=1u l=0.28u
M_M5 a_28_68# C VDD VNW pfet_03v3 ad=0.3588p pd=1.9u as=0.3588p ps=1.9u w=1.38u l=0.28u
M_M6 VDD a_28_68# Y VNW pfet_03v3 ad=0.828p pd=3.96u as=0.3588p ps=1.9u w=1.38u l=0.28u
M_M7 VSS D a_492_68# VPW nfet_03v3 ad=0.26p pd=1.52u as=0.26p ps=1.52u w=1u l=0.28u
M_M8 VDD D a_28_68# VNW pfet_03v3 ad=0.3588p pd=1.9u as=0.3588p ps=1.9u w=1.38u l=0.28u
M_M9 a_492_68# C a_332_68# VPW nfet_03v3 ad=0.26p pd=1.52u as=0.26p ps=1.52u w=1u l=0.28u
M_M10 a_28_68# A VDD VNW pfet_03v3 ad=0.3588p pd=1.9u as=0.6072p ps=3.64u w=1.38u l=0.28u
M_M11 a_332_68# B a_172_68# VPW nfet_03v3 ad=0.26p pd=1.52u as=0.26p ps=1.52u w=1u l=0.28u
.ends

* NGSPICE file created from gf180mcu_as_sc_mcu7t3v3__and4_4.ext - technology: gf180mcuD

.subckt gf180mcu_as_sc_mcu7t3v3__and4_4 VDD VNW VPW VSS A C B D Y
M_M0 VSS a_28_68# Y VPW nfet_03v3 ad=0.26p pd=1.52u as=0.26p ps=1.52u w=1u l=0.28u
M_M1 VDD B a_28_68# VNW pfet_03v3 ad=0.3588p pd=1.9u as=0.3588p ps=1.9u w=1.38u l=0.28u
M_M2 Y a_28_68# VDD VNW pfet_03v3 ad=0.3588p pd=1.9u as=0.3588p ps=1.9u w=1.38u l=0.28u
M_M3 a_172_68# A a_28_68# VPW nfet_03v3 ad=0.26p pd=1.52u as=0.44p ps=2.88u w=1u l=0.28u
M_M4 VDD a_28_68# Y VNW pfet_03v3 ad=0.9384p pd=4.12u as=0.3588p ps=1.9u w=1.38u l=0.28u
M_M5 Y a_28_68# VSS VPW nfet_03v3 ad=0.26p pd=1.52u as=0.26p ps=1.52u w=1u l=0.28u
M_M6 a_28_68# C VDD VNW pfet_03v3 ad=0.3588p pd=1.9u as=0.3588p ps=1.9u w=1.38u l=0.28u
M_M7 VDD a_28_68# Y VNW pfet_03v3 ad=0.3588p pd=1.9u as=0.3588p ps=1.9u w=1.38u l=0.28u
M_M8 VSS D a_492_68# VPW nfet_03v3 ad=0.26p pd=1.52u as=0.26p ps=1.52u w=1u l=0.28u
M_M9 VSS a_28_68# Y VPW nfet_03v3 ad=0.68p pd=3.36u as=0.26p ps=1.52u w=1u l=0.28u
M_M10 VDD D a_28_68# VNW pfet_03v3 ad=0.3588p pd=1.9u as=0.3588p ps=1.9u w=1.38u l=0.28u
M_M11 a_492_68# C a_332_68# VPW nfet_03v3 ad=0.26p pd=1.52u as=0.26p ps=1.52u w=1u l=0.28u
M_M12 Y a_28_68# VDD VNW pfet_03v3 ad=0.3588p pd=1.9u as=0.3588p ps=1.9u w=1.38u l=0.28u
M_M13 Y a_28_68# VSS VPW nfet_03v3 ad=0.26p pd=1.52u as=0.26p ps=1.52u w=1u l=0.28u
M_M14 a_28_68# A VDD VNW pfet_03v3 ad=0.3588p pd=1.9u as=0.6072p ps=3.64u w=1.38u l=0.28u
M_M15 a_332_68# B a_172_68# VPW nfet_03v3 ad=0.26p pd=1.52u as=0.26p ps=1.52u w=1u l=0.28u
.ends

* NGSPICE file created from gf180mcu_as_sc_mcu7t3v3__ao211_2.ext - technology: gf180mcuD

.subckt gf180mcu_as_sc_mcu7t3v3__ao211_2 VDD VNW VPW VSS A B C D Y
M_M0 a_28_440# B VDD VNW pfet_03v3 ad=0.3588p pd=1.9u as=0.3588p ps=1.9u w=1.38u l=0.28u
M_M1 a_172_68# A VSS VPW nfet_03v3 ad=0.26p pd=1.52u as=0.44p ps=2.88u w=1u l=0.28u
M_M2 VDD a_332_68# Y VNW pfet_03v3 ad=0.7176p pd=3.8u as=0.3588p ps=1.9u w=1.38u l=0.28u
M_M3 VSS a_332_68# Y VPW nfet_03v3 ad=0.52p pd=3.04u as=0.26p ps=1.52u w=1u l=0.28u
M_M4 a_492_440# C a_28_440# VNW pfet_03v3 ad=0.3588p pd=1.9u as=0.3588p ps=1.9u w=1.38u l=0.28u
M_M5 a_332_68# D VSS VPW nfet_03v3 ad=0.44p pd=2.88u as=0.26p ps=1.52u w=1u l=0.28u
M_M6 a_332_68# D a_492_440# VNW pfet_03v3 ad=0.6072p pd=3.64u as=0.3588p ps=1.9u w=1.38u l=0.28u
M_M7 Y a_332_68# VDD VNW pfet_03v3 ad=0.3588p pd=1.9u as=0.6072p ps=3.64u w=1.38u l=0.28u
M_M8 Y a_332_68# VSS VPW nfet_03v3 ad=0.26p pd=1.52u as=0.44p ps=2.88u w=1u l=0.28u
M_M9 VSS C a_332_68# VPW nfet_03v3 ad=0.26p pd=1.52u as=0.26p ps=1.52u w=1u l=0.28u
M_M10 VDD A a_28_440# VNW pfet_03v3 ad=0.3588p pd=1.9u as=0.6072p ps=3.64u w=1.38u l=0.28u
M_M11 a_332_68# B a_172_68# VPW nfet_03v3 ad=0.26p pd=1.52u as=0.26p ps=1.52u w=1u l=0.28u
.ends

* NGSPICE file created from gf180mcu_as_sc_mcu7t3v3__ao211_4.ext - technology: gf180mcuD

.subckt gf180mcu_as_sc_mcu7t3v3__ao211_4 VDD VNW VPW VSS A B C D Y
M_M0 a_28_440# B VDD VNW pfet_03v3 ad=0.3588p pd=1.9u as=0.3588p ps=1.9u w=1.38u l=0.28u
M_M1 Y a_332_68# VSS VPW nfet_03v3 ad=0.26p pd=1.52u as=0.26p ps=1.52u w=1u l=0.28u
M_M2 a_172_68# A VSS VPW nfet_03v3 ad=0.26p pd=1.52u as=0.44p ps=2.88u w=1u l=0.28u
M_M3 VDD a_332_68# Y VNW pfet_03v3 ad=0.3588p pd=1.9u as=0.3588p ps=1.9u w=1.38u l=0.28u
M_M4 VSS a_332_68# Y VPW nfet_03v3 ad=0.26p pd=1.52u as=0.26p ps=1.52u w=1u l=0.28u
M_M5 a_492_440# C a_28_440# VNW pfet_03v3 ad=0.3588p pd=1.9u as=0.3588p ps=1.9u w=1.38u l=0.28u
M_M6 a_332_68# D VSS VPW nfet_03v3 ad=0.44p pd=2.88u as=0.26p ps=1.52u w=1u l=0.28u
M_M7 Y a_332_68# VDD VNW pfet_03v3 ad=0.3588p pd=1.9u as=0.3588p ps=1.9u w=1.38u l=0.28u
M_M8 a_332_68# D a_492_440# VNW pfet_03v3 ad=0.6072p pd=3.64u as=0.3588p ps=1.9u w=1.38u l=0.28u
M_M9 Y a_332_68# VDD VNW pfet_03v3 ad=0.3588p pd=1.9u as=0.6072p ps=3.64u w=1.38u l=0.28u
M_M10 Y a_332_68# VSS VPW nfet_03v3 ad=0.26p pd=1.52u as=0.44p ps=2.88u w=1u l=0.28u
M_M11 VSS C a_332_68# VPW nfet_03v3 ad=0.26p pd=1.52u as=0.26p ps=1.52u w=1u l=0.28u
M_M12 VDD a_332_68# Y VNW pfet_03v3 ad=0.828p pd=3.96u as=0.3588p ps=1.9u w=1.38u l=0.28u
M_M13 VDD A a_28_440# VNW pfet_03v3 ad=0.3588p pd=1.9u as=0.6072p ps=3.64u w=1.38u l=0.28u
M_M14 VSS a_332_68# Y VPW nfet_03v3 ad=0.6p pd=3.2u as=0.26p ps=1.52u w=1u l=0.28u
M_M15 a_332_68# B a_172_68# VPW nfet_03v3 ad=0.26p pd=1.52u as=0.26p ps=1.52u w=1u l=0.28u
.ends

* NGSPICE file created from gf180mcu_as_sc_mcu7t3v3__ao21_2.ext - technology: gf180mcuD

.subckt gf180mcu_as_sc_mcu7t3v3__ao21_2 VDD VNW VPW VSS Y A B C
M_M0 VSS a_332_68# Y VPW nfet_03v3 ad=0.44p pd=2.88u as=0.3025p ps=1.605u w=1u l=0.28u
M_M1 a_28_440# B VDD VNW pfet_03v3 ad=0.3588p pd=1.9u as=0.3588p ps=1.9u w=1.38u l=0.28u
M_M2 a_172_68# A VSS VPW nfet_03v3 ad=0.26p pd=1.52u as=0.44p ps=2.88u w=1u l=0.28u
M_M3 a_332_68# C a_28_440# VNW pfet_03v3 ad=0.6072p pd=3.64u as=0.3588p ps=1.9u w=1.38u l=0.28u
M_M4 Y a_332_68# VDD VNW pfet_03v3 ad=0.41745p pd=1.985u as=0.6072p ps=3.64u w=1.38u l=0.28u
M_M5 VSS C a_332_68# VPW nfet_03v3 ad=0.58p pd=2.16u as=0.26p ps=1.52u w=1u l=0.28u
M_M6 Y a_332_68# VSS VPW nfet_03v3 ad=0.3025p pd=1.605u as=0.58p ps=2.16u w=1u l=0.28u
M_M7 VDD a_332_68# Y VNW pfet_03v3 ad=0.6072p pd=3.64u as=0.41745p ps=1.985u w=1.38u l=0.28u
M_M8 VDD A a_28_440# VNW pfet_03v3 ad=0.3588p pd=1.9u as=0.6072p ps=3.64u w=1.38u l=0.28u
M_M9 a_332_68# B a_172_68# VPW nfet_03v3 ad=0.26p pd=1.52u as=0.26p ps=1.52u w=1u l=0.28u
.ends

* NGSPICE file created from gf180mcu_as_sc_mcu7t3v3__ao21_4.ext - technology: gf180mcuD

.subckt gf180mcu_as_sc_mcu7t3v3__ao21_4 VDD VNW VPW VSS Y A B C
M_M0 VSS a_332_68# Y VPW nfet_03v3 ad=0.26p pd=1.52u as=0.3025p ps=1.605u w=1u l=0.28u
M_M1 a_28_440# B VDD VNW pfet_03v3 ad=0.3588p pd=1.9u as=0.3588p ps=1.9u w=1.38u l=0.28u
M_M2 Y a_332_68# VDD VNW pfet_03v3 ad=0.3588p pd=1.9u as=0.3588p ps=1.9u w=1.38u l=0.28u
M_M3 a_172_68# A VSS VPW nfet_03v3 ad=0.26p pd=1.52u as=0.44p ps=2.88u w=1u l=0.28u
M_M4 a_332_68# C a_28_440# VNW pfet_03v3 ad=0.6072p pd=3.64u as=0.3588p ps=1.9u w=1.38u l=0.28u
M_M5 Y a_332_68# VDD VNW pfet_03v3 ad=0.41745p pd=1.985u as=0.6072p ps=3.64u w=1.38u l=0.28u
M_M6 VDD a_332_68# Y VNW pfet_03v3 ad=0.6279p pd=3.67u as=0.3588p ps=1.9u w=1.38u l=0.28u
M_M7 VSS a_332_68# Y VPW nfet_03v3 ad=0.455p pd=2.91u as=0.26p ps=1.52u w=1u l=0.28u
M_M8 VSS C a_332_68# VPW nfet_03v3 ad=0.58p pd=2.16u as=0.26p ps=1.52u w=1u l=0.28u
M_M9 Y a_332_68# VSS VPW nfet_03v3 ad=0.26p pd=1.52u as=0.26p ps=1.52u w=1u l=0.28u
M_M10 Y a_332_68# VSS VPW nfet_03v3 ad=0.3025p pd=1.605u as=0.58p ps=2.16u w=1u l=0.28u
M_M11 VDD a_332_68# Y VNW pfet_03v3 ad=0.3588p pd=1.9u as=0.41745p ps=1.985u w=1.38u l=0.28u
M_M12 VDD A a_28_440# VNW pfet_03v3 ad=0.3588p pd=1.9u as=0.6072p ps=3.64u w=1.38u l=0.28u
M_M13 a_332_68# B a_172_68# VPW nfet_03v3 ad=0.26p pd=1.52u as=0.26p ps=1.52u w=1u l=0.28u
.ends

* NGSPICE file created from gf180mcu_as_sc_mcu7t3v3__ao21b_2.ext - technology: gf180mcuD

.subckt gf180mcu_as_sc_mcu7t3v3__ao21b_2 VDD VNW VPW VSS Y C B A
M_M0 a_364_440# C a_668_68# VNW pfet_03v3 ad=0.6072p pd=3.64u as=0.3588p ps=1.9u w=1.38u l=0.28u
M_M1 Y a_668_68# VDD VNW pfet_03v3 ad=0.3588p pd=1.9u as=0.6072p ps=3.64u w=1.38u l=0.28u
M_M2 VSS a_668_68# Y VPW nfet_03v3 ad=0.45p pd=2.9u as=0.26p ps=1.52u w=1u l=0.28u
M_M3 a_668_68# B a_508_68# VPW nfet_03v3 ad=0.26p pd=1.52u as=0.26p ps=1.52u w=1u l=0.28u
M_M4 VSS C a_668_68# VPW nfet_03v3 ad=0.58p pd=2.16u as=0.26p ps=1.52u w=1u l=0.28u
M_M5 a_220_68# A VSS VPW nfet_03v3 ad=0.44p pd=2.88u as=0.47p ps=2.94u w=1u l=0.28u
M_M6 Y a_668_68# VSS VPW nfet_03v3 ad=0.26p pd=1.52u as=0.58p ps=2.16u w=1u l=0.28u
M_M7 a_508_68# a_220_68# VSS VPW nfet_03v3 ad=0.26p pd=1.52u as=0.44p ps=2.88u w=1u l=0.28u
M_M8 a_220_68# A VDD VNW pfet_03v3 ad=0.6072p pd=3.64u as=0.6348p ps=3.68u w=1.38u l=0.28u
M_M9 VDD a_220_68# a_364_440# VNW pfet_03v3 ad=0.3588p pd=1.9u as=0.6072p ps=3.64u w=1.38u l=0.28u
M_M10 a_364_440# a_220_68# VDD VNW pfet_03v3 ad=0.3588p pd=1.9u as=0.3588p ps=1.9u w=1.38u l=0.28u
M_M11 a_668_68# C VSS VPW nfet_03v3 ad=0.26p pd=1.52u as=0.26p ps=1.52u w=1u l=0.28u
M_M12 VDD a_668_68# Y VNW pfet_03v3 ad=0.621p pd=3.66u as=0.3588p ps=1.9u w=1.38u l=0.28u
M_M13 a_668_68# C a_364_440# VNW pfet_03v3 ad=0.3588p pd=1.9u as=0.3588p ps=1.9u w=1.38u l=0.28u
M_M14 VSS a_220_68# a_828_68# VPW nfet_03v3 ad=0.26p pd=1.52u as=0.26p ps=1.52u w=1u l=0.28u
M_M15 a_364_440# B VDD VNW pfet_03v3 ad=0.3588p pd=1.9u as=0.3588p ps=1.9u w=1.38u l=0.28u
M_M16 a_828_68# B a_668_68# VPW nfet_03v3 ad=0.26p pd=1.52u as=0.26p ps=1.52u w=1u l=0.28u
M_M17 VDD B a_364_440# VNW pfet_03v3 ad=0.3588p pd=1.9u as=0.3588p ps=1.9u w=1.38u l=0.28u
.ends

* NGSPICE file created from gf180mcu_as_sc_mcu7t3v3__ao21b_4.ext - technology: gf180mcuD

.subckt gf180mcu_as_sc_mcu7t3v3__ao21b_4 VDD VNW VPW VSS Y C B A
M_M0 a_364_440# C a_668_68# VNW pfet_03v3 ad=0.6072p pd=3.64u as=0.3588p ps=1.9u w=1.38u l=0.28u
M_M1 Y a_668_68# VDD VNW pfet_03v3 ad=0.3588p pd=1.9u as=0.6072p ps=3.64u w=1.38u l=0.28u
M_M2 VSS a_668_68# Y VPW nfet_03v3 ad=0.26p pd=1.52u as=0.26p ps=1.52u w=1u l=0.28u
M_M3 a_668_68# B a_508_68# VPW nfet_03v3 ad=0.26p pd=1.52u as=0.26p ps=1.52u w=1u l=0.28u
M_M4 VSS C a_668_68# VPW nfet_03v3 ad=0.58p pd=2.16u as=0.26p ps=1.52u w=1u l=0.28u
M_M5 a_220_68# A VSS VPW nfet_03v3 ad=0.44p pd=2.88u as=0.47p ps=2.94u w=1u l=0.28u
M_M6 Y a_668_68# VSS VPW nfet_03v3 ad=0.26p pd=1.52u as=0.58p ps=2.16u w=1u l=0.28u
M_M7 a_508_68# a_220_68# VSS VPW nfet_03v3 ad=0.26p pd=1.52u as=0.44p ps=2.88u w=1u l=0.28u
M_M8 a_220_68# A VDD VNW pfet_03v3 ad=0.6072p pd=3.64u as=0.6348p ps=3.68u w=1.38u l=0.28u
M_M9 VDD a_220_68# a_364_440# VNW pfet_03v3 ad=0.3588p pd=1.9u as=0.6072p ps=3.64u w=1.38u l=0.28u
M_M10 a_364_440# a_220_68# VDD VNW pfet_03v3 ad=0.3588p pd=1.9u as=0.3588p ps=1.9u w=1.38u l=0.28u
M_M11 a_668_68# C VSS VPW nfet_03v3 ad=0.26p pd=1.52u as=0.26p ps=1.52u w=1u l=0.28u
M_M12 VDD a_668_68# Y VNW pfet_03v3 ad=0.3588p pd=1.9u as=0.3588p ps=1.9u w=1.38u l=0.28u
M_M13 a_668_68# C a_364_440# VNW pfet_03v3 ad=0.3588p pd=1.9u as=0.3588p ps=1.9u w=1.38u l=0.28u
M_M14 Y a_668_68# VDD VNW pfet_03v3 ad=0.3588p pd=1.9u as=0.3588p ps=1.9u w=1.38u l=0.28u
M_M15 VSS a_220_68# a_828_68# VPW nfet_03v3 ad=0.26p pd=1.52u as=0.26p ps=1.52u w=1u l=0.28u
M_M16 a_364_440# B VDD VNW pfet_03v3 ad=0.3588p pd=1.9u as=0.3588p ps=1.9u w=1.38u l=0.28u
M_M17 VDD a_668_68# Y VNW pfet_03v3 ad=0.7314p pd=3.82u as=0.3588p ps=1.9u w=1.38u l=0.28u
M_M18 Y a_668_68# VSS VPW nfet_03v3 ad=0.26p pd=1.52u as=0.26p ps=1.52u w=1u l=0.28u
M_M19 a_828_68# B a_668_68# VPW nfet_03v3 ad=0.26p pd=1.52u as=0.26p ps=1.52u w=1u l=0.28u
M_M20 VSS a_668_68# Y VPW nfet_03v3 ad=0.53p pd=3.06u as=0.26p ps=1.52u w=1u l=0.28u
M_M21 VDD B a_364_440# VNW pfet_03v3 ad=0.3588p pd=1.9u as=0.3588p ps=1.9u w=1.38u l=0.28u
.ends

* NGSPICE file created from gf180mcu_as_sc_mcu7t3v3__ao22_2.ext - technology: gf180mcuD

.subckt gf180mcu_as_sc_mcu7t3v3__ao22_2 VDD VNW VPW VSS A B C D Y
M_M0 a_620_68# C a_28_440# VPW nfet_03v3 ad=0.26p pd=1.52u as=0.44p ps=2.88u w=1u l=0.28u
M_M1 a_28_440# B a_172_440# VNW pfet_03v3 ad=0.6072p pd=3.64u as=0.3588p ps=1.9u w=1.38u l=0.28u
M_M2 a_172_440# C VDD VNW pfet_03v3 ad=0.3588p pd=1.9u as=0.6072p ps=3.64u w=1.38u l=0.28u
M_M3 a_172_68# A VSS VPW nfet_03v3 ad=0.26p pd=1.52u as=0.44p ps=2.88u w=1u l=0.28u
M_M4 VDD a_28_440# Y VNW pfet_03v3 ad=0.7176p pd=3.8u as=0.3588p ps=1.9u w=1.38u l=0.28u
M_M5 VSS a_28_440# Y VPW nfet_03v3 ad=0.52p pd=3.04u as=0.26p ps=1.52u w=1u l=0.28u
M_M6 VDD D a_172_440# VNW pfet_03v3 ad=0.3588p pd=1.9u as=0.3588p ps=1.9u w=1.38u l=0.28u
M_M7 Y a_28_440# VDD VNW pfet_03v3 ad=0.3588p pd=1.9u as=0.3588p ps=1.9u w=1.38u l=0.28u
M_M8 Y a_28_440# VSS VPW nfet_03v3 ad=0.26p pd=1.52u as=0.26p ps=1.52u w=1u l=0.28u
M_M9 VSS D a_620_68# VPW nfet_03v3 ad=0.26p pd=1.52u as=0.26p ps=1.52u w=1u l=0.28u
M_M10 a_172_440# A a_28_440# VNW pfet_03v3 ad=0.3588p pd=1.9u as=0.6072p ps=3.64u w=1.38u l=0.28u
M_M11 a_28_440# B a_172_68# VPW nfet_03v3 ad=0.44p pd=2.88u as=0.26p ps=1.52u w=1u l=0.28u
.ends

* NGSPICE file created from gf180mcu_as_sc_mcu7t3v3__ao22_4.ext - technology: gf180mcuD

.subckt gf180mcu_as_sc_mcu7t3v3__ao22_4 VDD VNW VPW VSS A B C D Y
M_M0 a_620_68# C a_28_440# VPW nfet_03v3 ad=0.26p pd=1.52u as=0.44p ps=2.88u w=1u l=0.28u
M_M1 a_28_440# B a_172_440# VNW pfet_03v3 ad=0.6072p pd=3.64u as=0.3588p ps=1.9u w=1.38u l=0.28u
M_M2 a_172_440# C VDD VNW pfet_03v3 ad=0.3588p pd=1.9u as=0.6072p ps=3.64u w=1.38u l=0.28u
M_M3 Y a_28_440# VSS VPW nfet_03v3 ad=0.26p pd=1.52u as=0.26p ps=1.52u w=1u l=0.28u
M_M4 a_172_68# A VSS VPW nfet_03v3 ad=0.26p pd=1.52u as=0.44p ps=2.88u w=1u l=0.28u
M_M5 VDD a_28_440# Y VNW pfet_03v3 ad=0.3588p pd=1.9u as=0.3588p ps=1.9u w=1.38u l=0.28u
M_M6 VSS a_28_440# Y VPW nfet_03v3 ad=0.26p pd=1.52u as=0.26p ps=1.52u w=1u l=0.28u
M_M7 VDD D a_172_440# VNW pfet_03v3 ad=0.3588p pd=1.9u as=0.3588p ps=1.9u w=1.38u l=0.28u
M_M8 Y a_28_440# VDD VNW pfet_03v3 ad=0.3588p pd=1.9u as=0.3588p ps=1.9u w=1.38u l=0.28u
M_M9 Y a_28_440# VDD VNW pfet_03v3 ad=0.3588p pd=1.9u as=0.3588p ps=1.9u w=1.38u l=0.28u
M_M10 Y a_28_440# VSS VPW nfet_03v3 ad=0.26p pd=1.52u as=0.26p ps=1.52u w=1u l=0.28u
M_M11 VDD a_28_440# Y VNW pfet_03v3 ad=0.6072p pd=3.64u as=0.3588p ps=1.9u w=1.38u l=0.28u
M_M12 VSS D a_620_68# VPW nfet_03v3 ad=0.26p pd=1.52u as=0.26p ps=1.52u w=1u l=0.28u
M_M13 a_172_440# A a_28_440# VNW pfet_03v3 ad=0.3588p pd=1.9u as=0.6072p ps=3.64u w=1.38u l=0.28u
M_M14 VSS a_28_440# Y VPW nfet_03v3 ad=0.44p pd=2.88u as=0.26p ps=1.52u w=1u l=0.28u
M_M15 a_28_440# B a_172_68# VPW nfet_03v3 ad=0.44p pd=2.88u as=0.26p ps=1.52u w=1u l=0.28u
.ends

* NGSPICE file created from gf180mcu_as_sc_mcu7t3v3__ao31_2.ext - technology: gf180mcuD

.subckt gf180mcu_as_sc_mcu7t3v3__ao31_2 VDD VNW VPW VSS D A B C Y
M_M0 VSS a_28_440# Y VPW nfet_03v3 ad=0.44p pd=2.88u as=0.26p ps=1.52u w=1u l=0.28u
M_M1 VDD A a_172_440# VNW pfet_03v3 ad=0.3588p pd=1.9u as=0.3588p ps=1.9u w=1.38u l=0.28u
M_M2 Y a_28_440# VDD VNW pfet_03v3 ad=0.3588p pd=1.9u as=0.3588p ps=1.9u w=1.38u l=0.28u
M_M3 a_28_440# D VSS VPW nfet_03v3 ad=0.26p pd=1.52u as=0.44p ps=2.88u w=1u l=0.28u
M_M4 Y a_28_440# VSS VPW nfet_03v3 ad=0.26p pd=1.52u as=0.26p ps=1.52u w=1u l=0.28u
M_M5 a_172_440# B VDD VNW pfet_03v3 ad=0.3588p pd=1.9u as=0.3588p ps=1.9u w=1.38u l=0.28u
M_M6 VDD a_28_440# Y VNW pfet_03v3 ad=0.6072p pd=3.64u as=0.3588p ps=1.9u w=1.38u l=0.28u
M_M7 VSS C a_492_68# VPW nfet_03v3 ad=0.26p pd=1.52u as=0.26p ps=1.52u w=1u l=0.28u
M_M8 VDD C a_172_440# VNW pfet_03v3 ad=0.3588p pd=1.9u as=0.3588p ps=1.9u w=1.38u l=0.28u
M_M9 a_492_68# B a_332_68# VPW nfet_03v3 ad=0.26p pd=1.52u as=0.26p ps=1.52u w=1u l=0.28u
M_M10 a_172_440# D a_28_440# VNW pfet_03v3 ad=0.3588p pd=1.9u as=0.6072p ps=3.64u w=1.38u l=0.28u
M_M11 a_332_68# A a_28_440# VPW nfet_03v3 ad=0.26p pd=1.52u as=0.26p ps=1.52u w=1u l=0.28u
.ends

* NGSPICE file created from gf180mcu_as_sc_mcu7t3v3__ao31_4.ext - technology: gf180mcuD

.subckt gf180mcu_as_sc_mcu7t3v3__ao31_4 VDD VNW VPW VSS D A B C Y
M_M0 VSS a_28_440# Y VPW nfet_03v3 ad=0.26p pd=1.52u as=0.26p ps=1.52u w=1u l=0.28u
M_M1 VDD A a_172_440# VNW pfet_03v3 ad=0.3588p pd=1.9u as=0.3588p ps=1.9u w=1.38u l=0.28u
M_M2 Y a_28_440# VDD VNW pfet_03v3 ad=0.3588p pd=1.9u as=0.3588p ps=1.9u w=1.38u l=0.28u
M_M3 a_28_440# D VSS VPW nfet_03v3 ad=0.26p pd=1.52u as=0.44p ps=2.88u w=1u l=0.28u
M_M4 VDD a_28_440# Y VNW pfet_03v3 ad=0.6072p pd=3.64u as=0.3588p ps=1.9u w=1.38u l=0.28u
M_M5 Y a_28_440# VSS VPW nfet_03v3 ad=0.26p pd=1.52u as=0.26p ps=1.52u w=1u l=0.28u
M_M6 a_172_440# B VDD VNW pfet_03v3 ad=0.3588p pd=1.9u as=0.3588p ps=1.9u w=1.38u l=0.28u
M_M7 VDD a_28_440# Y VNW pfet_03v3 ad=0.3588p pd=1.9u as=0.3588p ps=1.9u w=1.38u l=0.28u
M_M8 VSS C a_492_68# VPW nfet_03v3 ad=0.26p pd=1.52u as=0.26p ps=1.52u w=1u l=0.28u
M_M9 VSS a_28_440# Y VPW nfet_03v3 ad=0.44p pd=2.88u as=0.26p ps=1.52u w=1u l=0.28u
M_M10 VDD C a_172_440# VNW pfet_03v3 ad=0.3588p pd=1.9u as=0.3588p ps=1.9u w=1.38u l=0.28u
M_M11 a_492_68# B a_332_68# VPW nfet_03v3 ad=0.26p pd=1.52u as=0.26p ps=1.52u w=1u l=0.28u
M_M12 Y a_28_440# VDD VNW pfet_03v3 ad=0.3588p pd=1.9u as=0.3588p ps=1.9u w=1.38u l=0.28u
M_M13 Y a_28_440# VSS VPW nfet_03v3 ad=0.26p pd=1.52u as=0.26p ps=1.52u w=1u l=0.28u
M_M14 a_172_440# D a_28_440# VNW pfet_03v3 ad=0.3588p pd=1.9u as=0.6072p ps=3.64u w=1.38u l=0.28u
M_M15 a_332_68# A a_28_440# VPW nfet_03v3 ad=0.26p pd=1.52u as=0.26p ps=1.52u w=1u l=0.28u
.ends

* NGSPICE file created from gf180mcu_as_sc_mcu7t3v3__aoi211_2.ext - technology: gf180mcuD

.subckt gf180mcu_as_sc_mcu7t3v3__aoi211_2 VDD VNW VPW VSS A B C Y D
M_M0 VDD A a_172_440# VNW pfet_03v3 ad=0.3588p pd=1.9u as=0.3588p ps=1.9u w=1.38u l=0.28u
M_M1 Y D VSS VPW nfet_03v3 ad=0.26p pd=1.52u as=0.26p ps=1.52u w=1u l=0.28u
M_M2 VSS A a_28_68# VPW nfet_03v3 ad=0.26p pd=1.52u as=0.44p ps=2.88u w=1u l=0.28u
M_M3 a_796_440# C a_172_440# VNW pfet_03v3 ad=0.3588p pd=1.9u as=0.3588p ps=1.9u w=1.38u l=0.28u
M_M4 VSS C Y VPW nfet_03v3 ad=0.26p pd=1.52u as=0.26p ps=1.52u w=1u l=0.28u
M_M5 a_172_440# B VDD VNW pfet_03v3 ad=0.3588p pd=1.9u as=0.3588p ps=1.9u w=1.38u l=0.28u
M_M6 a_28_68# B Y VPW nfet_03v3 ad=0.44p pd=2.88u as=0.26p ps=1.52u w=1u l=0.28u
M_M7 Y D a_796_440# VNW pfet_03v3 ad=0.3588p pd=1.9u as=0.3588p ps=1.9u w=1.38u l=0.28u
M_M8 VDD B a_172_440# VNW pfet_03v3 ad=0.6072p pd=3.64u as=0.3588p ps=1.9u w=1.38u l=0.28u
M_M9 a_172_440# C a_796_440# VNW pfet_03v3 ad=0.3588p pd=1.9u as=0.6072p ps=3.64u w=1.38u l=0.28u
M_M10 Y C VSS VPW nfet_03v3 ad=0.26p pd=1.52u as=0.44p ps=2.88u w=1u l=0.28u
M_M11 Y B a_28_68# VPW nfet_03v3 ad=0.26p pd=1.52u as=0.26p ps=1.52u w=1u l=0.28u
M_M12 a_796_440# D Y VNW pfet_03v3 ad=0.6417p pd=3.69u as=0.3588p ps=1.9u w=1.38u l=0.28u
M_M13 a_172_440# A VDD VNW pfet_03v3 ad=0.3588p pd=1.9u as=0.6072p ps=3.64u w=1.38u l=0.28u
M_M14 VSS D Y VPW nfet_03v3 ad=0.465p pd=2.93u as=0.26p ps=1.52u w=1u l=0.28u
M_M15 a_28_68# A VSS VPW nfet_03v3 ad=0.26p pd=1.52u as=0.26p ps=1.52u w=1u l=0.28u
.ends

* NGSPICE file created from gf180mcu_as_sc_mcu7t3v3__aoi211_4.ext - technology: gf180mcuD

.subckt gf180mcu_as_sc_mcu7t3v3__aoi211_4 VDD VNW VPW VSS A B C D Y
M_M0 Y B a_172_68# VPW nfet_03v3 ad=0.26p pd=1.52u as=0.26p ps=1.52u w=1u l=0.28u
M_M1 a_28_440# A VDD VNW pfet_03v3 ad=0.3588p pd=1.9u as=0.3588p ps=1.9u w=1.38u l=0.28u
M_M2 VDD B a_28_440# VNW pfet_03v3 ad=0.3588p pd=1.9u as=0.3588p ps=1.9u w=1.38u l=0.28u
M_M3 a_172_68# A VSS VPW nfet_03v3 ad=0.26p pd=1.52u as=0.44p ps=2.88u w=1u l=0.28u
M_M4 a_2412_440# D Y VNW pfet_03v3 ad=0.3588p pd=1.9u as=0.3588p ps=1.9u w=1.38u l=0.28u
M_M5 VSS C Y VPW nfet_03v3 ad=0.26p pd=1.52u as=0.26p ps=1.52u w=1u l=0.28u
M_M6 VSS C Y VPW nfet_03v3 ad=0.44p pd=2.88u as=0.26p ps=1.52u w=1u l=0.28u
M_M7 a_28_440# A VDD VNW pfet_03v3 ad=0.3588p pd=1.9u as=0.3588p ps=1.9u w=1.38u l=0.28u
M_M8 a_1772_440# C a_28_440# VNW pfet_03v3 ad=0.3588p pd=1.9u as=0.3588p ps=1.9u w=1.38u l=0.28u
M_M9 a_172_68# B Y VPW nfet_03v3 ad=0.26p pd=1.52u as=0.26p ps=1.52u w=1u l=0.28u
M_M10 a_1452_440# C a_28_440# VNW pfet_03v3 ad=0.3588p pd=1.9u as=0.3588p ps=1.9u w=1.38u l=0.28u
M_M11 Y D a_1772_440# VNW pfet_03v3 ad=0.3588p pd=1.9u as=0.3588p ps=1.9u w=1.38u l=0.28u
M_M12 Y C VSS VPW nfet_03v3 ad=0.26p pd=1.52u as=0.26p ps=1.52u w=1u l=0.28u
M_M13 Y D VSS VPW nfet_03v3 ad=0.26p pd=1.52u as=0.26p ps=1.52u w=1u l=0.28u
M_M14 VDD A a_28_440# VNW pfet_03v3 ad=0.3588p pd=1.9u as=0.3588p ps=1.9u w=1.38u l=0.28u
M_M15 a_28_440# B VDD VNW pfet_03v3 ad=0.3588p pd=1.9u as=0.3588p ps=1.9u w=1.38u l=0.28u
M_M16 Y B a_172_68# VPW nfet_03v3 ad=0.26p pd=1.52u as=0.26p ps=1.52u w=1u l=0.28u
M_M17 a_1452_440# D Y VNW pfet_03v3 ad=0.3588p pd=1.9u as=0.3588p ps=1.9u w=1.38u l=0.28u
M_M18 a_28_440# C a_2412_440# VNW pfet_03v3 ad=0.6072p pd=3.64u as=0.3588p ps=1.9u w=1.38u l=0.28u
M_M19 VSS A a_172_68# VPW nfet_03v3 ad=0.26p pd=1.52u as=0.26p ps=1.52u w=1u l=0.28u
M_M20 VSS D Y VPW nfet_03v3 ad=0.26p pd=1.52u as=0.26p ps=1.52u w=1u l=0.28u
M_M21 a_28_440# B VDD VNW pfet_03v3 ad=0.3588p pd=1.9u as=0.3588p ps=1.9u w=1.38u l=0.28u
M_M22 Y D a_1452_440# VNW pfet_03v3 ad=0.3588p pd=1.9u as=0.3588p ps=1.9u w=1.38u l=0.28u
M_M23 a_172_68# A VSS VPW nfet_03v3 ad=0.26p pd=1.52u as=0.26p ps=1.52u w=1u l=0.28u
M_M24 VSS D Y VPW nfet_03v3 ad=0.26p pd=1.52u as=0.26p ps=1.52u w=1u l=0.28u
M_M25 VDD B a_28_440# VNW pfet_03v3 ad=0.3588p pd=1.9u as=0.3588p ps=1.9u w=1.38u l=0.28u
M_M26 a_28_440# C a_1452_440# VNW pfet_03v3 ad=0.3588p pd=1.9u as=0.3588p ps=1.9u w=1.38u l=0.28u
M_M27 a_172_68# B Y VPW nfet_03v3 ad=0.26p pd=1.52u as=0.26p ps=1.52u w=1u l=0.28u
M_M28 Y D VSS VPW nfet_03v3 ad=0.26p pd=1.52u as=0.26p ps=1.52u w=1u l=0.28u
M_M29 VDD A a_28_440# VNW pfet_03v3 ad=0.3588p pd=1.9u as=0.6072p ps=3.64u w=1.38u l=0.28u
M_M30 VSS A a_172_68# VPW nfet_03v3 ad=0.26p pd=1.52u as=0.26p ps=1.52u w=1u l=0.28u
M_M31 Y C VSS VPW nfet_03v3 ad=0.26p pd=1.52u as=0.26p ps=1.52u w=1u l=0.28u
.ends

* NGSPICE file created from gf180mcu_as_sc_mcu7t3v3__aoi21_2.ext - technology: gf180mcuD

.subckt gf180mcu_as_sc_mcu7t3v3__aoi21_2 VDD VNW VPW VSS Y C B A
M_M0 VSS C Y VPW nfet_03v3 ad=0.45p pd=2.9u as=0.26p ps=1.52u w=1u l=0.28u
M_M1 a_28_440# B VDD VNW pfet_03v3 ad=0.3588p pd=1.9u as=0.3588p ps=1.9u w=1.38u l=0.28u
M_M2 Y C a_28_440# VNW pfet_03v3 ad=0.3588p pd=1.9u as=0.3588p ps=1.9u w=1.38u l=0.28u
M_M3 a_172_68# A VSS VPW nfet_03v3 ad=0.26p pd=1.52u as=0.44p ps=2.88u w=1u l=0.28u
M_M4 Y C VSS VPW nfet_03v3 ad=0.26p pd=1.52u as=0.26p ps=1.52u w=1u l=0.28u
M_M5 VDD B a_28_440# VNW pfet_03v3 ad=0.3588p pd=1.9u as=0.3588p ps=1.9u w=1.38u l=0.28u
M_M6 a_28_440# C Y VNW pfet_03v3 ad=0.621p pd=3.66u as=0.3588p ps=1.9u w=1.38u l=0.28u
M_M7 VSS A a_492_68# VPW nfet_03v3 ad=0.26p pd=1.52u as=0.26p ps=1.52u w=1u l=0.28u
M_M8 a_28_440# A VDD VNW pfet_03v3 ad=0.3588p pd=1.9u as=0.3588p ps=1.9u w=1.38u l=0.28u
M_M9 a_492_68# B Y VPW nfet_03v3 ad=0.26p pd=1.52u as=0.26p ps=1.52u w=1u l=0.28u
M_M10 VDD A a_28_440# VNW pfet_03v3 ad=0.3588p pd=1.9u as=0.6072p ps=3.64u w=1.38u l=0.28u
M_M11 Y B a_172_68# VPW nfet_03v3 ad=0.26p pd=1.52u as=0.26p ps=1.52u w=1u l=0.28u
.ends

* NGSPICE file created from gf180mcu_as_sc_mcu7t3v3__aoi21_4.ext - technology: gf180mcuD

.subckt gf180mcu_as_sc_mcu7t3v3__aoi21_4 VDD VNW VPW VSS Y C B A
M_M0 Y A a_812_68# VPW nfet_03v3 ad=0.26p pd=1.52u as=0.26p ps=1.52u w=1u l=0.28u
M_M1 a_28_440# C Y VNW pfet_03v3 ad=0.3588p pd=1.9u as=0.3588p ps=1.9u w=1.38u l=0.28u
M_M2 VDD B a_28_440# VNW pfet_03v3 ad=0.3588p pd=1.9u as=0.3588p ps=1.9u w=1.38u l=0.28u
M_M3 Y C VSS VPW nfet_03v3 ad=0.26p pd=1.52u as=0.44p ps=2.88u w=1u l=0.28u
M_M4 VSS B a_812_68# VPW nfet_03v3 ad=0.26p pd=1.52u as=0.26p ps=1.52u w=1u l=0.28u
M_M5 a_28_440# A VDD VNW pfet_03v3 ad=0.3588p pd=1.9u as=0.3588p ps=1.9u w=1.38u l=0.28u
M_M6 VDD B a_28_440# VNW pfet_03v3 ad=0.3588p pd=1.9u as=0.3588p ps=1.9u w=1.38u l=0.28u
M_M7 a_812_68# B VSS VPW nfet_03v3 ad=0.26p pd=1.52u as=0.26p ps=1.52u w=1u l=0.28u
M_M8 VDD A a_28_440# VNW pfet_03v3 ad=0.3588p pd=1.9u as=0.3588p ps=1.9u w=1.38u l=0.28u
M_M9 a_28_440# B VDD VNW pfet_03v3 ad=0.6348p pd=3.68u as=0.3588p ps=1.9u w=1.38u l=0.28u
M_M10 a_812_68# A Y VPW nfet_03v3 ad=0.26p pd=1.52u as=0.26p ps=1.52u w=1u l=0.28u
M_M11 Y C a_28_440# VNW pfet_03v3 ad=0.3588p pd=1.9u as=0.3588p ps=1.9u w=1.38u l=0.28u
M_M12 a_28_440# A VDD VNW pfet_03v3 ad=0.3588p pd=1.9u as=0.3588p ps=1.9u w=1.38u l=0.28u
M_M13 VSS C Y VPW nfet_03v3 ad=0.26p pd=1.52u as=0.26p ps=1.52u w=1u l=0.28u
M_M14 Y A a_812_68# VPW nfet_03v3 ad=0.26p pd=1.52u as=0.26p ps=1.52u w=1u l=0.28u
M_M15 a_28_440# C Y VNW pfet_03v3 ad=0.3588p pd=1.9u as=0.3588p ps=1.9u w=1.38u l=0.28u
M_M16 Y C VSS VPW nfet_03v3 ad=0.26p pd=1.52u as=0.26p ps=1.52u w=1u l=0.28u
M_M17 VSS B a_812_68# VPW nfet_03v3 ad=0.46p pd=2.92u as=0.26p ps=1.52u w=1u l=0.28u
M_M18 VDD A a_28_440# VNW pfet_03v3 ad=0.3588p pd=1.9u as=0.3588p ps=1.9u w=1.38u l=0.28u
M_M19 a_28_440# B VDD VNW pfet_03v3 ad=0.3588p pd=1.9u as=0.3588p ps=1.9u w=1.38u l=0.28u
M_M20 a_812_68# A Y VPW nfet_03v3 ad=0.26p pd=1.52u as=0.26p ps=1.52u w=1u l=0.28u
M_M21 Y C a_28_440# VNW pfet_03v3 ad=0.3588p pd=1.9u as=0.6072p ps=3.64u w=1.38u l=0.28u
M_M22 VSS C Y VPW nfet_03v3 ad=0.26p pd=1.52u as=0.26p ps=1.52u w=1u l=0.28u
M_M23 a_812_68# B VSS VPW nfet_03v3 ad=0.26p pd=1.52u as=0.26p ps=1.52u w=1u l=0.28u
.ends

* NGSPICE file created from gf180mcu_as_sc_mcu7t3v3__aoi21b_2.ext - technology: gf180mcuD

.subckt gf180mcu_as_sc_mcu7t3v3__aoi21b_2 VDD VNW VPW VSS Y C B A
M_M0 a_364_440# C Y VNW pfet_03v3 ad=0.621p pd=3.66u as=0.3588p ps=1.9u w=1.38u l=0.28u
M_M1 Y B a_508_68# VPW nfet_03v3 ad=0.26p pd=1.52u as=0.26p ps=1.52u w=1u l=0.28u
M_M2 VSS C Y VPW nfet_03v3 ad=0.45p pd=2.9u as=0.26p ps=1.52u w=1u l=0.28u
M_M3 a_220_68# A VSS VPW nfet_03v3 ad=0.44p pd=2.88u as=0.47p ps=2.94u w=1u l=0.28u
M_M4 a_508_68# a_220_68# VSS VPW nfet_03v3 ad=0.26p pd=1.52u as=0.44p ps=2.88u w=1u l=0.28u
M_M5 a_220_68# A VDD VNW pfet_03v3 ad=0.6072p pd=3.64u as=0.6348p ps=3.68u w=1.38u l=0.28u
M_M6 VDD a_220_68# a_364_440# VNW pfet_03v3 ad=0.3588p pd=1.9u as=0.6072p ps=3.64u w=1.38u l=0.28u
M_M7 a_364_440# a_220_68# VDD VNW pfet_03v3 ad=0.3588p pd=1.9u as=0.3588p ps=1.9u w=1.38u l=0.28u
M_M8 Y C VSS VPW nfet_03v3 ad=0.26p pd=1.52u as=0.26p ps=1.52u w=1u l=0.28u
M_M9 Y C a_364_440# VNW pfet_03v3 ad=0.3588p pd=1.9u as=0.3588p ps=1.9u w=1.38u l=0.28u
M_M10 VSS a_220_68# a_828_68# VPW nfet_03v3 ad=0.26p pd=1.52u as=0.26p ps=1.52u w=1u l=0.28u
M_M11 a_364_440# B VDD VNW pfet_03v3 ad=0.3588p pd=1.9u as=0.3588p ps=1.9u w=1.38u l=0.28u
M_M12 a_828_68# B Y VPW nfet_03v3 ad=0.26p pd=1.52u as=0.26p ps=1.52u w=1u l=0.28u
M_M13 VDD B a_364_440# VNW pfet_03v3 ad=0.3588p pd=1.9u as=0.3588p ps=1.9u w=1.38u l=0.28u
.ends

* NGSPICE file created from gf180mcu_as_sc_mcu7t3v3__aoi21b_4.ext - technology: gf180mcuD

.subckt gf180mcu_as_sc_mcu7t3v3__aoi21b_4 VDD VNW VPW VSS Y C A B
M_M0 VSS A a_713_318# VPW nfet_03v3 ad=0.44p pd=2.88u as=0.44p ps=2.88u w=1u l=0.28u
M_M1 Y B a_812_68# VPW nfet_03v3 ad=0.26p pd=1.52u as=0.26p ps=1.52u w=1u l=0.28u
M_M2 a_28_440# C Y VNW pfet_03v3 ad=0.3588p pd=1.9u as=0.3588p ps=1.9u w=1.38u l=0.28u
M_M3 VDD a_713_318# a_28_440# VNW pfet_03v3 ad=0.3588p pd=1.9u as=0.3588p ps=1.9u w=1.38u l=0.28u
M_M4 Y C VSS VPW nfet_03v3 ad=0.26p pd=1.52u as=0.44p ps=2.88u w=1u l=0.28u
M_M5 VSS a_713_318# a_812_68# VPW nfet_03v3 ad=0.26p pd=1.52u as=0.26p ps=1.52u w=1u l=0.28u
M_M6 a_28_440# B VDD VNW pfet_03v3 ad=0.3588p pd=1.9u as=0.3588p ps=1.9u w=1.38u l=0.28u
M_M7 VDD a_713_318# a_28_440# VNW pfet_03v3 ad=0.3588p pd=1.9u as=0.3588p ps=1.9u w=1.38u l=0.28u
M_M8 a_812_68# a_713_318# VSS VPW nfet_03v3 ad=0.26p pd=1.52u as=0.26p ps=1.52u w=1u l=0.28u
M_M9 VDD B a_28_440# VNW pfet_03v3 ad=0.3588p pd=1.9u as=0.3588p ps=1.9u w=1.38u l=0.28u
M_M10 a_28_440# a_713_318# VDD VNW pfet_03v3 ad=0.6348p pd=3.68u as=0.3588p ps=1.9u w=1.38u l=0.28u
M_M11 a_812_68# B Y VPW nfet_03v3 ad=0.26p pd=1.52u as=0.26p ps=1.52u w=1u l=0.28u
M_M12 Y C a_28_440# VNW pfet_03v3 ad=0.3588p pd=1.9u as=0.3588p ps=1.9u w=1.38u l=0.28u
M_M13 a_28_440# B VDD VNW pfet_03v3 ad=0.3588p pd=1.9u as=0.3588p ps=1.9u w=1.38u l=0.28u
M_M14 VSS C Y VPW nfet_03v3 ad=0.26p pd=1.52u as=0.26p ps=1.52u w=1u l=0.28u
M_M15 Y B a_812_68# VPW nfet_03v3 ad=0.26p pd=1.52u as=0.26p ps=1.52u w=1u l=0.28u
M_M16 a_28_440# C Y VNW pfet_03v3 ad=0.3588p pd=1.9u as=0.3588p ps=1.9u w=1.38u l=0.28u
M_M17 Y C VSS VPW nfet_03v3 ad=0.26p pd=1.52u as=0.26p ps=1.52u w=1u l=0.28u
M_M18 VSS a_713_318# a_812_68# VPW nfet_03v3 ad=0.46p pd=2.92u as=0.26p ps=1.52u w=1u l=0.28u
M_M19 VDD B a_28_440# VNW pfet_03v3 ad=0.3588p pd=1.9u as=0.3588p ps=1.9u w=1.38u l=0.28u
M_M20 a_28_440# a_713_318# VDD VNW pfet_03v3 ad=0.3588p pd=1.9u as=0.3588p ps=1.9u w=1.38u l=0.28u
M_M21 a_812_68# B Y VPW nfet_03v3 ad=0.26p pd=1.52u as=0.26p ps=1.52u w=1u l=0.28u
M_M22 VDD A a_713_318# VNW pfet_03v3 ad=0.6072p pd=3.64u as=0.6072p ps=3.64u w=1.38u l=0.28u
M_M23 Y C a_28_440# VNW pfet_03v3 ad=0.3588p pd=1.9u as=0.6072p ps=3.64u w=1.38u l=0.28u
M_M24 VSS C Y VPW nfet_03v3 ad=0.26p pd=1.52u as=0.26p ps=1.52u w=1u l=0.28u
M_M25 a_812_68# a_713_318# VSS VPW nfet_03v3 ad=0.26p pd=1.52u as=0.26p ps=1.52u w=1u l=0.28u
.ends

* NGSPICE file created from gf180mcu_as_sc_mcu7t3v3__aoi22_2.ext - technology: gf180mcuD

.subckt gf180mcu_as_sc_mcu7t3v3__aoi22_2 VDD VNW VPW VSS Y A B C D
M_M0 a_172_440# D VDD VNW pfet_03v3 ad=0.7797p pd=3.89u as=0.3588p ps=1.9u w=1.38u l=0.28u
M_M1 Y A a_172_440# VNW pfet_03v3 ad=0.3588p pd=1.9u as=0.3588p ps=1.9u w=1.38u l=0.28u
M_M2 VSS A a_28_68# VPW nfet_03v3 ad=0.26p pd=1.52u as=0.44p ps=2.88u w=1u l=0.28u
M_M3 a_803_68# D VSS VPW nfet_03v3 ad=0.565p pd=3.13u as=0.26p ps=1.52u w=1u l=0.28u
M_M4 a_172_440# C VDD VNW pfet_03v3 ad=0.3588p pd=1.9u as=0.3588p ps=1.9u w=1.38u l=0.28u
M_M5 VSS D a_803_68# VPW nfet_03v3 ad=0.26p pd=1.52u as=0.26p ps=1.52u w=1u l=0.28u
M_M6 a_172_440# B Y VNW pfet_03v3 ad=0.3588p pd=1.9u as=0.3588p ps=1.9u w=1.38u l=0.28u
M_M7 a_28_68# B Y VPW nfet_03v3 ad=0.44p pd=2.88u as=0.26p ps=1.52u w=1u l=0.28u
M_M8 a_803_68# C Y VPW nfet_03v3 ad=0.26p pd=1.52u as=0.26p ps=1.52u w=1u l=0.28u
M_M9 Y B a_172_440# VNW pfet_03v3 ad=0.6072p pd=3.64u as=0.3588p ps=1.9u w=1.38u l=0.28u
M_M10 Y B a_28_68# VPW nfet_03v3 ad=0.26p pd=1.52u as=0.26p ps=1.52u w=1u l=0.28u
M_M11 VDD D a_172_440# VNW pfet_03v3 ad=0.3588p pd=1.9u as=0.3588p ps=1.9u w=1.38u l=0.28u
M_M12 VDD C a_172_440# VNW pfet_03v3 ad=0.3588p pd=1.9u as=0.6072p ps=3.64u w=1.38u l=0.28u
M_M13 a_172_440# A Y VNW pfet_03v3 ad=0.3588p pd=1.9u as=0.6072p ps=3.64u w=1.38u l=0.28u
M_M14 a_28_68# A VSS VPW nfet_03v3 ad=0.26p pd=1.52u as=0.26p ps=1.52u w=1u l=0.28u
M_M15 Y C a_803_68# VPW nfet_03v3 ad=0.26p pd=1.52u as=0.44p ps=2.88u w=1u l=0.28u
.ends

* NGSPICE file created from gf180mcu_as_sc_mcu7t3v3__aoi22_4.ext - technology: gf180mcuD

.subckt gf180mcu_as_sc_mcu7t3v3__aoi22_4 VDD VNW VPW VSS Y A B C D
M_M0 a_28_440# C VDD VNW pfet_03v3 ad=0.3588p pd=1.9u as=0.3588p ps=1.9u w=1.38u l=0.28u
M_M1 a_28_68# B Y VPW nfet_03v3 ad=0.26p pd=1.52u as=0.26p ps=1.52u w=1u l=0.28u
M_M2 a_28_440# A Y VNW pfet_03v3 ad=0.3588p pd=1.9u as=0.3588p ps=1.9u w=1.38u l=0.28u
M_M3 Y B a_28_440# VNW pfet_03v3 ad=0.3588p pd=1.9u as=0.3588p ps=1.9u w=1.38u l=0.28u
M_M4 VDD D a_28_440# VNW pfet_03v3 ad=0.3588p pd=1.9u as=0.3588p ps=1.9u w=1.38u l=0.28u
M_M5 VSS A a_28_68# VPW nfet_03v3 ad=0.26p pd=1.52u as=0.44p ps=2.88u w=1u l=0.28u
M_M6 VSS D a_1436_68# VPW nfet_03v3 ad=0.26p pd=1.52u as=0.26p ps=1.52u w=1u l=0.28u
M_M7 a_28_440# D VDD VNW pfet_03v3 ad=0.6072p pd=3.64u as=0.3588p ps=1.9u w=1.38u l=0.28u
M_M8 a_28_440# B Y VNW pfet_03v3 ad=0.8004p pd=2.54u as=0.3588p ps=1.9u w=1.38u l=0.28u
M_M9 VDD C a_28_440# VNW pfet_03v3 ad=0.3588p pd=1.9u as=0.8004p ps=2.54u w=1.38u l=0.28u
M_M10 Y C a_1436_68# VPW nfet_03v3 ad=0.26p pd=1.52u as=0.26p ps=1.52u w=1u l=0.28u
M_M11 Y B a_28_68# VPW nfet_03v3 ad=0.26p pd=1.52u as=0.26p ps=1.52u w=1u l=0.28u
M_M12 a_1436_68# C Y VPW nfet_03v3 ad=0.26p pd=1.52u as=0.26p ps=1.52u w=1u l=0.28u
M_M13 a_28_440# C VDD VNW pfet_03v3 ad=0.3588p pd=1.9u as=0.3588p ps=1.9u w=1.38u l=0.28u
M_M14 Y A a_28_440# VNW pfet_03v3 ad=0.3588p pd=1.9u as=0.3588p ps=1.9u w=1.38u l=0.28u
M_M15 a_1436_68# C Y VPW nfet_03v3 ad=0.26p pd=1.52u as=0.26p ps=1.52u w=1u l=0.28u
M_M16 a_1436_68# D VSS VPW nfet_03v3 ad=0.44p pd=2.88u as=0.26p ps=1.52u w=1u l=0.28u
M_M17 a_28_440# B Y VNW pfet_03v3 ad=0.3588p pd=1.9u as=0.3588p ps=1.9u w=1.38u l=0.28u
M_M18 a_28_68# A VSS VPW nfet_03v3 ad=0.26p pd=1.52u as=0.26p ps=1.52u w=1u l=0.28u
M_M19 a_28_440# D VDD VNW pfet_03v3 ad=0.3588p pd=1.9u as=0.3588p ps=1.9u w=1.38u l=0.28u
M_M20 a_28_68# B Y VPW nfet_03v3 ad=0.44p pd=2.88u as=0.26p ps=1.52u w=1u l=0.28u
M_M21 a_28_440# A Y VNW pfet_03v3 ad=0.3588p pd=1.9u as=0.3588p ps=1.9u w=1.38u l=0.28u
M_M22 Y C a_1436_68# VPW nfet_03v3 ad=0.26p pd=1.52u as=0.44p ps=2.88u w=1u l=0.28u
M_M23 VDD D a_28_440# VNW pfet_03v3 ad=0.3588p pd=1.9u as=0.3588p ps=1.9u w=1.38u l=0.28u
M_M24 VSS A a_28_68# VPW nfet_03v3 ad=0.26p pd=1.52u as=0.26p ps=1.52u w=1u l=0.28u
M_M25 VSS D a_1436_68# VPW nfet_03v3 ad=0.26p pd=1.52u as=0.26p ps=1.52u w=1u l=0.28u
M_M26 Y B a_28_440# VNW pfet_03v3 ad=0.3588p pd=1.9u as=0.3588p ps=1.9u w=1.38u l=0.28u
M_M27 VDD C a_28_440# VNW pfet_03v3 ad=0.3588p pd=1.9u as=0.3588p ps=1.9u w=1.38u l=0.28u
M_M28 Y B a_28_68# VPW nfet_03v3 ad=0.26p pd=1.52u as=0.26p ps=1.52u w=1u l=0.28u
M_M29 Y A a_28_440# VNW pfet_03v3 ad=0.3588p pd=1.9u as=0.6072p ps=3.64u w=1.38u l=0.28u
M_M30 a_1436_68# D VSS VPW nfet_03v3 ad=0.26p pd=1.52u as=0.26p ps=1.52u w=1u l=0.28u
M_M31 a_28_68# A VSS VPW nfet_03v3 ad=0.26p pd=1.52u as=0.26p ps=1.52u w=1u l=0.28u
.ends

* NGSPICE file created from gf180mcu_as_sc_mcu7t3v3__aoi31_2.ext - technology: gf180mcuD

.subckt gf180mcu_as_sc_mcu7t3v3__aoi31_2 VDD VNW VPW VSS A B C Y D
M_M0 a_28_440# A VDD VNW pfet_03v3 ad=0.3588p pd=1.9u as=0.3588p ps=1.9u w=1.38u l=0.28u
M_M1 VSS D Y VPW nfet_03v3 ad=0.2625p pd=1.525u as=0.26p ps=1.52u w=1u l=0.28u
M_M2 VSS A a_28_68# VPW nfet_03v3 ad=0.26p pd=1.52u as=0.44p ps=2.88u w=1u l=0.28u
M_M3 a_28_440# C VDD VNW pfet_03v3 ad=0.3588p pd=1.9u as=0.3588p ps=1.9u w=1.38u l=0.28u
M_M4 Y C a_492_68# VPW nfet_03v3 ad=0.26p pd=1.52u as=0.26p ps=1.52u w=1u l=0.28u
M_M5 VDD B a_28_440# VNW pfet_03v3 ad=0.3588p pd=1.9u as=0.3588p ps=1.9u w=1.38u l=0.28u
M_M6 a_28_68# B a_492_68# VPW nfet_03v3 ad=0.44p pd=2.88u as=0.26p ps=1.52u w=1u l=0.28u
M_M7 Y D a_28_440# VNW pfet_03v3 ad=0.36225p pd=1.905u as=0.3588p ps=1.9u w=1.38u l=0.28u
M_M8 a_28_440# B VDD VNW pfet_03v3 ad=0.8004p pd=2.54u as=0.3588p ps=1.9u w=1.38u l=0.28u
M_M9 VDD C a_28_440# VNW pfet_03v3 ad=0.3588p pd=1.9u as=0.8004p ps=2.54u w=1.38u l=0.28u
M_M10 a_492_68# C Y VPW nfet_03v3 ad=0.26p pd=1.52u as=0.44p ps=2.88u w=1u l=0.28u
M_M11 a_492_68# B a_28_68# VPW nfet_03v3 ad=0.26p pd=1.52u as=0.26p ps=1.52u w=1u l=0.28u
M_M12 Y D VSS VPW nfet_03v3 ad=0.44p pd=2.88u as=0.2625p ps=1.525u w=1u l=0.28u
M_M13 VDD A a_28_440# VNW pfet_03v3 ad=0.3588p pd=1.9u as=0.6072p ps=3.64u w=1.38u l=0.28u
M_M14 a_28_440# D Y VNW pfet_03v3 ad=0.6072p pd=3.64u as=0.36225p ps=1.905u w=1.38u l=0.28u
M_M15 a_28_68# A VSS VPW nfet_03v3 ad=0.26p pd=1.52u as=0.26p ps=1.52u w=1u l=0.28u
.ends

* NGSPICE file created from gf180mcu_as_sc_mcu7t3v3__aoi31_4.ext - technology: gf180mcuD

.subckt gf180mcu_as_sc_mcu7t3v3__aoi31_4 VDD VNW VPW VSS A B C D Y
M_M0 a_28_440# C VDD VNW pfet_03v3 ad=0.3588p pd=1.9u as=0.3588p ps=1.9u w=1.38u l=0.28u
M_M1 a_28_68# B a_812_68# VPW nfet_03v3 ad=0.26p pd=1.52u as=0.26p ps=1.52u w=1u l=0.28u
M_M2 a_28_440# A VDD VNW pfet_03v3 ad=0.3588p pd=1.9u as=0.3588p ps=1.9u w=1.38u l=0.28u
M_M3 VDD B a_28_440# VNW pfet_03v3 ad=0.3588p pd=1.9u as=0.3588p ps=1.9u w=1.38u l=0.28u
M_M4 Y D a_28_440# VNW pfet_03v3 ad=0.3588p pd=1.9u as=0.3588p ps=1.9u w=1.38u l=0.28u
M_M5 VSS A a_28_68# VPW nfet_03v3 ad=0.26p pd=1.52u as=0.44p ps=2.88u w=1u l=0.28u
M_M6 VSS D Y VPW nfet_03v3 ad=0.26p pd=1.52u as=0.26p ps=1.52u w=1u l=0.28u
M_M7 a_28_440# D Y VNW pfet_03v3 ad=1.2696p pd=4.6u as=0.3588p ps=1.9u w=1.38u l=0.28u
M_M8 a_28_440# B VDD VNW pfet_03v3 ad=0.8004p pd=2.54u as=0.3588p ps=1.9u w=1.38u l=0.28u
M_M9 VDD C a_28_440# VNW pfet_03v3 ad=0.3588p pd=1.9u as=0.8004p ps=2.54u w=1.38u l=0.28u
M_M10 a_812_68# C Y VPW nfet_03v3 ad=0.26p pd=1.52u as=0.26p ps=1.52u w=1u l=0.28u
M_M11 a_812_68# B a_28_68# VPW nfet_03v3 ad=0.26p pd=1.52u as=0.26p ps=1.52u w=1u l=0.28u
M_M12 Y C a_812_68# VPW nfet_03v3 ad=0.26p pd=1.52u as=0.26p ps=1.52u w=1u l=0.28u
M_M13 a_28_440# C VDD VNW pfet_03v3 ad=0.3588p pd=1.9u as=0.3588p ps=1.9u w=1.38u l=0.28u
M_M14 VDD A a_28_440# VNW pfet_03v3 ad=0.3588p pd=1.9u as=0.3588p ps=1.9u w=1.38u l=0.28u
M_M15 Y C a_812_68# VPW nfet_03v3 ad=0.26p pd=1.52u as=0.26p ps=1.52u w=1u l=0.28u
M_M16 Y D VSS VPW nfet_03v3 ad=0.44p pd=2.88u as=0.26p ps=1.52u w=1u l=0.28u
M_M17 a_28_440# B VDD VNW pfet_03v3 ad=0.3588p pd=1.9u as=0.3588p ps=1.9u w=1.38u l=0.28u
M_M18 a_28_68# A VSS VPW nfet_03v3 ad=0.26p pd=1.52u as=0.26p ps=1.52u w=1u l=0.28u
M_M19 a_28_440# D Y VNW pfet_03v3 ad=0.3588p pd=1.9u as=0.3588p ps=1.9u w=1.38u l=0.28u
M_M20 a_28_68# B a_812_68# VPW nfet_03v3 ad=0.44p pd=2.88u as=0.26p ps=1.52u w=1u l=0.28u
M_M21 a_28_440# A VDD VNW pfet_03v3 ad=0.3588p pd=1.9u as=0.3588p ps=1.9u w=1.38u l=0.28u
M_M22 a_812_68# C Y VPW nfet_03v3 ad=0.26p pd=1.52u as=0.44p ps=2.88u w=1u l=0.28u
M_M23 Y D a_28_440# VNW pfet_03v3 ad=0.3588p pd=1.9u as=0.3588p ps=1.9u w=1.38u l=0.28u
M_M24 VSS A a_28_68# VPW nfet_03v3 ad=0.26p pd=1.52u as=0.26p ps=1.52u w=1u l=0.28u
M_M25 VSS D Y VPW nfet_03v3 ad=0.26p pd=1.52u as=0.26p ps=1.52u w=1u l=0.28u
M_M26 VDD B a_28_440# VNW pfet_03v3 ad=0.3588p pd=1.9u as=0.3588p ps=1.9u w=1.38u l=0.28u
M_M27 VDD C a_28_440# VNW pfet_03v3 ad=0.3588p pd=1.9u as=0.3588p ps=1.9u w=1.38u l=0.28u
M_M28 a_812_68# B a_28_68# VPW nfet_03v3 ad=0.26p pd=1.52u as=0.26p ps=1.52u w=1u l=0.28u
M_M29 VDD A a_28_440# VNW pfet_03v3 ad=0.3588p pd=1.9u as=0.6072p ps=3.64u w=1.38u l=0.28u
M_M30 Y D VSS VPW nfet_03v3 ad=0.26p pd=1.52u as=0.26p ps=1.52u w=1u l=0.28u
M_M31 a_28_68# A VSS VPW nfet_03v3 ad=0.26p pd=1.52u as=0.26p ps=1.52u w=1u l=0.28u
.ends

* NGSPICE file created from gf180mcu_as_sc_mcu7t3v3__buff_12.ext - technology: gf180mcuD

.subckt gf180mcu_as_sc_mcu7t3v3__buff_12 VDD VNW VPW VSS A Y
M_M0 VSS a_172_68# Y VPW nfet_03v3 ad=0.985p pd=3.97u as=0.26p ps=1.52u w=1u l=0.28u
M_M1 VSS a_172_68# Y VPW nfet_03v3 ad=0.26p pd=1.52u as=0.26p ps=1.52u w=1u l=0.28u
M_M2 VDD A a_172_68# VNW pfet_03v3 ad=0.3588p pd=1.9u as=0.3588p ps=1.9u w=1.38u l=0.28u
M_M3 Y a_172_68# VDD VNW pfet_03v3 ad=0.3588p pd=1.9u as=0.3588p ps=1.9u w=1.38u l=0.28u
M_M4 Y a_172_68# VDD VNW pfet_03v3 ad=0.3588p pd=1.9u as=0.3588p ps=1.9u w=1.38u l=0.28u
M_M5 VDD a_172_68# Y VNW pfet_03v3 ad=1.3593p pd=4.73u as=0.3588p ps=1.9u w=1.38u l=0.28u
M_M6 a_172_68# A VSS VPW nfet_03v3 ad=0.26p pd=1.52u as=0.44p ps=2.88u w=1u l=0.28u
M_M7 VSS a_172_68# Y VPW nfet_03v3 ad=0.26p pd=1.52u as=0.26p ps=1.52u w=1u l=0.28u
M_M8 VDD a_172_68# Y VNW pfet_03v3 ad=0.3588p pd=1.9u as=0.3588p ps=1.9u w=1.38u l=0.28u
M_M9 Y a_172_68# VDD VNW pfet_03v3 ad=0.36915p pd=1.915u as=0.3588p ps=1.9u w=1.38u l=0.28u
M_M10 VDD a_172_68# Y VNW pfet_03v3 ad=0.3588p pd=1.9u as=0.3588p ps=1.9u w=1.38u l=0.28u
M_M11 Y a_172_68# VSS VPW nfet_03v3 ad=0.26p pd=1.52u as=0.26p ps=1.52u w=1u l=0.28u
M_M12 Y a_172_68# VSS VPW nfet_03v3 ad=0.26p pd=1.52u as=0.26p ps=1.52u w=1u l=0.28u
M_M13 Y a_172_68# VDD VNW pfet_03v3 ad=0.3588p pd=1.9u as=0.3588p ps=1.9u w=1.38u l=0.28u
M_M14 Y a_172_68# VSS VPW nfet_03v3 ad=0.26p pd=1.52u as=0.26p ps=1.52u w=1u l=0.28u
M_M15 a_172_68# A VDD VNW pfet_03v3 ad=0.3588p pd=1.9u as=0.3588p ps=1.9u w=1.38u l=0.28u
M_M16 VSS a_172_68# Y VPW nfet_03v3 ad=0.26p pd=1.52u as=0.26p ps=1.52u w=1u l=0.28u
M_M17 VDD a_172_68# Y VNW pfet_03v3 ad=0.3588p pd=1.9u as=0.3588p ps=1.9u w=1.38u l=0.28u
M_M18 VSS A a_172_68# VPW nfet_03v3 ad=0.26p pd=1.52u as=0.26p ps=1.52u w=1u l=0.28u
M_M19 VSS a_172_68# Y VPW nfet_03v3 ad=0.26p pd=1.52u as=0.26p ps=1.52u w=1u l=0.28u
M_M20 VSS a_172_68# Y VPW nfet_03v3 ad=0.26p pd=1.52u as=0.2675p ps=1.535u w=1u l=0.28u
M_M21 VDD A a_172_68# VNW pfet_03v3 ad=0.3588p pd=1.9u as=0.3588p ps=1.9u w=1.38u l=0.28u
M_M22 Y a_172_68# VSS VPW nfet_03v3 ad=0.26p pd=1.52u as=0.26p ps=1.52u w=1u l=0.28u
M_M23 Y a_172_68# VDD VNW pfet_03v3 ad=0.3588p pd=1.9u as=0.3588p ps=1.9u w=1.38u l=0.28u
M_M24 a_172_68# A VSS VPW nfet_03v3 ad=0.26p pd=1.52u as=0.26p ps=1.52u w=1u l=0.28u
M_M25 Y a_172_68# VDD VNW pfet_03v3 ad=0.3588p pd=1.9u as=0.3588p ps=1.9u w=1.38u l=0.28u
M_M26 VDD a_172_68# Y VNW pfet_03v3 ad=0.3588p pd=1.9u as=0.3588p ps=1.9u w=1.38u l=0.28u
M_M27 Y a_172_68# VSS VPW nfet_03v3 ad=0.26p pd=1.52u as=0.26p ps=1.52u w=1u l=0.28u
M_M28 a_172_68# A VDD VNW pfet_03v3 ad=0.3588p pd=1.9u as=0.6072p ps=3.64u w=1.38u l=0.28u
M_M29 VDD a_172_68# Y VNW pfet_03v3 ad=0.3588p pd=1.9u as=0.36915p ps=1.915u w=1.38u l=0.28u
M_M30 VSS A a_172_68# VPW nfet_03v3 ad=0.26p pd=1.52u as=0.26p ps=1.52u w=1u l=0.28u
M_M31 Y a_172_68# VSS VPW nfet_03v3 ad=0.2675p pd=1.535u as=0.26p ps=1.52u w=1u l=0.28u
.ends

* NGSPICE file created from gf180mcu_as_sc_mcu7t3v3__buff_16.ext - technology: gf180mcuD

.subckt gf180mcu_as_sc_mcu7t3v3__buff_16 VDD VNW VPW VSS A Y
M_M0 VDD a_172_68# Y VNW pfet_03v3 ad=0.8073p pd=3.93u as=0.3588p ps=1.9u w=1.38u l=0.28u
M_M1 VSS a_172_68# Y VPW nfet_03v3 ad=0.26p pd=1.52u as=0.26p ps=1.52u w=1u l=0.28u
M_M2 VSS a_172_68# Y VPW nfet_03v3 ad=0.26p pd=1.52u as=0.26p ps=1.52u w=1u l=0.28u
M_M3 VDD A a_172_68# VNW pfet_03v3 ad=0.3588p pd=1.9u as=0.3588p ps=1.9u w=1.38u l=0.28u
M_M4 Y a_172_68# VDD VNW pfet_03v3 ad=0.3588p pd=1.9u as=0.3588p ps=1.9u w=1.38u l=0.28u
M_M5 Y a_172_68# VDD VNW pfet_03v3 ad=0.3588p pd=1.9u as=0.3588p ps=1.9u w=1.38u l=0.28u
M_M6 VDD a_172_68# Y VNW pfet_03v3 ad=0.3588p pd=1.9u as=0.3588p ps=1.9u w=1.38u l=0.28u
M_M7 a_172_68# A VSS VPW nfet_03v3 ad=0.26p pd=1.52u as=0.44p ps=2.88u w=1u l=0.28u
M_M8 VSS a_172_68# Y VPW nfet_03v3 ad=0.26p pd=1.52u as=0.26p ps=1.52u w=1u l=0.28u
M_M9 VDD a_172_68# Y VNW pfet_03v3 ad=0.3588p pd=1.9u as=0.3588p ps=1.9u w=1.38u l=0.28u
M_M10 Y a_172_68# VDD VNW pfet_03v3 ad=0.36915p pd=1.915u as=0.3588p ps=1.9u w=1.38u l=0.28u
M_M11 VDD a_172_68# Y VNW pfet_03v3 ad=0.3588p pd=1.9u as=0.3588p ps=1.9u w=1.38u l=0.28u
M_M12 Y a_172_68# VSS VPW nfet_03v3 ad=0.26p pd=1.52u as=0.26p ps=1.52u w=1u l=0.28u
M_M13 Y a_172_68# VDD VNW pfet_03v3 ad=0.3588p pd=1.9u as=0.3588p ps=1.9u w=1.38u l=0.28u
M_M14 Y a_172_68# VSS VPW nfet_03v3 ad=0.26p pd=1.52u as=0.26p ps=1.52u w=1u l=0.28u
M_M15 Y a_172_68# VDD VNW pfet_03v3 ad=0.3588p pd=1.9u as=0.3588p ps=1.9u w=1.38u l=0.28u
M_M16 Y a_172_68# VSS VPW nfet_03v3 ad=0.26p pd=1.52u as=0.26p ps=1.52u w=1u l=0.28u
M_M17 Y a_172_68# VSS VPW nfet_03v3 ad=0.26p pd=1.52u as=0.26p ps=1.52u w=1u l=0.28u
M_M18 VSS a_172_68# Y VPW nfet_03v3 ad=0.585p pd=3.17u as=0.26p ps=1.52u w=1u l=0.28u
M_M19 a_172_68# A VDD VNW pfet_03v3 ad=0.3588p pd=1.9u as=0.3588p ps=1.9u w=1.38u l=0.28u
M_M20 VSS a_172_68# Y VPW nfet_03v3 ad=0.26p pd=1.52u as=0.26p ps=1.52u w=1u l=0.28u
M_M21 VDD a_172_68# Y VNW pfet_03v3 ad=0.3588p pd=1.9u as=0.3588p ps=1.9u w=1.38u l=0.28u
M_M22 VSS A a_172_68# VPW nfet_03v3 ad=0.26p pd=1.52u as=0.26p ps=1.52u w=1u l=0.28u
M_M23 VSS a_172_68# Y VPW nfet_03v3 ad=0.26p pd=1.52u as=0.26p ps=1.52u w=1u l=0.28u
M_M24 VSS a_172_68# Y VPW nfet_03v3 ad=0.26p pd=1.52u as=0.2675p ps=1.535u w=1u l=0.28u
M_M25 VSS a_172_68# Y VPW nfet_03v3 ad=0.26p pd=1.52u as=0.26p ps=1.52u w=1u l=0.28u
M_M26 VDD A a_172_68# VNW pfet_03v3 ad=0.3588p pd=1.9u as=0.3588p ps=1.9u w=1.38u l=0.28u
M_M27 Y a_172_68# VSS VPW nfet_03v3 ad=0.26p pd=1.52u as=0.26p ps=1.52u w=1u l=0.28u
M_M28 Y a_172_68# VDD VNW pfet_03v3 ad=0.3588p pd=1.9u as=0.3588p ps=1.9u w=1.38u l=0.28u
M_M29 VDD a_172_68# Y VNW pfet_03v3 ad=0.3588p pd=1.9u as=0.3588p ps=1.9u w=1.38u l=0.28u
M_M30 a_172_68# A VSS VPW nfet_03v3 ad=0.26p pd=1.52u as=0.26p ps=1.52u w=1u l=0.28u
M_M31 Y a_172_68# VDD VNW pfet_03v3 ad=0.3588p pd=1.9u as=0.3588p ps=1.9u w=1.38u l=0.28u
M_M32 VDD a_172_68# Y VNW pfet_03v3 ad=0.3588p pd=1.9u as=0.3588p ps=1.9u w=1.38u l=0.28u
M_M33 Y a_172_68# VSS VPW nfet_03v3 ad=0.26p pd=1.52u as=0.26p ps=1.52u w=1u l=0.28u
M_M34 Y a_172_68# VDD VNW pfet_03v3 ad=0.3588p pd=1.9u as=0.3588p ps=1.9u w=1.38u l=0.28u
M_M35 Y a_172_68# VSS VPW nfet_03v3 ad=0.26p pd=1.52u as=0.26p ps=1.52u w=1u l=0.28u
M_M36 a_172_68# A VDD VNW pfet_03v3 ad=0.3588p pd=1.9u as=0.6072p ps=3.64u w=1.38u l=0.28u
M_M37 VDD a_172_68# Y VNW pfet_03v3 ad=0.3588p pd=1.9u as=0.36915p ps=1.915u w=1.38u l=0.28u
M_M38 VSS A a_172_68# VPW nfet_03v3 ad=0.26p pd=1.52u as=0.26p ps=1.52u w=1u l=0.28u
M_M39 Y a_172_68# VSS VPW nfet_03v3 ad=0.2675p pd=1.535u as=0.26p ps=1.52u w=1u l=0.28u
.ends

* NGSPICE file created from gf180mcu_as_sc_mcu7t3v3__buff_2.ext - technology: gf180mcuD

.subckt gf180mcu_as_sc_mcu7t3v3__buff_2 VDD VNW VPW VSS A Y
M_M0 Y a_28_68# VDD VNW pfet_03v3 ad=0.3588p pd=1.9u as=0.3588p ps=1.9u w=1.38u l=0.28u
M_M1 VSS A a_28_68# VPW nfet_03v3 ad=0.26p pd=1.52u as=0.44p ps=2.88u w=1u l=0.28u
M_M2 VDD a_28_68# Y VNW pfet_03v3 ad=1.0488p pd=4.28u as=0.3588p ps=1.9u w=1.38u l=0.28u
M_M3 VSS a_28_68# Y VPW nfet_03v3 ad=0.76p pd=3.52u as=0.26p ps=1.52u w=1u l=0.28u
M_M4 VDD A a_28_68# VNW pfet_03v3 ad=0.3588p pd=1.9u as=0.6072p ps=3.64u w=1.38u l=0.28u
M_M5 Y a_28_68# VSS VPW nfet_03v3 ad=0.26p pd=1.52u as=0.26p ps=1.52u w=1u l=0.28u
.ends

* NGSPICE file created from gf180mcu_as_sc_mcu7t3v3__buff_4.ext - technology: gf180mcuD

.subckt gf180mcu_as_sc_mcu7t3v3__buff_4 VDD VNW VPW VSS A Y
M_M0 Y a_28_68# VDD VNW pfet_03v3 ad=0.3588p pd=1.9u as=0.3588p ps=1.9u w=1.38u l=0.28u
M_M1 VDD a_28_68# Y VNW pfet_03v3 ad=1.1592p pd=4.44u as=0.3588p ps=1.9u w=1.38u l=0.28u
M_M2 VSS A a_28_68# VPW nfet_03v3 ad=0.26p pd=1.52u as=0.44p ps=2.88u w=1u l=0.28u
M_M3 VSS a_28_68# Y VPW nfet_03v3 ad=0.84p pd=3.68u as=0.26p ps=1.52u w=1u l=0.28u
M_M4 VDD a_28_68# Y VNW pfet_03v3 ad=0.3588p pd=1.9u as=0.3588p ps=1.9u w=1.38u l=0.28u
M_M5 Y a_28_68# VSS VPW nfet_03v3 ad=0.26p pd=1.52u as=0.26p ps=1.52u w=1u l=0.28u
M_M6 Y a_28_68# VDD VNW pfet_03v3 ad=0.3588p pd=1.9u as=0.3588p ps=1.9u w=1.38u l=0.28u
M_M7 VSS a_28_68# Y VPW nfet_03v3 ad=0.26p pd=1.52u as=0.26p ps=1.52u w=1u l=0.28u
M_M8 VDD A a_28_68# VNW pfet_03v3 ad=0.3588p pd=1.9u as=0.6072p ps=3.64u w=1.38u l=0.28u
M_M9 Y a_28_68# VSS VPW nfet_03v3 ad=0.26p pd=1.52u as=0.26p ps=1.52u w=1u l=0.28u
.ends

* NGSPICE file created from gf180mcu_as_sc_mcu7t3v3__buff_8.ext - technology: gf180mcuD

.subckt gf180mcu_as_sc_mcu7t3v3__buff_8 VDD VNW VPW VSS A Y
M_M0 Y a_28_68# VSS VPW nfet_03v3 ad=0.26p pd=1.52u as=0.26p ps=1.52u w=1u l=0.28u
M_M1 a_28_68# A VDD VNW pfet_03v3 ad=0.3588p pd=1.9u as=0.3588p ps=1.9u w=1.38u l=0.28u
M_M2 VDD a_28_68# Y VNW pfet_03v3 ad=0.3588p pd=1.9u as=0.3588p ps=1.9u w=1.38u l=0.28u
M_M3 VSS A a_28_68# VPW nfet_03v3 ad=0.26p pd=1.52u as=0.44p ps=2.88u w=1u l=0.28u
M_M4 Y a_28_68# VSS VPW nfet_03v3 ad=0.26p pd=1.52u as=0.26p ps=1.52u w=1u l=0.28u
M_M5 Y a_28_68# VDD VNW pfet_03v3 ad=0.3588p pd=1.9u as=0.3588p ps=1.9u w=1.38u l=0.28u
M_M6 VDD a_28_68# Y VNW pfet_03v3 ad=1.0833p pd=4.33u as=0.3588p ps=1.9u w=1.38u l=0.28u
M_M7 VSS a_28_68# Y VPW nfet_03v3 ad=0.26p pd=1.52u as=0.26p ps=1.52u w=1u l=0.28u
M_M8 VDD a_28_68# Y VNW pfet_03v3 ad=0.3588p pd=1.9u as=0.3588p ps=1.9u w=1.38u l=0.28u
M_M9 VSS a_28_68# Y VPW nfet_03v3 ad=0.26p pd=1.52u as=0.26p ps=1.52u w=1u l=0.28u
M_M10 VDD A a_28_68# VNW pfet_03v3 ad=0.3588p pd=1.9u as=0.3588p ps=1.9u w=1.38u l=0.28u
M_M11 Y a_28_68# VDD VNW pfet_03v3 ad=0.3588p pd=1.9u as=0.3588p ps=1.9u w=1.38u l=0.28u
M_M12 Y a_28_68# VSS VPW nfet_03v3 ad=0.26p pd=1.52u as=0.26p ps=1.52u w=1u l=0.28u
M_M13 Y a_28_68# VSS VPW nfet_03v3 ad=0.26p pd=1.52u as=0.26p ps=1.52u w=1u l=0.28u
M_M14 Y a_28_68# VDD VNW pfet_03v3 ad=0.3588p pd=1.9u as=0.3588p ps=1.9u w=1.38u l=0.28u
M_M15 VSS A a_28_68# VPW nfet_03v3 ad=0.26p pd=1.52u as=0.26p ps=1.52u w=1u l=0.28u
M_M16 VDD a_28_68# Y VNW pfet_03v3 ad=0.3588p pd=1.9u as=0.3588p ps=1.9u w=1.38u l=0.28u
M_M17 Y a_28_68# VDD VNW pfet_03v3 ad=0.3588p pd=1.9u as=0.3588p ps=1.9u w=1.38u l=0.28u
M_M18 VSS a_28_68# Y VPW nfet_03v3 ad=0.26p pd=1.52u as=0.26p ps=1.52u w=1u l=0.28u
M_M19 VDD A a_28_68# VNW pfet_03v3 ad=0.3588p pd=1.9u as=0.6072p ps=3.64u w=1.38u l=0.28u
M_M20 a_28_68# A VSS VPW nfet_03v3 ad=0.26p pd=1.52u as=0.26p ps=1.52u w=1u l=0.28u
M_M21 VSS a_28_68# Y VPW nfet_03v3 ad=0.785p pd=3.57u as=0.26p ps=1.52u w=1u l=0.28u
.ends

* NGSPICE file created from gf180mcu_as_sc_mcu7t3v3__clkbuff_12.ext - technology: gf180mcuD

.subckt gf180mcu_as_sc_mcu7t3v3__clkbuff_12 VDD VNW VPW VSS A Y
M_M0 VSS a_172_68# Y VPW nfet_03v3 ad=0.7092p pd=3.41u as=0.1872p ps=1.24u w=0.72u l=0.28u
M_M1 VSS a_172_68# Y VPW nfet_03v3 ad=0.1872p pd=1.24u as=0.1872p ps=1.24u w=0.72u l=0.28u
M_M2 VDD A a_172_68# VNW pfet_03v3 ad=0.3588p pd=1.9u as=0.3588p ps=1.9u w=1.38u l=0.28u
M_M3 Y a_172_68# VDD VNW pfet_03v3 ad=0.3588p pd=1.9u as=0.3588p ps=1.9u w=1.38u l=0.28u
M_M4 Y a_172_68# VDD VNW pfet_03v3 ad=0.3588p pd=1.9u as=0.3588p ps=1.9u w=1.38u l=0.28u
M_M5 VDD a_172_68# Y VNW pfet_03v3 ad=1.3593p pd=4.73u as=0.3588p ps=1.9u w=1.38u l=0.28u
M_M6 a_172_68# A VSS VPW nfet_03v3 ad=0.1872p pd=1.24u as=0.3168p ps=2.32u w=0.72u l=0.28u
M_M7 VSS a_172_68# Y VPW nfet_03v3 ad=0.1872p pd=1.24u as=0.1872p ps=1.24u w=0.72u l=0.28u
M_M8 VDD a_172_68# Y VNW pfet_03v3 ad=0.3588p pd=1.9u as=0.3588p ps=1.9u w=1.38u l=0.28u
M_M9 Y a_172_68# VDD VNW pfet_03v3 ad=0.36915p pd=1.915u as=0.3588p ps=1.9u w=1.38u l=0.28u
M_M10 VDD a_172_68# Y VNW pfet_03v3 ad=0.3588p pd=1.9u as=0.3588p ps=1.9u w=1.38u l=0.28u
M_M11 Y a_172_68# VSS VPW nfet_03v3 ad=0.1872p pd=1.24u as=0.1872p ps=1.24u w=0.72u l=0.28u
M_M12 Y a_172_68# VSS VPW nfet_03v3 ad=0.1872p pd=1.24u as=0.1872p ps=1.24u w=0.72u l=0.28u
M_M13 Y a_172_68# VDD VNW pfet_03v3 ad=0.3588p pd=1.9u as=0.3588p ps=1.9u w=1.38u l=0.28u
M_M14 Y a_172_68# VSS VPW nfet_03v3 ad=0.1872p pd=1.24u as=0.1872p ps=1.24u w=0.72u l=0.28u
M_M15 a_172_68# A VDD VNW pfet_03v3 ad=0.3588p pd=1.9u as=0.3588p ps=1.9u w=1.38u l=0.28u
M_M16 VSS a_172_68# Y VPW nfet_03v3 ad=0.1872p pd=1.24u as=0.1872p ps=1.24u w=0.72u l=0.28u
M_M17 VDD a_172_68# Y VNW pfet_03v3 ad=0.3588p pd=1.9u as=0.3588p ps=1.9u w=1.38u l=0.28u
M_M18 VSS A a_172_68# VPW nfet_03v3 ad=0.1872p pd=1.24u as=0.1872p ps=1.24u w=0.72u l=0.28u
M_M19 VSS a_172_68# Y VPW nfet_03v3 ad=0.1872p pd=1.24u as=0.1872p ps=1.24u w=0.72u l=0.28u
M_M20 VSS a_172_68# Y VPW nfet_03v3 ad=0.1872p pd=1.24u as=0.1926p ps=1.255u w=0.72u l=0.28u
M_M21 VDD A a_172_68# VNW pfet_03v3 ad=0.3588p pd=1.9u as=0.3588p ps=1.9u w=1.38u l=0.28u
M_M22 Y a_172_68# VSS VPW nfet_03v3 ad=0.1872p pd=1.24u as=0.1872p ps=1.24u w=0.72u l=0.28u
M_M23 Y a_172_68# VDD VNW pfet_03v3 ad=0.3588p pd=1.9u as=0.3588p ps=1.9u w=1.38u l=0.28u
M_M24 a_172_68# A VSS VPW nfet_03v3 ad=0.1872p pd=1.24u as=0.1872p ps=1.24u w=0.72u l=0.28u
M_M25 Y a_172_68# VDD VNW pfet_03v3 ad=0.3588p pd=1.9u as=0.3588p ps=1.9u w=1.38u l=0.28u
M_M26 VDD a_172_68# Y VNW pfet_03v3 ad=0.3588p pd=1.9u as=0.3588p ps=1.9u w=1.38u l=0.28u
M_M27 Y a_172_68# VSS VPW nfet_03v3 ad=0.1872p pd=1.24u as=0.1872p ps=1.24u w=0.72u l=0.28u
M_M28 a_172_68# A VDD VNW pfet_03v3 ad=0.3588p pd=1.9u as=0.6072p ps=3.64u w=1.38u l=0.28u
M_M29 VDD a_172_68# Y VNW pfet_03v3 ad=0.3588p pd=1.9u as=0.36915p ps=1.915u w=1.38u l=0.28u
M_M30 VSS A a_172_68# VPW nfet_03v3 ad=0.1872p pd=1.24u as=0.1872p ps=1.24u w=0.72u l=0.28u
M_M31 Y a_172_68# VSS VPW nfet_03v3 ad=0.1926p pd=1.255u as=0.1872p ps=1.24u w=0.72u l=0.28u
.ends

* NGSPICE file created from gf180mcu_as_sc_mcu7t3v3__clkbuff_4.ext - technology: gf180mcuD

.subckt gf180mcu_as_sc_mcu7t3v3__clkbuff_4 VDD VNW VPW VSS A Y
M_M0 Y a_28_68# VDD VNW pfet_03v3 ad=0.3588p pd=1.9u as=0.3588p ps=1.9u w=1.38u l=0.28u
M_M1 VDD a_28_68# Y VNW pfet_03v3 ad=1.1592p pd=4.44u as=0.3588p ps=1.9u w=1.38u l=0.28u
M_M2 VSS A a_28_68# VPW nfet_03v3 ad=0.1872p pd=1.24u as=0.3168p ps=2.32u w=0.72u l=0.28u
M_M3 VSS a_28_68# Y VPW nfet_03v3 ad=0.6048p pd=3.12u as=0.1872p ps=1.24u w=0.72u l=0.28u
M_M4 VDD a_28_68# Y VNW pfet_03v3 ad=0.3588p pd=1.9u as=0.3588p ps=1.9u w=1.38u l=0.28u
M_M5 Y a_28_68# VSS VPW nfet_03v3 ad=0.1872p pd=1.24u as=0.1872p ps=1.24u w=0.72u l=0.28u
M_M6 Y a_28_68# VDD VNW pfet_03v3 ad=0.3588p pd=1.9u as=0.3588p ps=1.9u w=1.38u l=0.28u
M_M7 VSS a_28_68# Y VPW nfet_03v3 ad=0.1872p pd=1.24u as=0.1872p ps=1.24u w=0.72u l=0.28u
M_M8 VDD A a_28_68# VNW pfet_03v3 ad=0.3588p pd=1.9u as=0.6072p ps=3.64u w=1.38u l=0.28u
M_M9 Y a_28_68# VSS VPW nfet_03v3 ad=0.1872p pd=1.24u as=0.1872p ps=1.24u w=0.72u l=0.28u
.ends

* NGSPICE file created from gf180mcu_as_sc_mcu7t3v3__clkbuff_8.ext - technology: gf180mcuD

.subckt gf180mcu_as_sc_mcu7t3v3__clkbuff_8 VDD VNW VPW VSS A Y
M_M0 Y a_28_68# VSS VPW nfet_03v3 ad=0.1872p pd=1.24u as=0.1872p ps=1.24u w=0.72u l=0.28u
M_M1 a_28_68# A VDD VNW pfet_03v3 ad=0.3588p pd=1.9u as=0.3588p ps=1.9u w=1.38u l=0.28u
M_M2 VDD a_28_68# Y VNW pfet_03v3 ad=0.3588p pd=1.9u as=0.3588p ps=1.9u w=1.38u l=0.28u
M_M3 VSS A a_28_68# VPW nfet_03v3 ad=0.1872p pd=1.24u as=0.3168p ps=2.32u w=0.72u l=0.28u
M_M4 Y a_28_68# VSS VPW nfet_03v3 ad=0.1872p pd=1.24u as=0.1872p ps=1.24u w=0.72u l=0.28u
M_M5 Y a_28_68# VDD VNW pfet_03v3 ad=0.3588p pd=1.9u as=0.3588p ps=1.9u w=1.38u l=0.28u
M_M6 VDD a_28_68# Y VNW pfet_03v3 ad=1.0833p pd=4.33u as=0.3588p ps=1.9u w=1.38u l=0.28u
M_M7 VSS a_28_68# Y VPW nfet_03v3 ad=0.1872p pd=1.24u as=0.1872p ps=1.24u w=0.72u l=0.28u
M_M8 VDD a_28_68# Y VNW pfet_03v3 ad=0.3588p pd=1.9u as=0.3588p ps=1.9u w=1.38u l=0.28u
M_M9 VSS a_28_68# Y VPW nfet_03v3 ad=0.1872p pd=1.24u as=0.1872p ps=1.24u w=0.72u l=0.28u
M_M10 VDD A a_28_68# VNW pfet_03v3 ad=0.3588p pd=1.9u as=0.3588p ps=1.9u w=1.38u l=0.28u
M_M11 Y a_28_68# VDD VNW pfet_03v3 ad=0.3588p pd=1.9u as=0.3588p ps=1.9u w=1.38u l=0.28u
M_M12 Y a_28_68# VSS VPW nfet_03v3 ad=0.1872p pd=1.24u as=0.1872p ps=1.24u w=0.72u l=0.28u
M_M13 Y a_28_68# VSS VPW nfet_03v3 ad=0.1872p pd=1.24u as=0.1872p ps=1.24u w=0.72u l=0.28u
M_M14 Y a_28_68# VDD VNW pfet_03v3 ad=0.3588p pd=1.9u as=0.3588p ps=1.9u w=1.38u l=0.28u
M_M15 VSS A a_28_68# VPW nfet_03v3 ad=0.1872p pd=1.24u as=0.1872p ps=1.24u w=0.72u l=0.28u
M_M16 VDD a_28_68# Y VNW pfet_03v3 ad=0.3588p pd=1.9u as=0.3588p ps=1.9u w=1.38u l=0.28u
M_M17 Y a_28_68# VDD VNW pfet_03v3 ad=0.3588p pd=1.9u as=0.3588p ps=1.9u w=1.38u l=0.28u
M_M18 VSS a_28_68# Y VPW nfet_03v3 ad=0.1872p pd=1.24u as=0.1872p ps=1.24u w=0.72u l=0.28u
M_M19 VDD A a_28_68# VNW pfet_03v3 ad=0.3588p pd=1.9u as=0.6072p ps=3.64u w=1.38u l=0.28u
M_M20 a_28_68# A VSS VPW nfet_03v3 ad=0.1872p pd=1.24u as=0.1872p ps=1.24u w=0.72u l=0.28u
M_M21 VSS a_28_68# Y VPW nfet_03v3 ad=0.5652p pd=3.01u as=0.1872p ps=1.24u w=0.72u l=0.28u
.ends

* NGSPICE file created from gf180mcu_as_sc_mcu7t3v3__dfsrtp_2.ext - technology: gf180mcuD

.subckt gf180mcu_as_sc_mcu7t3v3__dfsrtp_2 VDD VNW VPW VSS CLK Q RN SN D
M_M0 a_332_68# a_28_68# VDD VNW pfet_03v3 ad=0.6693p pd=3.73u as=0.3588p ps=1.9u w=1.38u l=0.28u
M_M1 a_1430_68# a_1356_395# a_1314_68# VPW nfet_03v3 ad=0.215p pd=1.43u as=0.15p ps=1.3u w=1u l=0.28u
M_M2 a_1118_440# a_28_68# a_833_440# VNW pfet_03v3 ad=0.8211p pd=2.57u as=0.7866p ps=2.52u w=1.38u l=0.285u
M_M3 VSS CLK a_28_68# VPW nfet_03v3 ad=0.26p pd=1.52u as=0.44p ps=2.88u w=1u l=0.28u
M_M4 a_1356_395# SN a_1794_68# VPW nfet_03v3 ad=0.48p pd=1.96u as=0.405p ps=1.81u w=1u l=0.28u
M_M5 VSS a_3062_24# Q VPW nfet_03v3 ad=0.615p pd=3.23u as=0.26p ps=1.52u w=1u l=0.28u
M_M6 VSS a_3062_24# a_2951_68# VPW nfet_03v3 ad=0.38p pd=1.76u as=0.2775p ps=1.555u w=1u l=0.28u
M_M7 a_1794_68# a_833_440# VSS VPW nfet_03v3 ad=0.405p pd=1.81u as=0.415p ps=1.83u w=1u l=0.28u
M_M8 a_2447_68# a_28_68# a_2260_68# VPW nfet_03v3 ad=1.23p pd=4.46u as=0.3275p ps=1.655u w=1u l=0.28u
M_M9 a_639_68# D VDD VNW pfet_03v3 ad=0.4554p pd=2.04u as=0.7107p ps=3.79u w=1.38u l=0.285u
M_M10 VDD a_3062_24# a_2447_68# VNW pfet_03v3 ad=0.4554p pd=2.04u as=0.45195p ps=2.035u w=1.38u l=0.28u
M_M11 VDD a_833_440# a_1356_395# VNW pfet_03v3 ad=0.5037p pd=2.11u as=0.6072p ps=3.64u w=1.38u l=0.28u
M_M12 a_2447_68# a_332_68# a_2260_68# VNW pfet_03v3 ad=0.8487p pd=3.99u as=0.44505p ps=2.025u w=1.38u l=0.28u
M_M13 VDD a_1356_395# a_1118_440# VNW pfet_03v3 ad=0.3588p pd=1.9u as=0.8211p ps=2.57u w=1.38u l=0.28u
M_M14 Q a_3062_24# VDD VNW pfet_03v3 ad=0.3588p pd=1.9u as=0.6072p ps=3.64u w=1.38u l=0.28u
M_M15 Q a_3062_24# VSS VPW nfet_03v3 ad=0.26p pd=1.52u as=0.44p ps=2.88u w=1u l=0.28u
M_M16 a_2447_68# SN VDD VNW pfet_03v3 ad=0.45195p pd=2.035u as=0.7452p ps=3.84u w=1.38u l=0.28u
M_M17 VSS RN a_1430_68# VPW nfet_03v3 ad=0.415p pd=1.83u as=0.215p ps=1.43u w=1u l=0.28u
M_M18 a_639_68# D VSS VPW nfet_03v3 ad=0.62p pd=2.24u as=0.49p ps=2.98u w=1u l=0.28u
M_M19 a_833_440# a_28_68# a_639_68# VPW nfet_03v3 ad=0.7875p pd=2.575u as=0.62p ps=2.24u w=1u l=0.28u
M_M20 a_2260_68# a_28_68# a_1356_395# VNW pfet_03v3 ad=0.44505p pd=2.025u as=0.89355p ps=2.675u w=1.38u l=0.28u
M_M21 VDD a_2260_68# a_3062_24# VNW pfet_03v3 ad=0.8211p pd=3.95u as=0.4485p ps=2.03u w=1.38u l=0.28u
M_M22 a_3062_24# RN VDD VNW pfet_03v3 ad=0.4485p pd=2.03u as=0.4554p ps=2.04u w=1.38u l=0.28u
M_M23 a_833_440# a_332_68# a_639_68# VNW pfet_03v3 ad=0.7866p pd=2.52u as=0.4554p ps=2.04u w=1.38u l=0.28u
M_M24 VDD a_3062_24# Q VNW pfet_03v3 ad=0.8487p pd=3.99u as=0.3588p ps=1.9u w=1.38u l=0.28u
M_M25 a_1118_440# RN VDD VNW pfet_03v3 ad=0.6279p pd=3.67u as=0.3588p ps=1.9u w=1.38u l=0.28u
M_M26 a_2260_68# a_332_68# a_1356_395# VPW nfet_03v3 ad=0.3275p pd=1.655u as=0.48p ps=1.96u w=1u l=0.28u
M_M27 a_3062_24# a_2260_68# a_3326_68# VPW nfet_03v3 ad=0.505p pd=3.01u as=0.325p ps=1.65u w=1u l=0.28u
M_M28 a_1356_395# SN VDD VNW pfet_03v3 ad=0.89355p pd=2.675u as=0.5037p ps=2.11u w=1.38u l=0.28u
M_M29 a_1314_68# a_332_68# a_833_440# VPW nfet_03v3 ad=0.15p pd=1.3u as=0.7875p ps=2.575u w=1u l=0.28u
M_M30 a_2951_68# SN a_2447_68# VPW nfet_03v3 ad=0.2775p pd=1.555u as=0.61p ps=3.22u w=1u l=0.28u
M_M31 VDD CLK a_28_68# VNW pfet_03v3 ad=0.3588p pd=1.9u as=0.6072p ps=3.64u w=1.38u l=0.28u
M_M32 a_3326_68# RN VSS VPW nfet_03v3 ad=0.325p pd=1.65u as=0.38p ps=1.76u w=1u l=0.28u
M_M33 a_332_68# a_28_68# VSS VPW nfet_03v3 ad=0.485p pd=2.97u as=0.26p ps=1.52u w=1u l=0.28u
.ends

* NGSPICE file created from gf180mcu_as_sc_mcu7t3v3__dfxtn_2.ext - technology: gf180mcuD

.subckt gf180mcu_as_sc_mcu7t3v3__dfxtn_2 VDD VNW VPW VSS CLK D Q
M_M0 a_1709_68# a_332_68# a_1315_24# VNW pfet_03v3 ad=0.8418p pd=2.6u as=0.83145p ps=2.585u w=1.38u l=0.28u
M_M1 a_853_68# D a_629_68# VPW nfet_03v3 ad=0.875p pd=2.75u as=0.42p ps=1.84u w=1u l=0.28u
M_M2 VSS a_1315_24# a_1259_68# VPW nfet_03v3 ad=0.26p pd=1.52u as=0.14p ps=1.28u w=1u l=0.28u
M_M3 a_1709_68# a_28_68# a_1315_24# VPW nfet_03v3 ad=0.625p pd=2.25u as=0.305p ps=1.61u w=1u l=0.28u
M_M4 a_2015_68# a_332_68# a_1709_68# VPW nfet_03v3 ad=0.43p pd=1.86u as=0.625p ps=2.25u w=1u l=0.28u
M_M5 a_332_68# a_28_68# VDD VNW pfet_03v3 ad=0.6693p pd=3.73u as=0.3588p ps=1.9u w=1.38u l=0.28u
M_M6 VSS CLK a_28_68# VPW nfet_03v3 ad=0.26p pd=1.52u as=0.44p ps=2.88u w=1u l=0.28u
M_M7 a_1259_68# a_28_68# a_853_68# VPW nfet_03v3 ad=0.14p pd=1.28u as=0.875p ps=2.75u w=1u l=0.28u
M_M8 VDD a_2187_24# a_2128_440# VNW pfet_03v3 ad=0.3588p pd=1.9u as=0.20355p ps=1.675u w=1.38u l=0.28u
M_M9 a_2187_24# a_1709_68# VSS VPW nfet_03v3 ad=0.55p pd=3.1u as=0.26p ps=1.52u w=1u l=0.28u
M_M10 VDD a_1315_24# a_1064_440# VNW pfet_03v3 ad=0.3588p pd=1.9u as=0.86595p ps=2.635u w=1.38u l=0.28u
M_M11 a_735_440# a_28_68# VDD VNW pfet_03v3 ad=0.2139p pd=1.69u as=1.3317p ps=4.69u w=1.38u l=0.285u
M_M12 a_853_68# D a_735_440# VNW pfet_03v3 ad=0.5313p pd=2.15u as=0.2139p ps=1.69u w=1.38u l=0.28u
M_M13 a_629_68# a_332_68# VSS VPW nfet_03v3 ad=0.42p pd=1.84u as=0.44p ps=2.88u w=1u l=0.28u
M_M14 VSS a_2187_24# Q VPW nfet_03v3 ad=0.615p pd=3.23u as=0.26p ps=1.52u w=1u l=0.28u
M_M15 VSS a_2187_24# a_2015_68# VPW nfet_03v3 ad=0.26p pd=1.52u as=0.43p ps=1.86u w=1u l=0.28u
M_M16 a_1315_24# a_853_68# VDD VNW pfet_03v3 ad=0.83145p pd=2.585u as=0.3588p ps=1.9u w=1.38u l=0.28u
M_M17 Q a_2187_24# VDD VNW pfet_03v3 ad=0.3588p pd=1.9u as=0.6072p ps=3.64u w=1.38u l=0.28u
M_M18 a_2187_24# a_1709_68# VDD VNW pfet_03v3 ad=0.759p pd=3.86u as=0.3588p ps=1.9u w=1.38u l=0.28u
M_M19 Q a_2187_24# VSS VPW nfet_03v3 ad=0.26p pd=1.52u as=0.44p ps=2.88u w=1u l=0.28u
M_M20 a_1064_440# a_332_68# a_853_68# VNW pfet_03v3 ad=0.86595p pd=2.635u as=0.5313p ps=2.15u w=1.38u l=0.285u
M_M21 a_2128_440# a_28_68# a_1709_68# VNW pfet_03v3 ad=0.20355p pd=1.675u as=0.8418p ps=2.6u w=1.38u l=0.28u
M_M22 a_1315_24# a_853_68# VSS VPW nfet_03v3 ad=0.305p pd=1.61u as=0.26p ps=1.52u w=1u l=0.28u
M_M23 VDD a_2187_24# Q VNW pfet_03v3 ad=0.8487p pd=3.99u as=0.3588p ps=1.9u w=1.38u l=0.28u
M_M24 VDD CLK a_28_68# VNW pfet_03v3 ad=0.3588p pd=1.9u as=0.6072p ps=3.64u w=1.38u l=0.28u
M_M25 a_332_68# a_28_68# VSS VPW nfet_03v3 ad=0.485p pd=2.97u as=0.26p ps=1.52u w=1u l=0.28u
.ends

* NGSPICE file created from gf180mcu_as_sc_mcu7t3v3__dfxtp_2.ext - technology: gf180mcuD

.subckt gf180mcu_as_sc_mcu7t3v3__dfxtp_2 VDD VNW VPW VSS CLK D Q
M_M0 a_1709_68# a_28_68# a_1315_24# VNW pfet_03v3 ad=0.8418p pd=2.6u as=0.83145p ps=2.585u w=1.38u l=0.28u
M_M1 a_853_68# D a_629_68# VPW nfet_03v3 ad=0.875p pd=2.75u as=0.42p ps=1.84u w=1u l=0.28u
M_M2 VSS a_1315_24# a_1259_68# VPW nfet_03v3 ad=0.26p pd=1.52u as=0.14p ps=1.28u w=1u l=0.28u
M_M3 a_1709_68# a_332_68# a_1315_24# VPW nfet_03v3 ad=0.625p pd=2.25u as=0.305p ps=1.61u w=1u l=0.28u
M_M4 a_2015_68# a_28_68# a_1709_68# VPW nfet_03v3 ad=0.43p pd=1.86u as=0.625p ps=2.25u w=1u l=0.28u
M_M5 a_332_68# a_28_68# VDD VNW pfet_03v3 ad=0.6693p pd=3.73u as=0.3588p ps=1.9u w=1.38u l=0.28u
M_M6 VSS CLK a_28_68# VPW nfet_03v3 ad=0.26p pd=1.52u as=0.44p ps=2.88u w=1u l=0.28u
M_M7 a_1259_68# a_332_68# a_853_68# VPW nfet_03v3 ad=0.14p pd=1.28u as=0.875p ps=2.75u w=1u l=0.28u
M_M8 VDD a_2187_24# a_2128_440# VNW pfet_03v3 ad=0.3588p pd=1.9u as=0.20355p ps=1.675u w=1.38u l=0.28u
M_M9 a_2187_24# a_1709_68# VSS VPW nfet_03v3 ad=0.55p pd=3.1u as=0.26p ps=1.52u w=1u l=0.28u
M_M10 VDD a_1315_24# a_1064_440# VNW pfet_03v3 ad=0.3588p pd=1.9u as=0.86595p ps=2.635u w=1.38u l=0.28u
M_M11 a_735_440# a_332_68# VDD VNW pfet_03v3 ad=0.2139p pd=1.69u as=1.3317p ps=4.69u w=1.38u l=0.285u
M_M12 a_853_68# D a_735_440# VNW pfet_03v3 ad=0.5313p pd=2.15u as=0.2139p ps=1.69u w=1.38u l=0.28u
M_M13 a_629_68# a_28_68# VSS VPW nfet_03v3 ad=0.42p pd=1.84u as=0.44p ps=2.88u w=1u l=0.28u
M_M14 VSS a_2187_24# Q VPW nfet_03v3 ad=0.615p pd=3.23u as=0.26p ps=1.52u w=1u l=0.28u
M_M15 VSS a_2187_24# a_2015_68# VPW nfet_03v3 ad=0.26p pd=1.52u as=0.43p ps=1.86u w=1u l=0.28u
M_M16 a_1315_24# a_853_68# VDD VNW pfet_03v3 ad=0.83145p pd=2.585u as=0.3588p ps=1.9u w=1.38u l=0.28u
M_M17 Q a_2187_24# VDD VNW pfet_03v3 ad=0.3588p pd=1.9u as=0.6072p ps=3.64u w=1.38u l=0.28u
M_M18 a_2187_24# a_1709_68# VDD VNW pfet_03v3 ad=0.759p pd=3.86u as=0.3588p ps=1.9u w=1.38u l=0.28u
M_M19 Q a_2187_24# VSS VPW nfet_03v3 ad=0.26p pd=1.52u as=0.44p ps=2.88u w=1u l=0.28u
M_M20 a_1064_440# a_28_68# a_853_68# VNW pfet_03v3 ad=0.86595p pd=2.635u as=0.5313p ps=2.15u w=1.38u l=0.285u
M_M21 a_2128_440# a_332_68# a_1709_68# VNW pfet_03v3 ad=0.20355p pd=1.675u as=0.8418p ps=2.6u w=1.38u l=0.28u
M_M22 a_1315_24# a_853_68# VSS VPW nfet_03v3 ad=0.305p pd=1.61u as=0.26p ps=1.52u w=1u l=0.28u
M_M23 VDD a_2187_24# Q VNW pfet_03v3 ad=0.8487p pd=3.99u as=0.3588p ps=1.9u w=1.38u l=0.28u
M_M24 VDD CLK a_28_68# VNW pfet_03v3 ad=0.3588p pd=1.9u as=0.6072p ps=3.64u w=1.38u l=0.28u
M_M25 a_332_68# a_28_68# VSS VPW nfet_03v3 ad=0.485p pd=2.97u as=0.26p ps=1.52u w=1u l=0.28u
.ends

* NGSPICE file created from gf180mcu_as_sc_mcu7t3v3__dfxtp_4.ext - technology: gf180mcuD

.subckt gf180mcu_as_sc_mcu7t3v3__dfxtp_4 VDD VNW VPW VSS CLK D Q
M_M0 a_1709_68# a_28_68# a_1315_24# VNW pfet_03v3 ad=0.8418p pd=2.6u as=0.83145p ps=2.585u w=1.38u l=0.28u
M_M1 a_853_68# D a_629_68# VPW nfet_03v3 ad=0.875p pd=2.75u as=0.42p ps=1.84u w=1u l=0.28u
M_M2 Q a_2187_24# VDD VNW pfet_03v3 ad=0.36225p pd=1.905u as=0.3588p ps=1.9u w=1.38u l=0.28u
M_M3 VSS a_1315_24# a_1259_68# VPW nfet_03v3 ad=0.26p pd=1.52u as=0.14p ps=1.28u w=1u l=0.28u
M_M4 a_1709_68# a_332_68# a_1315_24# VPW nfet_03v3 ad=0.625p pd=2.25u as=0.305p ps=1.61u w=1u l=0.28u
M_M5 a_2015_68# a_28_68# a_1709_68# VPW nfet_03v3 ad=0.43p pd=1.86u as=0.625p ps=2.25u w=1u l=0.28u
M_M6 a_332_68# a_28_68# VDD VNW pfet_03v3 ad=0.6693p pd=3.73u as=0.3588p ps=1.9u w=1.38u l=0.28u
M_M7 VSS CLK a_28_68# VPW nfet_03v3 ad=0.26p pd=1.52u as=0.44p ps=2.88u w=1u l=0.28u
M_M8 a_1259_68# a_332_68# a_853_68# VPW nfet_03v3 ad=0.14p pd=1.28u as=0.875p ps=2.75u w=1u l=0.28u
M_M9 VDD a_2187_24# a_2128_440# VNW pfet_03v3 ad=0.3588p pd=1.9u as=0.20355p ps=1.675u w=1.38u l=0.28u
M_M10 a_2187_24# a_1709_68# VSS VPW nfet_03v3 ad=0.55p pd=3.1u as=0.26p ps=1.52u w=1u l=0.28u
M_M11 Q a_2187_24# VSS VPW nfet_03v3 ad=0.2625p pd=1.525u as=0.26p ps=1.52u w=1u l=0.28u
M_M12 VSS a_2187_24# Q VPW nfet_03v3 ad=0.58p pd=3.16u as=0.2625p ps=1.525u w=1u l=0.28u
M_M13 VDD a_1315_24# a_1064_440# VNW pfet_03v3 ad=0.3588p pd=1.9u as=0.86595p ps=2.635u w=1.38u l=0.28u
M_M14 a_735_440# a_332_68# VDD VNW pfet_03v3 ad=0.2139p pd=1.69u as=1.3317p ps=4.69u w=1.38u l=0.285u
M_M15 a_853_68# D a_735_440# VNW pfet_03v3 ad=0.5313p pd=2.15u as=0.2139p ps=1.69u w=1.38u l=0.28u
M_M16 a_629_68# a_28_68# VSS VPW nfet_03v3 ad=0.42p pd=1.84u as=0.44p ps=2.88u w=1u l=0.28u
M_M17 VSS a_2187_24# Q VPW nfet_03v3 ad=0.26p pd=1.52u as=0.26p ps=1.52u w=1u l=0.28u
M_M18 VDD a_2187_24# Q VNW pfet_03v3 ad=0.8004p pd=3.92u as=0.36225p ps=1.905u w=1.38u l=0.28u
M_M19 VSS a_2187_24# a_2015_68# VPW nfet_03v3 ad=0.26p pd=1.52u as=0.43p ps=1.86u w=1u l=0.28u
M_M20 a_1315_24# a_853_68# VDD VNW pfet_03v3 ad=0.83145p pd=2.585u as=0.3588p ps=1.9u w=1.38u l=0.28u
M_M21 Q a_2187_24# VDD VNW pfet_03v3 ad=0.3588p pd=1.9u as=0.6072p ps=3.64u w=1.38u l=0.28u
M_M22 a_2187_24# a_1709_68# VDD VNW pfet_03v3 ad=0.759p pd=3.86u as=0.3588p ps=1.9u w=1.38u l=0.28u
M_M23 Q a_2187_24# VSS VPW nfet_03v3 ad=0.26p pd=1.52u as=0.44p ps=2.88u w=1u l=0.28u
M_M24 a_1064_440# a_28_68# a_853_68# VNW pfet_03v3 ad=0.86595p pd=2.635u as=0.5313p ps=2.15u w=1.38u l=0.285u
M_M25 a_2128_440# a_332_68# a_1709_68# VNW pfet_03v3 ad=0.20355p pd=1.675u as=0.8418p ps=2.6u w=1.38u l=0.28u
M_M26 a_1315_24# a_853_68# VSS VPW nfet_03v3 ad=0.305p pd=1.61u as=0.26p ps=1.52u w=1u l=0.28u
M_M27 VDD a_2187_24# Q VNW pfet_03v3 ad=0.3588p pd=1.9u as=0.3588p ps=1.9u w=1.38u l=0.28u
M_M28 VDD CLK a_28_68# VNW pfet_03v3 ad=0.3588p pd=1.9u as=0.6072p ps=3.64u w=1.38u l=0.28u
M_M29 a_332_68# a_28_68# VSS VPW nfet_03v3 ad=0.485p pd=2.97u as=0.26p ps=1.52u w=1u l=0.28u
.ends

* NGSPICE file created from gf180mcu_as_sc_mcu7t3v3__diode_2.ext - technology: gf180mcuD

.subckt gf180mcu_as_sc_mcu7t3v3__diode_2 VDD VNW VPW VSS DIODE
D0 DIODE VNW diode_pd2nw_03v3 pj=1.93u area=0.2295p
D1 VPW DIODE diode_nd2ps_03v3 pj=1.83u area=0.209p
.ends

* NGSPICE file created from gf180mcu_as_sc_mcu7t3v3__dlxfn_2.ext - technology: gf180mcuD

.subckt gf180mcu_as_sc_mcu7t3v3__dlxfn_2 VDD VNW VPW VSS ENA D Q
M_M0 a_853_68# D a_629_68# VPW nfet_03v3 ad=0.875p pd=2.75u as=0.42p ps=1.84u w=1u l=0.28u
M_M1 VSS a_1315_24# a_1259_68# VPW nfet_03v3 ad=0.26p pd=1.52u as=0.14p ps=1.28u w=1u l=0.28u
M_M2 a_332_68# a_28_68# VDD VNW pfet_03v3 ad=0.6693p pd=3.73u as=0.3588p ps=1.9u w=1.38u l=0.28u
M_M3 VSS ENA a_28_68# VPW nfet_03v3 ad=0.26p pd=1.52u as=0.44p ps=2.88u w=1u l=0.28u
M_M4 a_1259_68# a_332_68# a_853_68# VPW nfet_03v3 ad=0.14p pd=1.28u as=0.875p ps=2.75u w=1u l=0.28u
M_M5 VDD a_1315_24# a_1064_440# VNW pfet_03v3 ad=0.3588p pd=1.9u as=0.86595p ps=2.635u w=1.38u l=0.28u
M_M6 a_735_440# a_332_68# VDD VNW pfet_03v3 ad=0.2139p pd=1.69u as=1.3317p ps=4.69u w=1.38u l=0.285u
M_M7 a_853_68# D a_735_440# VNW pfet_03v3 ad=0.5313p pd=2.15u as=0.2139p ps=1.69u w=1.38u l=0.28u
M_M8 a_629_68# a_28_68# VSS VPW nfet_03v3 ad=0.42p pd=1.84u as=0.44p ps=2.88u w=1u l=0.28u
M_M9 a_1315_24# a_853_68# VDD VNW pfet_03v3 ad=0.6072p pd=3.64u as=0.3588p ps=1.9u w=1.38u l=0.28u
M_M10 Q a_1315_24# VDD VNW pfet_03v3 ad=0.3588p pd=1.9u as=0.6072p ps=3.64u w=1.38u l=0.28u
M_M11 VSS a_1315_24# Q VPW nfet_03v3 ad=0.44p pd=2.88u as=0.26p ps=1.52u w=1u l=0.28u
M_M12 a_1064_440# a_28_68# a_853_68# VNW pfet_03v3 ad=0.86595p pd=2.635u as=0.5313p ps=2.15u w=1.38u l=0.285u
M_M13 VDD a_1315_24# Q VNW pfet_03v3 ad=0.6072p pd=3.64u as=0.3588p ps=1.9u w=1.38u l=0.28u
M_M14 a_1315_24# a_853_68# VSS VPW nfet_03v3 ad=0.44p pd=2.88u as=0.26p ps=1.52u w=1u l=0.28u
M_M15 VDD ENA a_28_68# VNW pfet_03v3 ad=0.3588p pd=1.9u as=0.6072p ps=3.64u w=1.38u l=0.28u
M_M16 a_332_68# a_28_68# VSS VPW nfet_03v3 ad=0.485p pd=2.97u as=0.26p ps=1.52u w=1u l=0.28u
M_M17 Q a_1315_24# VSS VPW nfet_03v3 ad=0.26p pd=1.52u as=0.44p ps=2.88u w=1u l=0.28u
.ends

* NGSPICE file created from gf180mcu_as_sc_mcu7t3v3__dlxfp_2.ext - technology: gf180mcuD

.subckt gf180mcu_as_sc_mcu7t3v3__dlxfp_2 VDD VNW VPW VSS ENA D Q
M_M0 a_853_68# D a_629_68# VPW nfet_03v3 ad=0.875p pd=2.75u as=0.42p ps=1.84u w=1u l=0.28u
M_M1 VSS a_1315_24# a_1259_68# VPW nfet_03v3 ad=0.26p pd=1.52u as=0.14p ps=1.28u w=1u l=0.28u
M_M2 a_332_68# a_28_68# VDD VNW pfet_03v3 ad=0.6693p pd=3.73u as=0.3588p ps=1.9u w=1.38u l=0.28u
M_M3 VSS ENA a_28_68# VPW nfet_03v3 ad=0.26p pd=1.52u as=0.44p ps=2.88u w=1u l=0.28u
M_M4 a_1259_68# a_28_68# a_853_68# VPW nfet_03v3 ad=0.14p pd=1.28u as=0.875p ps=2.75u w=1u l=0.28u
M_M5 VDD a_1315_24# a_1064_440# VNW pfet_03v3 ad=0.3588p pd=1.9u as=0.86595p ps=2.635u w=1.38u l=0.28u
M_M6 a_735_440# a_28_68# VDD VNW pfet_03v3 ad=0.2139p pd=1.69u as=1.3317p ps=4.69u w=1.38u l=0.285u
M_M7 a_853_68# D a_735_440# VNW pfet_03v3 ad=0.5313p pd=2.15u as=0.2139p ps=1.69u w=1.38u l=0.28u
M_M8 a_629_68# a_332_68# VSS VPW nfet_03v3 ad=0.42p pd=1.84u as=0.44p ps=2.88u w=1u l=0.28u
M_M9 a_1315_24# a_853_68# VDD VNW pfet_03v3 ad=0.6072p pd=3.64u as=0.3588p ps=1.9u w=1.38u l=0.28u
M_M10 Q a_1315_24# VDD VNW pfet_03v3 ad=0.3588p pd=1.9u as=0.6072p ps=3.64u w=1.38u l=0.28u
M_M11 VSS a_1315_24# Q VPW nfet_03v3 ad=0.44p pd=2.88u as=0.26p ps=1.52u w=1u l=0.28u
M_M12 a_1064_440# a_332_68# a_853_68# VNW pfet_03v3 ad=0.86595p pd=2.635u as=0.5313p ps=2.15u w=1.38u l=0.285u
M_M13 VDD a_1315_24# Q VNW pfet_03v3 ad=0.6072p pd=3.64u as=0.3588p ps=1.9u w=1.38u l=0.28u
M_M14 a_1315_24# a_853_68# VSS VPW nfet_03v3 ad=0.44p pd=2.88u as=0.26p ps=1.52u w=1u l=0.28u
M_M15 VDD ENA a_28_68# VNW pfet_03v3 ad=0.3588p pd=1.9u as=0.6072p ps=3.64u w=1.38u l=0.28u
M_M16 a_332_68# a_28_68# VSS VPW nfet_03v3 ad=0.485p pd=2.97u as=0.26p ps=1.52u w=1u l=0.28u
M_M17 Q a_1315_24# VSS VPW nfet_03v3 ad=0.26p pd=1.52u as=0.44p ps=2.88u w=1u l=0.28u
.ends

* NGSPICE file created from gf180mcu_as_sc_mcu7t3v3__dlxtn_2.ext - technology: gf180mcuD

.subckt gf180mcu_as_sc_mcu7t3v3__dlxtn_2 VDD VNW VPW VSS ENA D Q
M_M0 a_853_68# D a_629_68# VPW nfet_03v3 ad=0.875p pd=2.75u as=0.42p ps=1.84u w=1u l=0.28u
M_M1 VSS a_1315_24# a_1259_68# VPW nfet_03v3 ad=0.26p pd=1.52u as=0.14p ps=1.28u w=1u l=0.28u
M_M2 a_332_68# a_28_68# VDD VNW pfet_03v3 ad=0.6693p pd=3.73u as=0.3588p ps=1.9u w=1.38u l=0.28u
M_M3 VSS ENA a_28_68# VPW nfet_03v3 ad=0.26p pd=1.52u as=0.44p ps=2.88u w=1u l=0.28u
M_M4 a_1259_68# a_332_68# a_853_68# VPW nfet_03v3 ad=0.14p pd=1.28u as=0.875p ps=2.75u w=1u l=0.28u
M_M5 VDD a_1315_24# a_1064_440# VNW pfet_03v3 ad=0.3588p pd=1.9u as=0.86595p ps=2.635u w=1.38u l=0.28u
M_M6 a_735_440# a_332_68# VDD VNW pfet_03v3 ad=0.2139p pd=1.69u as=1.3317p ps=4.69u w=1.38u l=0.285u
M_M7 a_853_68# D a_735_440# VNW pfet_03v3 ad=0.5313p pd=2.15u as=0.2139p ps=1.69u w=1.38u l=0.28u
M_M8 a_629_68# a_28_68# VSS VPW nfet_03v3 ad=0.42p pd=1.84u as=0.44p ps=2.88u w=1u l=0.28u
M_M9 a_1315_24# a_853_68# VDD VNW pfet_03v3 ad=0.6072p pd=3.64u as=0.3588p ps=1.9u w=1.38u l=0.28u
M_M10 Q a_853_68# VDD VNW pfet_03v3 ad=0.3588p pd=1.9u as=0.6072p ps=3.64u w=1.38u l=0.28u
M_M11 VSS a_853_68# Q VPW nfet_03v3 ad=0.44p pd=2.88u as=0.26p ps=1.52u w=1u l=0.28u
M_M12 a_1064_440# a_28_68# a_853_68# VNW pfet_03v3 ad=0.86595p pd=2.635u as=0.5313p ps=2.15u w=1.38u l=0.285u
M_M13 VDD a_853_68# Q VNW pfet_03v3 ad=0.6072p pd=3.64u as=0.3588p ps=1.9u w=1.38u l=0.28u
M_M14 a_1315_24# a_853_68# VSS VPW nfet_03v3 ad=0.44p pd=2.88u as=0.26p ps=1.52u w=1u l=0.28u
M_M15 VDD ENA a_28_68# VNW pfet_03v3 ad=0.3588p pd=1.9u as=0.6072p ps=3.64u w=1.38u l=0.28u
M_M16 a_332_68# a_28_68# VSS VPW nfet_03v3 ad=0.485p pd=2.97u as=0.26p ps=1.52u w=1u l=0.28u
M_M17 Q a_853_68# VSS VPW nfet_03v3 ad=0.26p pd=1.52u as=0.44p ps=2.88u w=1u l=0.28u
.ends

* NGSPICE file created from gf180mcu_as_sc_mcu7t3v3__dlxtp_2.ext - technology: gf180mcuD

.subckt gf180mcu_as_sc_mcu7t3v3__dlxtp_2 VDD VNW VPW VSS ENA D Q
M_M0 a_853_68# D a_629_68# VPW nfet_03v3 ad=0.875p pd=2.75u as=0.42p ps=1.84u w=1u l=0.28u
M_M1 VSS a_1315_24# a_1259_68# VPW nfet_03v3 ad=0.26p pd=1.52u as=0.14p ps=1.28u w=1u l=0.28u
M_M2 a_332_68# a_28_68# VDD VNW pfet_03v3 ad=0.6693p pd=3.73u as=0.3588p ps=1.9u w=1.38u l=0.28u
M_M3 VSS ENA a_28_68# VPW nfet_03v3 ad=0.26p pd=1.52u as=0.44p ps=2.88u w=1u l=0.28u
M_M4 a_1259_68# a_28_68# a_853_68# VPW nfet_03v3 ad=0.14p pd=1.28u as=0.875p ps=2.75u w=1u l=0.28u
M_M5 VDD a_1315_24# a_1064_440# VNW pfet_03v3 ad=0.3588p pd=1.9u as=0.86595p ps=2.635u w=1.38u l=0.28u
M_M6 a_735_440# a_28_68# VDD VNW pfet_03v3 ad=0.2139p pd=1.69u as=1.3317p ps=4.69u w=1.38u l=0.285u
M_M7 a_853_68# D a_735_440# VNW pfet_03v3 ad=0.5313p pd=2.15u as=0.2139p ps=1.69u w=1.38u l=0.28u
M_M8 a_629_68# a_332_68# VSS VPW nfet_03v3 ad=0.42p pd=1.84u as=0.44p ps=2.88u w=1u l=0.28u
M_M9 a_1315_24# a_853_68# VDD VNW pfet_03v3 ad=0.6072p pd=3.64u as=0.3588p ps=1.9u w=1.38u l=0.28u
M_M10 Q a_853_68# VDD VNW pfet_03v3 ad=0.3588p pd=1.9u as=0.6072p ps=3.64u w=1.38u l=0.28u
M_M11 VSS a_853_68# Q VPW nfet_03v3 ad=0.44p pd=2.88u as=0.26p ps=1.52u w=1u l=0.28u
M_M12 a_1064_440# a_332_68# a_853_68# VNW pfet_03v3 ad=0.86595p pd=2.635u as=0.5313p ps=2.15u w=1.38u l=0.285u
M_M13 VDD a_853_68# Q VNW pfet_03v3 ad=0.6072p pd=3.64u as=0.3588p ps=1.9u w=1.38u l=0.28u
M_M14 a_1315_24# a_853_68# VSS VPW nfet_03v3 ad=0.44p pd=2.88u as=0.26p ps=1.52u w=1u l=0.28u
M_M15 VDD ENA a_28_68# VNW pfet_03v3 ad=0.3588p pd=1.9u as=0.6072p ps=3.64u w=1.38u l=0.28u
M_M16 a_332_68# a_28_68# VSS VPW nfet_03v3 ad=0.485p pd=2.97u as=0.26p ps=1.52u w=1u l=0.28u
M_M17 Q a_853_68# VSS VPW nfet_03v3 ad=0.26p pd=1.52u as=0.44p ps=2.88u w=1u l=0.28u
.ends

* NGSPICE file created from gf180mcu_as_sc_mcu7t3v3__dlybuff_2.ext - technology: gf180mcuD

.subckt gf180mcu_as_sc_mcu7t3v3__dlybuff_2 VDD VNW VPW VSS Y A
M_M0 VDD a_628_68# Y VNW pfet_03v3 ad=0.6072p pd=3.64u as=0.3588p ps=1.9u w=1.38u l=0.28u
M_M1 Y a_628_68# VSS VPW nfet_03v3 ad=0.26p pd=1.52u as=0.196p ps=1.52u w=1u l=0.28u
M_M2 a_460_68# a_28_68# a_356_68# VPW nfet_03v3 ad=0.351p pd=2.67u as=43.2f ps=0.6u w=0.36u l=0.28u
M_M3 VSS a_460_68# a_628_68# VPW nfet_03v3 ad=0.196p pd=1.52u as=0.351p ps=2.67u w=0.36u l=0.28u
M_M4 a_356_598# a_28_68# VDD VNW pfet_03v3 ad=70.8f pd=0.83u as=0.1534p ps=1.11u w=0.59u l=0.28u
M_M5 VDD a_460_68# a_628_68# VNW pfet_03v3 ad=0.2793p pd=1.9u as=0.4788p ps=3.13u w=0.585u l=0.28u
M_M6 a_356_68# a_28_68# VSS VPW nfet_03v3 ad=43.2f pd=0.6u as=93.59999f ps=0.88u w=0.36u l=0.28u
M_M7 Y a_628_68# VDD VNW pfet_03v3 ad=0.3588p pd=1.9u as=0.2793p ps=1.9u w=1.38u l=0.28u
M_M8 a_460_68# a_28_68# a_356_598# VNW pfet_03v3 ad=0.4798p pd=3.13u as=70.8f ps=0.83u w=0.59u l=0.28u
M_M9 VSS a_628_68# Y VPW nfet_03v3 ad=0.44p pd=2.88u as=0.26p ps=1.52u w=1u l=0.28u
M_M10 VSS A a_28_68# VPW nfet_03v3 ad=93.59999f pd=0.88u as=0.351p ps=2.67u w=0.36u l=0.28u
M_M11 VDD A a_28_68# VNW pfet_03v3 ad=0.1534p pd=1.11u as=0.4798p ps=3.13u w=0.59u l=0.28u
.ends

* NGSPICE file created from gf180mcu_as_sc_mcu7t3v3__dlybuff_4.ext - technology: gf180mcuD

.subckt gf180mcu_as_sc_mcu7t3v3__dlybuff_4 VDD VNW VPW VSS Y A
M_M0 VDD a_628_68# Y VNW pfet_03v3 ad=0.3588p pd=1.9u as=0.3588p ps=1.9u w=1.38u l=0.28u
M_M1 Y a_628_68# VSS VPW nfet_03v3 ad=0.26p pd=1.52u as=0.196p ps=1.52u w=1u l=0.28u
M_M2 VDD a_460_68# a_628_68# VNW pfet_03v3 ad=0.2798p pd=1.9u as=0.4798p ps=3.13u w=0.59u l=0.28u
M_M3 a_460_68# a_28_68# a_356_68# VPW nfet_03v3 ad=0.351p pd=2.67u as=43.2f ps=0.6u w=0.36u l=0.28u
M_M4 VSS a_460_68# a_628_68# VPW nfet_03v3 ad=0.196p pd=1.52u as=0.351p ps=2.67u w=0.36u l=0.28u
M_M5 a_356_598# a_28_68# VDD VNW pfet_03v3 ad=70.8f pd=0.83u as=0.1534p ps=1.11u w=0.59u l=0.28u
M_M6 Y a_628_68# VDD VNW pfet_03v3 ad=0.3588p pd=1.9u as=0.3588p ps=1.9u w=1.38u l=0.28u
M_M7 VSS a_628_68# Y VPW nfet_03v3 ad=0.52p pd=3.04u as=0.26p ps=1.52u w=1u l=0.28u
M_M8 VDD a_628_68# Y VNW pfet_03v3 ad=0.7176p pd=3.8u as=0.3588p ps=1.9u w=1.38u l=0.28u
M_M9 Y a_628_68# VSS VPW nfet_03v3 ad=0.26p pd=1.52u as=0.26p ps=1.52u w=1u l=0.28u
M_M10 a_356_68# a_28_68# VSS VPW nfet_03v3 ad=43.2f pd=0.6u as=93.59999f ps=0.88u w=0.36u l=0.28u
M_M11 Y a_628_68# VDD VNW pfet_03v3 ad=0.3588p pd=1.9u as=0.2798p ps=1.9u w=1.38u l=0.28u
M_M12 a_460_68# a_28_68# a_356_598# VNW pfet_03v3 ad=0.4798p pd=3.13u as=70.8f ps=0.83u w=0.59u l=0.28u
M_M13 VSS a_628_68# Y VPW nfet_03v3 ad=0.26p pd=1.52u as=0.26p ps=1.52u w=1u l=0.28u
M_M14 VSS A a_28_68# VPW nfet_03v3 ad=93.59999f pd=0.88u as=0.351p ps=2.67u w=0.36u l=0.28u
M_M15 VDD A a_28_68# VNW pfet_03v3 ad=0.1534p pd=1.11u as=0.4798p ps=3.13u w=0.59u l=0.28u
.ends

* NGSPICE file created from gf180mcu_as_sc_mcu7t3v3__dyn_dfxtp_2.ext - technology: gf180mcuD

.subckt gf180mcu_as_sc_mcu7t3v3__dyn_dfxtp_2 VDD VNW VPW VSS CLK D Q
M_M0 a_896_440# a_332_68# a_780_440# VNW pfet_03v3 ad=1.5939p pd=5.07u as=0.207p ps=1.68u w=1.38u l=0.28u
M_M1 VSS D a_476_68# VPW nfet_03v3 ad=0.26p pd=1.52u as=0.44p ps=2.88u w=1u l=0.28u
M_M2 a_332_68# a_28_68# VDD VNW pfet_03v3 ad=0.6072p pd=3.64u as=0.3588p ps=1.9u w=1.38u l=0.28u
M_M3 VDD D a_476_68# VNW pfet_03v3 ad=0.3588p pd=1.9u as=0.6072p ps=3.64u w=1.38u l=0.28u
M_M4 VSS CLK a_28_68# VPW nfet_03v3 ad=0.26p pd=1.52u as=0.44p ps=2.88u w=1u l=0.28u
M_M5 Q a_1447_440# VDD VNW pfet_03v3 ad=0.3588p pd=1.9u as=0.6072p ps=3.64u w=1.38u l=0.28u
M_M6 a_896_440# a_28_68# a_780_68# VPW nfet_03v3 ad=0.475p pd=2.95u as=0.49p ps=1.98u w=1u l=0.28u
M_M7 a_1327_440# a_896_440# VDD VNW pfet_03v3 ad=0.2208p pd=1.7u as=0.6072p ps=3.64u w=1.38u l=0.28u
M_M8 VSS a_1447_440# Q VPW nfet_03v3 ad=0.44p pd=2.88u as=0.26p ps=1.52u w=1u l=0.28u
M_M9 VDD a_1447_440# Q VNW pfet_03v3 ad=0.6072p pd=3.64u as=0.3588p ps=1.9u w=1.38u l=0.28u
M_M10 a_1447_440# a_28_68# a_1327_440# VNW pfet_03v3 ad=1.4835p pd=4.91u as=0.2208p ps=1.7u w=1.38u l=0.28u
M_M11 a_1327_68# a_896_440# VSS VPW nfet_03v3 ad=0.46p pd=1.92u as=0.44p ps=2.88u w=1u l=0.28u
M_M12 a_780_440# a_476_68# VDD VNW pfet_03v3 ad=0.207p pd=1.68u as=0.3588p ps=1.9u w=1.38u l=0.28u
M_M13 Q a_1447_440# VSS VPW nfet_03v3 ad=0.26p pd=1.52u as=0.44p ps=2.88u w=1u l=0.28u
M_M14 a_1447_440# a_332_68# a_1327_68# VPW nfet_03v3 ad=0.475p pd=2.95u as=0.46p ps=1.92u w=1u l=0.28u
M_M15 a_780_68# a_476_68# VSS VPW nfet_03v3 ad=0.49p pd=1.98u as=0.26p ps=1.52u w=1u l=0.28u
M_M16 VDD CLK a_28_68# VNW pfet_03v3 ad=0.3588p pd=1.9u as=0.6072p ps=3.64u w=1.38u l=0.28u
M_M17 a_332_68# a_28_68# VSS VPW nfet_03v3 ad=0.44p pd=2.88u as=0.26p ps=1.52u w=1u l=0.28u
.ends

* NGSPICE file created from gf180mcu_as_sc_mcu7t3v3__fill_1.ext - technology: gf180mcuD

.subckt gf180mcu_as_sc_mcu7t3v3__fill_1 VDD VNW VPW VSS
.ends

* NGSPICE file created from gf180mcu_as_sc_mcu7t3v3__fill_2.ext - technology: gf180mcuD

.subckt gf180mcu_as_sc_mcu7t3v3__fill_2 VDD VNW VPW VSS
.ends

* NGSPICE file created from gf180mcu_as_sc_mcu7t3v3__fill_4.ext - technology: gf180mcuD

.subckt gf180mcu_as_sc_mcu7t3v3__fill_4 VDD VNW VPW VSS
.ends

* NGSPICE file created from gf180mcu_as_sc_mcu7t3v3__fill_8.ext - technology: gf180mcuD

.subckt gf180mcu_as_sc_mcu7t3v3__fill_8 VDD VNW VPW VSS
.ends

* NGSPICE file created from gf180mcu_as_sc_mcu7t3v3__fillcap_16.ext - technology: gf180mcuD

.subckt gf180mcu_as_sc_mcu7t3v3__fillcap_16 VDD VNW VPW VSS
M_M0 a_126_406# a_28_498# VSS VPW nfet_03v3 ad=0.4356p pd=2.86u as=0.4851p ps=2.96u w=0.99u l=7.75u
M_M1 VDD a_126_406# a_28_498# VNW pfet_03v3 ad=0.4796p pd=3.06u as=0.5341p ps=3.16u w=1.09u l=7.75u
.ends

* NGSPICE file created from gf180mcu_as_sc_mcu7t3v3__fillcap_4.ext - technology: gf180mcuD

.subckt gf180mcu_as_sc_mcu7t3v3__fillcap_4 VDD VNW VPW VSS
M_M0 a_126_408# a_28_500# VSS VPW nfet_03v3 ad=0.44p pd=2.88u as=0.49p ps=2.98u w=1u l=1.03u
M_M1 VDD a_126_408# a_28_500# VNW pfet_03v3 ad=0.4752p pd=3.04u as=0.5292p ps=3.14u w=1.08u l=1.03u
.ends

* NGSPICE file created from gf180mcu_as_sc_mcu7t3v3__fillcap_8.ext - technology: gf180mcuD

.subckt gf180mcu_as_sc_mcu7t3v3__fillcap_8 VDD VNW VPW VSS
M_M0 a_126_406# a_28_498# VSS VPW nfet_03v3 ad=0.4356p pd=2.86u as=0.4851p ps=2.96u w=0.99u l=3.27u
M_M1 VDD a_126_406# a_28_498# VNW pfet_03v3 ad=0.4796p pd=3.06u as=0.5341p ps=3.16u w=1.09u l=3.27u
.ends

* NGSPICE file created from gf180mcu_as_sc_mcu7t3v3__hcf_7.ext - technology: gf180mcuD

.subckt gf180mcu_as_sc_mcu7t3v3__hcf_7 VDD VNW VPW VSS HCF
M_M0 VSS HCF VDD VPW nfet_03v3 ad=0.26p pd=1.52u as=0.26p ps=1.52u w=1u l=0.28u
M_M1 VDD HCF VSS VPW nfet_03v3 ad=0.26p pd=1.52u as=0.44p ps=2.88u w=1u l=0.28u
M_M2 VDD HCF VSS VPW nfet_03v3 ad=0.26p pd=1.52u as=0.26p ps=1.52u w=1u l=0.28u
M_M3 VSS HCF VDD VPW nfet_03v3 ad=0.26p pd=1.52u as=0.26p ps=1.52u w=1u l=0.28u
M_M4 VDD HCF VSS VPW nfet_03v3 ad=0.26p pd=1.52u as=0.26p ps=1.52u w=1u l=0.28u
M_M5 VDD HCF VSS VPW nfet_03v3 ad=0.92p pd=3.84u as=0.26p ps=1.52u w=1u l=0.28u
M_M6 VSS HCF VDD VPW nfet_03v3 ad=0.26p pd=1.52u as=0.26p ps=1.52u w=1u l=0.28u
.ends

* NGSPICE file created from gf180mcu_as_sc_mcu7t3v3__inv_2.ext - technology: gf180mcuD

.subckt gf180mcu_as_sc_mcu7t3v3__inv_2 VDD VNW VPW VSS Y A
M_M0 VDD A Y VNW pfet_03v3 ad=0.6072p pd=3.64u as=0.3588p ps=1.9u w=1.38u l=0.28u
M_M1 Y A VSS VPW nfet_03v3 ad=0.26p pd=1.52u as=0.44p ps=2.88u w=1u l=0.28u
M_M2 Y A VDD VNW pfet_03v3 ad=0.3588p pd=1.9u as=0.6072p ps=3.64u w=1.38u l=0.28u
M_M3 VSS A Y VPW nfet_03v3 ad=0.44p pd=2.88u as=0.26p ps=1.52u w=1u l=0.28u
.ends

* NGSPICE file created from gf180mcu_as_sc_mcu7t3v3__inv_4.ext - technology: gf180mcuD

.subckt gf180mcu_as_sc_mcu7t3v3__inv_4 VDD VNW VPW VSS Y A
M_M0 VDD A Y VNW pfet_03v3 ad=0.3588p pd=1.9u as=0.3588p ps=1.9u w=1.38u l=0.28u
M_M1 Y A VSS VPW nfet_03v3 ad=0.26p pd=1.52u as=0.44p ps=2.88u w=1u l=0.28u
M_M2 Y A VDD VNW pfet_03v3 ad=0.3588p pd=1.9u as=0.3588p ps=1.9u w=1.38u l=0.28u
M_M3 VSS A Y VPW nfet_03v3 ad=0.52p pd=3.04u as=0.26p ps=1.52u w=1u l=0.28u
M_M4 VDD A Y VNW pfet_03v3 ad=0.7176p pd=3.8u as=0.3588p ps=1.9u w=1.38u l=0.28u
M_M5 Y A VSS VPW nfet_03v3 ad=0.26p pd=1.52u as=0.26p ps=1.52u w=1u l=0.28u
M_M6 Y A VDD VNW pfet_03v3 ad=0.3588p pd=1.9u as=0.6072p ps=3.64u w=1.38u l=0.28u
M_M7 VSS A Y VPW nfet_03v3 ad=0.26p pd=1.52u as=0.26p ps=1.52u w=1u l=0.28u
.ends

* NGSPICE file created from gf180mcu_as_sc_mcu7t3v3__inv_6.ext - technology: gf180mcuD

.subckt gf180mcu_as_sc_mcu7t3v3__inv_6 VDD VNW VPW VSS Y A
M_M0 VSS A Y VPW nfet_03v3 ad=0.6p pd=3.2u as=0.26p ps=1.52u w=1u l=0.28u
M_M1 VDD A Y VNW pfet_03v3 ad=0.3588p pd=1.9u as=0.3588p ps=1.9u w=1.38u l=0.28u
M_M2 Y A VDD VNW pfet_03v3 ad=0.3588p pd=1.9u as=0.3588p ps=1.9u w=1.38u l=0.28u
M_M3 Y A VSS VPW nfet_03v3 ad=0.26p pd=1.52u as=0.44p ps=2.88u w=1u l=0.28u
M_M4 Y A VSS VPW nfet_03v3 ad=0.26p pd=1.52u as=0.26p ps=1.52u w=1u l=0.28u
M_M5 Y A VDD VNW pfet_03v3 ad=0.3588p pd=1.9u as=0.3588p ps=1.9u w=1.38u l=0.28u
M_M6 VDD A Y VNW pfet_03v3 ad=0.828p pd=3.96u as=0.3588p ps=1.9u w=1.38u l=0.28u
M_M7 VSS A Y VPW nfet_03v3 ad=0.26p pd=1.52u as=0.26p ps=1.52u w=1u l=0.28u
M_M8 VDD A Y VNW pfet_03v3 ad=0.3588p pd=1.9u as=0.3588p ps=1.9u w=1.38u l=0.28u
M_M9 Y A VSS VPW nfet_03v3 ad=0.26p pd=1.52u as=0.26p ps=1.52u w=1u l=0.28u
M_M10 Y A VDD VNW pfet_03v3 ad=0.3588p pd=1.9u as=0.6072p ps=3.64u w=1.38u l=0.28u
M_M11 VSS A Y VPW nfet_03v3 ad=0.26p pd=1.52u as=0.26p ps=1.52u w=1u l=0.28u
.ends

* NGSPICE file created from gf180mcu_as_sc_mcu7t3v3__inv_8.ext - technology: gf180mcuD

.subckt gf180mcu_as_sc_mcu7t3v3__inv_8 VDD VNW VPW VSS Y A
M_M0 VSS A Y VPW nfet_03v3 ad=0.26p pd=1.52u as=0.26p ps=1.52u w=1u l=0.28u
M_M1 VDD A Y VNW pfet_03v3 ad=0.3588p pd=1.9u as=0.3588p ps=1.9u w=1.38u l=0.28u
M_M2 Y A VDD VNW pfet_03v3 ad=0.3588p pd=1.9u as=0.3588p ps=1.9u w=1.38u l=0.28u
M_M3 Y A VSS VPW nfet_03v3 ad=0.26p pd=1.52u as=0.44p ps=2.88u w=1u l=0.28u
M_M4 VDD A Y VNW pfet_03v3 ad=0.9384p pd=4.12u as=0.3588p ps=1.9u w=1.38u l=0.28u
M_M5 Y A VSS VPW nfet_03v3 ad=0.26p pd=1.52u as=0.26p ps=1.52u w=1u l=0.28u
M_M6 Y A VDD VNW pfet_03v3 ad=0.3588p pd=1.9u as=0.3588p ps=1.9u w=1.38u l=0.28u
M_M7 VDD A Y VNW pfet_03v3 ad=0.3588p pd=1.9u as=0.3588p ps=1.9u w=1.38u l=0.28u
M_M8 VSS A Y VPW nfet_03v3 ad=0.26p pd=1.52u as=0.26p ps=1.52u w=1u l=0.28u
M_M9 VSS A Y VPW nfet_03v3 ad=0.68p pd=3.36u as=0.26p ps=1.52u w=1u l=0.28u
M_M10 VDD A Y VNW pfet_03v3 ad=0.3588p pd=1.9u as=0.3588p ps=1.9u w=1.38u l=0.28u
M_M11 Y A VSS VPW nfet_03v3 ad=0.26p pd=1.52u as=0.26p ps=1.52u w=1u l=0.28u
M_M12 Y A VDD VNW pfet_03v3 ad=0.3588p pd=1.9u as=0.3588p ps=1.9u w=1.38u l=0.28u
M_M13 Y A VSS VPW nfet_03v3 ad=0.26p pd=1.52u as=0.26p ps=1.52u w=1u l=0.28u
M_M14 Y A VDD VNW pfet_03v3 ad=0.3588p pd=1.9u as=0.6072p ps=3.64u w=1.38u l=0.28u
M_M15 VSS A Y VPW nfet_03v3 ad=0.26p pd=1.52u as=0.26p ps=1.52u w=1u l=0.28u
.ends

* NGSPICE file created from gf180mcu_as_sc_mcu7t3v3__invz_2.ext - technology: gf180mcuD

.subckt gf180mcu_as_sc_mcu7t3v3__invz_2 VDD VNW VPW VSS EN A Y
M_M0 VDD a_428_440# Y VNW pfet_03v3 ad=0.6693p pd=2.35u as=0.4623p ps=2.05u w=1.38u l=0.28u
M_M1 a_428_440# EN VDD VNW pfet_03v3 ad=0.3864p pd=1.94u as=0.69p ps=2.38u w=1.38u l=0.28u
M_M2 a_848_348# A VSS VPW nfet_03v3 ad=0.52p pd=3.04u as=0.36p ps=1.72u w=1u l=0.28u
M_M3 VSS EN a_28_68# VPW nfet_03v3 ad=0.26p pd=1.52u as=0.44p ps=2.88u w=1u l=0.28u
M_M4 Y a_332_68# VSS VPW nfet_03v3 ad=0.61p pd=2.22u as=0.27p ps=1.54u w=1u l=0.28u
M_M5 Y a_428_440# VDD VNW pfet_03v3 ad=0.4623p pd=2.05u as=0.6348p ps=2.3u w=1.38u l=0.28u
M_M6 a_848_348# A VDD VNW pfet_03v3 ad=0.7176p pd=3.8u as=0.6693p ps=2.35u w=1.38u l=0.28u
M_M7 VSS a_332_68# Y VPW nfet_03v3 ad=0.36p pd=1.72u as=0.61p ps=2.22u w=1u l=0.28u
M_M8 a_428_440# EN a_332_68# VPW nfet_03v3 ad=1.52p pd=5.04u as=0.26p ps=1.52u w=1u l=0.28u
M_M9 VSS a_848_348# a_332_68# VPW nfet_03v3 ad=0.27p pd=1.54u as=0.44p ps=2.88u w=1u l=0.28u
M_M10 a_332_68# a_28_68# a_428_440# VNW pfet_03v3 ad=0.6072p pd=3.64u as=0.3864p ps=1.94u w=1.38u l=0.28u
M_M11 VDD EN a_28_68# VNW pfet_03v3 ad=0.69p pd=2.38u as=0.6072p ps=3.64u w=1.38u l=0.28u
M_M12 VDD a_848_348# a_428_440# VNW pfet_03v3 ad=0.6348p pd=2.3u as=1.2351p ps=4.55u w=1.38u l=0.28u
M_M13 a_332_68# a_28_68# VSS VPW nfet_03v3 ad=0.26p pd=1.52u as=0.26p ps=1.52u w=1u l=0.28u
.ends

* NGSPICE file created from gf180mcu_as_sc_mcu7t3v3__maj3_2.ext - technology: gf180mcuD

.subckt gf180mcu_as_sc_mcu7t3v3__maj3_2 VDD VNW VPW VSS Y A B C
M_M0 a_436_68# B VSS VPW nfet_03v3 ad=0.12p pd=1.24u as=0.26p ps=1.52u w=1u l=0.28u
M_M1 VSS A a_700_68# VPW nfet_03v3 ad=0.26p pd=1.52u as=0.12p ps=1.24u w=1u l=0.28u
M_M2 Y a_28_68# VDD VNW pfet_03v3 ad=0.4485p pd=2.03u as=0.3588p ps=1.9u w=1.38u l=0.28u
M_M3 a_172_68# A a_28_68# VPW nfet_03v3 ad=0.12p pd=1.24u as=0.44p ps=2.88u w=1u l=0.28u
M_M4 VSS a_28_68# Y VPW nfet_03v3 ad=0.83p pd=3.66u as=0.325p ps=1.65u w=1u l=0.28u
M_M5 VSS B a_172_68# VPW nfet_03v3 ad=0.26p pd=1.52u as=0.12p ps=1.24u w=1u l=0.28u
M_M6 VDD B a_172_440# VNW pfet_03v3 ad=0.3588p pd=1.9u as=0.1656p ps=1.62u w=1.38u l=0.28u
M_M7 a_700_440# C a_28_68# VNW pfet_03v3 ad=0.1656p pd=1.62u as=0.3588p ps=1.9u w=1.38u l=0.28u
M_M8 a_700_68# C a_28_68# VPW nfet_03v3 ad=0.12p pd=1.24u as=0.26p ps=1.52u w=1u l=0.28u
M_M9 a_436_440# B VDD VNW pfet_03v3 ad=0.1656p pd=1.62u as=0.3588p ps=1.9u w=1.38u l=0.28u
M_M10 a_28_68# C a_436_68# VPW nfet_03v3 ad=0.26p pd=1.52u as=0.12p ps=1.24u w=1u l=0.28u
M_M11 VDD A a_700_440# VNW pfet_03v3 ad=0.3588p pd=1.9u as=0.1656p ps=1.62u w=1.38u l=0.28u
M_M12 Y a_28_68# VSS VPW nfet_03v3 ad=0.325p pd=1.65u as=0.26p ps=1.52u w=1u l=0.28u
M_M13 a_28_68# C a_436_440# VNW pfet_03v3 ad=0.3588p pd=1.9u as=0.1656p ps=1.62u w=1.38u l=0.28u
M_M14 a_172_440# A a_28_68# VNW pfet_03v3 ad=0.1656p pd=1.62u as=0.6072p ps=3.64u w=1.38u l=0.28u
M_M15 VDD a_28_68# Y VNW pfet_03v3 ad=1.1454p pd=4.42u as=0.4485p ps=2.03u w=1.38u l=0.28u
.ends

* NGSPICE file created from gf180mcu_as_sc_mcu7t3v3__maj3_4.ext - technology: gf180mcuD

.subckt gf180mcu_as_sc_mcu7t3v3__maj3_4 VDD VNW VPW VSS Y A B C
M_M0 Y a_28_68# VSS VPW nfet_03v3 ad=0.26p pd=1.52u as=0.26p ps=1.52u w=1u l=0.28u
M_M1 a_436_68# B VSS VPW nfet_03v3 ad=0.12p pd=1.24u as=0.26p ps=1.52u w=1u l=0.28u
M_M2 VSS A a_700_68# VPW nfet_03v3 ad=0.26p pd=1.52u as=0.12p ps=1.24u w=1u l=0.28u
M_M3 Y a_28_68# VDD VNW pfet_03v3 ad=0.4485p pd=2.03u as=0.3588p ps=1.9u w=1.38u l=0.28u
M_M4 a_172_68# A a_28_68# VPW nfet_03v3 ad=0.12p pd=1.24u as=0.44p ps=2.88u w=1u l=0.28u
M_M5 VSS a_28_68# Y VPW nfet_03v3 ad=0.26p pd=1.52u as=0.325p ps=1.65u w=1u l=0.28u
M_M6 VSS B a_172_68# VPW nfet_03v3 ad=0.26p pd=1.52u as=0.12p ps=1.24u w=1u l=0.28u
M_M7 VDD B a_172_440# VNW pfet_03v3 ad=0.3588p pd=1.9u as=0.1656p ps=1.62u w=1.38u l=0.28u
M_M8 a_700_440# C a_28_68# VNW pfet_03v3 ad=0.1656p pd=1.62u as=0.3588p ps=1.9u w=1.38u l=0.28u
M_M9 Y a_28_68# VDD VNW pfet_03v3 ad=0.3588p pd=1.9u as=0.3588p ps=1.9u w=1.38u l=0.28u
M_M10 a_700_68# C a_28_68# VPW nfet_03v3 ad=0.12p pd=1.24u as=0.26p ps=1.52u w=1u l=0.28u
M_M11 a_436_440# B VDD VNW pfet_03v3 ad=0.1656p pd=1.62u as=0.3588p ps=1.9u w=1.38u l=0.28u
M_M12 a_28_68# C a_436_68# VPW nfet_03v3 ad=0.26p pd=1.52u as=0.12p ps=1.24u w=1u l=0.28u
M_M13 VDD A a_700_440# VNW pfet_03v3 ad=0.3588p pd=1.9u as=0.1656p ps=1.62u w=1.38u l=0.28u
M_M14 VDD a_28_68# Y VNW pfet_03v3 ad=0.8211p pd=3.95u as=0.3588p ps=1.9u w=1.38u l=0.28u
M_M15 VSS a_28_68# Y VPW nfet_03v3 ad=0.575p pd=3.15u as=0.26p ps=1.52u w=1u l=0.28u
M_M16 Y a_28_68# VSS VPW nfet_03v3 ad=0.325p pd=1.65u as=0.26p ps=1.52u w=1u l=0.28u
M_M17 a_28_68# C a_436_440# VNW pfet_03v3 ad=0.3588p pd=1.9u as=0.1656p ps=1.62u w=1.38u l=0.28u
M_M18 a_172_440# A a_28_68# VNW pfet_03v3 ad=0.1656p pd=1.62u as=0.6072p ps=3.64u w=1.38u l=0.28u
M_M19 VDD a_28_68# Y VNW pfet_03v3 ad=0.3588p pd=1.9u as=0.4485p ps=2.03u w=1.38u l=0.28u
.ends

* NGSPICE file created from gf180mcu_as_sc_mcu7t3v3__mux2_2.ext - technology: gf180mcuD

.subckt gf180mcu_as_sc_mcu7t3v3__mux2_2 VDD VNW VPW VSS S B A Y
M_M0 a_744_440# S a_464_68# VNW pfet_03v3 ad=0.1932p pd=1.66u as=0.3588p ps=1.9u w=1.38u l=0.28u
M_M1 VDD A a_744_440# VNW pfet_03v3 ad=0.3588p pd=1.9u as=0.1932p ps=1.66u w=1.38u l=0.28u
M_M2 a_332_440# B VDD VNW pfet_03v3 ad=0.6762p pd=2.36u as=0.3588p ps=1.9u w=1.38u l=0.28u
M_M3 a_464_68# S a_332_68# VPW nfet_03v3 ad=0.26p pd=1.52u as=0.19p ps=1.38u w=1u l=0.28u
M_M4 VSS S a_28_68# VPW nfet_03v3 ad=0.26p pd=1.52u as=0.44p ps=2.88u w=1u l=0.28u
M_M5 Y a_464_68# VDD VNW pfet_03v3 ad=0.3726p pd=1.92u as=0.3588p ps=1.9u w=1.38u l=0.28u
M_M6 Y a_464_68# VSS VPW nfet_03v3 ad=0.27p pd=1.54u as=0.26p ps=1.52u w=1u l=0.28u
M_M7 VSS A a_624_68# VPW nfet_03v3 ad=0.26p pd=1.52u as=0.44p ps=1.88u w=1u l=0.28u
M_M8 VDD a_464_68# Y VNW pfet_03v3 ad=0.828p pd=3.96u as=0.3726p ps=1.92u w=1.38u l=0.28u
M_M9 VSS a_464_68# Y VPW nfet_03v3 ad=0.6p pd=3.2u as=0.27p ps=1.54u w=1u l=0.28u
M_M10 a_464_68# a_28_68# a_332_440# VNW pfet_03v3 ad=0.3588p pd=1.9u as=0.6762p ps=2.36u w=1.38u l=0.28u
M_M11 VDD S a_28_68# VNW pfet_03v3 ad=0.3588p pd=1.9u as=0.6072p ps=3.64u w=1.38u l=0.28u
M_M12 a_624_68# a_28_68# a_464_68# VPW nfet_03v3 ad=0.44p pd=1.88u as=0.26p ps=1.52u w=1u l=0.28u
M_M13 a_332_68# B VSS VPW nfet_03v3 ad=0.19p pd=1.38u as=0.26p ps=1.52u w=1u l=0.28u
.ends

* NGSPICE file created from gf180mcu_as_sc_mcu7t3v3__mux2_4.ext - technology: gf180mcuD

.subckt gf180mcu_as_sc_mcu7t3v3__mux2_4 VDD VNW VPW VSS S B A Y
M_M0 a_744_440# S a_464_68# VNW pfet_03v3 ad=0.1932p pd=1.66u as=0.3588p ps=1.9u w=1.38u l=0.28u
M_M1 VDD A a_744_440# VNW pfet_03v3 ad=0.3588p pd=1.9u as=0.1932p ps=1.66u w=1.38u l=0.28u
M_M2 VDD a_464_68# Y VNW pfet_03v3 ad=0.828p pd=3.96u as=0.3588p ps=1.9u w=1.38u l=0.28u
M_M3 a_332_440# B VDD VNW pfet_03v3 ad=0.6762p pd=2.36u as=0.3588p ps=1.9u w=1.38u l=0.28u
M_M4 a_464_68# S a_332_68# VPW nfet_03v3 ad=0.26p pd=1.52u as=0.19p ps=1.38u w=1u l=0.28u
M_M5 VSS S a_28_68# VPW nfet_03v3 ad=0.26p pd=1.52u as=0.44p ps=2.88u w=1u l=0.28u
M_M6 Y a_464_68# VDD VNW pfet_03v3 ad=0.3726p pd=1.92u as=0.3588p ps=1.9u w=1.38u l=0.28u
M_M7 Y a_464_68# VSS VPW nfet_03v3 ad=0.27p pd=1.54u as=0.26p ps=1.52u w=1u l=0.28u
M_M8 VSS a_464_68# Y VPW nfet_03v3 ad=0.6p pd=3.2u as=0.26p ps=1.52u w=1u l=0.28u
M_M9 VSS A a_624_68# VPW nfet_03v3 ad=0.26p pd=1.52u as=0.44p ps=1.88u w=1u l=0.28u
M_M10 VDD a_464_68# Y VNW pfet_03v3 ad=0.3588p pd=1.9u as=0.3726p ps=1.92u w=1.38u l=0.28u
M_M11 Y a_464_68# VSS VPW nfet_03v3 ad=0.26p pd=1.52u as=0.26p ps=1.52u w=1u l=0.28u
M_M12 Y a_464_68# VDD VNW pfet_03v3 ad=0.3588p pd=1.9u as=0.3588p ps=1.9u w=1.38u l=0.28u
M_M13 VSS a_464_68# Y VPW nfet_03v3 ad=0.26p pd=1.52u as=0.27p ps=1.54u w=1u l=0.28u
M_M14 a_464_68# a_28_68# a_332_440# VNW pfet_03v3 ad=0.3588p pd=1.9u as=0.6762p ps=2.36u w=1.38u l=0.28u
M_M15 VDD S a_28_68# VNW pfet_03v3 ad=0.3588p pd=1.9u as=0.6072p ps=3.64u w=1.38u l=0.28u
M_M16 a_624_68# a_28_68# a_464_68# VPW nfet_03v3 ad=0.44p pd=1.88u as=0.26p ps=1.52u w=1u l=0.28u
M_M17 a_332_68# B VSS VPW nfet_03v3 ad=0.19p pd=1.38u as=0.26p ps=1.52u w=1u l=0.28u
.ends

* NGSPICE file created from gf180mcu_as_sc_mcu7t3v3__mux4_1.ext - technology: gf180mcuD

.subckt gf180mcu_as_sc_mcu7t3v3__mux4_1 VDD VNW VPW VSS C D Y B A S0 S1
M_M0 VSS A a_2839_68# VPW nfet_03v3 ad=0.265p pd=1.53u as=0.57p ps=2.14u w=1u l=0.28u
M_M1 a_1115_24# S1 a_428_68# VPW nfet_03v3 ad=0.26p pd=1.52u as=1.075p ps=4.15u w=1u l=0.28u
M_M2 a_2839_68# a_372_24# a_1746_68# VPW nfet_03v3 ad=0.57p pd=2.14u as=0.6525p ps=2.305u w=1u l=0.28u
M_M3 a_172_68# C VSS VPW nfet_03v3 ad=0.5p pd=2u as=0.44p ps=2.88u w=1u l=0.28u
M_M4 a_2354_68# B VSS VPW nfet_03v3 ad=0.28p pd=1.56u as=0.26p ps=1.52u w=1u l=0.28u
M_M5 a_1746_68# S0 a_2354_68# VPW nfet_03v3 ad=0.6525p pd=2.305u as=0.28p ps=1.56u w=1u l=0.28u
M_M6 VDD D a_724_440# VNW pfet_03v3 ad=0.3588p pd=1.9u as=0.79695p ps=2.535u w=1.38u l=0.28u
M_M7 a_428_68# S0 a_172_68# VNW pfet_03v3 ad=0.3588p pd=1.9u as=1.1592p ps=3.06u w=1.38u l=0.28u
M_M8 a_1115_24# a_1650_320# a_428_68# VNW pfet_03v3 ad=0.3588p pd=1.9u as=2.5875p ps=6.51u w=1.38u l=0.28u
M_M9 a_1746_68# a_372_24# a_2354_68# VNW pfet_03v3 ad=0.8625p pd=2.63u as=0.7935p ps=2.53u w=1.38u l=0.28u
M_M10 VSS S1 a_1650_320# VPW nfet_03v3 ad=0.26p pd=1.52u as=0.44p ps=2.88u w=1u l=0.28u
M_M11 a_724_440# a_372_24# a_428_68# VNW pfet_03v3 ad=0.79695p pd=2.535u as=0.3588p ps=1.9u w=1.38u l=0.28u
M_M12 a_372_24# S0 VDD VNW pfet_03v3 ad=1.0971p pd=4.35u as=0.3657p ps=1.91u w=1.38u l=0.28u
M_M13 Y a_1115_24# VSS VPW nfet_03v3 ad=0.44p pd=2.88u as=0.26p ps=1.52u w=1u l=0.28u
M_M14 a_2839_68# S0 a_1746_68# VNW pfet_03v3 ad=0.41745p pd=1.985u as=0.8625p ps=2.63u w=1.38u l=0.28u
M_M15 VDD S1 a_1650_320# VNW pfet_03v3 ad=0.3588p pd=1.9u as=0.6072p ps=3.64u w=1.38u l=0.28u
M_M16 a_372_24# S0 VSS VPW nfet_03v3 ad=0.795p pd=3.59u as=0.265p ps=1.53u w=1u l=0.28u
M_M17 VDD A a_2839_68# VNW pfet_03v3 ad=0.3657p pd=1.91u as=0.41745p ps=1.985u w=1.38u l=0.28u
M_M18 a_2354_68# B VDD VNW pfet_03v3 ad=0.7935p pd=2.53u as=0.3588p ps=1.9u w=1.38u l=0.28u
M_M19 a_724_440# S0 a_428_68# VPW nfet_03v3 ad=0.315p pd=1.63u as=0.8625p ps=2.725u w=1u l=0.28u
M_M20 Y a_1115_24# VDD VNW pfet_03v3 ad=0.6072p pd=3.64u as=0.3588p ps=1.9u w=1.38u l=0.28u
M_M21 a_1746_68# S1 a_1115_24# VNW pfet_03v3 ad=0.6072p pd=3.64u as=0.3588p ps=1.9u w=1.38u l=0.28u
M_M22 a_428_68# a_372_24# a_172_68# VPW nfet_03v3 ad=0.8625p pd=2.725u as=0.5p ps=2u w=1u l=0.28u
M_M23 VSS D a_724_440# VPW nfet_03v3 ad=0.26p pd=1.52u as=0.315p ps=1.63u w=1u l=0.28u
M_M24 a_1746_68# a_1650_320# a_1115_24# VPW nfet_03v3 ad=1.24p pd=4.48u as=0.26p ps=1.52u w=1u l=0.28u
M_M25 a_172_68# C VDD VNW pfet_03v3 ad=1.1592p pd=3.06u as=0.6072p ps=3.64u w=1.38u l=0.28u
.ends

* NGSPICE file created from gf180mcu_as_sc_mcu7t3v3__mux4_2.ext - technology: gf180mcuD

.subckt gf180mcu_as_sc_mcu7t3v3__mux4_2 VDD VNW VPW VSS C D Y B A S0 S1
M_M0 VDD a_1115_24# Y VNW pfet_03v3 ad=1.0488p pd=4.28u as=0.3588p ps=1.9u w=1.38u l=0.28u
M_M1 a_372_24# S0 VDD VNW pfet_03v3 ad=1.0971p pd=4.35u as=0.3657p ps=1.91u w=1.38u l=0.28u
M_M2 a_172_68# C VSS VPW nfet_03v3 ad=0.5p pd=2u as=0.44p ps=2.88u w=1u l=0.28u
M_M3 a_1970_68# S1 a_1115_24# VNW pfet_03v3 ad=0.6072p pd=3.64u as=0.3588p ps=1.9u w=1.38u l=0.28u
M_M4 a_3063_68# S0 a_1970_68# VNW pfet_03v3 ad=0.41745p pd=1.985u as=0.8625p ps=2.63u w=1.38u l=0.28u
M_M5 VDD S1 a_1874_320# VNW pfet_03v3 ad=0.3588p pd=1.9u as=0.6072p ps=3.64u w=1.38u l=0.28u
M_M6 VSS A a_3063_68# VPW nfet_03v3 ad=0.265p pd=1.53u as=0.57p ps=2.14u w=1u l=0.28u
M_M7 a_1115_24# a_1874_320# a_428_68# VNW pfet_03v3 ad=0.3588p pd=1.9u as=2.5875p ps=6.51u w=1.38u l=0.28u
M_M8 a_1970_68# a_372_24# a_2578_68# VNW pfet_03v3 ad=0.8625p pd=2.63u as=0.7935p ps=2.53u w=1.38u l=0.28u
M_M9 VDD A a_3063_68# VNW pfet_03v3 ad=0.3657p pd=1.91u as=0.41745p ps=1.985u w=1.38u l=0.28u
M_M10 VDD D a_724_440# VNW pfet_03v3 ad=0.3588p pd=1.9u as=0.79695p ps=2.535u w=1.38u l=0.28u
M_M11 VSS a_1115_24# Y VPW nfet_03v3 ad=0.76p pd=3.52u as=0.26p ps=1.52u w=1u l=0.28u
M_M12 a_428_68# S0 a_172_68# VNW pfet_03v3 ad=0.3588p pd=1.9u as=1.1592p ps=3.06u w=1.38u l=0.28u
M_M13 a_2578_68# B VSS VPW nfet_03v3 ad=0.28p pd=1.56u as=0.26p ps=1.52u w=1u l=0.28u
M_M14 a_724_440# a_372_24# a_428_68# VNW pfet_03v3 ad=0.79695p pd=2.535u as=0.3588p ps=1.9u w=1.38u l=0.28u
M_M15 Y a_1115_24# VSS VPW nfet_03v3 ad=0.26p pd=1.52u as=0.26p ps=1.52u w=1u l=0.28u
M_M16 a_1970_68# a_1874_320# a_1115_24# VPW nfet_03v3 ad=1.24p pd=4.48u as=0.26p ps=1.52u w=1u l=0.28u
M_M17 a_1970_68# S0 a_2578_68# VPW nfet_03v3 ad=0.6525p pd=2.305u as=0.28p ps=1.56u w=1u l=0.28u
M_M18 a_2578_68# B VDD VNW pfet_03v3 ad=0.7935p pd=2.53u as=0.3588p ps=1.9u w=1.38u l=0.28u
M_M19 VSS S1 a_1874_320# VPW nfet_03v3 ad=0.26p pd=1.52u as=0.44p ps=2.88u w=1u l=0.28u
M_M20 a_1115_24# S1 a_428_68# VPW nfet_03v3 ad=0.26p pd=1.52u as=1.075p ps=4.15u w=1u l=0.28u
M_M21 a_724_440# S0 a_428_68# VPW nfet_03v3 ad=0.315p pd=1.63u as=0.8625p ps=2.725u w=1u l=0.28u
M_M22 Y a_1115_24# VDD VNW pfet_03v3 ad=0.3588p pd=1.9u as=0.3588p ps=1.9u w=1.38u l=0.28u
M_M23 a_428_68# a_372_24# a_172_68# VPW nfet_03v3 ad=0.8625p pd=2.725u as=0.5p ps=2u w=1u l=0.28u
M_M24 VSS D a_724_440# VPW nfet_03v3 ad=0.26p pd=1.52u as=0.315p ps=1.63u w=1u l=0.28u
M_M25 a_172_68# C VDD VNW pfet_03v3 ad=1.1592p pd=3.06u as=0.6072p ps=3.64u w=1.38u l=0.28u
M_M26 a_3063_68# a_372_24# a_1970_68# VPW nfet_03v3 ad=0.57p pd=2.14u as=0.6525p ps=2.305u w=1u l=0.28u
M_M27 a_372_24# S0 VSS VPW nfet_03v3 ad=0.795p pd=3.59u as=0.265p ps=1.53u w=1u l=0.28u
.ends

* NGSPICE file created from gf180mcu_as_sc_mcu7t3v3__nand2_2.ext - technology: gf180mcuD

.subckt gf180mcu_as_sc_mcu7t3v3__nand2_2 VDD VNW VPW VSS Y B A
M_M0 VDD A Y VNW pfet_03v3 ad=0.3588p pd=1.9u as=0.3588p ps=1.9u w=1.38u l=0.28u
M_M1 VSS A a_28_68# VPW nfet_03v3 ad=0.26p pd=1.52u as=0.44p ps=2.88u w=1u l=0.28u
M_M2 Y B VDD VNW pfet_03v3 ad=0.3588p pd=1.9u as=0.3588p ps=1.9u w=1.38u l=0.28u
M_M3 a_28_68# B Y VPW nfet_03v3 ad=0.515p pd=3.03u as=0.26p ps=1.52u w=1u l=0.28u
M_M4 VDD B Y VNW pfet_03v3 ad=0.7176p pd=3.8u as=0.3588p ps=1.9u w=1.38u l=0.28u
M_M5 Y B a_28_68# VPW nfet_03v3 ad=0.26p pd=1.52u as=0.26p ps=1.52u w=1u l=0.28u
M_M6 Y A VDD VNW pfet_03v3 ad=0.3588p pd=1.9u as=0.6072p ps=3.64u w=1.38u l=0.28u
M_M7 a_28_68# A VSS VPW nfet_03v3 ad=0.26p pd=1.52u as=0.26p ps=1.52u w=1u l=0.28u
.ends

* NGSPICE file created from gf180mcu_as_sc_mcu7t3v3__nand2_4.ext - technology: gf180mcuD

.subckt gf180mcu_as_sc_mcu7t3v3__nand2_4 VDD VNW VPW VSS Y A B
M_M0 a_28_68# B Y VPW nfet_03v3 ad=0.26p pd=1.52u as=0.26p ps=1.52u w=1u l=0.28u
M_M1 VDD A Y VNW pfet_03v3 ad=0.3588p pd=1.9u as=0.3588p ps=1.9u w=1.38u l=0.28u
M_M2 Y B VDD VNW pfet_03v3 ad=0.3588p pd=1.9u as=0.3588p ps=1.9u w=1.38u l=0.28u
M_M3 VSS A a_28_68# VPW nfet_03v3 ad=0.26p pd=1.52u as=0.44p ps=2.88u w=1u l=0.28u
M_M4 VDD B Y VNW pfet_03v3 ad=0.9384p pd=4.12u as=0.3588p ps=1.9u w=1.38u l=0.28u
M_M5 Y B a_28_68# VPW nfet_03v3 ad=0.26p pd=1.52u as=0.26p ps=1.52u w=1u l=0.28u
M_M6 Y A VDD VNW pfet_03v3 ad=0.3588p pd=1.9u as=0.3588p ps=1.9u w=1.38u l=0.28u
M_M7 VDD B Y VNW pfet_03v3 ad=0.3588p pd=1.9u as=0.3588p ps=1.9u w=1.38u l=0.28u
M_M8 a_28_68# A VSS VPW nfet_03v3 ad=0.26p pd=1.52u as=0.26p ps=1.52u w=1u l=0.28u
M_M9 a_28_68# B Y VPW nfet_03v3 ad=0.68p pd=3.36u as=0.26p ps=1.52u w=1u l=0.28u
M_M10 VDD A Y VNW pfet_03v3 ad=0.3588p pd=1.9u as=0.3588p ps=1.9u w=1.38u l=0.28u
M_M11 VSS A a_28_68# VPW nfet_03v3 ad=0.26p pd=1.52u as=0.26p ps=1.52u w=1u l=0.28u
M_M12 Y B VDD VNW pfet_03v3 ad=0.3588p pd=1.9u as=0.3588p ps=1.9u w=1.38u l=0.28u
M_M13 Y B a_28_68# VPW nfet_03v3 ad=0.26p pd=1.52u as=0.26p ps=1.52u w=1u l=0.28u
M_M14 Y A VDD VNW pfet_03v3 ad=0.3588p pd=1.9u as=0.6072p ps=3.64u w=1.38u l=0.28u
M_M15 a_28_68# A VSS VPW nfet_03v3 ad=0.26p pd=1.52u as=0.26p ps=1.52u w=1u l=0.28u
.ends

* NGSPICE file created from gf180mcu_as_sc_mcu7t3v3__nand2b_2.ext - technology: gf180mcuD

.subckt gf180mcu_as_sc_mcu7t3v3__nand2b_2 VDD VNW VPW VSS Y B A
M_M0 a_364_68# a_220_68# VSS VPW nfet_03v3 ad=0.26p pd=1.52u as=0.26p ps=1.52u w=1u l=0.28u
M_M1 a_220_68# A VSS VPW nfet_03v3 ad=0.44p pd=2.88u as=0.46p ps=2.92u w=1u l=0.28u
M_M2 VSS a_220_68# a_364_68# VPW nfet_03v3 ad=0.26p pd=1.52u as=0.44p ps=2.88u w=1u l=0.28u
M_M3 a_220_68# A VDD VNW pfet_03v3 ad=0.6072p pd=3.64u as=0.6348p ps=3.68u w=1.38u l=0.28u
M_M4 Y a_220_68# VDD VNW pfet_03v3 ad=0.3588p pd=1.9u as=0.6072p ps=3.64u w=1.38u l=0.28u
M_M5 VDD B Y VNW pfet_03v3 ad=0.7176p pd=3.8u as=0.3588p ps=1.9u w=1.38u l=0.28u
M_M6 a_364_68# B Y VPW nfet_03v3 ad=0.515p pd=3.03u as=0.26p ps=1.52u w=1u l=0.28u
M_M7 VDD a_220_68# Y VNW pfet_03v3 ad=0.3588p pd=1.9u as=0.3588p ps=1.9u w=1.38u l=0.28u
M_M8 Y B a_364_68# VPW nfet_03v3 ad=0.26p pd=1.52u as=0.26p ps=1.52u w=1u l=0.28u
M_M9 Y B VDD VNW pfet_03v3 ad=0.3588p pd=1.9u as=0.3588p ps=1.9u w=1.38u l=0.28u
.ends

* NGSPICE file created from gf180mcu_as_sc_mcu7t3v3__nand2b_4.ext - technology: gf180mcuD

.subckt gf180mcu_as_sc_mcu7t3v3__nand2b_4 VDD VNW VPW VSS Y A B
M_M0 VDD B Y VNW pfet_03v3 ad=0.3588p pd=1.9u as=0.3588p ps=1.9u w=1.38u l=0.28u
M_M1 a_364_68# a_220_68# VSS VPW nfet_03v3 ad=0.26p pd=1.52u as=0.26p ps=1.52u w=1u l=0.28u
M_M2 a_364_68# B Y VPW nfet_03v3 ad=0.26p pd=1.52u as=0.26p ps=1.52u w=1u l=0.28u
M_M3 a_220_68# A VSS VPW nfet_03v3 ad=0.44p pd=2.88u as=0.44p ps=2.88u w=1u l=0.28u
M_M4 VSS a_220_68# a_364_68# VPW nfet_03v3 ad=0.26p pd=1.52u as=0.44p ps=2.88u w=1u l=0.28u
M_M5 a_220_68# A VDD VNW pfet_03v3 ad=0.6072p pd=3.64u as=0.6072p ps=3.64u w=1.38u l=0.28u
M_M6 Y a_220_68# VDD VNW pfet_03v3 ad=0.3588p pd=1.9u as=0.6072p ps=3.64u w=1.38u l=0.28u
M_M7 VDD a_220_68# Y VNW pfet_03v3 ad=0.3588p pd=1.9u as=0.3588p ps=1.9u w=1.38u l=0.28u
M_M8 Y B a_364_68# VPW nfet_03v3 ad=0.26p pd=1.52u as=0.26p ps=1.52u w=1u l=0.28u
M_M9 Y B VDD VNW pfet_03v3 ad=0.3588p pd=1.9u as=0.3588p ps=1.9u w=1.38u l=0.28u
M_M10 Y B VDD VNW pfet_03v3 ad=0.3588p pd=1.9u as=0.3588p ps=1.9u w=1.38u l=0.28u
M_M11 VDD B Y VNW pfet_03v3 ad=0.9384p pd=4.12u as=0.3588p ps=1.9u w=1.38u l=0.28u
M_M12 a_364_68# a_220_68# VSS VPW nfet_03v3 ad=0.26p pd=1.52u as=0.26p ps=1.52u w=1u l=0.28u
M_M13 a_364_68# B Y VPW nfet_03v3 ad=0.68p pd=3.36u as=0.26p ps=1.52u w=1u l=0.28u
M_M14 VDD a_220_68# Y VNW pfet_03v3 ad=0.3588p pd=1.9u as=0.3588p ps=1.9u w=1.38u l=0.28u
M_M15 VSS a_220_68# a_364_68# VPW nfet_03v3 ad=0.26p pd=1.52u as=0.26p ps=1.52u w=1u l=0.28u
M_M16 Y B a_364_68# VPW nfet_03v3 ad=0.26p pd=1.52u as=0.26p ps=1.52u w=1u l=0.28u
M_M17 Y a_220_68# VDD VNW pfet_03v3 ad=0.3588p pd=1.9u as=0.3588p ps=1.9u w=1.38u l=0.28u
.ends

* NGSPICE file created from gf180mcu_as_sc_mcu7t3v3__nand3_2.ext - technology: gf180mcuD

.subckt gf180mcu_as_sc_mcu7t3v3__nand3_2 VDD VNW VPW VSS A B C Y
M_M0 VDD A Y VNW pfet_03v3 ad=0.3588p pd=1.9u as=0.3588p ps=1.9u w=1.38u l=0.28u
M_M1 VSS A a_28_68# VPW nfet_03v3 ad=0.26p pd=1.52u as=0.44p ps=2.88u w=1u l=0.28u
M_M2 VDD C Y VNW pfet_03v3 ad=0.621p pd=3.66u as=0.3588p ps=1.9u w=1.38u l=0.28u
M_M3 a_492_68# C Y VPW nfet_03v3 ad=0.45p pd=2.9u as=0.26p ps=1.52u w=1u l=0.28u
M_M4 Y B VDD VNW pfet_03v3 ad=0.3588p pd=1.9u as=0.3588p ps=1.9u w=1.38u l=0.28u
M_M5 a_28_68# B a_492_68# VPW nfet_03v3 ad=0.44p pd=2.88u as=0.26p ps=1.52u w=1u l=0.28u
M_M6 VDD B Y VNW pfet_03v3 ad=0.8004p pd=2.54u as=0.3588p ps=1.9u w=1.38u l=0.28u
M_M7 Y C VDD VNW pfet_03v3 ad=0.3588p pd=1.9u as=0.8004p ps=2.54u w=1.38u l=0.28u
M_M8 Y C a_492_68# VPW nfet_03v3 ad=0.26p pd=1.52u as=0.44p ps=2.88u w=1u l=0.28u
M_M9 a_492_68# B a_28_68# VPW nfet_03v3 ad=0.26p pd=1.52u as=0.26p ps=1.52u w=1u l=0.28u
M_M10 Y A VDD VNW pfet_03v3 ad=0.3588p pd=1.9u as=0.6072p ps=3.64u w=1.38u l=0.28u
M_M11 a_28_68# A VSS VPW nfet_03v3 ad=0.26p pd=1.52u as=0.26p ps=1.52u w=1u l=0.28u
.ends

* NGSPICE file created from gf180mcu_as_sc_mcu7t3v3__nand3b_2.ext - technology: gf180mcuD

.subckt gf180mcu_as_sc_mcu7t3v3__nand3b_2 VDD VNW VPW VSS A B C Y
M_M0 a_364_68# a_172_68# VSS VPW nfet_03v3 ad=0.26p pd=1.52u as=0.26p ps=1.52u w=1u l=0.28u
M_M1 a_172_68# A VSS VPW nfet_03v3 ad=0.68p pd=3.36u as=0.44p ps=2.88u w=1u l=0.28u
M_M2 VSS a_172_68# a_364_68# VPW nfet_03v3 ad=0.26p pd=1.52u as=0.44p ps=2.88u w=1u l=0.28u
M_M3 Y a_172_68# VDD VNW pfet_03v3 ad=0.3588p pd=1.9u as=0.6072p ps=3.64u w=1.38u l=0.28u
M_M4 VDD B Y VNW pfet_03v3 ad=0.8004p pd=2.54u as=0.3588p ps=1.9u w=1.38u l=0.28u
M_M5 Y C VDD VNW pfet_03v3 ad=0.3588p pd=1.9u as=0.8004p ps=2.54u w=1.38u l=0.28u
M_M6 a_828_68# C Y VPW nfet_03v3 ad=0.45p pd=2.9u as=0.26p ps=1.52u w=1u l=0.28u
M_M7 VDD C Y VNW pfet_03v3 ad=0.621p pd=3.66u as=0.3588p ps=1.9u w=1.38u l=0.28u
M_M8 a_364_68# B a_828_68# VPW nfet_03v3 ad=0.44p pd=2.88u as=0.26p ps=1.52u w=1u l=0.28u
M_M9 Y C a_828_68# VPW nfet_03v3 ad=0.26p pd=1.52u as=0.44p ps=2.88u w=1u l=0.28u
M_M10 VDD a_172_68# Y VNW pfet_03v3 ad=0.3588p pd=1.9u as=0.3588p ps=1.9u w=1.38u l=0.28u
M_M11 a_828_68# B a_364_68# VPW nfet_03v3 ad=0.26p pd=1.52u as=0.26p ps=1.52u w=1u l=0.28u
M_M12 Y B VDD VNW pfet_03v3 ad=0.3588p pd=1.9u as=0.3588p ps=1.9u w=1.38u l=0.28u
M_M13 a_172_68# A VDD VNW pfet_03v3 ad=0.9384p pd=4.12u as=0.6072p ps=3.64u w=1.38u l=0.28u
.ends

* NGSPICE file created from gf180mcu_as_sc_mcu7t3v3__nand3bb_2.ext - technology: gf180mcuD

.subckt gf180mcu_as_sc_mcu7t3v3__nand3bb_2 VDD VNW VPW VSS A B C Y
M_M0 a_364_68# a_172_68# VSS VPW nfet_03v3 ad=0.26p pd=1.52u as=0.26p ps=1.52u w=1u l=0.28u
M_M1 a_172_68# A VSS VPW nfet_03v3 ad=0.68p pd=3.36u as=0.44p ps=2.88u w=1u l=0.28u
M_M2 VSS a_172_68# a_364_68# VPW nfet_03v3 ad=0.26p pd=1.52u as=0.44p ps=2.88u w=1u l=0.28u
M_M3 Y a_172_68# VDD VNW pfet_03v3 ad=0.3588p pd=1.9u as=0.6072p ps=3.64u w=1.38u l=0.28u
M_M4 VDD B Y VNW pfet_03v3 ad=0.8004p pd=2.54u as=0.3588p ps=1.9u w=1.38u l=0.28u
M_M5 Y a_1220_24# VDD VNW pfet_03v3 ad=0.3588p pd=1.9u as=0.8004p ps=2.54u w=1.38u l=0.28u
M_M6 a_828_68# a_1220_24# Y VPW nfet_03v3 ad=0.45p pd=2.9u as=0.26p ps=1.52u w=1u l=0.28u
M_M7 VSS C a_1220_24# VPW nfet_03v3 ad=0.505p pd=3.01u as=0.44p ps=2.88u w=1u l=0.28u
M_M8 VDD a_1220_24# Y VNW pfet_03v3 ad=0.621p pd=3.66u as=0.3588p ps=1.9u w=1.38u l=0.28u
M_M9 a_364_68# B a_828_68# VPW nfet_03v3 ad=0.44p pd=2.88u as=0.26p ps=1.52u w=1u l=0.28u
M_M10 Y a_1220_24# a_828_68# VPW nfet_03v3 ad=0.26p pd=1.52u as=0.44p ps=2.88u w=1u l=0.28u
M_M11 VDD a_172_68# Y VNW pfet_03v3 ad=0.3588p pd=1.9u as=0.3588p ps=1.9u w=1.38u l=0.28u
M_M12 a_828_68# B a_364_68# VPW nfet_03v3 ad=0.26p pd=1.52u as=0.26p ps=1.52u w=1u l=0.28u
M_M13 Y B VDD VNW pfet_03v3 ad=0.3588p pd=1.9u as=0.3588p ps=1.9u w=1.38u l=0.28u
M_M14 a_172_68# A VDD VNW pfet_03v3 ad=0.9384p pd=4.12u as=0.6072p ps=3.64u w=1.38u l=0.28u
M_M15 VDD C a_1220_24# VNW pfet_03v3 ad=0.6969p pd=3.77u as=0.6072p ps=3.64u w=1.38u l=0.28u
.ends

* NGSPICE file created from gf180mcu_as_sc_mcu7t3v3__nand4_2.ext - technology: gf180mcuD

.subckt gf180mcu_as_sc_mcu7t3v3__nand4_2 VDD VNW VPW VSS A B C D Y
M_M0 VDD A Y VNW pfet_03v3 ad=0.3588p pd=1.9u as=0.3588p ps=1.9u w=1.38u l=0.28u
M_M1 Y D a_796_68# VPW nfet_03v3 ad=0.26p pd=1.52u as=0.26p ps=1.52u w=1u l=0.28u
M_M2 VSS A a_28_68# VPW nfet_03v3 ad=0.26p pd=1.52u as=0.44p ps=2.88u w=1u l=0.28u
M_M3 VDD C Y VNW pfet_03v3 ad=0.3588p pd=1.9u as=0.3588p ps=1.9u w=1.38u l=0.28u
M_M4 a_796_68# C a_492_68# VPW nfet_03v3 ad=0.26p pd=1.52u as=0.26p ps=1.52u w=1u l=0.28u
M_M5 Y B VDD VNW pfet_03v3 ad=0.3588p pd=1.9u as=0.3588p ps=1.9u w=1.38u l=0.28u
M_M6 a_28_68# B a_492_68# VPW nfet_03v3 ad=0.44p pd=2.88u as=0.26p ps=1.52u w=1u l=0.28u
M_M7 Y D VDD VNW pfet_03v3 ad=0.3588p pd=1.9u as=0.3588p ps=1.9u w=1.38u l=0.28u
M_M8 VDD B Y VNW pfet_03v3 ad=0.8004p pd=2.54u as=0.3588p ps=1.9u w=1.38u l=0.28u
M_M9 Y C VDD VNW pfet_03v3 ad=0.3588p pd=1.9u as=0.8004p ps=2.54u w=1.38u l=0.28u
M_M10 a_492_68# C a_796_68# VPW nfet_03v3 ad=0.26p pd=1.52u as=0.44p ps=2.88u w=1u l=0.28u
M_M11 a_492_68# B a_28_68# VPW nfet_03v3 ad=0.26p pd=1.52u as=0.26p ps=1.52u w=1u l=0.28u
M_M12 VDD D Y VNW pfet_03v3 ad=0.6348p pd=3.68u as=0.3588p ps=1.9u w=1.38u l=0.28u
M_M13 Y A VDD VNW pfet_03v3 ad=0.3588p pd=1.9u as=0.6072p ps=3.64u w=1.38u l=0.28u
M_M14 a_796_68# D Y VPW nfet_03v3 ad=0.46p pd=2.92u as=0.26p ps=1.52u w=1u l=0.28u
M_M15 a_28_68# A VSS VPW nfet_03v3 ad=0.26p pd=1.52u as=0.26p ps=1.52u w=1u l=0.28u
.ends

* NGSPICE file created from gf180mcu_as_sc_mcu7t3v3__nand4b_2.ext - technology: gf180mcuD

.subckt gf180mcu_as_sc_mcu7t3v3__nand4b_2 VDD VNW VPW VSS A B C D Y
M_M0 Y D VDD VNW pfet_03v3 ad=0.3588p pd=1.9u as=0.3588p ps=1.9u w=1.38u l=0.28u
M_M1 a_1132_68# D Y VPW nfet_03v3 ad=0.46p pd=2.92u as=0.26p ps=1.52u w=1u l=0.28u
M_M2 a_364_68# a_220_68# VSS VPW nfet_03v3 ad=0.26p pd=1.52u as=0.26p ps=1.52u w=1u l=0.28u
M_M3 a_220_68# A VSS VPW nfet_03v3 ad=0.44p pd=2.88u as=0.49p ps=2.98u w=1u l=0.28u
M_M4 Y D a_1132_68# VPW nfet_03v3 ad=0.26p pd=1.52u as=0.26p ps=1.52u w=1u l=0.28u
M_M5 VSS a_220_68# a_364_68# VPW nfet_03v3 ad=0.26p pd=1.52u as=0.44p ps=2.88u w=1u l=0.28u
M_M6 a_220_68# A VDD VNW pfet_03v3 ad=0.6072p pd=3.64u as=0.6762p ps=3.74u w=1.38u l=0.28u
M_M7 Y a_220_68# VDD VNW pfet_03v3 ad=0.3588p pd=1.9u as=0.6072p ps=3.64u w=1.38u l=0.28u
M_M8 VDD B Y VNW pfet_03v3 ad=0.8004p pd=2.54u as=0.3588p ps=1.9u w=1.38u l=0.28u
M_M9 Y C VDD VNW pfet_03v3 ad=0.3588p pd=1.9u as=0.8004p ps=2.54u w=1.38u l=0.28u
M_M10 VDD D Y VNW pfet_03v3 ad=0.6348p pd=3.68u as=0.3588p ps=1.9u w=1.38u l=0.28u
M_M11 a_1132_68# C a_828_68# VPW nfet_03v3 ad=0.26p pd=1.52u as=0.26p ps=1.52u w=1u l=0.28u
M_M12 VDD C Y VNW pfet_03v3 ad=0.3588p pd=1.9u as=0.3588p ps=1.9u w=1.38u l=0.28u
M_M13 a_364_68# B a_828_68# VPW nfet_03v3 ad=0.44p pd=2.88u as=0.26p ps=1.52u w=1u l=0.28u
M_M14 a_828_68# C a_1132_68# VPW nfet_03v3 ad=0.26p pd=1.52u as=0.44p ps=2.88u w=1u l=0.28u
M_M15 VDD a_220_68# Y VNW pfet_03v3 ad=0.3588p pd=1.9u as=0.3588p ps=1.9u w=1.38u l=0.28u
M_M16 a_828_68# B a_364_68# VPW nfet_03v3 ad=0.26p pd=1.52u as=0.26p ps=1.52u w=1u l=0.28u
M_M17 Y B VDD VNW pfet_03v3 ad=0.3588p pd=1.9u as=0.3588p ps=1.9u w=1.38u l=0.28u
.ends

* NGSPICE file created from gf180mcu_as_sc_mcu7t3v3__nand4bb_2.ext - technology: gf180mcuD

.subckt gf180mcu_as_sc_mcu7t3v3__nand4bb_2 VDD VNW VPW VSS A B C D Y
M_M0 Y a_1540_24# VDD VNW pfet_03v3 ad=0.3588p pd=1.9u as=0.3588p ps=1.9u w=1.38u l=0.28u
M_M1 a_1132_68# a_1540_24# Y VPW nfet_03v3 ad=0.465p pd=2.93u as=0.26p ps=1.52u w=1u l=0.28u
M_M2 a_364_68# a_220_68# VSS VPW nfet_03v3 ad=0.26p pd=1.52u as=0.26p ps=1.52u w=1u l=0.28u
M_M3 VDD D a_1540_24# VNW pfet_03v3 ad=0.6072p pd=3.64u as=0.6072p ps=3.64u w=1.38u l=0.28u
M_M4 a_220_68# A VSS VPW nfet_03v3 ad=0.44p pd=2.88u as=0.49p ps=2.98u w=1u l=0.28u
M_M5 Y a_1540_24# a_1132_68# VPW nfet_03v3 ad=0.26p pd=1.52u as=0.26p ps=1.52u w=1u l=0.28u
M_M6 VSS a_220_68# a_364_68# VPW nfet_03v3 ad=0.26p pd=1.52u as=0.44p ps=2.88u w=1u l=0.28u
M_M7 a_220_68# A VDD VNW pfet_03v3 ad=0.6072p pd=3.64u as=0.6762p ps=3.74u w=1.38u l=0.28u
M_M8 Y a_220_68# VDD VNW pfet_03v3 ad=0.3588p pd=1.9u as=0.6072p ps=3.64u w=1.38u l=0.28u
M_M9 VDD B Y VNW pfet_03v3 ad=0.8004p pd=2.54u as=0.3588p ps=1.9u w=1.38u l=0.28u
M_M10 Y C VDD VNW pfet_03v3 ad=0.3588p pd=1.9u as=0.8004p ps=2.54u w=1.38u l=0.28u
M_M11 VDD a_1540_24# Y VNW pfet_03v3 ad=0.6417p pd=3.69u as=0.3588p ps=1.9u w=1.38u l=0.28u
M_M12 a_1132_68# C a_828_68# VPW nfet_03v3 ad=0.26p pd=1.52u as=0.26p ps=1.52u w=1u l=0.28u
M_M13 VDD C Y VNW pfet_03v3 ad=0.3588p pd=1.9u as=0.3588p ps=1.9u w=1.38u l=0.28u
M_M14 a_364_68# B a_828_68# VPW nfet_03v3 ad=0.44p pd=2.88u as=0.26p ps=1.52u w=1u l=0.28u
M_M15 a_828_68# C a_1132_68# VPW nfet_03v3 ad=0.26p pd=1.52u as=0.44p ps=2.88u w=1u l=0.28u
M_M16 VDD a_220_68# Y VNW pfet_03v3 ad=0.3588p pd=1.9u as=0.3588p ps=1.9u w=1.38u l=0.28u
M_M17 a_828_68# B a_364_68# VPW nfet_03v3 ad=0.26p pd=1.52u as=0.26p ps=1.52u w=1u l=0.28u
M_M18 Y B VDD VNW pfet_03v3 ad=0.3588p pd=1.9u as=0.3588p ps=1.9u w=1.38u l=0.28u
M_M19 VSS D a_1540_24# VPW nfet_03v3 ad=0.44p pd=2.88u as=0.44p ps=2.88u w=1u l=0.28u
.ends

* NGSPICE file created from gf180mcu_as_sc_mcu7t3v3__nor2_2.ext - technology: gf180mcuD

.subckt gf180mcu_as_sc_mcu7t3v3__nor2_2 VDD VNW VPW VSS Y B A
M_M0 a_28_440# A VDD VNW pfet_03v3 ad=0.3588p pd=1.9u as=0.3588p ps=1.9u w=1.38u l=0.28u
M_M1 Y A VSS VPW nfet_03v3 ad=0.26p pd=1.52u as=0.44p ps=2.88u w=1u l=0.28u
M_M2 Y B a_28_440# VNW pfet_03v3 ad=0.3588p pd=1.9u as=0.3588p ps=1.9u w=1.38u l=0.28u
M_M3 VSS B Y VPW nfet_03v3 ad=0.515p pd=3.03u as=0.26p ps=1.52u w=1u l=0.28u
M_M4 a_28_440# B Y VNW pfet_03v3 ad=0.7176p pd=3.8u as=0.3588p ps=1.9u w=1.38u l=0.28u
M_M5 Y B VSS VPW nfet_03v3 ad=0.26p pd=1.52u as=0.26p ps=1.52u w=1u l=0.28u
M_M6 VDD A a_28_440# VNW pfet_03v3 ad=0.3588p pd=1.9u as=0.6072p ps=3.64u w=1.38u l=0.28u
M_M7 VSS A Y VPW nfet_03v3 ad=0.26p pd=1.52u as=0.26p ps=1.52u w=1u l=0.28u
.ends

* NGSPICE file created from gf180mcu_as_sc_mcu7t3v3__nor2_4.ext - technology: gf180mcuD

.subckt gf180mcu_as_sc_mcu7t3v3__nor2_4 VDD VNW VPW VSS Y A B
M_M0 VSS B Y VPW nfet_03v3 ad=0.26p pd=1.52u as=0.26p ps=1.52u w=1u l=0.28u
M_M1 a_28_440# A VDD VNW pfet_03v3 ad=0.3588p pd=1.9u as=0.3588p ps=1.9u w=1.38u l=0.28u
M_M2 Y B a_28_440# VNW pfet_03v3 ad=0.3588p pd=1.9u as=0.3588p ps=1.9u w=1.38u l=0.28u
M_M3 Y A VSS VPW nfet_03v3 ad=0.26p pd=1.52u as=0.44p ps=2.88u w=1u l=0.28u
M_M4 a_28_440# B Y VNW pfet_03v3 ad=0.9384p pd=4.12u as=0.3588p ps=1.9u w=1.38u l=0.28u
M_M5 Y B VSS VPW nfet_03v3 ad=0.26p pd=1.52u as=0.26p ps=1.52u w=1u l=0.28u
M_M6 VDD A a_28_440# VNW pfet_03v3 ad=0.3588p pd=1.9u as=0.3588p ps=1.9u w=1.38u l=0.28u
M_M7 a_28_440# B Y VNW pfet_03v3 ad=0.3588p pd=1.9u as=0.3588p ps=1.9u w=1.38u l=0.28u
M_M8 VSS A Y VPW nfet_03v3 ad=0.26p pd=1.52u as=0.26p ps=1.52u w=1u l=0.28u
M_M9 VSS B Y VPW nfet_03v3 ad=0.68p pd=3.36u as=0.26p ps=1.52u w=1u l=0.28u
M_M10 a_28_440# A VDD VNW pfet_03v3 ad=0.3588p pd=1.9u as=0.3588p ps=1.9u w=1.38u l=0.28u
M_M11 Y A VSS VPW nfet_03v3 ad=0.26p pd=1.52u as=0.26p ps=1.52u w=1u l=0.28u
M_M12 Y B a_28_440# VNW pfet_03v3 ad=0.3588p pd=1.9u as=0.3588p ps=1.9u w=1.38u l=0.28u
M_M13 Y B VSS VPW nfet_03v3 ad=0.26p pd=1.52u as=0.26p ps=1.52u w=1u l=0.28u
M_M14 VDD A a_28_440# VNW pfet_03v3 ad=0.3588p pd=1.9u as=0.6072p ps=3.64u w=1.38u l=0.28u
M_M15 VSS A Y VPW nfet_03v3 ad=0.26p pd=1.52u as=0.26p ps=1.52u w=1u l=0.28u
.ends

* NGSPICE file created from gf180mcu_as_sc_mcu7t3v3__nor2b_2.ext - technology: gf180mcuD

.subckt gf180mcu_as_sc_mcu7t3v3__nor2b_2 VDD VNW VPW VSS Y B A
M_M0 VSS a_220_68# Y VPW nfet_03v3 ad=0.26p pd=1.52u as=0.26p ps=1.52u w=1u l=0.28u
M_M1 a_220_68# A VSS VPW nfet_03v3 ad=0.44p pd=2.88u as=0.445p ps=2.89u w=1u l=0.28u
M_M2 Y a_220_68# VSS VPW nfet_03v3 ad=0.26p pd=1.52u as=0.44p ps=2.88u w=1u l=0.28u
M_M3 a_220_68# A VDD VNW pfet_03v3 ad=0.6072p pd=3.64u as=0.6141p ps=3.65u w=1.38u l=0.28u
M_M4 VDD a_220_68# a_364_440# VNW pfet_03v3 ad=0.3588p pd=1.9u as=0.6072p ps=3.64u w=1.38u l=0.28u
M_M5 a_364_440# B Y VNW pfet_03v3 ad=0.7176p pd=3.8u as=0.3588p ps=1.9u w=1.38u l=0.28u
M_M6 VSS B Y VPW nfet_03v3 ad=0.515p pd=3.03u as=0.26p ps=1.52u w=1u l=0.28u
M_M7 a_364_440# a_220_68# VDD VNW pfet_03v3 ad=0.3588p pd=1.9u as=0.3588p ps=1.9u w=1.38u l=0.28u
M_M8 Y B VSS VPW nfet_03v3 ad=0.26p pd=1.52u as=0.26p ps=1.52u w=1u l=0.28u
M_M9 Y B a_364_440# VNW pfet_03v3 ad=0.3588p pd=1.9u as=0.3588p ps=1.9u w=1.38u l=0.28u
.ends

* NGSPICE file created from gf180mcu_as_sc_mcu7t3v3__nor2b_4.ext - technology: gf180mcuD

.subckt gf180mcu_as_sc_mcu7t3v3__nor2b_4 VDD VNW VPW VSS Y A B
M_M0 a_364_440# B Y VNW pfet_03v3 ad=0.3588p pd=1.9u as=0.3588p ps=1.9u w=1.38u l=0.28u
M_M1 VSS a_220_68# Y VPW nfet_03v3 ad=0.26p pd=1.52u as=0.26p ps=1.52u w=1u l=0.28u
M_M2 VSS B Y VPW nfet_03v3 ad=0.26p pd=1.52u as=0.26p ps=1.52u w=1u l=0.28u
M_M3 a_220_68# A VSS VPW nfet_03v3 ad=0.44p pd=2.88u as=0.445p ps=2.89u w=1u l=0.28u
M_M4 Y a_220_68# VSS VPW nfet_03v3 ad=0.26p pd=1.52u as=0.44p ps=2.88u w=1u l=0.28u
M_M5 a_220_68# A VDD VNW pfet_03v3 ad=0.6072p pd=3.64u as=0.6141p ps=3.65u w=1.38u l=0.28u
M_M6 VDD a_220_68# a_364_440# VNW pfet_03v3 ad=0.3588p pd=1.9u as=0.6072p ps=3.64u w=1.38u l=0.28u
M_M7 a_364_440# a_220_68# VDD VNW pfet_03v3 ad=0.3588p pd=1.9u as=0.3588p ps=1.9u w=1.38u l=0.28u
M_M8 Y B VSS VPW nfet_03v3 ad=0.26p pd=1.52u as=0.26p ps=1.52u w=1u l=0.28u
M_M9 Y B a_364_440# VNW pfet_03v3 ad=0.3588p pd=1.9u as=0.3588p ps=1.9u w=1.38u l=0.28u
M_M10 Y B a_364_440# VNW pfet_03v3 ad=0.3588p pd=1.9u as=0.3588p ps=1.9u w=1.38u l=0.28u
M_M11 a_364_440# B Y VNW pfet_03v3 ad=0.9384p pd=4.12u as=0.3588p ps=1.9u w=1.38u l=0.28u
M_M12 VSS a_220_68# Y VPW nfet_03v3 ad=0.26p pd=1.52u as=0.26p ps=1.52u w=1u l=0.28u
M_M13 VSS B Y VPW nfet_03v3 ad=0.68p pd=3.36u as=0.26p ps=1.52u w=1u l=0.28u
M_M14 a_364_440# a_220_68# VDD VNW pfet_03v3 ad=0.3588p pd=1.9u as=0.3588p ps=1.9u w=1.38u l=0.28u
M_M15 Y a_220_68# VSS VPW nfet_03v3 ad=0.26p pd=1.52u as=0.26p ps=1.52u w=1u l=0.28u
M_M16 Y B VSS VPW nfet_03v3 ad=0.26p pd=1.52u as=0.26p ps=1.52u w=1u l=0.28u
M_M17 VDD a_220_68# a_364_440# VNW pfet_03v3 ad=0.3588p pd=1.9u as=0.3588p ps=1.9u w=1.38u l=0.28u
.ends

* NGSPICE file created from gf180mcu_as_sc_mcu7t3v3__nor3_2.ext - technology: gf180mcuD

.subckt gf180mcu_as_sc_mcu7t3v3__nor3_2 VDD VNW VPW VSS A B C Y
M_M0 a_28_440# A VDD VNW pfet_03v3 ad=0.3588p pd=1.9u as=0.3588p ps=1.9u w=1.38u l=0.28u
M_M1 Y A VSS VPW nfet_03v3 ad=0.26p pd=1.52u as=0.44p ps=2.88u w=1u l=0.28u
M_M2 a_492_440# C Y VNW pfet_03v3 ad=0.621p pd=3.66u as=0.3588p ps=1.9u w=1.38u l=0.28u
M_M3 VSS C Y VPW nfet_03v3 ad=0.45p pd=2.9u as=0.26p ps=1.52u w=1u l=0.28u
M_M4 a_492_440# B a_28_440# VNW pfet_03v3 ad=0.3588p pd=1.9u as=0.3588p ps=1.9u w=1.38u l=0.28u
M_M5 VSS B Y VPW nfet_03v3 ad=0.58p pd=2.16u as=0.26p ps=1.52u w=1u l=0.28u
M_M6 a_28_440# B a_492_440# VNW pfet_03v3 ad=0.6072p pd=3.64u as=0.3588p ps=1.9u w=1.38u l=0.28u
M_M7 Y C a_492_440# VNW pfet_03v3 ad=0.3588p pd=1.9u as=0.6072p ps=3.64u w=1.38u l=0.28u
M_M8 Y C VSS VPW nfet_03v3 ad=0.26p pd=1.52u as=0.58p ps=2.16u w=1u l=0.28u
M_M9 Y B VSS VPW nfet_03v3 ad=0.26p pd=1.52u as=0.26p ps=1.52u w=1u l=0.28u
M_M10 VDD A a_28_440# VNW pfet_03v3 ad=0.3588p pd=1.9u as=0.6072p ps=3.64u w=1.38u l=0.28u
M_M11 VSS A Y VPW nfet_03v3 ad=0.26p pd=1.52u as=0.26p ps=1.52u w=1u l=0.28u
.ends

* NGSPICE file created from gf180mcu_as_sc_mcu7t3v3__nor3b_2.ext - technology: gf180mcuD

.subckt gf180mcu_as_sc_mcu7t3v3__nor3b_2 VDD VNW VPW VSS A B C Y
M_M0 VSS a_220_68# Y VPW nfet_03v3 ad=0.26p pd=1.52u as=0.26p ps=1.52u w=1u l=0.28u
M_M1 a_220_68# A VSS VPW nfet_03v3 ad=0.44p pd=2.88u as=0.44p ps=2.88u w=1u l=0.28u
M_M2 Y a_220_68# VSS VPW nfet_03v3 ad=0.26p pd=1.52u as=0.44p ps=2.88u w=1u l=0.28u
M_M3 a_220_68# A VDD VNW pfet_03v3 ad=0.6072p pd=3.64u as=0.6072p ps=3.64u w=1.38u l=0.28u
M_M4 VDD a_220_68# a_364_440# VNW pfet_03v3 ad=0.3588p pd=1.9u as=0.6072p ps=3.64u w=1.38u l=0.28u
M_M5 a_364_440# B a_828_440# VNW pfet_03v3 ad=0.6072p pd=3.64u as=0.3588p ps=1.9u w=1.38u l=0.28u
M_M6 Y C a_828_440# VNW pfet_03v3 ad=0.3588p pd=1.9u as=0.6072p ps=3.64u w=1.38u l=0.28u
M_M7 VSS C Y VPW nfet_03v3 ad=0.45p pd=2.9u as=0.26p ps=1.52u w=1u l=0.28u
M_M8 a_828_440# C Y VNW pfet_03v3 ad=0.621p pd=3.66u as=0.3588p ps=1.9u w=1.38u l=0.28u
M_M9 VSS B Y VPW nfet_03v3 ad=0.58p pd=2.16u as=0.26p ps=1.52u w=1u l=0.28u
M_M10 Y C VSS VPW nfet_03v3 ad=0.26p pd=1.52u as=0.58p ps=2.16u w=1u l=0.28u
M_M11 a_364_440# a_220_68# VDD VNW pfet_03v3 ad=0.3588p pd=1.9u as=0.3588p ps=1.9u w=1.38u l=0.28u
M_M12 Y B VSS VPW nfet_03v3 ad=0.26p pd=1.52u as=0.26p ps=1.52u w=1u l=0.28u
M_M13 a_828_440# B a_364_440# VNW pfet_03v3 ad=0.3588p pd=1.9u as=0.3588p ps=1.9u w=1.38u l=0.28u
.ends

* NGSPICE file created from gf180mcu_as_sc_mcu7t3v3__nor3bb_2.ext - technology: gf180mcuD

.subckt gf180mcu_as_sc_mcu7t3v3__nor3bb_2 VDD VNW VPW VSS A B C Y
M_M0 VSS a_220_68# Y VPW nfet_03v3 ad=0.26p pd=1.52u as=0.26p ps=1.52u w=1u l=0.28u
M_M1 VSS C a_1220_24# VPW nfet_03v3 ad=0.44p pd=2.88u as=0.44p ps=2.88u w=1u l=0.28u
M_M2 a_220_68# A VSS VPW nfet_03v3 ad=0.44p pd=2.88u as=0.44p ps=2.88u w=1u l=0.28u
M_M3 Y a_220_68# VSS VPW nfet_03v3 ad=0.26p pd=1.52u as=0.44p ps=2.88u w=1u l=0.28u
M_M4 a_220_68# A VDD VNW pfet_03v3 ad=0.6072p pd=3.64u as=0.6072p ps=3.64u w=1.38u l=0.28u
M_M5 VDD a_220_68# a_364_440# VNW pfet_03v3 ad=0.3588p pd=1.9u as=0.6072p ps=3.64u w=1.38u l=0.28u
M_M6 a_364_440# B a_828_440# VNW pfet_03v3 ad=0.6072p pd=3.64u as=0.3588p ps=1.9u w=1.38u l=0.28u
M_M7 Y a_1220_24# a_828_440# VNW pfet_03v3 ad=0.3588p pd=1.9u as=0.6072p ps=3.64u w=1.38u l=0.28u
M_M8 VSS a_1220_24# Y VPW nfet_03v3 ad=0.44p pd=2.88u as=0.26p ps=1.52u w=1u l=0.28u
M_M9 a_828_440# a_1220_24# Y VNW pfet_03v3 ad=0.6072p pd=3.64u as=0.3588p ps=1.9u w=1.38u l=0.28u
M_M10 VSS B Y VPW nfet_03v3 ad=0.58p pd=2.16u as=0.26p ps=1.52u w=1u l=0.28u
M_M11 VDD C a_1220_24# VNW pfet_03v3 ad=0.6072p pd=3.64u as=0.6072p ps=3.64u w=1.38u l=0.28u
M_M12 Y a_1220_24# VSS VPW nfet_03v3 ad=0.26p pd=1.52u as=0.58p ps=2.16u w=1u l=0.28u
M_M13 a_364_440# a_220_68# VDD VNW pfet_03v3 ad=0.3588p pd=1.9u as=0.3588p ps=1.9u w=1.38u l=0.28u
M_M14 Y B VSS VPW nfet_03v3 ad=0.26p pd=1.52u as=0.26p ps=1.52u w=1u l=0.28u
M_M15 a_828_440# B a_364_440# VNW pfet_03v3 ad=0.3588p pd=1.9u as=0.3588p ps=1.9u w=1.38u l=0.28u
.ends

* NGSPICE file created from gf180mcu_as_sc_mcu7t3v3__oa211_2.ext - technology: gf180mcuD

.subckt gf180mcu_as_sc_mcu7t3v3__oa211_2 VDD VNW VPW VSS A B C D Y
M_M0 a_332_440# B a_172_440# VNW pfet_03v3 ad=0.3588p pd=1.9u as=0.3588p ps=1.9u w=1.38u l=0.28u
M_M1 VSS A a_28_68# VPW nfet_03v3 ad=0.26p pd=1.52u as=0.44p ps=2.88u w=1u l=0.28u
M_M2 VDD a_332_440# Y VNW pfet_03v3 ad=0.7176p pd=3.8u as=0.3588p ps=1.9u w=1.38u l=0.28u
M_M3 VSS a_332_440# Y VPW nfet_03v3 ad=0.52p pd=3.04u as=0.26p ps=1.52u w=1u l=0.28u
M_M4 VDD C a_332_440# VNW pfet_03v3 ad=0.3588p pd=1.9u as=0.3588p ps=1.9u w=1.38u l=0.28u
M_M5 a_332_440# D a_492_68# VPW nfet_03v3 ad=0.44p pd=2.88u as=0.26p ps=1.52u w=1u l=0.28u
M_M6 a_332_440# D VDD VNW pfet_03v3 ad=0.6072p pd=3.64u as=0.3588p ps=1.9u w=1.38u l=0.28u
M_M7 Y a_332_440# VDD VNW pfet_03v3 ad=0.3588p pd=1.9u as=0.6072p ps=3.64u w=1.38u l=0.28u
M_M8 Y a_332_440# VSS VPW nfet_03v3 ad=0.26p pd=1.52u as=0.44p ps=2.88u w=1u l=0.28u
M_M9 a_492_68# C a_28_68# VPW nfet_03v3 ad=0.26p pd=1.52u as=0.26p ps=1.52u w=1u l=0.28u
M_M10 a_172_440# A VDD VNW pfet_03v3 ad=0.3588p pd=1.9u as=0.6072p ps=3.64u w=1.38u l=0.28u
M_M11 a_28_68# B VSS VPW nfet_03v3 ad=0.26p pd=1.52u as=0.26p ps=1.52u w=1u l=0.28u
.ends

* NGSPICE file created from gf180mcu_as_sc_mcu7t3v3__oa211_4.ext - technology: gf180mcuD

.subckt gf180mcu_as_sc_mcu7t3v3__oa211_4 VDD VNW VPW VSS A B C D Y
M_M0 a_332_440# B a_172_440# VNW pfet_03v3 ad=0.3588p pd=1.9u as=0.3588p ps=1.9u w=1.38u l=0.28u
M_M1 Y a_332_440# VSS VPW nfet_03v3 ad=0.26p pd=1.52u as=0.26p ps=1.52u w=1u l=0.28u
M_M2 VSS A a_28_68# VPW nfet_03v3 ad=0.26p pd=1.52u as=0.44p ps=2.88u w=1u l=0.28u
M_M3 VDD a_332_440# Y VNW pfet_03v3 ad=0.3588p pd=1.9u as=0.3588p ps=1.9u w=1.38u l=0.28u
M_M4 VSS a_332_440# Y VPW nfet_03v3 ad=0.26p pd=1.52u as=0.26p ps=1.52u w=1u l=0.28u
M_M5 VDD C a_332_440# VNW pfet_03v3 ad=0.3588p pd=1.9u as=0.3588p ps=1.9u w=1.38u l=0.28u
M_M6 a_332_440# D a_492_68# VPW nfet_03v3 ad=0.44p pd=2.88u as=0.26p ps=1.52u w=1u l=0.28u
M_M7 Y a_332_440# VDD VNW pfet_03v3 ad=0.3588p pd=1.9u as=0.3588p ps=1.9u w=1.38u l=0.28u
M_M8 a_332_440# D VDD VNW pfet_03v3 ad=0.6072p pd=3.64u as=0.3588p ps=1.9u w=1.38u l=0.28u
M_M9 Y a_332_440# VDD VNW pfet_03v3 ad=0.3588p pd=1.9u as=0.6072p ps=3.64u w=1.38u l=0.28u
M_M10 Y a_332_440# VSS VPW nfet_03v3 ad=0.26p pd=1.52u as=0.44p ps=2.88u w=1u l=0.28u
M_M11 a_492_68# C a_28_68# VPW nfet_03v3 ad=0.26p pd=1.52u as=0.26p ps=1.52u w=1u l=0.28u
M_M12 VDD a_332_440# Y VNW pfet_03v3 ad=0.6072p pd=3.64u as=0.3588p ps=1.9u w=1.38u l=0.28u
M_M13 a_172_440# A VDD VNW pfet_03v3 ad=0.3588p pd=1.9u as=0.6072p ps=3.64u w=1.38u l=0.28u
M_M14 VSS a_332_440# Y VPW nfet_03v3 ad=0.44p pd=2.88u as=0.26p ps=1.52u w=1u l=0.28u
M_M15 a_28_68# B VSS VPW nfet_03v3 ad=0.26p pd=1.52u as=0.26p ps=1.52u w=1u l=0.28u
.ends

* NGSPICE file created from gf180mcu_as_sc_mcu7t3v3__oa21_2.ext - technology: gf180mcuD

.subckt gf180mcu_as_sc_mcu7t3v3__oa21_2 VDD VNW VPW VSS A B C Y
M_M0 a_332_440# B a_172_440# VNW pfet_03v3 ad=0.3588p pd=1.9u as=0.3588p ps=1.9u w=1.38u l=0.28u
M_M1 VSS A a_28_68# VPW nfet_03v3 ad=0.26p pd=1.52u as=0.44p ps=2.88u w=1u l=0.28u
M_M2 VDD C a_332_440# VNW pfet_03v3 ad=0.6072p pd=3.64u as=0.3588p ps=1.9u w=1.38u l=0.28u
M_M3 Y a_332_440# VDD VNW pfet_03v3 ad=0.3588p pd=1.9u as=0.6072p ps=3.64u w=1.38u l=0.28u
M_M4 VDD a_332_440# Y VNW pfet_03v3 ad=0.6555p pd=3.71u as=0.3588p ps=1.9u w=1.38u l=0.28u
M_M5 VSS a_332_440# Y VPW nfet_03v3 ad=0.475p pd=2.95u as=0.26p ps=1.52u w=1u l=0.28u
M_M6 a_332_440# C a_28_68# VPW nfet_03v3 ad=0.44p pd=2.88u as=0.26p ps=1.52u w=1u l=0.28u
M_M7 Y a_332_440# VSS VPW nfet_03v3 ad=0.26p pd=1.52u as=0.44p ps=2.88u w=1u l=0.28u
M_M8 a_172_440# A VDD VNW pfet_03v3 ad=0.3588p pd=1.9u as=0.6072p ps=3.64u w=1.38u l=0.28u
M_M9 a_28_68# B VSS VPW nfet_03v3 ad=0.26p pd=1.52u as=0.26p ps=1.52u w=1u l=0.28u
.ends

* NGSPICE file created from gf180mcu_as_sc_mcu7t3v3__oa21_4.ext - technology: gf180mcuD

.subckt gf180mcu_as_sc_mcu7t3v3__oa21_4 VDD VNW VPW VSS A B C Y
M_M0 a_332_440# B a_172_440# VNW pfet_03v3 ad=0.3588p pd=1.9u as=0.3588p ps=1.9u w=1.38u l=0.28u
M_M1 VSS a_332_440# Y VPW nfet_03v3 ad=0.455p pd=2.91u as=0.26p ps=1.52u w=1u l=0.28u
M_M2 VSS A a_28_68# VPW nfet_03v3 ad=0.26p pd=1.52u as=0.44p ps=2.88u w=1u l=0.28u
M_M3 Y a_332_440# VDD VNW pfet_03v3 ad=0.3588p pd=1.9u as=0.3588p ps=1.9u w=1.38u l=0.28u
M_M4 Y a_332_440# VSS VPW nfet_03v3 ad=0.26p pd=1.52u as=0.26p ps=1.52u w=1u l=0.28u
M_M5 VDD C a_332_440# VNW pfet_03v3 ad=0.6072p pd=3.64u as=0.3588p ps=1.9u w=1.38u l=0.28u
M_M6 Y a_332_440# VDD VNW pfet_03v3 ad=0.3588p pd=1.9u as=0.6072p ps=3.64u w=1.38u l=0.28u
M_M7 VDD a_332_440# Y VNW pfet_03v3 ad=0.6279p pd=3.67u as=0.3588p ps=1.9u w=1.38u l=0.28u
M_M8 VDD a_332_440# Y VNW pfet_03v3 ad=0.3588p pd=1.9u as=0.3588p ps=1.9u w=1.38u l=0.28u
M_M9 VSS a_332_440# Y VPW nfet_03v3 ad=0.26p pd=1.52u as=0.26p ps=1.52u w=1u l=0.28u
M_M10 a_332_440# C a_28_68# VPW nfet_03v3 ad=0.44p pd=2.88u as=0.26p ps=1.52u w=1u l=0.28u
M_M11 Y a_332_440# VSS VPW nfet_03v3 ad=0.26p pd=1.52u as=0.44p ps=2.88u w=1u l=0.28u
M_M12 a_172_440# A VDD VNW pfet_03v3 ad=0.3588p pd=1.9u as=0.6072p ps=3.64u w=1.38u l=0.28u
M_M13 a_28_68# B VSS VPW nfet_03v3 ad=0.26p pd=1.52u as=0.26p ps=1.52u w=1u l=0.28u
.ends

* NGSPICE file created from gf180mcu_as_sc_mcu7t3v3__oa22_2.ext - technology: gf180mcuD

.subckt gf180mcu_as_sc_mcu7t3v3__oa22_2 VDD VNW VPW VSS C D B A Y
M_M0 a_172_68# D a_172_440# VNW pfet_03v3 ad=0.3588p pd=1.9u as=0.3588p ps=1.9u w=1.38u l=0.28u
M_M1 a_172_68# C a_28_68# VPW nfet_03v3 ad=0.26p pd=1.52u as=0.44p ps=2.88u w=1u l=0.28u
M_M2 VDD a_172_68# Y VNW pfet_03v3 ad=0.7176p pd=3.8u as=0.3588p ps=1.9u w=1.38u l=0.28u
M_M3 VSS a_172_68# Y VPW nfet_03v3 ad=0.52p pd=3.04u as=0.26p ps=1.52u w=1u l=0.28u
M_M4 a_492_440# B a_172_68# VNW pfet_03v3 ad=0.3588p pd=1.9u as=0.3588p ps=1.9u w=1.38u l=0.28u
M_M5 a_28_68# A VSS VPW nfet_03v3 ad=0.44p pd=2.88u as=0.26p ps=1.52u w=1u l=0.28u
M_M6 VDD A a_492_440# VNW pfet_03v3 ad=0.8004p pd=2.54u as=0.3588p ps=1.9u w=1.38u l=0.28u
M_M7 Y a_172_68# VDD VNW pfet_03v3 ad=0.3588p pd=1.9u as=0.8004p ps=2.54u w=1.38u l=0.28u
M_M8 Y a_172_68# VSS VPW nfet_03v3 ad=0.26p pd=1.52u as=0.44p ps=2.88u w=1u l=0.28u
M_M9 VSS B a_28_68# VPW nfet_03v3 ad=0.26p pd=1.52u as=0.26p ps=1.52u w=1u l=0.28u
M_M10 a_172_440# C VDD VNW pfet_03v3 ad=0.3588p pd=1.9u as=0.6072p ps=3.64u w=1.38u l=0.28u
M_M11 a_28_68# D a_172_68# VPW nfet_03v3 ad=0.26p pd=1.52u as=0.26p ps=1.52u w=1u l=0.28u
.ends

* NGSPICE file created from gf180mcu_as_sc_mcu7t3v3__oa22_4.ext - technology: gf180mcuD

.subckt gf180mcu_as_sc_mcu7t3v3__oa22_4 VDD VNW VPW VSS C D B A Y
M_M0 a_172_68# D a_172_440# VNW pfet_03v3 ad=0.3588p pd=1.9u as=0.3588p ps=1.9u w=1.38u l=0.28u
M_M1 Y a_172_68# VSS VPW nfet_03v3 ad=0.26p pd=1.52u as=0.26p ps=1.52u w=1u l=0.28u
M_M2 a_172_68# C a_28_68# VPW nfet_03v3 ad=0.26p pd=1.52u as=0.44p ps=2.88u w=1u l=0.28u
M_M3 VDD a_172_68# Y VNW pfet_03v3 ad=0.3588p pd=1.9u as=0.3588p ps=1.9u w=1.38u l=0.28u
M_M4 VSS a_172_68# Y VPW nfet_03v3 ad=0.26p pd=1.52u as=0.26p ps=1.52u w=1u l=0.28u
M_M5 a_492_440# B a_172_68# VNW pfet_03v3 ad=0.3588p pd=1.9u as=0.3588p ps=1.9u w=1.38u l=0.28u
M_M6 a_28_68# A VSS VPW nfet_03v3 ad=0.44p pd=2.88u as=0.26p ps=1.52u w=1u l=0.28u
M_M7 Y a_172_68# VDD VNW pfet_03v3 ad=0.3588p pd=1.9u as=0.3588p ps=1.9u w=1.38u l=0.28u
M_M8 VDD A a_492_440# VNW pfet_03v3 ad=0.8004p pd=2.54u as=0.3588p ps=1.9u w=1.38u l=0.28u
M_M9 Y a_172_68# VDD VNW pfet_03v3 ad=0.3588p pd=1.9u as=0.8004p ps=2.54u w=1.38u l=0.28u
M_M10 Y a_172_68# VSS VPW nfet_03v3 ad=0.26p pd=1.52u as=0.44p ps=2.88u w=1u l=0.28u
M_M11 VSS B a_28_68# VPW nfet_03v3 ad=0.26p pd=1.52u as=0.26p ps=1.52u w=1u l=0.28u
M_M12 VDD a_172_68# Y VNW pfet_03v3 ad=0.828p pd=3.96u as=0.3588p ps=1.9u w=1.38u l=0.28u
M_M13 a_172_440# C VDD VNW pfet_03v3 ad=0.3588p pd=1.9u as=0.6072p ps=3.64u w=1.38u l=0.28u
M_M14 VSS a_172_68# Y VPW nfet_03v3 ad=0.6p pd=3.2u as=0.26p ps=1.52u w=1u l=0.28u
M_M15 a_28_68# D a_172_68# VPW nfet_03v3 ad=0.26p pd=1.52u as=0.26p ps=1.52u w=1u l=0.28u
.ends

* NGSPICE file created from gf180mcu_as_sc_mcu7t3v3__oai211_2.ext - technology: gf180mcuD

.subckt gf180mcu_as_sc_mcu7t3v3__oai211_2 VDD VNW VPW VSS A B C Y D
M_M0 a_28_440# A VDD VNW pfet_03v3 ad=0.3588p pd=1.9u as=0.3588p ps=1.9u w=1.38u l=0.28u
M_M1 a_796_68# D Y VPW nfet_03v3 ad=0.44p pd=2.88u as=0.26p ps=1.52u w=1u l=0.28u
M_M2 a_172_68# A VSS VPW nfet_03v3 ad=0.26p pd=1.52u as=0.44p ps=2.88u w=1u l=0.28u
M_M3 VDD C Y VNW pfet_03v3 ad=0.3588p pd=1.9u as=0.3588p ps=1.9u w=1.38u l=0.28u
M_M4 Y D a_796_68# VPW nfet_03v3 ad=0.26p pd=1.52u as=0.26p ps=1.52u w=1u l=0.28u
M_M5 Y D VDD VNW pfet_03v3 ad=0.3588p pd=1.9u as=0.3588p ps=1.9u w=1.38u l=0.28u
M_M6 Y B a_28_440# VNW pfet_03v3 ad=0.3588p pd=1.9u as=0.3588p ps=1.9u w=1.38u l=0.28u
M_M7 a_796_68# C a_172_68# VPW nfet_03v3 ad=0.26p pd=1.52u as=0.26p ps=1.52u w=1u l=0.28u
M_M8 VSS B a_172_68# VPW nfet_03v3 ad=0.44p pd=2.88u as=0.26p ps=1.52u w=1u l=0.28u
M_M9 a_28_440# B Y VNW pfet_03v3 ad=0.6072p pd=3.64u as=0.3588p ps=1.9u w=1.38u l=0.28u
M_M10 Y C VDD VNW pfet_03v3 ad=0.3588p pd=1.9u as=0.9936p ps=4.2u w=1.38u l=0.28u
M_M11 a_172_68# B VSS VPW nfet_03v3 ad=0.26p pd=1.52u as=0.26p ps=1.52u w=1u l=0.28u
M_M12 VDD D Y VNW pfet_03v3 ad=0.6072p pd=3.64u as=0.3588p ps=1.9u w=1.38u l=0.28u
M_M13 a_172_68# C a_796_68# VPW nfet_03v3 ad=0.26p pd=1.52u as=0.72p ps=3.44u w=1u l=0.28u
M_M14 VDD A a_28_440# VNW pfet_03v3 ad=0.3588p pd=1.9u as=0.6072p ps=3.64u w=1.38u l=0.28u
M_M15 VSS A a_172_68# VPW nfet_03v3 ad=0.26p pd=1.52u as=0.26p ps=1.52u w=1u l=0.28u
.ends

* NGSPICE file created from gf180mcu_as_sc_mcu7t3v3__oai211_4.ext - technology: gf180mcuD

.subckt gf180mcu_as_sc_mcu7t3v3__oai211_4 VDD VNW VPW VSS A B C D Y
M_M0 a_28_68# B VSS VPW nfet_03v3 ad=0.26p pd=1.52u as=0.26p ps=1.52u w=1u l=0.28u
M_M1 VDD A a_172_440# VNW pfet_03v3 ad=0.3588p pd=1.9u as=0.3588p ps=1.9u w=1.38u l=0.28u
M_M2 a_172_440# B Y VNW pfet_03v3 ad=0.3588p pd=1.9u as=0.3588p ps=1.9u w=1.38u l=0.28u
M_M3 VSS A a_28_68# VPW nfet_03v3 ad=0.26p pd=1.52u as=0.44p ps=2.88u w=1u l=0.28u
M_M4 Y D VDD VNW pfet_03v3 ad=0.3588p pd=1.9u as=0.3588p ps=1.9u w=1.38u l=0.28u
M_M5 a_28_68# C a_1452_68# VPW nfet_03v3 ad=0.26p pd=1.52u as=0.26p ps=1.52u w=1u l=0.28u
M_M6 a_28_68# C a_2412_68# VPW nfet_03v3 ad=1p pd=4u as=0.26p ps=1.52u w=1u l=0.28u
M_M7 VDD A a_172_440# VNW pfet_03v3 ad=0.3588p pd=1.9u as=0.3588p ps=1.9u w=1.38u l=0.28u
M_M8 Y C VDD VNW pfet_03v3 ad=0.3588p pd=1.9u as=0.3588p ps=1.9u w=1.38u l=0.28u
M_M9 VSS B a_28_68# VPW nfet_03v3 ad=0.26p pd=1.52u as=0.26p ps=1.52u w=1u l=0.28u
M_M10 Y C VDD VNW pfet_03v3 ad=0.3588p pd=1.9u as=0.3588p ps=1.9u w=1.38u l=0.28u
M_M11 VDD D Y VNW pfet_03v3 ad=0.3588p pd=1.9u as=0.3588p ps=1.9u w=1.38u l=0.28u
M_M12 a_1452_68# C a_28_68# VPW nfet_03v3 ad=0.26p pd=1.52u as=0.26p ps=1.52u w=1u l=0.28u
M_M13 a_2412_68# D Y VPW nfet_03v3 ad=0.26p pd=1.52u as=0.26p ps=1.52u w=1u l=0.28u
M_M14 a_172_440# A VDD VNW pfet_03v3 ad=0.3588p pd=1.9u as=0.3588p ps=1.9u w=1.38u l=0.28u
M_M15 Y B a_172_440# VNW pfet_03v3 ad=0.3588p pd=1.9u as=0.3588p ps=1.9u w=1.38u l=0.28u
M_M16 a_28_68# B VSS VPW nfet_03v3 ad=0.26p pd=1.52u as=0.26p ps=1.52u w=1u l=0.28u
M_M17 Y D VDD VNW pfet_03v3 ad=0.3588p pd=1.9u as=0.3588p ps=1.9u w=1.38u l=0.28u
M_M18 VDD C Y VNW pfet_03v3 ad=1.38p pd=4.76u as=0.3588p ps=1.9u w=1.38u l=0.28u
M_M19 a_28_68# A VSS VPW nfet_03v3 ad=0.26p pd=1.52u as=0.26p ps=1.52u w=1u l=0.28u
M_M20 Y D a_1452_68# VPW nfet_03v3 ad=0.26p pd=1.52u as=0.26p ps=1.52u w=1u l=0.28u
M_M21 Y B a_172_440# VNW pfet_03v3 ad=0.3588p pd=1.9u as=0.3588p ps=1.9u w=1.38u l=0.28u
M_M22 VDD D Y VNW pfet_03v3 ad=0.3588p pd=1.9u as=0.3588p ps=1.9u w=1.38u l=0.28u
M_M23 VSS A a_28_68# VPW nfet_03v3 ad=0.26p pd=1.52u as=0.26p ps=1.52u w=1u l=0.28u
M_M24 Y D a_1772_68# VPW nfet_03v3 ad=0.26p pd=1.52u as=0.26p ps=1.52u w=1u l=0.28u
M_M25 a_172_440# B Y VNW pfet_03v3 ad=0.3588p pd=1.9u as=0.3588p ps=1.9u w=1.38u l=0.28u
M_M26 VDD C Y VNW pfet_03v3 ad=0.3588p pd=1.9u as=0.3588p ps=1.9u w=1.38u l=0.28u
M_M27 VSS B a_28_68# VPW nfet_03v3 ad=0.26p pd=1.52u as=0.26p ps=1.52u w=1u l=0.28u
M_M28 a_1452_68# D Y VPW nfet_03v3 ad=0.26p pd=1.52u as=0.26p ps=1.52u w=1u l=0.28u
M_M29 a_172_440# A VDD VNW pfet_03v3 ad=0.3588p pd=1.9u as=0.6072p ps=3.64u w=1.38u l=0.28u
M_M30 a_28_68# A VSS VPW nfet_03v3 ad=0.26p pd=1.52u as=0.26p ps=1.52u w=1u l=0.28u
M_M31 a_1772_68# C a_28_68# VPW nfet_03v3 ad=0.26p pd=1.52u as=0.26p ps=1.52u w=1u l=0.28u
.ends

* NGSPICE file created from gf180mcu_as_sc_mcu7t3v3__oai21_2.ext - technology: gf180mcuD

.subckt gf180mcu_as_sc_mcu7t3v3__oai21_2 VDD VNW VPW VSS A B C Y
M_M0 a_28_68# C Y VPW nfet_03v3 ad=0.6p pd=3.2u as=0.26p ps=1.52u w=1u l=0.28u
M_M1 Y B a_172_440# VNW pfet_03v3 ad=0.3588p pd=1.9u as=0.3588p ps=1.9u w=1.38u l=0.28u
M_M2 Y C VDD VNW pfet_03v3 ad=0.3588p pd=1.9u as=0.3588p ps=1.9u w=1.38u l=0.28u
M_M3 VSS A a_28_68# VPW nfet_03v3 ad=0.26p pd=1.52u as=0.44p ps=2.88u w=1u l=0.28u
M_M4 Y C a_28_68# VPW nfet_03v3 ad=0.26p pd=1.52u as=0.26p ps=1.52u w=1u l=0.28u
M_M5 a_172_440# B Y VNW pfet_03v3 ad=0.3588p pd=1.9u as=0.3588p ps=1.9u w=1.38u l=0.28u
M_M6 VDD C Y VNW pfet_03v3 ad=0.828p pd=3.96u as=0.3588p ps=1.9u w=1.38u l=0.28u
M_M7 a_28_68# A VSS VPW nfet_03v3 ad=0.26p pd=1.52u as=0.26p ps=1.52u w=1u l=0.28u
M_M8 VDD A a_172_440# VNW pfet_03v3 ad=0.3588p pd=1.9u as=0.3588p ps=1.9u w=1.38u l=0.28u
M_M9 VSS B a_28_68# VPW nfet_03v3 ad=0.26p pd=1.52u as=0.26p ps=1.52u w=1u l=0.28u
M_M10 a_172_440# A VDD VNW pfet_03v3 ad=0.3588p pd=1.9u as=0.6072p ps=3.64u w=1.38u l=0.28u
M_M11 a_28_68# B VSS VPW nfet_03v3 ad=0.26p pd=1.52u as=0.26p ps=1.52u w=1u l=0.28u
.ends

* NGSPICE file created from gf180mcu_as_sc_mcu7t3v3__oai21_4.ext - technology: gf180mcuD

.subckt gf180mcu_as_sc_mcu7t3v3__oai21_4 VDD VNW VPW VSS A B C Y
M_M0 a_28_68# B VSS VPW nfet_03v3 ad=0.26p pd=1.52u as=0.26p ps=1.52u w=1u l=0.28u
M_M1 VDD A a_172_440# VNW pfet_03v3 ad=0.3588p pd=1.9u as=0.3588p ps=1.9u w=1.38u l=0.28u
M_M2 a_172_440# B Y VNW pfet_03v3 ad=0.3588p pd=1.9u as=0.3588p ps=1.9u w=1.38u l=0.28u
M_M3 VSS A a_28_68# VPW nfet_03v3 ad=0.26p pd=1.52u as=0.44p ps=2.88u w=1u l=0.28u
M_M4 a_28_68# C Y VPW nfet_03v3 ad=0.26p pd=1.52u as=0.26p ps=1.52u w=1u l=0.28u
M_M5 VDD A a_172_440# VNW pfet_03v3 ad=0.3588p pd=1.9u as=0.3588p ps=1.9u w=1.38u l=0.28u
M_M6 Y C VDD VNW pfet_03v3 ad=0.3588p pd=1.9u as=0.3588p ps=1.9u w=1.38u l=0.28u
M_M7 VSS B a_28_68# VPW nfet_03v3 ad=0.26p pd=1.52u as=0.26p ps=1.52u w=1u l=0.28u
M_M8 Y C VDD VNW pfet_03v3 ad=0.3588p pd=1.9u as=0.3588p ps=1.9u w=1.38u l=0.28u
M_M9 VDD C Y VNW pfet_03v3 ad=1.1592p pd=4.44u as=0.3588p ps=1.9u w=1.38u l=0.28u
M_M10 Y C a_28_68# VPW nfet_03v3 ad=0.26p pd=1.52u as=0.26p ps=1.52u w=1u l=0.28u
M_M11 a_172_440# A VDD VNW pfet_03v3 ad=0.3588p pd=1.9u as=0.3588p ps=1.9u w=1.38u l=0.28u
M_M12 Y B a_172_440# VNW pfet_03v3 ad=0.3588p pd=1.9u as=0.3588p ps=1.9u w=1.38u l=0.28u
M_M13 a_28_68# B VSS VPW nfet_03v3 ad=0.26p pd=1.52u as=0.26p ps=1.52u w=1u l=0.28u
M_M14 a_28_68# A VSS VPW nfet_03v3 ad=0.26p pd=1.52u as=0.26p ps=1.52u w=1u l=0.28u
M_M15 Y B a_172_440# VNW pfet_03v3 ad=0.3588p pd=1.9u as=0.3588p ps=1.9u w=1.38u l=0.28u
M_M16 VSS A a_28_68# VPW nfet_03v3 ad=0.26p pd=1.52u as=0.26p ps=1.52u w=1u l=0.28u
M_M17 a_28_68# C Y VPW nfet_03v3 ad=0.84p pd=3.68u as=0.26p ps=1.52u w=1u l=0.28u
M_M18 a_172_440# B Y VNW pfet_03v3 ad=0.3588p pd=1.9u as=0.3588p ps=1.9u w=1.38u l=0.28u
M_M19 VDD C Y VNW pfet_03v3 ad=0.3588p pd=1.9u as=0.3588p ps=1.9u w=1.38u l=0.28u
M_M20 VSS B a_28_68# VPW nfet_03v3 ad=0.26p pd=1.52u as=0.26p ps=1.52u w=1u l=0.28u
M_M21 a_172_440# A VDD VNW pfet_03v3 ad=0.3588p pd=1.9u as=0.6072p ps=3.64u w=1.38u l=0.28u
M_M22 a_28_68# A VSS VPW nfet_03v3 ad=0.26p pd=1.52u as=0.26p ps=1.52u w=1u l=0.28u
M_M23 Y C a_28_68# VPW nfet_03v3 ad=0.26p pd=1.52u as=0.26p ps=1.52u w=1u l=0.28u
.ends

* NGSPICE file created from gf180mcu_as_sc_mcu7t3v3__oai22_2.ext - technology: gf180mcuD

.subckt gf180mcu_as_sc_mcu7t3v3__oai22_2 VDD VNW VPW VSS A B C D Y
M_M0 a_28_440# A VDD VNW pfet_03v3 ad=0.3588p pd=1.9u as=0.3588p ps=1.9u w=1.38u l=0.28u
M_M1 VSS D a_28_68# VPW nfet_03v3 ad=0.26p pd=1.52u as=0.26p ps=1.52u w=1u l=0.28u
M_M2 Y A a_28_68# VPW nfet_03v3 ad=0.26p pd=1.52u as=0.44p ps=2.88u w=1u l=0.28u
M_M3 a_796_440# C Y VNW pfet_03v3 ad=0.3588p pd=1.9u as=0.3588p ps=1.9u w=1.38u l=0.28u
M_M4 a_28_68# C VSS VPW nfet_03v3 ad=0.26p pd=1.52u as=0.26p ps=1.52u w=1u l=0.28u
M_M5 Y B a_28_440# VNW pfet_03v3 ad=0.3588p pd=1.9u as=0.3588p ps=1.9u w=1.38u l=0.28u
M_M6 a_28_68# B Y VPW nfet_03v3 ad=0.58p pd=2.16u as=0.26p ps=1.52u w=1u l=0.28u
M_M7 VDD D a_796_440# VNW pfet_03v3 ad=0.3588p pd=1.9u as=0.3588p ps=1.9u w=1.38u l=0.28u
M_M8 a_28_440# B Y VNW pfet_03v3 ad=0.6072p pd=3.64u as=0.3588p ps=1.9u w=1.38u l=0.28u
M_M9 Y C a_796_440# VNW pfet_03v3 ad=0.3588p pd=1.9u as=0.6072p ps=3.64u w=1.38u l=0.28u
M_M10 VSS C a_28_68# VPW nfet_03v3 ad=0.26p pd=1.52u as=0.58p ps=2.16u w=1u l=0.28u
M_M11 Y B a_28_68# VPW nfet_03v3 ad=0.26p pd=1.52u as=0.26p ps=1.52u w=1u l=0.28u
M_M12 a_796_440# D VDD VNW pfet_03v3 ad=0.6072p pd=3.64u as=0.3588p ps=1.9u w=1.38u l=0.28u
M_M13 VDD A a_28_440# VNW pfet_03v3 ad=0.3588p pd=1.9u as=0.6072p ps=3.64u w=1.38u l=0.28u
M_M14 a_28_68# D VSS VPW nfet_03v3 ad=0.44p pd=2.88u as=0.26p ps=1.52u w=1u l=0.28u
M_M15 a_28_68# A Y VPW nfet_03v3 ad=0.26p pd=1.52u as=0.26p ps=1.52u w=1u l=0.28u
.ends

* NGSPICE file created from gf180mcu_as_sc_mcu7t3v3__oai22_4.ext - technology: gf180mcuD

.subckt gf180mcu_as_sc_mcu7t3v3__oai22_4 VDD VNW VPW VSS A B C D Y
M_M0 a_28_68# C VSS VPW nfet_03v3 ad=0.26p pd=1.52u as=0.26p ps=1.52u w=1u l=0.28u
M_M1 VDD D a_172_440# VNW pfet_03v3 ad=0.3588p pd=1.9u as=0.3588p ps=1.9u w=1.38u l=0.28u
M_M2 a_172_440# C Y VNW pfet_03v3 ad=0.3588p pd=1.9u as=0.3588p ps=1.9u w=1.38u l=0.28u
M_M3 VSS D a_28_68# VPW nfet_03v3 ad=0.26p pd=1.52u as=0.44p ps=2.88u w=1u l=0.28u
M_M4 a_1452_440# B Y VNW pfet_03v3 ad=0.3588p pd=1.9u as=0.3588p ps=1.9u w=1.38u l=0.28u
M_M5 a_28_68# A Y VPW nfet_03v3 ad=0.26p pd=1.52u as=0.26p ps=1.52u w=1u l=0.28u
M_M6 a_28_68# A Y VPW nfet_03v3 ad=0.44p pd=2.88u as=0.26p ps=1.52u w=1u l=0.28u
M_M7 VDD D a_172_440# VNW pfet_03v3 ad=0.3588p pd=1.9u as=0.3588p ps=1.9u w=1.38u l=0.28u
M_M8 a_1452_440# A VDD VNW pfet_03v3 ad=0.3588p pd=1.9u as=0.3588p ps=1.9u w=1.38u l=0.28u
M_M9 VSS C a_28_68# VPW nfet_03v3 ad=0.26p pd=1.52u as=0.26p ps=1.52u w=1u l=0.28u
M_M10 a_1452_440# A VDD VNW pfet_03v3 ad=0.3588p pd=1.9u as=0.3588p ps=1.9u w=1.38u l=0.28u
M_M11 Y B a_1452_440# VNW pfet_03v3 ad=0.3588p pd=1.9u as=0.3588p ps=1.9u w=1.38u l=0.28u
M_M12 Y A a_28_68# VPW nfet_03v3 ad=0.26p pd=1.52u as=0.26p ps=1.52u w=1u l=0.28u
M_M13 Y B a_28_68# VPW nfet_03v3 ad=0.26p pd=1.52u as=0.26p ps=1.52u w=1u l=0.28u
M_M14 a_172_440# D VDD VNW pfet_03v3 ad=0.3588p pd=1.9u as=0.3588p ps=1.9u w=1.38u l=0.28u
M_M15 Y C a_172_440# VNW pfet_03v3 ad=0.3588p pd=1.9u as=0.3588p ps=1.9u w=1.38u l=0.28u
M_M16 a_28_68# C VSS VPW nfet_03v3 ad=0.26p pd=1.52u as=0.26p ps=1.52u w=1u l=0.28u
M_M17 a_1452_440# B Y VNW pfet_03v3 ad=0.3588p pd=1.9u as=0.3588p ps=1.9u w=1.38u l=0.28u
M_M18 VDD A a_1452_440# VNW pfet_03v3 ad=0.6072p pd=3.64u as=0.3588p ps=1.9u w=1.38u l=0.28u
M_M19 a_28_68# D VSS VPW nfet_03v3 ad=0.26p pd=1.52u as=0.26p ps=1.52u w=1u l=0.28u
M_M20 a_28_68# B Y VPW nfet_03v3 ad=0.26p pd=1.52u as=0.26p ps=1.52u w=1u l=0.28u
M_M21 Y C a_172_440# VNW pfet_03v3 ad=0.3588p pd=1.9u as=0.3588p ps=1.9u w=1.38u l=0.28u
M_M22 Y B a_1452_440# VNW pfet_03v3 ad=0.3588p pd=1.9u as=0.3588p ps=1.9u w=1.38u l=0.28u
M_M23 VSS D a_28_68# VPW nfet_03v3 ad=0.26p pd=1.52u as=0.26p ps=1.52u w=1u l=0.28u
M_M24 a_28_68# B Y VPW nfet_03v3 ad=0.26p pd=1.52u as=0.26p ps=1.52u w=1u l=0.28u
M_M25 a_172_440# C Y VNW pfet_03v3 ad=0.3588p pd=1.9u as=0.3588p ps=1.9u w=1.38u l=0.28u
M_M26 VDD A a_1452_440# VNW pfet_03v3 ad=0.3588p pd=1.9u as=0.3588p ps=1.9u w=1.38u l=0.28u
M_M27 VSS C a_28_68# VPW nfet_03v3 ad=0.26p pd=1.52u as=0.26p ps=1.52u w=1u l=0.28u
M_M28 Y B a_28_68# VPW nfet_03v3 ad=0.26p pd=1.52u as=0.26p ps=1.52u w=1u l=0.28u
M_M29 a_172_440# D VDD VNW pfet_03v3 ad=0.3588p pd=1.9u as=0.6072p ps=3.64u w=1.38u l=0.28u
M_M30 a_28_68# D VSS VPW nfet_03v3 ad=0.26p pd=1.52u as=0.26p ps=1.52u w=1u l=0.28u
M_M31 Y A a_28_68# VPW nfet_03v3 ad=0.26p pd=1.52u as=0.26p ps=1.52u w=1u l=0.28u
.ends

* NGSPICE file created from gf180mcu_as_sc_mcu7t3v3__or2_2.ext - technology: gf180mcuD

.subckt gf180mcu_as_sc_mcu7t3v3__or2_2 VDD VNW VPW VSS B A Y
M_M0 VDD B a_172_440# VNW pfet_03v3 ad=0.3588p pd=1.9u as=0.3588p ps=1.9u w=1.38u l=0.28u
M_M1 a_28_440# A VSS VPW nfet_03v3 ad=0.26p pd=1.52u as=0.44p ps=2.88u w=1u l=0.28u
M_M2 Y a_28_440# VDD VNW pfet_03v3 ad=0.3588p pd=1.9u as=0.3588p ps=1.9u w=1.38u l=0.28u
M_M3 VSS a_28_440# Y VPW nfet_03v3 ad=0.52p pd=3.04u as=0.26p ps=1.52u w=1u l=0.28u
M_M4 VDD a_28_440# Y VNW pfet_03v3 ad=0.7176p pd=3.8u as=0.3588p ps=1.9u w=1.38u l=0.28u
M_M5 Y a_28_440# VSS VPW nfet_03v3 ad=0.26p pd=1.52u as=0.26p ps=1.52u w=1u l=0.28u
M_M6 a_172_440# A a_28_440# VNW pfet_03v3 ad=0.3588p pd=1.9u as=0.6072p ps=3.64u w=1.38u l=0.28u
M_M7 VSS B a_28_440# VPW nfet_03v3 ad=0.26p pd=1.52u as=0.26p ps=1.52u w=1u l=0.28u
.ends

* NGSPICE file created from gf180mcu_as_sc_mcu7t3v3__or2_4.ext - technology: gf180mcuD

.subckt gf180mcu_as_sc_mcu7t3v3__or2_4 VDD VNW VPW VSS B A Y
M_M0 VSS a_28_440# Y VPW nfet_03v3 ad=0.6p pd=3.2u as=0.26p ps=1.52u w=1u l=0.28u
M_M1 VDD B a_172_440# VNW pfet_03v3 ad=0.3588p pd=1.9u as=0.3588p ps=1.9u w=1.38u l=0.28u
M_M2 Y a_28_440# VDD VNW pfet_03v3 ad=0.3588p pd=1.9u as=0.3588p ps=1.9u w=1.38u l=0.28u
M_M3 a_28_440# A VSS VPW nfet_03v3 ad=0.26p pd=1.52u as=0.44p ps=2.88u w=1u l=0.28u
M_M4 Y a_28_440# VSS VPW nfet_03v3 ad=0.26p pd=1.52u as=0.26p ps=1.52u w=1u l=0.28u
M_M5 Y a_28_440# VDD VNW pfet_03v3 ad=0.3588p pd=1.9u as=0.3588p ps=1.9u w=1.38u l=0.28u
M_M6 VDD a_28_440# Y VNW pfet_03v3 ad=0.828p pd=3.96u as=0.3588p ps=1.9u w=1.38u l=0.28u
M_M7 VSS a_28_440# Y VPW nfet_03v3 ad=0.26p pd=1.52u as=0.26p ps=1.52u w=1u l=0.28u
M_M8 VDD a_28_440# Y VNW pfet_03v3 ad=0.3588p pd=1.9u as=0.3588p ps=1.9u w=1.38u l=0.28u
M_M9 Y a_28_440# VSS VPW nfet_03v3 ad=0.26p pd=1.52u as=0.26p ps=1.52u w=1u l=0.28u
M_M10 a_172_440# A a_28_440# VNW pfet_03v3 ad=0.3588p pd=1.9u as=0.6072p ps=3.64u w=1.38u l=0.28u
M_M11 VSS B a_28_440# VPW nfet_03v3 ad=0.26p pd=1.52u as=0.26p ps=1.52u w=1u l=0.28u
.ends

* NGSPICE file created from gf180mcu_as_sc_mcu7t3v3__or3_2.ext - technology: gf180mcuD

.subckt gf180mcu_as_sc_mcu7t3v3__or3_2 VDD VNW VPW VSS Y B A C
M_M0 a_332_440# B a_172_440# VNW pfet_03v3 ad=0.3588p pd=1.9u as=0.3588p ps=1.9u w=1.38u l=0.28u
M_M1 VDD a_28_68# Y VNW pfet_03v3 ad=1.1592p pd=4.44u as=0.3588p ps=1.9u w=1.38u l=0.28u
M_M2 VSS A a_28_68# VPW nfet_03v3 ad=0.26p pd=1.52u as=0.44p ps=2.88u w=1u l=0.28u
M_M3 VSS a_28_68# Y VPW nfet_03v3 ad=0.84p pd=3.68u as=0.26p ps=1.52u w=1u l=0.28u
M_M4 VDD C a_332_440# VNW pfet_03v3 ad=0.3588p pd=1.9u as=0.3588p ps=1.9u w=1.38u l=0.28u
M_M5 Y a_28_68# VSS VPW nfet_03v3 ad=0.26p pd=1.52u as=0.26p ps=1.52u w=1u l=0.28u
M_M6 Y a_28_68# VDD VNW pfet_03v3 ad=0.3588p pd=1.9u as=0.3588p ps=1.9u w=1.38u l=0.28u
M_M7 VSS C a_28_68# VPW nfet_03v3 ad=0.26p pd=1.52u as=0.26p ps=1.52u w=1u l=0.28u
M_M8 a_172_440# A a_28_68# VNW pfet_03v3 ad=0.3588p pd=1.9u as=0.6072p ps=3.64u w=1.38u l=0.28u
M_M9 a_28_68# B VSS VPW nfet_03v3 ad=0.26p pd=1.52u as=0.26p ps=1.52u w=1u l=0.28u
.ends

* NGSPICE file created from gf180mcu_as_sc_mcu7t3v3__or3_4.ext - technology: gf180mcuD

.subckt gf180mcu_as_sc_mcu7t3v3__or3_4 VDD VNW VPW VSS Y B A C
M_M0 Y a_28_68# VSS VPW nfet_03v3 ad=0.26p pd=1.52u as=0.26p ps=1.52u w=1u l=0.28u
M_M1 a_332_440# B a_172_440# VNW pfet_03v3 ad=0.3588p pd=1.9u as=0.3588p ps=1.9u w=1.38u l=0.28u
M_M2 VDD a_28_68# Y VNW pfet_03v3 ad=0.3588p pd=1.9u as=0.3588p ps=1.9u w=1.38u l=0.28u
M_M3 VSS A a_28_68# VPW nfet_03v3 ad=0.26p pd=1.52u as=0.44p ps=2.88u w=1u l=0.28u
M_M4 VSS a_28_68# Y VPW nfet_03v3 ad=0.26p pd=1.52u as=0.26p ps=1.52u w=1u l=0.28u
M_M5 VDD C a_332_440# VNW pfet_03v3 ad=0.3588p pd=1.9u as=0.3588p ps=1.9u w=1.38u l=0.28u
M_M6 Y a_28_68# VDD VNW pfet_03v3 ad=0.3588p pd=1.9u as=0.3588p ps=1.9u w=1.38u l=0.28u
M_M7 Y a_28_68# VSS VPW nfet_03v3 ad=0.26p pd=1.52u as=0.26p ps=1.52u w=1u l=0.28u
M_M8 Y a_28_68# VDD VNW pfet_03v3 ad=0.3588p pd=1.9u as=0.3588p ps=1.9u w=1.38u l=0.28u
M_M9 VSS C a_28_68# VPW nfet_03v3 ad=0.26p pd=1.52u as=0.26p ps=1.52u w=1u l=0.28u
M_M10 VDD a_28_68# Y VNW pfet_03v3 ad=0.6072p pd=3.64u as=0.3588p ps=1.9u w=1.38u l=0.28u
M_M11 VSS a_28_68# Y VPW nfet_03v3 ad=0.44p pd=2.88u as=0.26p ps=1.52u w=1u l=0.28u
M_M12 a_172_440# A a_28_68# VNW pfet_03v3 ad=0.3588p pd=1.9u as=0.6072p ps=3.64u w=1.38u l=0.28u
M_M13 a_28_68# B VSS VPW nfet_03v3 ad=0.26p pd=1.52u as=0.26p ps=1.52u w=1u l=0.28u
.ends

* NGSPICE file created from gf180mcu_as_sc_mcu7t3v3__or4_2.ext - technology: gf180mcuD

.subckt gf180mcu_as_sc_mcu7t3v3__or4_2 VDD VNW VPW VSS A B C D Y
M_M0 VSS a_28_440# Y VPW nfet_03v3 ad=0.6p pd=3.2u as=0.26p ps=1.52u w=1u l=0.28u
M_M1 a_332_440# B a_172_440# VNW pfet_03v3 ad=0.3588p pd=1.9u as=0.3588p ps=1.9u w=1.38u l=0.28u
M_M2 Y a_28_440# VDD VNW pfet_03v3 ad=0.3588p pd=1.9u as=0.3588p ps=1.9u w=1.38u l=0.28u
M_M3 a_28_440# A VSS VPW nfet_03v3 ad=0.26p pd=1.52u as=0.44p ps=2.88u w=1u l=0.28u
M_M4 Y a_28_440# VSS VPW nfet_03v3 ad=0.26p pd=1.52u as=0.26p ps=1.52u w=1u l=0.28u
M_M5 a_492_440# C a_332_440# VNW pfet_03v3 ad=0.3588p pd=1.9u as=0.3588p ps=1.9u w=1.38u l=0.28u
M_M6 VDD a_28_440# Y VNW pfet_03v3 ad=0.828p pd=3.96u as=0.3588p ps=1.9u w=1.38u l=0.28u
M_M7 VSS D a_28_440# VPW nfet_03v3 ad=0.26p pd=1.52u as=0.26p ps=1.52u w=1u l=0.28u
M_M8 VDD D a_492_440# VNW pfet_03v3 ad=0.3588p pd=1.9u as=0.3588p ps=1.9u w=1.38u l=0.28u
M_M9 a_28_440# C VSS VPW nfet_03v3 ad=0.26p pd=1.52u as=0.26p ps=1.52u w=1u l=0.28u
M_M10 a_172_440# A a_28_440# VNW pfet_03v3 ad=0.3588p pd=1.9u as=0.6072p ps=3.64u w=1.38u l=0.28u
M_M11 VSS B a_28_440# VPW nfet_03v3 ad=0.26p pd=1.52u as=0.26p ps=1.52u w=1u l=0.28u
.ends

* NGSPICE file created from gf180mcu_as_sc_mcu7t3v3__or4_4.ext - technology: gf180mcuD

.subckt gf180mcu_as_sc_mcu7t3v3__or4_4 VDD VNW VPW VSS A B C D Y
M_M0 VSS a_28_440# Y VPW nfet_03v3 ad=0.26p pd=1.52u as=0.26p ps=1.52u w=1u l=0.28u
M_M1 a_332_440# B a_172_440# VNW pfet_03v3 ad=0.3588p pd=1.9u as=0.3588p ps=1.9u w=1.38u l=0.28u
M_M2 Y a_28_440# VDD VNW pfet_03v3 ad=0.3588p pd=1.9u as=0.3588p ps=1.9u w=1.38u l=0.28u
M_M3 a_28_440# A VSS VPW nfet_03v3 ad=0.26p pd=1.52u as=0.44p ps=2.88u w=1u l=0.28u
M_M4 VDD a_28_440# Y VNW pfet_03v3 ad=0.9384p pd=4.12u as=0.3588p ps=1.9u w=1.38u l=0.28u
M_M5 Y a_28_440# VSS VPW nfet_03v3 ad=0.26p pd=1.52u as=0.26p ps=1.52u w=1u l=0.28u
M_M6 a_492_440# C a_332_440# VNW pfet_03v3 ad=0.3588p pd=1.9u as=0.3588p ps=1.9u w=1.38u l=0.28u
M_M7 VDD a_28_440# Y VNW pfet_03v3 ad=0.3588p pd=1.9u as=0.3588p ps=1.9u w=1.38u l=0.28u
M_M8 VSS D a_28_440# VPW nfet_03v3 ad=0.26p pd=1.52u as=0.26p ps=1.52u w=1u l=0.28u
M_M9 VSS a_28_440# Y VPW nfet_03v3 ad=0.68p pd=3.36u as=0.26p ps=1.52u w=1u l=0.28u
M_M10 VDD D a_492_440# VNW pfet_03v3 ad=0.3588p pd=1.9u as=0.3588p ps=1.9u w=1.38u l=0.28u
M_M11 a_28_440# C VSS VPW nfet_03v3 ad=0.26p pd=1.52u as=0.26p ps=1.52u w=1u l=0.28u
M_M12 Y a_28_440# VDD VNW pfet_03v3 ad=0.3588p pd=1.9u as=0.3588p ps=1.9u w=1.38u l=0.28u
M_M13 Y a_28_440# VSS VPW nfet_03v3 ad=0.26p pd=1.52u as=0.26p ps=1.52u w=1u l=0.28u
M_M14 a_172_440# A a_28_440# VNW pfet_03v3 ad=0.3588p pd=1.9u as=0.6072p ps=3.64u w=1.38u l=0.28u
M_M15 VSS B a_28_440# VPW nfet_03v3 ad=0.26p pd=1.52u as=0.26p ps=1.52u w=1u l=0.28u
.ends

* NGSPICE file created from gf180mcu_as_sc_mcu7t3v3__tap_2.ext - technology: gf180mcuD

.subckt gf180mcu_as_sc_mcu7t3v3__tap_2 VDD VSS
.ends

* NGSPICE file created from gf180mcu_as_sc_mcu7t3v3__tieh_4.ext - technology: gf180mcuD

.subckt gf180mcu_as_sc_mcu7t3v3__tieh_4 VDD VNW VPW VSS ONE
M_M0 a_112_319# a_112_319# VSS VPW nfet_03v3 ad=0.44p pd=2.88u as=0.44p ps=2.88u w=1u l=0.28u
M_M1 ONE a_112_319# VDD VNW pfet_03v3 ad=0.6072p pd=3.64u as=0.6072p ps=3.64u w=1.38u l=0.28u
.ends

* NGSPICE file created from gf180mcu_as_sc_mcu7t3v3__tiel_4.ext - technology: gf180mcuD

.subckt gf180mcu_as_sc_mcu7t3v3__tiel_4 VDD VNW VPW VSS ZERO
M_M0 ZERO a_112_319# VSS VPW nfet_03v3 ad=0.44p pd=2.88u as=0.44p ps=2.88u w=1u l=0.28u
M_M1 a_112_319# a_112_319# VDD VNW pfet_03v3 ad=0.6072p pd=3.64u as=0.6072p ps=3.64u w=1.38u l=0.28u
.ends

* NGSPICE file created from gf180mcu_as_sc_mcu7t3v3__xnor2_2.ext - technology: gf180mcuD

.subckt gf180mcu_as_sc_mcu7t3v3__xnor2_2 VDD VNW VPW VSS B A Y
M_M0 VSS a_556_68# Y VPW nfet_03v3 ad=0.85p pd=3.7u as=0.285p ps=1.57u w=1u l=0.28u
M_M1 VDD a_556_68# Y VNW pfet_03v3 ad=1.173p pd=4.46u as=0.3933p ps=1.95u w=1.38u l=0.28u
M_M2 Y a_556_68# VSS VPW nfet_03v3 ad=0.285p pd=1.57u as=0.26p ps=1.52u w=1u l=0.28u
M_M3 a_332_440# A VDD VNW pfet_03v3 ad=0.5796p pd=2.22u as=0.3588p ps=1.9u w=1.38u l=0.28u
M_M4 VSS A a_28_68# VPW nfet_03v3 ad=0.54p pd=2.08u as=0.44p ps=2.88u w=1u l=0.28u
M_M5 a_556_68# a_500_24# a_444_68# VPW nfet_03v3 ad=0.62p pd=2.24u as=0.14p ps=1.28u w=1u l=0.28u
M_M6 a_500_24# A a_556_68# VPW nfet_03v3 ad=0.31p pd=1.62u as=0.62p ps=2.24u w=1u l=0.28u
M_M7 a_500_24# a_28_68# a_556_68# VNW pfet_03v3 ad=0.7866p pd=2.52u as=0.4968p ps=2.1u w=1.38u l=0.28u
M_M8 VDD B a_500_24# VNW pfet_03v3 ad=0.3588p pd=1.9u as=0.7866p ps=2.52u w=1.38u l=0.28u
M_M9 VSS B a_500_24# VPW nfet_03v3 ad=0.26p pd=1.52u as=0.31p ps=1.62u w=1u l=0.28u
M_M10 a_444_68# a_28_68# VSS VPW nfet_03v3 ad=0.14p pd=1.28u as=0.54p ps=2.08u w=1u l=0.28u
M_M11 Y a_556_68# VDD VNW pfet_03v3 ad=0.3933p pd=1.95u as=0.3588p ps=1.9u w=1.38u l=0.28u
M_M12 VDD A a_28_68# VNW pfet_03v3 ad=0.3588p pd=1.9u as=0.6072p ps=3.64u w=1.38u l=0.28u
M_M13 a_556_68# a_500_24# a_332_440# VNW pfet_03v3 ad=0.4968p pd=2.1u as=0.5796p ps=2.22u w=1.38u l=0.28u
.ends

* NGSPICE file created from gf180mcu_as_sc_mcu7t3v3__xnor2_4.ext - technology: gf180mcuD

.subckt gf180mcu_as_sc_mcu7t3v3__xnor2_4 VDD VNW VPW VSS B A Y
M_M0 VSS a_556_68# Y VPW nfet_03v3 ad=0.26p pd=1.52u as=0.285p ps=1.57u w=1u l=0.28u
M_M1 VDD a_556_68# Y VNW pfet_03v3 ad=0.3588p pd=1.9u as=0.3933p ps=1.95u w=1.38u l=0.28u
M_M2 Y a_556_68# VSS VPW nfet_03v3 ad=0.285p pd=1.57u as=0.26p ps=1.52u w=1u l=0.28u
M_M3 a_332_440# A VDD VNW pfet_03v3 ad=0.5796p pd=2.22u as=0.3588p ps=1.9u w=1.38u l=0.28u
M_M4 VSS A a_28_68# VPW nfet_03v3 ad=0.54p pd=2.08u as=0.44p ps=2.88u w=1u l=0.28u
M_M5 a_556_68# a_500_24# a_444_68# VPW nfet_03v3 ad=0.62p pd=2.24u as=0.14p ps=1.28u w=1u l=0.28u
M_M6 Y a_556_68# VDD VNW pfet_03v3 ad=0.3588p pd=1.9u as=0.3588p ps=1.9u w=1.38u l=0.28u
M_M7 a_500_24# A a_556_68# VPW nfet_03v3 ad=0.31p pd=1.62u as=0.62p ps=2.24u w=1u l=0.28u
M_M8 a_500_24# a_28_68# a_556_68# VNW pfet_03v3 ad=0.7866p pd=2.52u as=0.4968p ps=2.1u w=1.38u l=0.28u
M_M9 VDD B a_500_24# VNW pfet_03v3 ad=0.3588p pd=1.9u as=0.7866p ps=2.52u w=1.38u l=0.28u
M_M10 VSS B a_500_24# VPW nfet_03v3 ad=0.26p pd=1.52u as=0.31p ps=1.62u w=1u l=0.28u
M_M11 VSS a_556_68# Y VPW nfet_03v3 ad=0.56p pd=3.12u as=0.26p ps=1.52u w=1u l=0.28u
M_M12 VDD a_556_68# Y VNW pfet_03v3 ad=0.7314p pd=3.82u as=0.3588p ps=1.9u w=1.38u l=0.28u
M_M13 a_444_68# a_28_68# VSS VPW nfet_03v3 ad=0.14p pd=1.28u as=0.54p ps=2.08u w=1u l=0.28u
M_M14 Y a_556_68# VSS VPW nfet_03v3 ad=0.26p pd=1.52u as=0.26p ps=1.52u w=1u l=0.28u
M_M15 Y a_556_68# VDD VNW pfet_03v3 ad=0.3933p pd=1.95u as=0.3588p ps=1.9u w=1.38u l=0.28u
M_M16 VDD A a_28_68# VNW pfet_03v3 ad=0.3588p pd=1.9u as=0.6072p ps=3.64u w=1.38u l=0.28u
M_M17 a_556_68# a_500_24# a_332_440# VNW pfet_03v3 ad=0.4968p pd=2.1u as=0.5796p ps=2.22u w=1.38u l=0.28u
.ends

* NGSPICE file created from gf180mcu_as_sc_mcu7t3v3__xor2_2.ext - technology: gf180mcuD

.subckt gf180mcu_as_sc_mcu7t3v3__xor2_2 VDD VNW VPW VSS B A Y
M_M0 VSS a_556_68# Y VPW nfet_03v3 ad=0.85p pd=3.7u as=0.285p ps=1.57u w=1u l=0.28u
M_M1 VDD a_556_68# Y VNW pfet_03v3 ad=1.173p pd=4.46u as=0.3933p ps=1.95u w=1.38u l=0.28u
M_M2 Y a_556_68# VSS VPW nfet_03v3 ad=0.285p pd=1.57u as=0.26p ps=1.52u w=1u l=0.28u
M_M3 a_332_440# a_28_68# VDD VNW pfet_03v3 ad=0.5796p pd=2.22u as=0.3588p ps=1.9u w=1.38u l=0.28u
M_M4 VSS A a_28_68# VPW nfet_03v3 ad=0.54p pd=2.08u as=0.44p ps=2.88u w=1u l=0.28u
M_M5 a_556_68# a_500_24# a_444_68# VPW nfet_03v3 ad=0.62p pd=2.24u as=0.14p ps=1.28u w=1u l=0.28u
M_M6 a_500_24# a_28_68# a_556_68# VPW nfet_03v3 ad=0.31p pd=1.62u as=0.62p ps=2.24u w=1u l=0.28u
M_M7 a_500_24# A a_556_68# VNW pfet_03v3 ad=0.7866p pd=2.52u as=0.4968p ps=2.1u w=1.38u l=0.28u
M_M8 VDD B a_500_24# VNW pfet_03v3 ad=0.3588p pd=1.9u as=0.7866p ps=2.52u w=1.38u l=0.28u
M_M9 VSS B a_500_24# VPW nfet_03v3 ad=0.26p pd=1.52u as=0.31p ps=1.62u w=1u l=0.28u
M_M10 a_444_68# A VSS VPW nfet_03v3 ad=0.14p pd=1.28u as=0.54p ps=2.08u w=1u l=0.28u
M_M11 Y a_556_68# VDD VNW pfet_03v3 ad=0.3933p pd=1.95u as=0.3588p ps=1.9u w=1.38u l=0.28u
M_M12 VDD A a_28_68# VNW pfet_03v3 ad=0.3588p pd=1.9u as=0.6072p ps=3.64u w=1.38u l=0.28u
M_M13 a_556_68# a_500_24# a_332_440# VNW pfet_03v3 ad=0.4968p pd=2.1u as=0.5796p ps=2.22u w=1.38u l=0.28u
.ends

* NGSPICE file created from gf180mcu_as_sc_mcu7t3v3__xor2_4.ext - technology: gf180mcuD

.subckt gf180mcu_as_sc_mcu7t3v3__xor2_4 VDD VNW VPW VSS B A Y
M_M0 VSS a_556_68# Y VPW nfet_03v3 ad=0.26p pd=1.52u as=0.285p ps=1.57u w=1u l=0.28u
M_M1 VDD a_556_68# Y VNW pfet_03v3 ad=0.3588p pd=1.9u as=0.3933p ps=1.95u w=1.38u l=0.28u
M_M2 Y a_556_68# VSS VPW nfet_03v3 ad=0.285p pd=1.57u as=0.26p ps=1.52u w=1u l=0.28u
M_M3 a_332_440# a_28_68# VDD VNW pfet_03v3 ad=0.5796p pd=2.22u as=0.3588p ps=1.9u w=1.38u l=0.28u
M_M4 VSS A a_28_68# VPW nfet_03v3 ad=0.54p pd=2.08u as=0.44p ps=2.88u w=1u l=0.28u
M_M5 a_556_68# a_500_24# a_444_68# VPW nfet_03v3 ad=0.62p pd=2.24u as=0.14p ps=1.28u w=1u l=0.28u
M_M6 Y a_556_68# VDD VNW pfet_03v3 ad=0.3588p pd=1.9u as=0.3588p ps=1.9u w=1.38u l=0.28u
M_M7 a_500_24# a_28_68# a_556_68# VPW nfet_03v3 ad=0.31p pd=1.62u as=0.62p ps=2.24u w=1u l=0.28u
M_M8 a_500_24# A a_556_68# VNW pfet_03v3 ad=0.7866p pd=2.52u as=0.4968p ps=2.1u w=1.38u l=0.28u
M_M9 VDD B a_500_24# VNW pfet_03v3 ad=0.3588p pd=1.9u as=0.7866p ps=2.52u w=1.38u l=0.28u
M_M10 VSS B a_500_24# VPW nfet_03v3 ad=0.26p pd=1.52u as=0.31p ps=1.62u w=1u l=0.28u
M_M11 VSS a_556_68# Y VPW nfet_03v3 ad=0.725p pd=3.45u as=0.26p ps=1.52u w=1u l=0.28u
M_M12 VDD a_556_68# Y VNW pfet_03v3 ad=1.0005p pd=4.21u as=0.3588p ps=1.9u w=1.38u l=0.28u
M_M13 a_444_68# A VSS VPW nfet_03v3 ad=0.14p pd=1.28u as=0.54p ps=2.08u w=1u l=0.28u
M_M14 Y a_556_68# VSS VPW nfet_03v3 ad=0.26p pd=1.52u as=0.26p ps=1.52u w=1u l=0.28u
M_M15 Y a_556_68# VDD VNW pfet_03v3 ad=0.3933p pd=1.95u as=0.3588p ps=1.9u w=1.38u l=0.28u
M_M16 VDD A a_28_68# VNW pfet_03v3 ad=0.3588p pd=1.9u as=0.6072p ps=3.64u w=1.38u l=0.28u
M_M17 a_556_68# a_500_24# a_332_440# VNW pfet_03v3 ad=0.4968p pd=2.1u as=0.5796p ps=2.22u w=1.38u l=0.28u
.ends

* CDL Netlist generated by OpenROAD

*.BUSDELIMITER [

.SUBCKT PLL_RING_DCO_PHYS COARSE_MUX[0] COARSE_MUX[10] COARSE_MUX[11]
+ COARSE_MUX[12] COARSE_MUX[13] COARSE_MUX[14] COARSE_MUX[1]
+ COARSE_MUX[2] COARSE_MUX[3] COARSE_MUX[4] COARSE_MUX[5] COARSE_MUX[6]
+ COARSE_MUX[7] COARSE_MUX[8] COARSE_MUX[9] DCO_EN FINE_MUX[0]
+ FINE_MUX[10] FINE_MUX[11] FINE_MUX[12] FINE_MUX[13] FINE_MUX[14]
+ FINE_MUX[15] FINE_MUX[16] FINE_MUX[17] FINE_MUX[18] FINE_MUX[19]
+ FINE_MUX[1] FINE_MUX[20] FINE_MUX[21] FINE_MUX[22] FINE_MUX[23]
+ FINE_MUX[24] FINE_MUX[25] FINE_MUX[26] FINE_MUX[27] FINE_MUX[28]
+ FINE_MUX[29] FINE_MUX[2] FINE_MUX[30] FINE_MUX[3] FINE_MUX[4]
+ FINE_MUX[5] FINE_MUX[6] FINE_MUX[7] FINE_MUX[8] FINE_MUX[9]
+ INJ_EDGE INJ_EN MID_MUX[0] MID_MUX[10] MID_MUX[11] MID_MUX[12]
+ MID_MUX[13] MID_MUX[14] MID_MUX[1] MID_MUX[2] MID_MUX[3] MID_MUX[4]
+ MID_MUX[5] MID_MUX[6] MID_MUX[7] MID_MUX[8] MID_MUX[9] MID_OUT
+ OUT REF SS_BBPD[0] SS_BBPD[1] VDD VSS
XFILLER_0_104 VDD VDD VSS VSS gf180mcu_as_sc_mcu7t3v3__fillcap_16
XFILLER_0_120 VDD VDD VSS VSS gf180mcu_as_sc_mcu7t3v3__fillcap_16
XFILLER_0_138 VDD VDD VSS VSS gf180mcu_as_sc_mcu7t3v3__fillcap_4
XFILLER_0_165 VDD VDD VSS VSS gf180mcu_as_sc_mcu7t3v3__fillcap_4
XFILLER_0_169 VDD VDD VSS VSS gf180mcu_as_sc_mcu7t3v3__fill_1
XFILLER_0_18 VDD VDD VSS VSS gf180mcu_as_sc_mcu7t3v3__fillcap_16
XFILLER_0_184 VDD VDD VSS VSS gf180mcu_as_sc_mcu7t3v3__fillcap_16
XFILLER_0_2 VDD VDD VSS VSS gf180mcu_as_sc_mcu7t3v3__fillcap_16
XFILLER_0_200 VDD VDD VSS VSS gf180mcu_as_sc_mcu7t3v3__fillcap_4
XFILLER_0_224 VDD VDD VSS VSS gf180mcu_as_sc_mcu7t3v3__fill_1
XFILLER_0_237 VDD VDD VSS VSS gf180mcu_as_sc_mcu7t3v3__fill_1
XFILLER_0_240 VDD VDD VSS VSS gf180mcu_as_sc_mcu7t3v3__fillcap_16
XFILLER_0_256 VDD VDD VSS VSS gf180mcu_as_sc_mcu7t3v3__fillcap_16
XFILLER_0_274 VDD VDD VSS VSS gf180mcu_as_sc_mcu7t3v3__fill_2
XFILLER_0_276 VDD VDD VSS VSS gf180mcu_as_sc_mcu7t3v3__fill_1
XFILLER_0_36 VDD VDD VSS VSS gf180mcu_as_sc_mcu7t3v3__fillcap_16
XFILLER_0_52 VDD VDD VSS VSS gf180mcu_as_sc_mcu7t3v3__fillcap_16
XFILLER_0_70 VDD VDD VSS VSS gf180mcu_as_sc_mcu7t3v3__fillcap_16
XFILLER_0_86 VDD VDD VSS VSS gf180mcu_as_sc_mcu7t3v3__fillcap_16
XFILLER_10_103 VDD VDD VSS VSS gf180mcu_as_sc_mcu7t3v3__fill_2
XFILLER_10_107 VDD VDD VSS VSS gf180mcu_as_sc_mcu7t3v3__fillcap_4
XFILLER_10_111 VDD VDD VSS VSS gf180mcu_as_sc_mcu7t3v3__fill_1
XFILLER_10_136 VDD VDD VSS VSS gf180mcu_as_sc_mcu7t3v3__fill_1
XFILLER_10_149 VDD VDD VSS VSS gf180mcu_as_sc_mcu7t3v3__fillcap_4
XFILLER_10_171 VDD VDD VSS VSS gf180mcu_as_sc_mcu7t3v3__fillcap_4
XFILLER_10_177 VDD VDD VSS VSS gf180mcu_as_sc_mcu7t3v3__fillcap_8
XFILLER_10_18 VDD VDD VSS VSS gf180mcu_as_sc_mcu7t3v3__fillcap_16
XFILLER_10_185 VDD VDD VSS VSS gf180mcu_as_sc_mcu7t3v3__fillcap_4
XFILLER_10_189 VDD VDD VSS VSS gf180mcu_as_sc_mcu7t3v3__fill_2
XFILLER_10_2 VDD VDD VSS VSS gf180mcu_as_sc_mcu7t3v3__fillcap_16
XFILLER_10_203 VDD VDD VSS VSS gf180mcu_as_sc_mcu7t3v3__fillcap_16
XFILLER_10_219 VDD VDD VSS VSS gf180mcu_as_sc_mcu7t3v3__fillcap_16
XFILLER_10_235 VDD VDD VSS VSS gf180mcu_as_sc_mcu7t3v3__fill_2
XFILLER_10_244 VDD VDD VSS VSS gf180mcu_as_sc_mcu7t3v3__fill_1
XFILLER_10_257 VDD VDD VSS VSS gf180mcu_as_sc_mcu7t3v3__fillcap_8
XFILLER_10_34 VDD VDD VSS VSS gf180mcu_as_sc_mcu7t3v3__fill_1
XFILLER_10_37 VDD VDD VSS VSS gf180mcu_as_sc_mcu7t3v3__fill_1
XFILLER_10_44 VDD VDD VSS VSS gf180mcu_as_sc_mcu7t3v3__fillcap_16
XFILLER_10_60 VDD VDD VSS VSS gf180mcu_as_sc_mcu7t3v3__fillcap_8
XFILLER_10_68 VDD VDD VSS VSS gf180mcu_as_sc_mcu7t3v3__fillcap_4
XFILLER_10_72 VDD VDD VSS VSS gf180mcu_as_sc_mcu7t3v3__fill_1
XFILLER_10_85 VDD VDD VSS VSS gf180mcu_as_sc_mcu7t3v3__fillcap_4
XFILLER_10_95 VDD VDD VSS VSS gf180mcu_as_sc_mcu7t3v3__fillcap_8
XFILLER_11_104 VDD VDD VSS VSS gf180mcu_as_sc_mcu7t3v3__fillcap_4
XFILLER_11_108 VDD VDD VSS VSS gf180mcu_as_sc_mcu7t3v3__fill_2
XFILLER_11_116 VDD VDD VSS VSS gf180mcu_as_sc_mcu7t3v3__fillcap_8
XFILLER_11_124 VDD VDD VSS VSS gf180mcu_as_sc_mcu7t3v3__fillcap_4
XFILLER_11_142 VDD VDD VSS VSS gf180mcu_as_sc_mcu7t3v3__fill_2
XFILLER_11_156 VDD VDD VSS VSS gf180mcu_as_sc_mcu7t3v3__fillcap_16
XFILLER_11_172 VDD VDD VSS VSS gf180mcu_as_sc_mcu7t3v3__fillcap_16
XFILLER_11_18 VDD VDD VSS VSS gf180mcu_as_sc_mcu7t3v3__fillcap_16
XFILLER_11_188 VDD VDD VSS VSS gf180mcu_as_sc_mcu7t3v3__fillcap_4
XFILLER_11_2 VDD VDD VSS VSS gf180mcu_as_sc_mcu7t3v3__fillcap_16
XFILLER_11_204 VDD VDD VSS VSS gf180mcu_as_sc_mcu7t3v3__fillcap_4
XFILLER_11_208 VDD VDD VSS VSS gf180mcu_as_sc_mcu7t3v3__fill_2
XFILLER_11_212 VDD VDD VSS VSS gf180mcu_as_sc_mcu7t3v3__fillcap_16
XFILLER_11_228 VDD VDD VSS VSS gf180mcu_as_sc_mcu7t3v3__fillcap_4
XFILLER_11_232 VDD VDD VSS VSS gf180mcu_as_sc_mcu7t3v3__fill_2
XFILLER_11_251 VDD VDD VSS VSS gf180mcu_as_sc_mcu7t3v3__fillcap_8
XFILLER_11_259 VDD VDD VSS VSS gf180mcu_as_sc_mcu7t3v3__fill_2
XFILLER_11_272 VDD VDD VSS VSS gf180mcu_as_sc_mcu7t3v3__fillcap_4
XFILLER_11_276 VDD VDD VSS VSS gf180mcu_as_sc_mcu7t3v3__fill_1
XFILLER_11_34 VDD VDD VSS VSS gf180mcu_as_sc_mcu7t3v3__fill_2
XFILLER_11_36 VDD VDD VSS VSS gf180mcu_as_sc_mcu7t3v3__fill_1
XFILLER_11_55 VDD VDD VSS VSS gf180mcu_as_sc_mcu7t3v3__fillcap_8
XFILLER_11_63 VDD VDD VSS VSS gf180mcu_as_sc_mcu7t3v3__fillcap_4
XFILLER_11_67 VDD VDD VSS VSS gf180mcu_as_sc_mcu7t3v3__fill_2
XFILLER_11_69 VDD VDD VSS VSS gf180mcu_as_sc_mcu7t3v3__fill_1
XFILLER_11_72 VDD VDD VSS VSS gf180mcu_as_sc_mcu7t3v3__fillcap_16
XFILLER_11_88 VDD VDD VSS VSS gf180mcu_as_sc_mcu7t3v3__fillcap_16
XFILLER_12_101 VDD VDD VSS VSS gf180mcu_as_sc_mcu7t3v3__fillcap_4
XFILLER_12_107 VDD VDD VSS VSS gf180mcu_as_sc_mcu7t3v3__fillcap_16
XFILLER_12_123 VDD VDD VSS VSS gf180mcu_as_sc_mcu7t3v3__fillcap_16
XFILLER_12_139 VDD VDD VSS VSS gf180mcu_as_sc_mcu7t3v3__fillcap_16
XFILLER_12_155 VDD VDD VSS VSS gf180mcu_as_sc_mcu7t3v3__fillcap_16
XFILLER_12_171 VDD VDD VSS VSS gf180mcu_as_sc_mcu7t3v3__fillcap_4
XFILLER_12_177 VDD VDD VSS VSS gf180mcu_as_sc_mcu7t3v3__fillcap_16
XFILLER_12_18 VDD VDD VSS VSS gf180mcu_as_sc_mcu7t3v3__fillcap_16
XFILLER_12_193 VDD VDD VSS VSS gf180mcu_as_sc_mcu7t3v3__fill_2
XFILLER_12_195 VDD VDD VSS VSS gf180mcu_as_sc_mcu7t3v3__fill_1
XFILLER_12_2 VDD VDD VSS VSS gf180mcu_as_sc_mcu7t3v3__fillcap_16
XFILLER_12_208 VDD VDD VSS VSS gf180mcu_as_sc_mcu7t3v3__fillcap_16
XFILLER_12_238 VDD VDD VSS VSS gf180mcu_as_sc_mcu7t3v3__fillcap_4
XFILLER_12_242 VDD VDD VSS VSS gf180mcu_as_sc_mcu7t3v3__fill_2
XFILLER_12_244 VDD VDD VSS VSS gf180mcu_as_sc_mcu7t3v3__fill_1
XFILLER_12_247 VDD VDD VSS VSS gf180mcu_as_sc_mcu7t3v3__fillcap_4
XFILLER_12_251 VDD VDD VSS VSS gf180mcu_as_sc_mcu7t3v3__fill_1
XFILLER_12_34 VDD VDD VSS VSS gf180mcu_as_sc_mcu7t3v3__fill_1
XFILLER_12_37 VDD VDD VSS VSS gf180mcu_as_sc_mcu7t3v3__fillcap_4
XFILLER_12_41 VDD VDD VSS VSS gf180mcu_as_sc_mcu7t3v3__fill_1
XFILLER_12_60 VDD VDD VSS VSS gf180mcu_as_sc_mcu7t3v3__fillcap_16
XFILLER_12_82 VDD VDD VSS VSS gf180mcu_as_sc_mcu7t3v3__fillcap_8
XFILLER_12_90 VDD VDD VSS VSS gf180mcu_as_sc_mcu7t3v3__fillcap_4
XFILLER_12_94 VDD VDD VSS VSS gf180mcu_as_sc_mcu7t3v3__fill_1
XFILLER_13_106 VDD VDD VSS VSS gf180mcu_as_sc_mcu7t3v3__fillcap_16
XFILLER_13_122 VDD VDD VSS VSS gf180mcu_as_sc_mcu7t3v3__fillcap_16
XFILLER_13_138 VDD VDD VSS VSS gf180mcu_as_sc_mcu7t3v3__fill_2
XFILLER_13_142 VDD VDD VSS VSS gf180mcu_as_sc_mcu7t3v3__fillcap_16
XFILLER_13_15 VDD VDD VSS VSS gf180mcu_as_sc_mcu7t3v3__fillcap_4
XFILLER_13_158 VDD VDD VSS VSS gf180mcu_as_sc_mcu7t3v3__fillcap_4
XFILLER_13_162 VDD VDD VSS VSS gf180mcu_as_sc_mcu7t3v3__fill_1
XFILLER_13_175 VDD VDD VSS VSS gf180mcu_as_sc_mcu7t3v3__fill_1
XFILLER_13_182 VDD VDD VSS VSS gf180mcu_as_sc_mcu7t3v3__fillcap_8
XFILLER_13_190 VDD VDD VSS VSS gf180mcu_as_sc_mcu7t3v3__fill_2
XFILLER_13_2 VDD VDD VSS VSS gf180mcu_as_sc_mcu7t3v3__fillcap_4
XFILLER_13_204 VDD VDD VSS VSS gf180mcu_as_sc_mcu7t3v3__fillcap_4
XFILLER_13_208 VDD VDD VSS VSS gf180mcu_as_sc_mcu7t3v3__fill_2
XFILLER_13_212 VDD VDD VSS VSS gf180mcu_as_sc_mcu7t3v3__fillcap_8
XFILLER_13_220 VDD VDD VSS VSS gf180mcu_as_sc_mcu7t3v3__fillcap_4
XFILLER_13_224 VDD VDD VSS VSS gf180mcu_as_sc_mcu7t3v3__fill_2
XFILLER_13_226 VDD VDD VSS VSS gf180mcu_as_sc_mcu7t3v3__fill_1
XFILLER_13_237 VDD VDD VSS VSS gf180mcu_as_sc_mcu7t3v3__fillcap_8
XFILLER_13_245 VDD VDD VSS VSS gf180mcu_as_sc_mcu7t3v3__fillcap_4
XFILLER_13_249 VDD VDD VSS VSS gf180mcu_as_sc_mcu7t3v3__fill_2
XFILLER_13_270 VDD VDD VSS VSS gf180mcu_as_sc_mcu7t3v3__fill_1
XFILLER_13_46 VDD VDD VSS VSS gf180mcu_as_sc_mcu7t3v3__fillcap_4
XFILLER_13_50 VDD VDD VSS VSS gf180mcu_as_sc_mcu7t3v3__fill_1
XFILLER_13_6 VDD VDD VSS VSS gf180mcu_as_sc_mcu7t3v3__fill_2
XFILLER_13_69 VDD VDD VSS VSS gf180mcu_as_sc_mcu7t3v3__fill_1
XFILLER_13_72 VDD VDD VSS VSS gf180mcu_as_sc_mcu7t3v3__fillcap_4
XFILLER_13_8 VDD VDD VSS VSS gf180mcu_as_sc_mcu7t3v3__fill_1
XFILLER_14_113 VDD VDD VSS VSS gf180mcu_as_sc_mcu7t3v3__fillcap_16
XFILLER_14_129 VDD VDD VSS VSS gf180mcu_as_sc_mcu7t3v3__fill_2
XFILLER_14_137 VDD VDD VSS VSS gf180mcu_as_sc_mcu7t3v3__fillcap_16
XFILLER_14_153 VDD VDD VSS VSS gf180mcu_as_sc_mcu7t3v3__fillcap_8
XFILLER_14_173 VDD VDD VSS VSS gf180mcu_as_sc_mcu7t3v3__fill_2
XFILLER_14_201 VDD VDD VSS VSS gf180mcu_as_sc_mcu7t3v3__fillcap_16
XFILLER_14_241 VDD VDD VSS VSS gf180mcu_as_sc_mcu7t3v3__fillcap_4
XFILLER_14_270 VDD VDD VSS VSS gf180mcu_as_sc_mcu7t3v3__fill_1
XFILLER_14_29 VDD VDD VSS VSS gf180mcu_as_sc_mcu7t3v3__fillcap_4
XFILLER_14_33 VDD VDD VSS VSS gf180mcu_as_sc_mcu7t3v3__fill_2
XFILLER_14_37 VDD VDD VSS VSS gf180mcu_as_sc_mcu7t3v3__fillcap_16
XFILLER_14_53 VDD VDD VSS VSS gf180mcu_as_sc_mcu7t3v3__fillcap_4
XFILLER_14_57 VDD VDD VSS VSS gf180mcu_as_sc_mcu7t3v3__fill_2
XFILLER_14_59 VDD VDD VSS VSS gf180mcu_as_sc_mcu7t3v3__fill_1
XFILLER_14_78 VDD VDD VSS VSS gf180mcu_as_sc_mcu7t3v3__fillcap_16
XFILLER_14_94 VDD VDD VSS VSS gf180mcu_as_sc_mcu7t3v3__fillcap_4
XFILLER_14_98 VDD VDD VSS VSS gf180mcu_as_sc_mcu7t3v3__fill_1
XFILLER_15_115 VDD VDD VSS VSS gf180mcu_as_sc_mcu7t3v3__fillcap_4
XFILLER_15_119 VDD VDD VSS VSS gf180mcu_as_sc_mcu7t3v3__fill_2
XFILLER_15_121 VDD VDD VSS VSS gf180mcu_as_sc_mcu7t3v3__fill_1
XFILLER_15_142 VDD VDD VSS VSS gf180mcu_as_sc_mcu7t3v3__fillcap_16
XFILLER_15_158 VDD VDD VSS VSS gf180mcu_as_sc_mcu7t3v3__fillcap_4
XFILLER_15_174 VDD VDD VSS VSS gf180mcu_as_sc_mcu7t3v3__fillcap_16
XFILLER_15_190 VDD VDD VSS VSS gf180mcu_as_sc_mcu7t3v3__fillcap_16
XFILLER_15_206 VDD VDD VSS VSS gf180mcu_as_sc_mcu7t3v3__fillcap_4
XFILLER_15_21 VDD VDD VSS VSS gf180mcu_as_sc_mcu7t3v3__fill_2
XFILLER_15_212 VDD VDD VSS VSS gf180mcu_as_sc_mcu7t3v3__fillcap_8
XFILLER_15_220 VDD VDD VSS VSS gf180mcu_as_sc_mcu7t3v3__fillcap_4
XFILLER_15_224 VDD VDD VSS VSS gf180mcu_as_sc_mcu7t3v3__fill_2
XFILLER_15_23 VDD VDD VSS VSS gf180mcu_as_sc_mcu7t3v3__fill_1
XFILLER_15_233 VDD VDD VSS VSS gf180mcu_as_sc_mcu7t3v3__fillcap_16
XFILLER_15_249 VDD VDD VSS VSS gf180mcu_as_sc_mcu7t3v3__fillcap_4
XFILLER_15_30 VDD VDD VSS VSS gf180mcu_as_sc_mcu7t3v3__fillcap_4
XFILLER_15_34 VDD VDD VSS VSS gf180mcu_as_sc_mcu7t3v3__fill_2
XFILLER_15_36 VDD VDD VSS VSS gf180mcu_as_sc_mcu7t3v3__fill_1
XFILLER_15_43 VDD VDD VSS VSS gf180mcu_as_sc_mcu7t3v3__fillcap_16
XFILLER_15_59 VDD VDD VSS VSS gf180mcu_as_sc_mcu7t3v3__fill_2
XFILLER_15_67 VDD VDD VSS VSS gf180mcu_as_sc_mcu7t3v3__fill_2
XFILLER_15_69 VDD VDD VSS VSS gf180mcu_as_sc_mcu7t3v3__fill_1
XFILLER_15_72 VDD VDD VSS VSS gf180mcu_as_sc_mcu7t3v3__fillcap_16
XFILLER_15_8 VDD VDD VSS VSS gf180mcu_as_sc_mcu7t3v3__fill_1
XFILLER_15_88 VDD VDD VSS VSS gf180mcu_as_sc_mcu7t3v3__fillcap_8
XFILLER_15_96 VDD VDD VSS VSS gf180mcu_as_sc_mcu7t3v3__fill_1
XFILLER_16_100 VDD VDD VSS VSS gf180mcu_as_sc_mcu7t3v3__fillcap_4
XFILLER_16_104 VDD VDD VSS VSS gf180mcu_as_sc_mcu7t3v3__fill_1
XFILLER_16_107 VDD VDD VSS VSS gf180mcu_as_sc_mcu7t3v3__fillcap_8
XFILLER_16_115 VDD VDD VSS VSS gf180mcu_as_sc_mcu7t3v3__fillcap_4
XFILLER_16_131 VDD VDD VSS VSS gf180mcu_as_sc_mcu7t3v3__fillcap_4
XFILLER_16_135 VDD VDD VSS VSS gf180mcu_as_sc_mcu7t3v3__fill_1
XFILLER_16_142 VDD VDD VSS VSS gf180mcu_as_sc_mcu7t3v3__fillcap_8
XFILLER_16_150 VDD VDD VSS VSS gf180mcu_as_sc_mcu7t3v3__fillcap_4
XFILLER_16_154 VDD VDD VSS VSS gf180mcu_as_sc_mcu7t3v3__fill_2
XFILLER_16_156 VDD VDD VSS VSS gf180mcu_as_sc_mcu7t3v3__fill_1
XFILLER_16_169 VDD VDD VSS VSS gf180mcu_as_sc_mcu7t3v3__fillcap_4
XFILLER_16_173 VDD VDD VSS VSS gf180mcu_as_sc_mcu7t3v3__fill_2
XFILLER_16_177 VDD VDD VSS VSS gf180mcu_as_sc_mcu7t3v3__fillcap_16
XFILLER_16_193 VDD VDD VSS VSS gf180mcu_as_sc_mcu7t3v3__fillcap_16
XFILLER_16_209 VDD VDD VSS VSS gf180mcu_as_sc_mcu7t3v3__fillcap_8
XFILLER_16_217 VDD VDD VSS VSS gf180mcu_as_sc_mcu7t3v3__fillcap_4
XFILLER_16_221 VDD VDD VSS VSS gf180mcu_as_sc_mcu7t3v3__fill_2
XFILLER_16_240 VDD VDD VSS VSS gf180mcu_as_sc_mcu7t3v3__fillcap_4
XFILLER_16_244 VDD VDD VSS VSS gf180mcu_as_sc_mcu7t3v3__fill_1
XFILLER_16_247 VDD VDD VSS VSS gf180mcu_as_sc_mcu7t3v3__fillcap_4
XFILLER_16_251 VDD VDD VSS VSS gf180mcu_as_sc_mcu7t3v3__fill_2
XFILLER_16_268 VDD VDD VSS VSS gf180mcu_as_sc_mcu7t3v3__fill_2
XFILLER_16_270 VDD VDD VSS VSS gf180mcu_as_sc_mcu7t3v3__fill_1
XFILLER_16_28 VDD VDD VSS VSS gf180mcu_as_sc_mcu7t3v3__fillcap_4
XFILLER_16_32 VDD VDD VSS VSS gf180mcu_as_sc_mcu7t3v3__fill_2
XFILLER_16_34 VDD VDD VSS VSS gf180mcu_as_sc_mcu7t3v3__fill_1
XFILLER_16_37 VDD VDD VSS VSS gf180mcu_as_sc_mcu7t3v3__fillcap_16
XFILLER_16_53 VDD VDD VSS VSS gf180mcu_as_sc_mcu7t3v3__fillcap_16
XFILLER_16_69 VDD VDD VSS VSS gf180mcu_as_sc_mcu7t3v3__fill_2
XFILLER_16_77 VDD VDD VSS VSS gf180mcu_as_sc_mcu7t3v3__fillcap_4
XFILLER_16_87 VDD VDD VSS VSS gf180mcu_as_sc_mcu7t3v3__fillcap_4
XFILLER_16_91 VDD VDD VSS VSS gf180mcu_as_sc_mcu7t3v3__fill_2
XFILLER_16_93 VDD VDD VSS VSS gf180mcu_as_sc_mcu7t3v3__fill_1
XFILLER_17_10 VDD VDD VSS VSS gf180mcu_as_sc_mcu7t3v3__fillcap_4
XFILLER_17_114 VDD VDD VSS VSS gf180mcu_as_sc_mcu7t3v3__fill_2
XFILLER_17_128 VDD VDD VSS VSS gf180mcu_as_sc_mcu7t3v3__fillcap_4
XFILLER_17_132 VDD VDD VSS VSS gf180mcu_as_sc_mcu7t3v3__fill_2
XFILLER_17_14 VDD VDD VSS VSS gf180mcu_as_sc_mcu7t3v3__fill_2
XFILLER_17_148 VDD VDD VSS VSS gf180mcu_as_sc_mcu7t3v3__fillcap_16
XFILLER_17_170 VDD VDD VSS VSS gf180mcu_as_sc_mcu7t3v3__fillcap_16
XFILLER_17_186 VDD VDD VSS VSS gf180mcu_as_sc_mcu7t3v3__fillcap_16
XFILLER_17_2 VDD VDD VSS VSS gf180mcu_as_sc_mcu7t3v3__fillcap_8
XFILLER_17_202 VDD VDD VSS VSS gf180mcu_as_sc_mcu7t3v3__fillcap_8
XFILLER_17_212 VDD VDD VSS VSS gf180mcu_as_sc_mcu7t3v3__fillcap_8
XFILLER_17_220 VDD VDD VSS VSS gf180mcu_as_sc_mcu7t3v3__fillcap_4
XFILLER_17_224 VDD VDD VSS VSS gf180mcu_as_sc_mcu7t3v3__fill_1
XFILLER_17_239 VDD VDD VSS VSS gf180mcu_as_sc_mcu7t3v3__fillcap_8
XFILLER_17_24 VDD VDD VSS VSS gf180mcu_as_sc_mcu7t3v3__fillcap_4
XFILLER_17_268 VDD VDD VSS VSS gf180mcu_as_sc_mcu7t3v3__fill_2
XFILLER_17_270 VDD VDD VSS VSS gf180mcu_as_sc_mcu7t3v3__fill_1
XFILLER_17_28 VDD VDD VSS VSS gf180mcu_as_sc_mcu7t3v3__fill_1
XFILLER_17_33 VDD VDD VSS VSS gf180mcu_as_sc_mcu7t3v3__fillcap_8
XFILLER_17_41 VDD VDD VSS VSS gf180mcu_as_sc_mcu7t3v3__fillcap_4
XFILLER_17_45 VDD VDD VSS VSS gf180mcu_as_sc_mcu7t3v3__fill_2
XFILLER_17_47 VDD VDD VSS VSS gf180mcu_as_sc_mcu7t3v3__fill_1
XFILLER_17_60 VDD VDD VSS VSS gf180mcu_as_sc_mcu7t3v3__fillcap_4
XFILLER_17_72 VDD VDD VSS VSS gf180mcu_as_sc_mcu7t3v3__fill_2
XFILLER_17_98 VDD VDD VSS VSS gf180mcu_as_sc_mcu7t3v3__fillcap_16
XFILLER_18_103 VDD VDD VSS VSS gf180mcu_as_sc_mcu7t3v3__fill_2
XFILLER_18_107 VDD VDD VSS VSS gf180mcu_as_sc_mcu7t3v3__fillcap_4
XFILLER_18_111 VDD VDD VSS VSS gf180mcu_as_sc_mcu7t3v3__fill_1
XFILLER_18_124 VDD VDD VSS VSS gf180mcu_as_sc_mcu7t3v3__fillcap_8
XFILLER_18_132 VDD VDD VSS VSS gf180mcu_as_sc_mcu7t3v3__fill_2
XFILLER_18_14 VDD VDD VSS VSS gf180mcu_as_sc_mcu7t3v3__fillcap_4
XFILLER_18_152 VDD VDD VSS VSS gf180mcu_as_sc_mcu7t3v3__fillcap_8
XFILLER_18_160 VDD VDD VSS VSS gf180mcu_as_sc_mcu7t3v3__fill_2
XFILLER_18_162 VDD VDD VSS VSS gf180mcu_as_sc_mcu7t3v3__fill_1
XFILLER_18_177 VDD VDD VSS VSS gf180mcu_as_sc_mcu7t3v3__fillcap_16
XFILLER_18_18 VDD VDD VSS VSS gf180mcu_as_sc_mcu7t3v3__fill_2
XFILLER_18_193 VDD VDD VSS VSS gf180mcu_as_sc_mcu7t3v3__fillcap_16
XFILLER_18_20 VDD VDD VSS VSS gf180mcu_as_sc_mcu7t3v3__fill_1
XFILLER_18_209 VDD VDD VSS VSS gf180mcu_as_sc_mcu7t3v3__fillcap_8
XFILLER_18_217 VDD VDD VSS VSS gf180mcu_as_sc_mcu7t3v3__fillcap_4
XFILLER_18_221 VDD VDD VSS VSS gf180mcu_as_sc_mcu7t3v3__fill_2
XFILLER_18_240 VDD VDD VSS VSS gf180mcu_as_sc_mcu7t3v3__fillcap_4
XFILLER_18_244 VDD VDD VSS VSS gf180mcu_as_sc_mcu7t3v3__fill_1
XFILLER_18_247 VDD VDD VSS VSS gf180mcu_as_sc_mcu7t3v3__fillcap_4
XFILLER_18_251 VDD VDD VSS VSS gf180mcu_as_sc_mcu7t3v3__fill_2
XFILLER_18_253 VDD VDD VSS VSS gf180mcu_as_sc_mcu7t3v3__fill_1
XFILLER_18_269 VDD VDD VSS VSS gf180mcu_as_sc_mcu7t3v3__fill_2
XFILLER_18_37 VDD VDD VSS VSS gf180mcu_as_sc_mcu7t3v3__fillcap_8
XFILLER_18_45 VDD VDD VSS VSS gf180mcu_as_sc_mcu7t3v3__fill_2
XFILLER_18_65 VDD VDD VSS VSS gf180mcu_as_sc_mcu7t3v3__fill_1
XFILLER_18_72 VDD VDD VSS VSS gf180mcu_as_sc_mcu7t3v3__fill_1
XFILLER_18_79 VDD VDD VSS VSS gf180mcu_as_sc_mcu7t3v3__fillcap_16
XFILLER_18_95 VDD VDD VSS VSS gf180mcu_as_sc_mcu7t3v3__fillcap_8
XFILLER_19_122 VDD VDD VSS VSS gf180mcu_as_sc_mcu7t3v3__fillcap_16
XFILLER_19_138 VDD VDD VSS VSS gf180mcu_as_sc_mcu7t3v3__fill_2
XFILLER_19_142 VDD VDD VSS VSS gf180mcu_as_sc_mcu7t3v3__fillcap_4
XFILLER_19_146 VDD VDD VSS VSS gf180mcu_as_sc_mcu7t3v3__fill_1
XFILLER_19_171 VDD VDD VSS VSS gf180mcu_as_sc_mcu7t3v3__fillcap_16
XFILLER_19_187 VDD VDD VSS VSS gf180mcu_as_sc_mcu7t3v3__fillcap_16
XFILLER_19_203 VDD VDD VSS VSS gf180mcu_as_sc_mcu7t3v3__fillcap_4
XFILLER_19_207 VDD VDD VSS VSS gf180mcu_as_sc_mcu7t3v3__fill_2
XFILLER_19_209 VDD VDD VSS VSS gf180mcu_as_sc_mcu7t3v3__fill_1
XFILLER_19_212 VDD VDD VSS VSS gf180mcu_as_sc_mcu7t3v3__fillcap_8
XFILLER_19_22 VDD VDD VSS VSS gf180mcu_as_sc_mcu7t3v3__fill_2
XFILLER_19_220 VDD VDD VSS VSS gf180mcu_as_sc_mcu7t3v3__fillcap_4
XFILLER_19_224 VDD VDD VSS VSS gf180mcu_as_sc_mcu7t3v3__fill_2
XFILLER_19_238 VDD VDD VSS VSS gf180mcu_as_sc_mcu7t3v3__fillcap_8
XFILLER_19_246 VDD VDD VSS VSS gf180mcu_as_sc_mcu7t3v3__fillcap_4
XFILLER_19_250 VDD VDD VSS VSS gf180mcu_as_sc_mcu7t3v3__fill_2
XFILLER_19_31 VDD VDD VSS VSS gf180mcu_as_sc_mcu7t3v3__fillcap_4
XFILLER_19_35 VDD VDD VSS VSS gf180mcu_as_sc_mcu7t3v3__fill_1
XFILLER_19_42 VDD VDD VSS VSS gf180mcu_as_sc_mcu7t3v3__fill_2
XFILLER_19_50 VDD VDD VSS VSS gf180mcu_as_sc_mcu7t3v3__fillcap_16
XFILLER_19_66 VDD VDD VSS VSS gf180mcu_as_sc_mcu7t3v3__fillcap_4
XFILLER_19_72 VDD VDD VSS VSS gf180mcu_as_sc_mcu7t3v3__fillcap_16
XFILLER_19_88 VDD VDD VSS VSS gf180mcu_as_sc_mcu7t3v3__fillcap_16
XFILLER_1_104 VDD VDD VSS VSS gf180mcu_as_sc_mcu7t3v3__fillcap_16
XFILLER_1_120 VDD VDD VSS VSS gf180mcu_as_sc_mcu7t3v3__fillcap_16
XFILLER_1_136 VDD VDD VSS VSS gf180mcu_as_sc_mcu7t3v3__fillcap_4
XFILLER_1_142 VDD VDD VSS VSS gf180mcu_as_sc_mcu7t3v3__fillcap_4
XFILLER_1_146 VDD VDD VSS VSS gf180mcu_as_sc_mcu7t3v3__fill_2
XFILLER_1_163 VDD VDD VSS VSS gf180mcu_as_sc_mcu7t3v3__fill_1
XFILLER_1_175 VDD VDD VSS VSS gf180mcu_as_sc_mcu7t3v3__fillcap_16
XFILLER_1_18 VDD VDD VSS VSS gf180mcu_as_sc_mcu7t3v3__fillcap_16
XFILLER_1_191 VDD VDD VSS VSS gf180mcu_as_sc_mcu7t3v3__fillcap_4
XFILLER_1_195 VDD VDD VSS VSS gf180mcu_as_sc_mcu7t3v3__fill_2
XFILLER_1_197 VDD VDD VSS VSS gf180mcu_as_sc_mcu7t3v3__fill_1
XFILLER_1_2 VDD VDD VSS VSS gf180mcu_as_sc_mcu7t3v3__fillcap_16
XFILLER_1_205 VDD VDD VSS VSS gf180mcu_as_sc_mcu7t3v3__fillcap_4
XFILLER_1_209 VDD VDD VSS VSS gf180mcu_as_sc_mcu7t3v3__fill_1
XFILLER_1_226 VDD VDD VSS VSS gf180mcu_as_sc_mcu7t3v3__fill_2
XFILLER_1_235 VDD VDD VSS VSS gf180mcu_as_sc_mcu7t3v3__fill_2
XFILLER_1_237 VDD VDD VSS VSS gf180mcu_as_sc_mcu7t3v3__fill_1
XFILLER_1_245 VDD VDD VSS VSS gf180mcu_as_sc_mcu7t3v3__fillcap_4
XFILLER_1_256 VDD VDD VSS VSS gf180mcu_as_sc_mcu7t3v3__fillcap_16
XFILLER_1_272 VDD VDD VSS VSS gf180mcu_as_sc_mcu7t3v3__fillcap_4
XFILLER_1_276 VDD VDD VSS VSS gf180mcu_as_sc_mcu7t3v3__fill_1
XFILLER_1_34 VDD VDD VSS VSS gf180mcu_as_sc_mcu7t3v3__fillcap_16
XFILLER_1_50 VDD VDD VSS VSS gf180mcu_as_sc_mcu7t3v3__fillcap_16
XFILLER_1_66 VDD VDD VSS VSS gf180mcu_as_sc_mcu7t3v3__fillcap_4
XFILLER_1_72 VDD VDD VSS VSS gf180mcu_as_sc_mcu7t3v3__fillcap_16
XFILLER_1_88 VDD VDD VSS VSS gf180mcu_as_sc_mcu7t3v3__fillcap_16
XFILLER_20_103 VDD VDD VSS VSS gf180mcu_as_sc_mcu7t3v3__fill_2
XFILLER_20_107 VDD VDD VSS VSS gf180mcu_as_sc_mcu7t3v3__fillcap_4
XFILLER_20_123 VDD VDD VSS VSS gf180mcu_as_sc_mcu7t3v3__fillcap_16
XFILLER_20_139 VDD VDD VSS VSS gf180mcu_as_sc_mcu7t3v3__fillcap_16
XFILLER_20_155 VDD VDD VSS VSS gf180mcu_as_sc_mcu7t3v3__fillcap_8
XFILLER_20_163 VDD VDD VSS VSS gf180mcu_as_sc_mcu7t3v3__fill_1
XFILLER_20_171 VDD VDD VSS VSS gf180mcu_as_sc_mcu7t3v3__fillcap_4
XFILLER_20_177 VDD VDD VSS VSS gf180mcu_as_sc_mcu7t3v3__fillcap_16
XFILLER_20_18 VDD VDD VSS VSS gf180mcu_as_sc_mcu7t3v3__fill_2
XFILLER_20_193 VDD VDD VSS VSS gf180mcu_as_sc_mcu7t3v3__fillcap_16
XFILLER_20_2 VDD VDD VSS VSS gf180mcu_as_sc_mcu7t3v3__fillcap_4
XFILLER_20_20 VDD VDD VSS VSS gf180mcu_as_sc_mcu7t3v3__fill_1
XFILLER_20_209 VDD VDD VSS VSS gf180mcu_as_sc_mcu7t3v3__fillcap_8
XFILLER_20_217 VDD VDD VSS VSS gf180mcu_as_sc_mcu7t3v3__fill_2
XFILLER_20_231 VDD VDD VSS VSS gf180mcu_as_sc_mcu7t3v3__fillcap_8
XFILLER_20_239 VDD VDD VSS VSS gf180mcu_as_sc_mcu7t3v3__fillcap_4
XFILLER_20_243 VDD VDD VSS VSS gf180mcu_as_sc_mcu7t3v3__fill_2
XFILLER_20_247 VDD VDD VSS VSS gf180mcu_as_sc_mcu7t3v3__fillcap_8
XFILLER_20_255 VDD VDD VSS VSS gf180mcu_as_sc_mcu7t3v3__fillcap_4
XFILLER_20_270 VDD VDD VSS VSS gf180mcu_as_sc_mcu7t3v3__fill_1
XFILLER_20_28 VDD VDD VSS VSS gf180mcu_as_sc_mcu7t3v3__fill_2
XFILLER_20_30 VDD VDD VSS VSS gf180mcu_as_sc_mcu7t3v3__fill_1
XFILLER_20_47 VDD VDD VSS VSS gf180mcu_as_sc_mcu7t3v3__fillcap_16
XFILLER_20_6 VDD VDD VSS VSS gf180mcu_as_sc_mcu7t3v3__fill_1
XFILLER_20_63 VDD VDD VSS VSS gf180mcu_as_sc_mcu7t3v3__fillcap_16
XFILLER_20_79 VDD VDD VSS VSS gf180mcu_as_sc_mcu7t3v3__fillcap_16
XFILLER_20_95 VDD VDD VSS VSS gf180mcu_as_sc_mcu7t3v3__fillcap_8
XFILLER_21_104 VDD VDD VSS VSS gf180mcu_as_sc_mcu7t3v3__fillcap_4
XFILLER_21_120 VDD VDD VSS VSS gf180mcu_as_sc_mcu7t3v3__fill_2
XFILLER_21_128 VDD VDD VSS VSS gf180mcu_as_sc_mcu7t3v3__fillcap_8
XFILLER_21_136 VDD VDD VSS VSS gf180mcu_as_sc_mcu7t3v3__fillcap_4
XFILLER_21_142 VDD VDD VSS VSS gf180mcu_as_sc_mcu7t3v3__fillcap_8
XFILLER_21_150 VDD VDD VSS VSS gf180mcu_as_sc_mcu7t3v3__fillcap_4
XFILLER_21_164 VDD VDD VSS VSS gf180mcu_as_sc_mcu7t3v3__fillcap_16
XFILLER_21_18 VDD VDD VSS VSS gf180mcu_as_sc_mcu7t3v3__fillcap_16
XFILLER_21_180 VDD VDD VSS VSS gf180mcu_as_sc_mcu7t3v3__fillcap_16
XFILLER_21_196 VDD VDD VSS VSS gf180mcu_as_sc_mcu7t3v3__fillcap_8
XFILLER_21_2 VDD VDD VSS VSS gf180mcu_as_sc_mcu7t3v3__fill_1
XFILLER_21_204 VDD VDD VSS VSS gf180mcu_as_sc_mcu7t3v3__fillcap_4
XFILLER_21_208 VDD VDD VSS VSS gf180mcu_as_sc_mcu7t3v3__fill_2
XFILLER_21_212 VDD VDD VSS VSS gf180mcu_as_sc_mcu7t3v3__fillcap_8
XFILLER_21_220 VDD VDD VSS VSS gf180mcu_as_sc_mcu7t3v3__fill_1
XFILLER_21_239 VDD VDD VSS VSS gf180mcu_as_sc_mcu7t3v3__fillcap_16
XFILLER_21_270 VDD VDD VSS VSS gf180mcu_as_sc_mcu7t3v3__fill_1
XFILLER_21_34 VDD VDD VSS VSS gf180mcu_as_sc_mcu7t3v3__fillcap_16
XFILLER_21_50 VDD VDD VSS VSS gf180mcu_as_sc_mcu7t3v3__fillcap_16
XFILLER_21_66 VDD VDD VSS VSS gf180mcu_as_sc_mcu7t3v3__fillcap_4
XFILLER_21_72 VDD VDD VSS VSS gf180mcu_as_sc_mcu7t3v3__fillcap_16
XFILLER_21_88 VDD VDD VSS VSS gf180mcu_as_sc_mcu7t3v3__fillcap_16
XFILLER_22_101 VDD VDD VSS VSS gf180mcu_as_sc_mcu7t3v3__fillcap_4
XFILLER_22_107 VDD VDD VSS VSS gf180mcu_as_sc_mcu7t3v3__fillcap_4
XFILLER_22_111 VDD VDD VSS VSS gf180mcu_as_sc_mcu7t3v3__fill_1
XFILLER_22_136 VDD VDD VSS VSS gf180mcu_as_sc_mcu7t3v3__fillcap_16
XFILLER_22_152 VDD VDD VSS VSS gf180mcu_as_sc_mcu7t3v3__fillcap_16
XFILLER_22_168 VDD VDD VSS VSS gf180mcu_as_sc_mcu7t3v3__fillcap_4
XFILLER_22_172 VDD VDD VSS VSS gf180mcu_as_sc_mcu7t3v3__fill_2
XFILLER_22_174 VDD VDD VSS VSS gf180mcu_as_sc_mcu7t3v3__fill_1
XFILLER_22_177 VDD VDD VSS VSS gf180mcu_as_sc_mcu7t3v3__fillcap_16
XFILLER_22_193 VDD VDD VSS VSS gf180mcu_as_sc_mcu7t3v3__fillcap_16
XFILLER_22_2 VDD VDD VSS VSS gf180mcu_as_sc_mcu7t3v3__fill_1
XFILLER_22_209 VDD VDD VSS VSS gf180mcu_as_sc_mcu7t3v3__fillcap_8
XFILLER_22_217 VDD VDD VSS VSS gf180mcu_as_sc_mcu7t3v3__fillcap_4
XFILLER_22_221 VDD VDD VSS VSS gf180mcu_as_sc_mcu7t3v3__fill_1
XFILLER_22_234 VDD VDD VSS VSS gf180mcu_as_sc_mcu7t3v3__fillcap_8
XFILLER_22_24 VDD VDD VSS VSS gf180mcu_as_sc_mcu7t3v3__fillcap_8
XFILLER_22_242 VDD VDD VSS VSS gf180mcu_as_sc_mcu7t3v3__fill_2
XFILLER_22_244 VDD VDD VSS VSS gf180mcu_as_sc_mcu7t3v3__fill_1
XFILLER_22_247 VDD VDD VSS VSS gf180mcu_as_sc_mcu7t3v3__fillcap_8
XFILLER_22_255 VDD VDD VSS VSS gf180mcu_as_sc_mcu7t3v3__fillcap_4
XFILLER_22_274 VDD VDD VSS VSS gf180mcu_as_sc_mcu7t3v3__fill_2
XFILLER_22_276 VDD VDD VSS VSS gf180mcu_as_sc_mcu7t3v3__fill_1
XFILLER_22_32 VDD VDD VSS VSS gf180mcu_as_sc_mcu7t3v3__fill_2
XFILLER_22_34 VDD VDD VSS VSS gf180mcu_as_sc_mcu7t3v3__fill_1
XFILLER_22_37 VDD VDD VSS VSS gf180mcu_as_sc_mcu7t3v3__fillcap_16
XFILLER_22_53 VDD VDD VSS VSS gf180mcu_as_sc_mcu7t3v3__fillcap_16
XFILLER_22_69 VDD VDD VSS VSS gf180mcu_as_sc_mcu7t3v3__fillcap_16
XFILLER_22_85 VDD VDD VSS VSS gf180mcu_as_sc_mcu7t3v3__fillcap_16
XFILLER_23_104 VDD VDD VSS VSS gf180mcu_as_sc_mcu7t3v3__fillcap_8
XFILLER_23_112 VDD VDD VSS VSS gf180mcu_as_sc_mcu7t3v3__fillcap_4
XFILLER_23_116 VDD VDD VSS VSS gf180mcu_as_sc_mcu7t3v3__fill_1
XFILLER_23_123 VDD VDD VSS VSS gf180mcu_as_sc_mcu7t3v3__fillcap_4
XFILLER_23_127 VDD VDD VSS VSS gf180mcu_as_sc_mcu7t3v3__fill_1
XFILLER_23_154 VDD VDD VSS VSS gf180mcu_as_sc_mcu7t3v3__fill_2
XFILLER_23_156 VDD VDD VSS VSS gf180mcu_as_sc_mcu7t3v3__fill_1
XFILLER_23_175 VDD VDD VSS VSS gf180mcu_as_sc_mcu7t3v3__fill_1
XFILLER_23_182 VDD VDD VSS VSS gf180mcu_as_sc_mcu7t3v3__fillcap_4
XFILLER_23_186 VDD VDD VSS VSS gf180mcu_as_sc_mcu7t3v3__fill_2
XFILLER_23_2 VDD VDD VSS VSS gf180mcu_as_sc_mcu7t3v3__fill_1
XFILLER_23_200 VDD VDD VSS VSS gf180mcu_as_sc_mcu7t3v3__fillcap_8
XFILLER_23_208 VDD VDD VSS VSS gf180mcu_as_sc_mcu7t3v3__fill_2
XFILLER_23_212 VDD VDD VSS VSS gf180mcu_as_sc_mcu7t3v3__fillcap_8
XFILLER_23_22 VDD VDD VSS VSS gf180mcu_as_sc_mcu7t3v3__fillcap_4
XFILLER_23_220 VDD VDD VSS VSS gf180mcu_as_sc_mcu7t3v3__fill_2
XFILLER_23_222 VDD VDD VSS VSS gf180mcu_as_sc_mcu7t3v3__fill_1
XFILLER_23_235 VDD VDD VSS VSS gf180mcu_as_sc_mcu7t3v3__fillcap_16
XFILLER_23_251 VDD VDD VSS VSS gf180mcu_as_sc_mcu7t3v3__fillcap_16
XFILLER_23_26 VDD VDD VSS VSS gf180mcu_as_sc_mcu7t3v3__fill_1
XFILLER_23_267 VDD VDD VSS VSS gf180mcu_as_sc_mcu7t3v3__fillcap_8
XFILLER_23_275 VDD VDD VSS VSS gf180mcu_as_sc_mcu7t3v3__fill_2
XFILLER_23_42 VDD VDD VSS VSS gf180mcu_as_sc_mcu7t3v3__fillcap_16
XFILLER_23_58 VDD VDD VSS VSS gf180mcu_as_sc_mcu7t3v3__fillcap_8
XFILLER_23_66 VDD VDD VSS VSS gf180mcu_as_sc_mcu7t3v3__fillcap_4
XFILLER_23_72 VDD VDD VSS VSS gf180mcu_as_sc_mcu7t3v3__fillcap_16
XFILLER_23_88 VDD VDD VSS VSS gf180mcu_as_sc_mcu7t3v3__fillcap_16
XFILLER_24_101 VDD VDD VSS VSS gf180mcu_as_sc_mcu7t3v3__fillcap_4
XFILLER_24_107 VDD VDD VSS VSS gf180mcu_as_sc_mcu7t3v3__fillcap_16
XFILLER_24_123 VDD VDD VSS VSS gf180mcu_as_sc_mcu7t3v3__fillcap_16
XFILLER_24_139 VDD VDD VSS VSS gf180mcu_as_sc_mcu7t3v3__fill_1
XFILLER_24_14 VDD VDD VSS VSS gf180mcu_as_sc_mcu7t3v3__fillcap_16
XFILLER_24_170 VDD VDD VSS VSS gf180mcu_as_sc_mcu7t3v3__fillcap_4
XFILLER_24_174 VDD VDD VSS VSS gf180mcu_as_sc_mcu7t3v3__fill_1
XFILLER_24_201 VDD VDD VSS VSS gf180mcu_as_sc_mcu7t3v3__fillcap_16
XFILLER_24_217 VDD VDD VSS VSS gf180mcu_as_sc_mcu7t3v3__fillcap_4
XFILLER_24_221 VDD VDD VSS VSS gf180mcu_as_sc_mcu7t3v3__fill_2
XFILLER_24_235 VDD VDD VSS VSS gf180mcu_as_sc_mcu7t3v3__fillcap_8
XFILLER_24_243 VDD VDD VSS VSS gf180mcu_as_sc_mcu7t3v3__fill_2
XFILLER_24_247 VDD VDD VSS VSS gf180mcu_as_sc_mcu7t3v3__fillcap_16
XFILLER_24_263 VDD VDD VSS VSS gf180mcu_as_sc_mcu7t3v3__fillcap_8
XFILLER_24_271 VDD VDD VSS VSS gf180mcu_as_sc_mcu7t3v3__fillcap_4
XFILLER_24_275 VDD VDD VSS VSS gf180mcu_as_sc_mcu7t3v3__fill_2
XFILLER_24_30 VDD VDD VSS VSS gf180mcu_as_sc_mcu7t3v3__fill_1
XFILLER_24_37 VDD VDD VSS VSS gf180mcu_as_sc_mcu7t3v3__fillcap_16
XFILLER_24_53 VDD VDD VSS VSS gf180mcu_as_sc_mcu7t3v3__fillcap_16
XFILLER_24_69 VDD VDD VSS VSS gf180mcu_as_sc_mcu7t3v3__fillcap_16
XFILLER_24_85 VDD VDD VSS VSS gf180mcu_as_sc_mcu7t3v3__fillcap_16
XFILLER_25_104 VDD VDD VSS VSS gf180mcu_as_sc_mcu7t3v3__fillcap_16
XFILLER_25_120 VDD VDD VSS VSS gf180mcu_as_sc_mcu7t3v3__fillcap_16
XFILLER_25_136 VDD VDD VSS VSS gf180mcu_as_sc_mcu7t3v3__fillcap_4
XFILLER_25_14 VDD VDD VSS VSS gf180mcu_as_sc_mcu7t3v3__fillcap_4
XFILLER_25_142 VDD VDD VSS VSS gf180mcu_as_sc_mcu7t3v3__fillcap_16
XFILLER_25_158 VDD VDD VSS VSS gf180mcu_as_sc_mcu7t3v3__fillcap_4
XFILLER_25_162 VDD VDD VSS VSS gf180mcu_as_sc_mcu7t3v3__fill_1
XFILLER_25_175 VDD VDD VSS VSS gf180mcu_as_sc_mcu7t3v3__fillcap_16
XFILLER_25_191 VDD VDD VSS VSS gf180mcu_as_sc_mcu7t3v3__fillcap_4
XFILLER_25_207 VDD VDD VSS VSS gf180mcu_as_sc_mcu7t3v3__fill_2
XFILLER_25_209 VDD VDD VSS VSS gf180mcu_as_sc_mcu7t3v3__fill_1
XFILLER_25_212 VDD VDD VSS VSS gf180mcu_as_sc_mcu7t3v3__fillcap_8
XFILLER_25_22 VDD VDD VSS VSS gf180mcu_as_sc_mcu7t3v3__fillcap_4
XFILLER_25_220 VDD VDD VSS VSS gf180mcu_as_sc_mcu7t3v3__fill_2
XFILLER_25_234 VDD VDD VSS VSS gf180mcu_as_sc_mcu7t3v3__fillcap_16
XFILLER_25_250 VDD VDD VSS VSS gf180mcu_as_sc_mcu7t3v3__fillcap_16
XFILLER_25_26 VDD VDD VSS VSS gf180mcu_as_sc_mcu7t3v3__fill_2
XFILLER_25_266 VDD VDD VSS VSS gf180mcu_as_sc_mcu7t3v3__fillcap_8
XFILLER_25_274 VDD VDD VSS VSS gf180mcu_as_sc_mcu7t3v3__fill_2
XFILLER_25_276 VDD VDD VSS VSS gf180mcu_as_sc_mcu7t3v3__fill_1
XFILLER_25_43 VDD VDD VSS VSS gf180mcu_as_sc_mcu7t3v3__fillcap_16
XFILLER_25_59 VDD VDD VSS VSS gf180mcu_as_sc_mcu7t3v3__fillcap_8
XFILLER_25_67 VDD VDD VSS VSS gf180mcu_as_sc_mcu7t3v3__fill_2
XFILLER_25_69 VDD VDD VSS VSS gf180mcu_as_sc_mcu7t3v3__fill_1
XFILLER_25_72 VDD VDD VSS VSS gf180mcu_as_sc_mcu7t3v3__fillcap_16
XFILLER_25_88 VDD VDD VSS VSS gf180mcu_as_sc_mcu7t3v3__fillcap_16
XFILLER_26_104 VDD VDD VSS VSS gf180mcu_as_sc_mcu7t3v3__fill_1
XFILLER_26_107 VDD VDD VSS VSS gf180mcu_as_sc_mcu7t3v3__fillcap_16
XFILLER_26_123 VDD VDD VSS VSS gf180mcu_as_sc_mcu7t3v3__fillcap_16
XFILLER_26_139 VDD VDD VSS VSS gf180mcu_as_sc_mcu7t3v3__fillcap_16
XFILLER_26_14 VDD VDD VSS VSS gf180mcu_as_sc_mcu7t3v3__fill_1
XFILLER_26_155 VDD VDD VSS VSS gf180mcu_as_sc_mcu7t3v3__fillcap_16
XFILLER_26_171 VDD VDD VSS VSS gf180mcu_as_sc_mcu7t3v3__fillcap_4
XFILLER_26_177 VDD VDD VSS VSS gf180mcu_as_sc_mcu7t3v3__fillcap_16
XFILLER_26_193 VDD VDD VSS VSS gf180mcu_as_sc_mcu7t3v3__fillcap_4
XFILLER_26_197 VDD VDD VSS VSS gf180mcu_as_sc_mcu7t3v3__fill_1
XFILLER_26_204 VDD VDD VSS VSS gf180mcu_as_sc_mcu7t3v3__fillcap_16
XFILLER_26_220 VDD VDD VSS VSS gf180mcu_as_sc_mcu7t3v3__fill_1
XFILLER_26_239 VDD VDD VSS VSS gf180mcu_as_sc_mcu7t3v3__fillcap_4
XFILLER_26_243 VDD VDD VSS VSS gf180mcu_as_sc_mcu7t3v3__fill_2
XFILLER_26_247 VDD VDD VSS VSS gf180mcu_as_sc_mcu7t3v3__fillcap_16
XFILLER_26_26 VDD VDD VSS VSS gf180mcu_as_sc_mcu7t3v3__fillcap_8
XFILLER_26_263 VDD VDD VSS VSS gf180mcu_as_sc_mcu7t3v3__fillcap_8
XFILLER_26_271 VDD VDD VSS VSS gf180mcu_as_sc_mcu7t3v3__fillcap_4
XFILLER_26_275 VDD VDD VSS VSS gf180mcu_as_sc_mcu7t3v3__fill_2
XFILLER_26_34 VDD VDD VSS VSS gf180mcu_as_sc_mcu7t3v3__fill_1
XFILLER_26_48 VDD VDD VSS VSS gf180mcu_as_sc_mcu7t3v3__fillcap_16
XFILLER_26_64 VDD VDD VSS VSS gf180mcu_as_sc_mcu7t3v3__fillcap_16
XFILLER_26_80 VDD VDD VSS VSS gf180mcu_as_sc_mcu7t3v3__fillcap_16
XFILLER_26_96 VDD VDD VSS VSS gf180mcu_as_sc_mcu7t3v3__fillcap_8
XFILLER_27_104 VDD VDD VSS VSS gf180mcu_as_sc_mcu7t3v3__fillcap_16
XFILLER_27_120 VDD VDD VSS VSS gf180mcu_as_sc_mcu7t3v3__fillcap_16
XFILLER_27_136 VDD VDD VSS VSS gf180mcu_as_sc_mcu7t3v3__fillcap_4
XFILLER_27_142 VDD VDD VSS VSS gf180mcu_as_sc_mcu7t3v3__fillcap_16
XFILLER_27_158 VDD VDD VSS VSS gf180mcu_as_sc_mcu7t3v3__fillcap_8
XFILLER_27_166 VDD VDD VSS VSS gf180mcu_as_sc_mcu7t3v3__fillcap_4
XFILLER_27_176 VDD VDD VSS VSS gf180mcu_as_sc_mcu7t3v3__fillcap_8
XFILLER_27_18 VDD VDD VSS VSS gf180mcu_as_sc_mcu7t3v3__fillcap_16
XFILLER_27_184 VDD VDD VSS VSS gf180mcu_as_sc_mcu7t3v3__fillcap_4
XFILLER_27_194 VDD VDD VSS VSS gf180mcu_as_sc_mcu7t3v3__fillcap_4
XFILLER_27_2 VDD VDD VSS VSS gf180mcu_as_sc_mcu7t3v3__fill_1
XFILLER_27_212 VDD VDD VSS VSS gf180mcu_as_sc_mcu7t3v3__fillcap_8
XFILLER_27_220 VDD VDD VSS VSS gf180mcu_as_sc_mcu7t3v3__fill_1
XFILLER_27_239 VDD VDD VSS VSS gf180mcu_as_sc_mcu7t3v3__fillcap_16
XFILLER_27_255 VDD VDD VSS VSS gf180mcu_as_sc_mcu7t3v3__fillcap_16
XFILLER_27_271 VDD VDD VSS VSS gf180mcu_as_sc_mcu7t3v3__fillcap_4
XFILLER_27_275 VDD VDD VSS VSS gf180mcu_as_sc_mcu7t3v3__fill_2
XFILLER_27_34 VDD VDD VSS VSS gf180mcu_as_sc_mcu7t3v3__fillcap_16
XFILLER_27_50 VDD VDD VSS VSS gf180mcu_as_sc_mcu7t3v3__fillcap_16
XFILLER_27_66 VDD VDD VSS VSS gf180mcu_as_sc_mcu7t3v3__fillcap_4
XFILLER_27_72 VDD VDD VSS VSS gf180mcu_as_sc_mcu7t3v3__fillcap_16
XFILLER_27_88 VDD VDD VSS VSS gf180mcu_as_sc_mcu7t3v3__fillcap_16
XFILLER_28_107 VDD VDD VSS VSS gf180mcu_as_sc_mcu7t3v3__fillcap_16
XFILLER_28_123 VDD VDD VSS VSS gf180mcu_as_sc_mcu7t3v3__fillcap_16
XFILLER_28_139 VDD VDD VSS VSS gf180mcu_as_sc_mcu7t3v3__fillcap_16
XFILLER_28_155 VDD VDD VSS VSS gf180mcu_as_sc_mcu7t3v3__fill_2
XFILLER_28_2 VDD VDD VSS VSS gf180mcu_as_sc_mcu7t3v3__fill_1
XFILLER_28_207 VDD VDD VSS VSS gf180mcu_as_sc_mcu7t3v3__fillcap_16
XFILLER_28_223 VDD VDD VSS VSS gf180mcu_as_sc_mcu7t3v3__fillcap_4
XFILLER_28_239 VDD VDD VSS VSS gf180mcu_as_sc_mcu7t3v3__fillcap_4
XFILLER_28_243 VDD VDD VSS VSS gf180mcu_as_sc_mcu7t3v3__fill_2
XFILLER_28_247 VDD VDD VSS VSS gf180mcu_as_sc_mcu7t3v3__fillcap_16
XFILLER_28_263 VDD VDD VSS VSS gf180mcu_as_sc_mcu7t3v3__fillcap_8
XFILLER_28_271 VDD VDD VSS VSS gf180mcu_as_sc_mcu7t3v3__fillcap_4
XFILLER_28_275 VDD VDD VSS VSS gf180mcu_as_sc_mcu7t3v3__fill_2
XFILLER_28_41 VDD VDD VSS VSS gf180mcu_as_sc_mcu7t3v3__fillcap_16
XFILLER_28_57 VDD VDD VSS VSS gf180mcu_as_sc_mcu7t3v3__fillcap_16
XFILLER_28_73 VDD VDD VSS VSS gf180mcu_as_sc_mcu7t3v3__fillcap_16
XFILLER_28_89 VDD VDD VSS VSS gf180mcu_as_sc_mcu7t3v3__fillcap_16
XFILLER_29_104 VDD VDD VSS VSS gf180mcu_as_sc_mcu7t3v3__fillcap_16
XFILLER_29_120 VDD VDD VSS VSS gf180mcu_as_sc_mcu7t3v3__fillcap_16
XFILLER_29_136 VDD VDD VSS VSS gf180mcu_as_sc_mcu7t3v3__fillcap_4
XFILLER_29_142 VDD VDD VSS VSS gf180mcu_as_sc_mcu7t3v3__fillcap_4
XFILLER_29_146 VDD VDD VSS VSS gf180mcu_as_sc_mcu7t3v3__fill_1
XFILLER_29_171 VDD VDD VSS VSS gf180mcu_as_sc_mcu7t3v3__fillcap_16
XFILLER_29_18 VDD VDD VSS VSS gf180mcu_as_sc_mcu7t3v3__fillcap_16
XFILLER_29_187 VDD VDD VSS VSS gf180mcu_as_sc_mcu7t3v3__fillcap_4
XFILLER_29_191 VDD VDD VSS VSS gf180mcu_as_sc_mcu7t3v3__fill_2
XFILLER_29_193 VDD VDD VSS VSS gf180mcu_as_sc_mcu7t3v3__fill_1
XFILLER_29_2 VDD VDD VSS VSS gf180mcu_as_sc_mcu7t3v3__fill_1
XFILLER_29_206 VDD VDD VSS VSS gf180mcu_as_sc_mcu7t3v3__fillcap_4
XFILLER_29_212 VDD VDD VSS VSS gf180mcu_as_sc_mcu7t3v3__fillcap_16
XFILLER_29_228 VDD VDD VSS VSS gf180mcu_as_sc_mcu7t3v3__fill_1
XFILLER_29_241 VDD VDD VSS VSS gf180mcu_as_sc_mcu7t3v3__fillcap_16
XFILLER_29_257 VDD VDD VSS VSS gf180mcu_as_sc_mcu7t3v3__fillcap_16
XFILLER_29_273 VDD VDD VSS VSS gf180mcu_as_sc_mcu7t3v3__fillcap_4
XFILLER_29_34 VDD VDD VSS VSS gf180mcu_as_sc_mcu7t3v3__fillcap_16
XFILLER_29_50 VDD VDD VSS VSS gf180mcu_as_sc_mcu7t3v3__fillcap_16
XFILLER_29_66 VDD VDD VSS VSS gf180mcu_as_sc_mcu7t3v3__fillcap_4
XFILLER_29_72 VDD VDD VSS VSS gf180mcu_as_sc_mcu7t3v3__fillcap_16
XFILLER_29_88 VDD VDD VSS VSS gf180mcu_as_sc_mcu7t3v3__fillcap_16
XFILLER_2_101 VDD VDD VSS VSS gf180mcu_as_sc_mcu7t3v3__fillcap_4
XFILLER_2_107 VDD VDD VSS VSS gf180mcu_as_sc_mcu7t3v3__fillcap_16
XFILLER_2_123 VDD VDD VSS VSS gf180mcu_as_sc_mcu7t3v3__fillcap_16
XFILLER_2_139 VDD VDD VSS VSS gf180mcu_as_sc_mcu7t3v3__fillcap_8
XFILLER_2_147 VDD VDD VSS VSS gf180mcu_as_sc_mcu7t3v3__fillcap_4
XFILLER_2_166 VDD VDD VSS VSS gf180mcu_as_sc_mcu7t3v3__fill_2
XFILLER_2_172 VDD VDD VSS VSS gf180mcu_as_sc_mcu7t3v3__fill_2
XFILLER_2_174 VDD VDD VSS VSS gf180mcu_as_sc_mcu7t3v3__fill_1
XFILLER_2_177 VDD VDD VSS VSS gf180mcu_as_sc_mcu7t3v3__fillcap_8
XFILLER_2_18 VDD VDD VSS VSS gf180mcu_as_sc_mcu7t3v3__fillcap_16
XFILLER_2_185 VDD VDD VSS VSS gf180mcu_as_sc_mcu7t3v3__fillcap_4
XFILLER_2_189 VDD VDD VSS VSS gf180mcu_as_sc_mcu7t3v3__fill_2
XFILLER_2_191 VDD VDD VSS VSS gf180mcu_as_sc_mcu7t3v3__fill_1
XFILLER_2_2 VDD VDD VSS VSS gf180mcu_as_sc_mcu7t3v3__fillcap_16
XFILLER_2_218 VDD VDD VSS VSS gf180mcu_as_sc_mcu7t3v3__fill_2
XFILLER_2_230 VDD VDD VSS VSS gf180mcu_as_sc_mcu7t3v3__fill_1
XFILLER_2_241 VDD VDD VSS VSS gf180mcu_as_sc_mcu7t3v3__fillcap_4
XFILLER_2_264 VDD VDD VSS VSS gf180mcu_as_sc_mcu7t3v3__fillcap_8
XFILLER_2_272 VDD VDD VSS VSS gf180mcu_as_sc_mcu7t3v3__fillcap_4
XFILLER_2_276 VDD VDD VSS VSS gf180mcu_as_sc_mcu7t3v3__fill_1
XFILLER_2_34 VDD VDD VSS VSS gf180mcu_as_sc_mcu7t3v3__fill_1
XFILLER_2_37 VDD VDD VSS VSS gf180mcu_as_sc_mcu7t3v3__fillcap_16
XFILLER_2_53 VDD VDD VSS VSS gf180mcu_as_sc_mcu7t3v3__fillcap_16
XFILLER_2_69 VDD VDD VSS VSS gf180mcu_as_sc_mcu7t3v3__fillcap_16
XFILLER_2_85 VDD VDD VSS VSS gf180mcu_as_sc_mcu7t3v3__fillcap_16
XFILLER_30_101 VDD VDD VSS VSS gf180mcu_as_sc_mcu7t3v3__fillcap_4
XFILLER_30_107 VDD VDD VSS VSS gf180mcu_as_sc_mcu7t3v3__fillcap_16
XFILLER_30_123 VDD VDD VSS VSS gf180mcu_as_sc_mcu7t3v3__fillcap_16
XFILLER_30_139 VDD VDD VSS VSS gf180mcu_as_sc_mcu7t3v3__fillcap_4
XFILLER_30_143 VDD VDD VSS VSS gf180mcu_as_sc_mcu7t3v3__fill_1
XFILLER_30_156 VDD VDD VSS VSS gf180mcu_as_sc_mcu7t3v3__fillcap_16
XFILLER_30_172 VDD VDD VSS VSS gf180mcu_as_sc_mcu7t3v3__fill_2
XFILLER_30_174 VDD VDD VSS VSS gf180mcu_as_sc_mcu7t3v3__fill_1
XFILLER_30_177 VDD VDD VSS VSS gf180mcu_as_sc_mcu7t3v3__fillcap_16
XFILLER_30_18 VDD VDD VSS VSS gf180mcu_as_sc_mcu7t3v3__fillcap_16
XFILLER_30_193 VDD VDD VSS VSS gf180mcu_as_sc_mcu7t3v3__fillcap_16
XFILLER_30_209 VDD VDD VSS VSS gf180mcu_as_sc_mcu7t3v3__fillcap_16
XFILLER_30_225 VDD VDD VSS VSS gf180mcu_as_sc_mcu7t3v3__fillcap_4
XFILLER_30_229 VDD VDD VSS VSS gf180mcu_as_sc_mcu7t3v3__fill_2
XFILLER_30_231 VDD VDD VSS VSS gf180mcu_as_sc_mcu7t3v3__fill_1
XFILLER_30_244 VDD VDD VSS VSS gf180mcu_as_sc_mcu7t3v3__fill_1
XFILLER_30_247 VDD VDD VSS VSS gf180mcu_as_sc_mcu7t3v3__fillcap_16
XFILLER_30_263 VDD VDD VSS VSS gf180mcu_as_sc_mcu7t3v3__fillcap_8
XFILLER_30_271 VDD VDD VSS VSS gf180mcu_as_sc_mcu7t3v3__fillcap_4
XFILLER_30_275 VDD VDD VSS VSS gf180mcu_as_sc_mcu7t3v3__fill_2
XFILLER_30_34 VDD VDD VSS VSS gf180mcu_as_sc_mcu7t3v3__fill_1
XFILLER_30_37 VDD VDD VSS VSS gf180mcu_as_sc_mcu7t3v3__fillcap_16
XFILLER_30_53 VDD VDD VSS VSS gf180mcu_as_sc_mcu7t3v3__fillcap_16
XFILLER_30_69 VDD VDD VSS VSS gf180mcu_as_sc_mcu7t3v3__fillcap_16
XFILLER_30_85 VDD VDD VSS VSS gf180mcu_as_sc_mcu7t3v3__fillcap_16
XFILLER_31_104 VDD VDD VSS VSS gf180mcu_as_sc_mcu7t3v3__fillcap_16
XFILLER_31_120 VDD VDD VSS VSS gf180mcu_as_sc_mcu7t3v3__fillcap_16
XFILLER_31_136 VDD VDD VSS VSS gf180mcu_as_sc_mcu7t3v3__fillcap_4
XFILLER_31_142 VDD VDD VSS VSS gf180mcu_as_sc_mcu7t3v3__fillcap_8
XFILLER_31_156 VDD VDD VSS VSS gf180mcu_as_sc_mcu7t3v3__fillcap_16
XFILLER_31_172 VDD VDD VSS VSS gf180mcu_as_sc_mcu7t3v3__fillcap_16
XFILLER_31_188 VDD VDD VSS VSS gf180mcu_as_sc_mcu7t3v3__fill_2
XFILLER_31_208 VDD VDD VSS VSS gf180mcu_as_sc_mcu7t3v3__fill_2
XFILLER_31_218 VDD VDD VSS VSS gf180mcu_as_sc_mcu7t3v3__fillcap_4
XFILLER_31_222 VDD VDD VSS VSS gf180mcu_as_sc_mcu7t3v3__fill_2
XFILLER_31_224 VDD VDD VSS VSS gf180mcu_as_sc_mcu7t3v3__fill_1
XFILLER_31_23 VDD VDD VSS VSS gf180mcu_as_sc_mcu7t3v3__fillcap_16
XFILLER_31_231 VDD VDD VSS VSS gf180mcu_as_sc_mcu7t3v3__fillcap_4
XFILLER_31_247 VDD VDD VSS VSS gf180mcu_as_sc_mcu7t3v3__fillcap_16
XFILLER_31_263 VDD VDD VSS VSS gf180mcu_as_sc_mcu7t3v3__fillcap_8
XFILLER_31_271 VDD VDD VSS VSS gf180mcu_as_sc_mcu7t3v3__fillcap_4
XFILLER_31_275 VDD VDD VSS VSS gf180mcu_as_sc_mcu7t3v3__fill_2
XFILLER_31_39 VDD VDD VSS VSS gf180mcu_as_sc_mcu7t3v3__fillcap_16
XFILLER_31_55 VDD VDD VSS VSS gf180mcu_as_sc_mcu7t3v3__fillcap_8
XFILLER_31_63 VDD VDD VSS VSS gf180mcu_as_sc_mcu7t3v3__fillcap_4
XFILLER_31_67 VDD VDD VSS VSS gf180mcu_as_sc_mcu7t3v3__fill_2
XFILLER_31_69 VDD VDD VSS VSS gf180mcu_as_sc_mcu7t3v3__fill_1
XFILLER_31_72 VDD VDD VSS VSS gf180mcu_as_sc_mcu7t3v3__fillcap_16
XFILLER_31_88 VDD VDD VSS VSS gf180mcu_as_sc_mcu7t3v3__fillcap_16
XFILLER_32_101 VDD VDD VSS VSS gf180mcu_as_sc_mcu7t3v3__fillcap_4
XFILLER_32_107 VDD VDD VSS VSS gf180mcu_as_sc_mcu7t3v3__fillcap_8
XFILLER_32_115 VDD VDD VSS VSS gf180mcu_as_sc_mcu7t3v3__fill_2
XFILLER_32_121 VDD VDD VSS VSS gf180mcu_as_sc_mcu7t3v3__fillcap_4
XFILLER_32_129 VDD VDD VSS VSS gf180mcu_as_sc_mcu7t3v3__fillcap_16
XFILLER_32_145 VDD VDD VSS VSS gf180mcu_as_sc_mcu7t3v3__fillcap_4
XFILLER_32_149 VDD VDD VSS VSS gf180mcu_as_sc_mcu7t3v3__fill_2
XFILLER_32_177 VDD VDD VSS VSS gf180mcu_as_sc_mcu7t3v3__fill_2
XFILLER_32_247 VDD VDD VSS VSS gf180mcu_as_sc_mcu7t3v3__fillcap_16
XFILLER_32_263 VDD VDD VSS VSS gf180mcu_as_sc_mcu7t3v3__fillcap_8
XFILLER_32_271 VDD VDD VSS VSS gf180mcu_as_sc_mcu7t3v3__fillcap_4
XFILLER_32_275 VDD VDD VSS VSS gf180mcu_as_sc_mcu7t3v3__fill_2
XFILLER_32_29 VDD VDD VSS VSS gf180mcu_as_sc_mcu7t3v3__fillcap_4
XFILLER_32_33 VDD VDD VSS VSS gf180mcu_as_sc_mcu7t3v3__fill_2
XFILLER_32_37 VDD VDD VSS VSS gf180mcu_as_sc_mcu7t3v3__fillcap_16
XFILLER_32_53 VDD VDD VSS VSS gf180mcu_as_sc_mcu7t3v3__fillcap_16
XFILLER_32_69 VDD VDD VSS VSS gf180mcu_as_sc_mcu7t3v3__fillcap_16
XFILLER_32_85 VDD VDD VSS VSS gf180mcu_as_sc_mcu7t3v3__fillcap_16
XFILLER_33_104 VDD VDD VSS VSS gf180mcu_as_sc_mcu7t3v3__fillcap_4
XFILLER_33_108 VDD VDD VSS VSS gf180mcu_as_sc_mcu7t3v3__fill_2
XFILLER_33_132 VDD VDD VSS VSS gf180mcu_as_sc_mcu7t3v3__fillcap_8
XFILLER_33_142 VDD VDD VSS VSS gf180mcu_as_sc_mcu7t3v3__fillcap_8
XFILLER_33_150 VDD VDD VSS VSS gf180mcu_as_sc_mcu7t3v3__fillcap_4
XFILLER_33_184 VDD VDD VSS VSS gf180mcu_as_sc_mcu7t3v3__fillcap_16
XFILLER_33_200 VDD VDD VSS VSS gf180mcu_as_sc_mcu7t3v3__fillcap_8
XFILLER_33_208 VDD VDD VSS VSS gf180mcu_as_sc_mcu7t3v3__fill_2
XFILLER_33_212 VDD VDD VSS VSS gf180mcu_as_sc_mcu7t3v3__fill_2
XFILLER_33_220 VDD VDD VSS VSS gf180mcu_as_sc_mcu7t3v3__fillcap_8
XFILLER_33_228 VDD VDD VSS VSS gf180mcu_as_sc_mcu7t3v3__fill_2
XFILLER_33_23 VDD VDD VSS VSS gf180mcu_as_sc_mcu7t3v3__fillcap_16
XFILLER_33_230 VDD VDD VSS VSS gf180mcu_as_sc_mcu7t3v3__fill_1
XFILLER_33_243 VDD VDD VSS VSS gf180mcu_as_sc_mcu7t3v3__fillcap_16
XFILLER_33_259 VDD VDD VSS VSS gf180mcu_as_sc_mcu7t3v3__fillcap_16
XFILLER_33_275 VDD VDD VSS VSS gf180mcu_as_sc_mcu7t3v3__fill_2
XFILLER_33_39 VDD VDD VSS VSS gf180mcu_as_sc_mcu7t3v3__fillcap_16
XFILLER_33_55 VDD VDD VSS VSS gf180mcu_as_sc_mcu7t3v3__fillcap_8
XFILLER_33_63 VDD VDD VSS VSS gf180mcu_as_sc_mcu7t3v3__fillcap_4
XFILLER_33_67 VDD VDD VSS VSS gf180mcu_as_sc_mcu7t3v3__fill_2
XFILLER_33_69 VDD VDD VSS VSS gf180mcu_as_sc_mcu7t3v3__fill_1
XFILLER_33_72 VDD VDD VSS VSS gf180mcu_as_sc_mcu7t3v3__fillcap_16
XFILLER_33_88 VDD VDD VSS VSS gf180mcu_as_sc_mcu7t3v3__fillcap_16
XFILLER_34_101 VDD VDD VSS VSS gf180mcu_as_sc_mcu7t3v3__fillcap_4
XFILLER_34_107 VDD VDD VSS VSS gf180mcu_as_sc_mcu7t3v3__fill_2
XFILLER_34_109 VDD VDD VSS VSS gf180mcu_as_sc_mcu7t3v3__fill_1
XFILLER_34_121 VDD VDD VSS VSS gf180mcu_as_sc_mcu7t3v3__fillcap_16
XFILLER_34_137 VDD VDD VSS VSS gf180mcu_as_sc_mcu7t3v3__fillcap_16
XFILLER_34_153 VDD VDD VSS VSS gf180mcu_as_sc_mcu7t3v3__fillcap_16
XFILLER_34_169 VDD VDD VSS VSS gf180mcu_as_sc_mcu7t3v3__fillcap_4
XFILLER_34_173 VDD VDD VSS VSS gf180mcu_as_sc_mcu7t3v3__fill_2
XFILLER_34_177 VDD VDD VSS VSS gf180mcu_as_sc_mcu7t3v3__fillcap_16
XFILLER_34_18 VDD VDD VSS VSS gf180mcu_as_sc_mcu7t3v3__fillcap_16
XFILLER_34_193 VDD VDD VSS VSS gf180mcu_as_sc_mcu7t3v3__fillcap_16
XFILLER_34_2 VDD VDD VSS VSS gf180mcu_as_sc_mcu7t3v3__fillcap_4
XFILLER_34_209 VDD VDD VSS VSS gf180mcu_as_sc_mcu7t3v3__fillcap_16
XFILLER_34_225 VDD VDD VSS VSS gf180mcu_as_sc_mcu7t3v3__fillcap_16
XFILLER_34_241 VDD VDD VSS VSS gf180mcu_as_sc_mcu7t3v3__fillcap_4
XFILLER_34_247 VDD VDD VSS VSS gf180mcu_as_sc_mcu7t3v3__fillcap_16
XFILLER_34_263 VDD VDD VSS VSS gf180mcu_as_sc_mcu7t3v3__fillcap_8
XFILLER_34_271 VDD VDD VSS VSS gf180mcu_as_sc_mcu7t3v3__fillcap_4
XFILLER_34_275 VDD VDD VSS VSS gf180mcu_as_sc_mcu7t3v3__fill_2
XFILLER_34_34 VDD VDD VSS VSS gf180mcu_as_sc_mcu7t3v3__fill_1
XFILLER_34_37 VDD VDD VSS VSS gf180mcu_as_sc_mcu7t3v3__fillcap_16
XFILLER_34_53 VDD VDD VSS VSS gf180mcu_as_sc_mcu7t3v3__fillcap_16
XFILLER_34_6 VDD VDD VSS VSS gf180mcu_as_sc_mcu7t3v3__fill_1
XFILLER_34_69 VDD VDD VSS VSS gf180mcu_as_sc_mcu7t3v3__fillcap_16
XFILLER_34_85 VDD VDD VSS VSS gf180mcu_as_sc_mcu7t3v3__fillcap_16
XFILLER_35_104 VDD VDD VSS VSS gf180mcu_as_sc_mcu7t3v3__fillcap_8
XFILLER_35_112 VDD VDD VSS VSS gf180mcu_as_sc_mcu7t3v3__fill_2
XFILLER_35_118 VDD VDD VSS VSS gf180mcu_as_sc_mcu7t3v3__fillcap_8
XFILLER_35_126 VDD VDD VSS VSS gf180mcu_as_sc_mcu7t3v3__fill_1
XFILLER_35_131 VDD VDD VSS VSS gf180mcu_as_sc_mcu7t3v3__fillcap_4
XFILLER_35_139 VDD VDD VSS VSS gf180mcu_as_sc_mcu7t3v3__fill_1
XFILLER_35_146 VDD VDD VSS VSS gf180mcu_as_sc_mcu7t3v3__fillcap_16
XFILLER_35_162 VDD VDD VSS VSS gf180mcu_as_sc_mcu7t3v3__fillcap_16
XFILLER_35_178 VDD VDD VSS VSS gf180mcu_as_sc_mcu7t3v3__fillcap_16
XFILLER_35_194 VDD VDD VSS VSS gf180mcu_as_sc_mcu7t3v3__fillcap_16
XFILLER_35_212 VDD VDD VSS VSS gf180mcu_as_sc_mcu7t3v3__fillcap_16
XFILLER_35_228 VDD VDD VSS VSS gf180mcu_as_sc_mcu7t3v3__fillcap_16
XFILLER_35_24 VDD VDD VSS VSS gf180mcu_as_sc_mcu7t3v3__fillcap_16
XFILLER_35_244 VDD VDD VSS VSS gf180mcu_as_sc_mcu7t3v3__fillcap_16
XFILLER_35_260 VDD VDD VSS VSS gf180mcu_as_sc_mcu7t3v3__fillcap_16
XFILLER_35_276 VDD VDD VSS VSS gf180mcu_as_sc_mcu7t3v3__fill_1
XFILLER_35_40 VDD VDD VSS VSS gf180mcu_as_sc_mcu7t3v3__fillcap_16
XFILLER_35_56 VDD VDD VSS VSS gf180mcu_as_sc_mcu7t3v3__fillcap_8
XFILLER_35_64 VDD VDD VSS VSS gf180mcu_as_sc_mcu7t3v3__fillcap_4
XFILLER_35_68 VDD VDD VSS VSS gf180mcu_as_sc_mcu7t3v3__fill_2
XFILLER_35_72 VDD VDD VSS VSS gf180mcu_as_sc_mcu7t3v3__fillcap_4
XFILLER_35_76 VDD VDD VSS VSS gf180mcu_as_sc_mcu7t3v3__fill_2
XFILLER_35_8 VDD VDD VSS VSS gf180mcu_as_sc_mcu7t3v3__fillcap_16
XFILLER_35_95 VDD VDD VSS VSS gf180mcu_as_sc_mcu7t3v3__fillcap_4
XFILLER_35_99 VDD VDD VSS VSS gf180mcu_as_sc_mcu7t3v3__fill_1
XFILLER_36_121 VDD VDD VSS VSS gf180mcu_as_sc_mcu7t3v3__fill_2
XFILLER_36_129 VDD VDD VSS VSS gf180mcu_as_sc_mcu7t3v3__fill_1
XFILLER_36_152 VDD VDD VSS VSS gf180mcu_as_sc_mcu7t3v3__fillcap_16
XFILLER_36_168 VDD VDD VSS VSS gf180mcu_as_sc_mcu7t3v3__fillcap_4
XFILLER_36_172 VDD VDD VSS VSS gf180mcu_as_sc_mcu7t3v3__fill_2
XFILLER_36_174 VDD VDD VSS VSS gf180mcu_as_sc_mcu7t3v3__fill_1
XFILLER_36_177 VDD VDD VSS VSS gf180mcu_as_sc_mcu7t3v3__fillcap_16
XFILLER_36_18 VDD VDD VSS VSS gf180mcu_as_sc_mcu7t3v3__fillcap_16
XFILLER_36_193 VDD VDD VSS VSS gf180mcu_as_sc_mcu7t3v3__fillcap_16
XFILLER_36_2 VDD VDD VSS VSS gf180mcu_as_sc_mcu7t3v3__fillcap_16
XFILLER_36_209 VDD VDD VSS VSS gf180mcu_as_sc_mcu7t3v3__fillcap_16
XFILLER_36_225 VDD VDD VSS VSS gf180mcu_as_sc_mcu7t3v3__fillcap_16
XFILLER_36_241 VDD VDD VSS VSS gf180mcu_as_sc_mcu7t3v3__fillcap_4
XFILLER_36_247 VDD VDD VSS VSS gf180mcu_as_sc_mcu7t3v3__fillcap_16
XFILLER_36_263 VDD VDD VSS VSS gf180mcu_as_sc_mcu7t3v3__fillcap_8
XFILLER_36_271 VDD VDD VSS VSS gf180mcu_as_sc_mcu7t3v3__fillcap_4
XFILLER_36_275 VDD VDD VSS VSS gf180mcu_as_sc_mcu7t3v3__fill_2
XFILLER_36_34 VDD VDD VSS VSS gf180mcu_as_sc_mcu7t3v3__fill_1
XFILLER_36_37 VDD VDD VSS VSS gf180mcu_as_sc_mcu7t3v3__fillcap_16
XFILLER_36_53 VDD VDD VSS VSS gf180mcu_as_sc_mcu7t3v3__fillcap_16
XFILLER_36_69 VDD VDD VSS VSS gf180mcu_as_sc_mcu7t3v3__fill_2
XFILLER_36_71 VDD VDD VSS VSS gf180mcu_as_sc_mcu7t3v3__fill_1
XFILLER_36_93 VDD VDD VSS VSS gf180mcu_as_sc_mcu7t3v3__fill_1
XFILLER_37_142 VDD VDD VSS VSS gf180mcu_as_sc_mcu7t3v3__fill_1
XFILLER_37_158 VDD VDD VSS VSS gf180mcu_as_sc_mcu7t3v3__fillcap_16
XFILLER_37_174 VDD VDD VSS VSS gf180mcu_as_sc_mcu7t3v3__fillcap_16
XFILLER_37_18 VDD VDD VSS VSS gf180mcu_as_sc_mcu7t3v3__fillcap_16
XFILLER_37_190 VDD VDD VSS VSS gf180mcu_as_sc_mcu7t3v3__fillcap_16
XFILLER_37_2 VDD VDD VSS VSS gf180mcu_as_sc_mcu7t3v3__fillcap_16
XFILLER_37_206 VDD VDD VSS VSS gf180mcu_as_sc_mcu7t3v3__fillcap_4
XFILLER_37_212 VDD VDD VSS VSS gf180mcu_as_sc_mcu7t3v3__fillcap_16
XFILLER_37_228 VDD VDD VSS VSS gf180mcu_as_sc_mcu7t3v3__fillcap_16
XFILLER_37_244 VDD VDD VSS VSS gf180mcu_as_sc_mcu7t3v3__fillcap_16
XFILLER_37_260 VDD VDD VSS VSS gf180mcu_as_sc_mcu7t3v3__fillcap_16
XFILLER_37_276 VDD VDD VSS VSS gf180mcu_as_sc_mcu7t3v3__fill_1
XFILLER_37_34 VDD VDD VSS VSS gf180mcu_as_sc_mcu7t3v3__fillcap_16
XFILLER_37_50 VDD VDD VSS VSS gf180mcu_as_sc_mcu7t3v3__fillcap_8
XFILLER_37_58 VDD VDD VSS VSS gf180mcu_as_sc_mcu7t3v3__fillcap_4
XFILLER_37_72 VDD VDD VSS VSS gf180mcu_as_sc_mcu7t3v3__fill_2
XFILLER_37_74 VDD VDD VSS VSS gf180mcu_as_sc_mcu7t3v3__fill_1
XFILLER_38_104 VDD VDD VSS VSS gf180mcu_as_sc_mcu7t3v3__fill_2
XFILLER_38_144 VDD VDD VSS VSS gf180mcu_as_sc_mcu7t3v3__fill_2
XFILLER_38_150 VDD VDD VSS VSS gf180mcu_as_sc_mcu7t3v3__fillcap_16
XFILLER_38_166 VDD VDD VSS VSS gf180mcu_as_sc_mcu7t3v3__fillcap_4
XFILLER_38_172 VDD VDD VSS VSS gf180mcu_as_sc_mcu7t3v3__fillcap_16
XFILLER_38_18 VDD VDD VSS VSS gf180mcu_as_sc_mcu7t3v3__fillcap_16
XFILLER_38_188 VDD VDD VSS VSS gf180mcu_as_sc_mcu7t3v3__fillcap_16
XFILLER_38_2 VDD VDD VSS VSS gf180mcu_as_sc_mcu7t3v3__fillcap_16
XFILLER_38_206 VDD VDD VSS VSS gf180mcu_as_sc_mcu7t3v3__fillcap_16
XFILLER_38_222 VDD VDD VSS VSS gf180mcu_as_sc_mcu7t3v3__fillcap_16
XFILLER_38_240 VDD VDD VSS VSS gf180mcu_as_sc_mcu7t3v3__fillcap_16
XFILLER_38_256 VDD VDD VSS VSS gf180mcu_as_sc_mcu7t3v3__fillcap_16
XFILLER_38_274 VDD VDD VSS VSS gf180mcu_as_sc_mcu7t3v3__fill_2
XFILLER_38_276 VDD VDD VSS VSS gf180mcu_as_sc_mcu7t3v3__fill_1
XFILLER_38_36 VDD VDD VSS VSS gf180mcu_as_sc_mcu7t3v3__fillcap_16
XFILLER_38_52 VDD VDD VSS VSS gf180mcu_as_sc_mcu7t3v3__fillcap_8
XFILLER_38_60 VDD VDD VSS VSS gf180mcu_as_sc_mcu7t3v3__fill_2
XFILLER_38_70 VDD VDD VSS VSS gf180mcu_as_sc_mcu7t3v3__fill_2
XFILLER_38_83 VDD VDD VSS VSS gf180mcu_as_sc_mcu7t3v3__fill_1
XFILLER_3_104 VDD VDD VSS VSS gf180mcu_as_sc_mcu7t3v3__fillcap_16
XFILLER_3_120 VDD VDD VSS VSS gf180mcu_as_sc_mcu7t3v3__fillcap_16
XFILLER_3_136 VDD VDD VSS VSS gf180mcu_as_sc_mcu7t3v3__fillcap_4
XFILLER_3_142 VDD VDD VSS VSS gf180mcu_as_sc_mcu7t3v3__fillcap_16
XFILLER_3_162 VDD VDD VSS VSS gf180mcu_as_sc_mcu7t3v3__fillcap_16
XFILLER_3_178 VDD VDD VSS VSS gf180mcu_as_sc_mcu7t3v3__fillcap_16
XFILLER_3_18 VDD VDD VSS VSS gf180mcu_as_sc_mcu7t3v3__fillcap_16
XFILLER_3_194 VDD VDD VSS VSS gf180mcu_as_sc_mcu7t3v3__fillcap_8
XFILLER_3_2 VDD VDD VSS VSS gf180mcu_as_sc_mcu7t3v3__fillcap_16
XFILLER_3_202 VDD VDD VSS VSS gf180mcu_as_sc_mcu7t3v3__fill_1
XFILLER_3_219 VDD VDD VSS VSS gf180mcu_as_sc_mcu7t3v3__fillcap_4
XFILLER_3_223 VDD VDD VSS VSS gf180mcu_as_sc_mcu7t3v3__fill_2
XFILLER_3_232 VDD VDD VSS VSS gf180mcu_as_sc_mcu7t3v3__fillcap_8
XFILLER_3_247 VDD VDD VSS VSS gf180mcu_as_sc_mcu7t3v3__fill_2
XFILLER_3_249 VDD VDD VSS VSS gf180mcu_as_sc_mcu7t3v3__fill_1
XFILLER_3_267 VDD VDD VSS VSS gf180mcu_as_sc_mcu7t3v3__fillcap_8
XFILLER_3_275 VDD VDD VSS VSS gf180mcu_as_sc_mcu7t3v3__fill_2
XFILLER_3_34 VDD VDD VSS VSS gf180mcu_as_sc_mcu7t3v3__fillcap_16
XFILLER_3_50 VDD VDD VSS VSS gf180mcu_as_sc_mcu7t3v3__fillcap_16
XFILLER_3_66 VDD VDD VSS VSS gf180mcu_as_sc_mcu7t3v3__fillcap_4
XFILLER_3_72 VDD VDD VSS VSS gf180mcu_as_sc_mcu7t3v3__fillcap_16
XFILLER_3_88 VDD VDD VSS VSS gf180mcu_as_sc_mcu7t3v3__fillcap_16
XFILLER_4_101 VDD VDD VSS VSS gf180mcu_as_sc_mcu7t3v3__fillcap_4
XFILLER_4_107 VDD VDD VSS VSS gf180mcu_as_sc_mcu7t3v3__fillcap_16
XFILLER_4_123 VDD VDD VSS VSS gf180mcu_as_sc_mcu7t3v3__fillcap_16
XFILLER_4_139 VDD VDD VSS VSS gf180mcu_as_sc_mcu7t3v3__fillcap_16
XFILLER_4_155 VDD VDD VSS VSS gf180mcu_as_sc_mcu7t3v3__fillcap_16
XFILLER_4_171 VDD VDD VSS VSS gf180mcu_as_sc_mcu7t3v3__fillcap_4
XFILLER_4_177 VDD VDD VSS VSS gf180mcu_as_sc_mcu7t3v3__fillcap_16
XFILLER_4_18 VDD VDD VSS VSS gf180mcu_as_sc_mcu7t3v3__fillcap_16
XFILLER_4_193 VDD VDD VSS VSS gf180mcu_as_sc_mcu7t3v3__fillcap_16
XFILLER_4_2 VDD VDD VSS VSS gf180mcu_as_sc_mcu7t3v3__fillcap_16
XFILLER_4_209 VDD VDD VSS VSS gf180mcu_as_sc_mcu7t3v3__fillcap_16
XFILLER_4_225 VDD VDD VSS VSS gf180mcu_as_sc_mcu7t3v3__fillcap_16
XFILLER_4_241 VDD VDD VSS VSS gf180mcu_as_sc_mcu7t3v3__fillcap_4
XFILLER_4_247 VDD VDD VSS VSS gf180mcu_as_sc_mcu7t3v3__fillcap_8
XFILLER_4_255 VDD VDD VSS VSS gf180mcu_as_sc_mcu7t3v3__fillcap_4
XFILLER_4_266 VDD VDD VSS VSS gf180mcu_as_sc_mcu7t3v3__fillcap_4
XFILLER_4_270 VDD VDD VSS VSS gf180mcu_as_sc_mcu7t3v3__fill_1
XFILLER_4_34 VDD VDD VSS VSS gf180mcu_as_sc_mcu7t3v3__fill_1
XFILLER_4_37 VDD VDD VSS VSS gf180mcu_as_sc_mcu7t3v3__fillcap_16
XFILLER_4_53 VDD VDD VSS VSS gf180mcu_as_sc_mcu7t3v3__fillcap_16
XFILLER_4_69 VDD VDD VSS VSS gf180mcu_as_sc_mcu7t3v3__fillcap_16
XFILLER_4_85 VDD VDD VSS VSS gf180mcu_as_sc_mcu7t3v3__fillcap_16
XFILLER_5_104 VDD VDD VSS VSS gf180mcu_as_sc_mcu7t3v3__fillcap_16
XFILLER_5_120 VDD VDD VSS VSS gf180mcu_as_sc_mcu7t3v3__fillcap_16
XFILLER_5_136 VDD VDD VSS VSS gf180mcu_as_sc_mcu7t3v3__fillcap_4
XFILLER_5_142 VDD VDD VSS VSS gf180mcu_as_sc_mcu7t3v3__fillcap_16
XFILLER_5_158 VDD VDD VSS VSS gf180mcu_as_sc_mcu7t3v3__fillcap_16
XFILLER_5_174 VDD VDD VSS VSS gf180mcu_as_sc_mcu7t3v3__fillcap_16
XFILLER_5_18 VDD VDD VSS VSS gf180mcu_as_sc_mcu7t3v3__fillcap_16
XFILLER_5_190 VDD VDD VSS VSS gf180mcu_as_sc_mcu7t3v3__fillcap_16
XFILLER_5_2 VDD VDD VSS VSS gf180mcu_as_sc_mcu7t3v3__fillcap_16
XFILLER_5_206 VDD VDD VSS VSS gf180mcu_as_sc_mcu7t3v3__fillcap_4
XFILLER_5_212 VDD VDD VSS VSS gf180mcu_as_sc_mcu7t3v3__fillcap_16
XFILLER_5_228 VDD VDD VSS VSS gf180mcu_as_sc_mcu7t3v3__fillcap_16
XFILLER_5_244 VDD VDD VSS VSS gf180mcu_as_sc_mcu7t3v3__fillcap_8
XFILLER_5_252 VDD VDD VSS VSS gf180mcu_as_sc_mcu7t3v3__fillcap_4
XFILLER_5_256 VDD VDD VSS VSS gf180mcu_as_sc_mcu7t3v3__fill_2
XFILLER_5_275 VDD VDD VSS VSS gf180mcu_as_sc_mcu7t3v3__fill_2
XFILLER_5_34 VDD VDD VSS VSS gf180mcu_as_sc_mcu7t3v3__fillcap_16
XFILLER_5_50 VDD VDD VSS VSS gf180mcu_as_sc_mcu7t3v3__fillcap_16
XFILLER_5_66 VDD VDD VSS VSS gf180mcu_as_sc_mcu7t3v3__fillcap_4
XFILLER_5_72 VDD VDD VSS VSS gf180mcu_as_sc_mcu7t3v3__fillcap_16
XFILLER_5_88 VDD VDD VSS VSS gf180mcu_as_sc_mcu7t3v3__fillcap_16
XFILLER_6_101 VDD VDD VSS VSS gf180mcu_as_sc_mcu7t3v3__fillcap_4
XFILLER_6_107 VDD VDD VSS VSS gf180mcu_as_sc_mcu7t3v3__fillcap_16
XFILLER_6_123 VDD VDD VSS VSS gf180mcu_as_sc_mcu7t3v3__fillcap_16
XFILLER_6_139 VDD VDD VSS VSS gf180mcu_as_sc_mcu7t3v3__fillcap_16
XFILLER_6_155 VDD VDD VSS VSS gf180mcu_as_sc_mcu7t3v3__fillcap_16
XFILLER_6_171 VDD VDD VSS VSS gf180mcu_as_sc_mcu7t3v3__fillcap_4
XFILLER_6_177 VDD VDD VSS VSS gf180mcu_as_sc_mcu7t3v3__fillcap_16
XFILLER_6_18 VDD VDD VSS VSS gf180mcu_as_sc_mcu7t3v3__fillcap_16
XFILLER_6_193 VDD VDD VSS VSS gf180mcu_as_sc_mcu7t3v3__fillcap_16
XFILLER_6_2 VDD VDD VSS VSS gf180mcu_as_sc_mcu7t3v3__fillcap_16
XFILLER_6_209 VDD VDD VSS VSS gf180mcu_as_sc_mcu7t3v3__fillcap_16
XFILLER_6_225 VDD VDD VSS VSS gf180mcu_as_sc_mcu7t3v3__fillcap_16
XFILLER_6_241 VDD VDD VSS VSS gf180mcu_as_sc_mcu7t3v3__fillcap_4
XFILLER_6_247 VDD VDD VSS VSS gf180mcu_as_sc_mcu7t3v3__fillcap_8
XFILLER_6_255 VDD VDD VSS VSS gf180mcu_as_sc_mcu7t3v3__fill_2
XFILLER_6_257 VDD VDD VSS VSS gf180mcu_as_sc_mcu7t3v3__fill_1
XFILLER_6_272 VDD VDD VSS VSS gf180mcu_as_sc_mcu7t3v3__fillcap_4
XFILLER_6_276 VDD VDD VSS VSS gf180mcu_as_sc_mcu7t3v3__fill_1
XFILLER_6_34 VDD VDD VSS VSS gf180mcu_as_sc_mcu7t3v3__fill_1
XFILLER_6_37 VDD VDD VSS VSS gf180mcu_as_sc_mcu7t3v3__fillcap_16
XFILLER_6_53 VDD VDD VSS VSS gf180mcu_as_sc_mcu7t3v3__fillcap_16
XFILLER_6_69 VDD VDD VSS VSS gf180mcu_as_sc_mcu7t3v3__fillcap_16
XFILLER_6_85 VDD VDD VSS VSS gf180mcu_as_sc_mcu7t3v3__fillcap_16
XFILLER_7_104 VDD VDD VSS VSS gf180mcu_as_sc_mcu7t3v3__fillcap_16
XFILLER_7_120 VDD VDD VSS VSS gf180mcu_as_sc_mcu7t3v3__fillcap_16
XFILLER_7_136 VDD VDD VSS VSS gf180mcu_as_sc_mcu7t3v3__fillcap_4
XFILLER_7_142 VDD VDD VSS VSS gf180mcu_as_sc_mcu7t3v3__fillcap_16
XFILLER_7_158 VDD VDD VSS VSS gf180mcu_as_sc_mcu7t3v3__fillcap_16
XFILLER_7_174 VDD VDD VSS VSS gf180mcu_as_sc_mcu7t3v3__fillcap_8
XFILLER_7_18 VDD VDD VSS VSS gf180mcu_as_sc_mcu7t3v3__fillcap_16
XFILLER_7_182 VDD VDD VSS VSS gf180mcu_as_sc_mcu7t3v3__fill_2
XFILLER_7_184 VDD VDD VSS VSS gf180mcu_as_sc_mcu7t3v3__fill_1
XFILLER_7_191 VDD VDD VSS VSS gf180mcu_as_sc_mcu7t3v3__fillcap_16
XFILLER_7_2 VDD VDD VSS VSS gf180mcu_as_sc_mcu7t3v3__fillcap_16
XFILLER_7_207 VDD VDD VSS VSS gf180mcu_as_sc_mcu7t3v3__fill_2
XFILLER_7_209 VDD VDD VSS VSS gf180mcu_as_sc_mcu7t3v3__fill_1
XFILLER_7_212 VDD VDD VSS VSS gf180mcu_as_sc_mcu7t3v3__fillcap_16
XFILLER_7_228 VDD VDD VSS VSS gf180mcu_as_sc_mcu7t3v3__fillcap_16
XFILLER_7_244 VDD VDD VSS VSS gf180mcu_as_sc_mcu7t3v3__fillcap_8
XFILLER_7_252 VDD VDD VSS VSS gf180mcu_as_sc_mcu7t3v3__fillcap_4
XFILLER_7_256 VDD VDD VSS VSS gf180mcu_as_sc_mcu7t3v3__fill_1
XFILLER_7_267 VDD VDD VSS VSS gf180mcu_as_sc_mcu7t3v3__fillcap_4
XFILLER_7_34 VDD VDD VSS VSS gf180mcu_as_sc_mcu7t3v3__fillcap_4
XFILLER_7_38 VDD VDD VSS VSS gf180mcu_as_sc_mcu7t3v3__fill_1
XFILLER_7_51 VDD VDD VSS VSS gf180mcu_as_sc_mcu7t3v3__fillcap_16
XFILLER_7_67 VDD VDD VSS VSS gf180mcu_as_sc_mcu7t3v3__fill_2
XFILLER_7_69 VDD VDD VSS VSS gf180mcu_as_sc_mcu7t3v3__fill_1
XFILLER_7_72 VDD VDD VSS VSS gf180mcu_as_sc_mcu7t3v3__fillcap_16
XFILLER_7_88 VDD VDD VSS VSS gf180mcu_as_sc_mcu7t3v3__fillcap_16
XFILLER_8_100 VDD VDD VSS VSS gf180mcu_as_sc_mcu7t3v3__fillcap_4
XFILLER_8_104 VDD VDD VSS VSS gf180mcu_as_sc_mcu7t3v3__fill_1
XFILLER_8_107 VDD VDD VSS VSS gf180mcu_as_sc_mcu7t3v3__fillcap_16
XFILLER_8_123 VDD VDD VSS VSS gf180mcu_as_sc_mcu7t3v3__fillcap_16
XFILLER_8_139 VDD VDD VSS VSS gf180mcu_as_sc_mcu7t3v3__fillcap_16
XFILLER_8_155 VDD VDD VSS VSS gf180mcu_as_sc_mcu7t3v3__fillcap_8
XFILLER_8_163 VDD VDD VSS VSS gf180mcu_as_sc_mcu7t3v3__fill_2
XFILLER_8_171 VDD VDD VSS VSS gf180mcu_as_sc_mcu7t3v3__fillcap_4
XFILLER_8_18 VDD VDD VSS VSS gf180mcu_as_sc_mcu7t3v3__fillcap_16
XFILLER_8_2 VDD VDD VSS VSS gf180mcu_as_sc_mcu7t3v3__fillcap_16
XFILLER_8_201 VDD VDD VSS VSS gf180mcu_as_sc_mcu7t3v3__fillcap_16
XFILLER_8_217 VDD VDD VSS VSS gf180mcu_as_sc_mcu7t3v3__fillcap_16
XFILLER_8_233 VDD VDD VSS VSS gf180mcu_as_sc_mcu7t3v3__fillcap_8
XFILLER_8_241 VDD VDD VSS VSS gf180mcu_as_sc_mcu7t3v3__fillcap_4
XFILLER_8_247 VDD VDD VSS VSS gf180mcu_as_sc_mcu7t3v3__fillcap_4
XFILLER_8_251 VDD VDD VSS VSS gf180mcu_as_sc_mcu7t3v3__fill_2
XFILLER_8_270 VDD VDD VSS VSS gf180mcu_as_sc_mcu7t3v3__fill_1
XFILLER_8_34 VDD VDD VSS VSS gf180mcu_as_sc_mcu7t3v3__fill_1
XFILLER_8_37 VDD VDD VSS VSS gf180mcu_as_sc_mcu7t3v3__fillcap_4
XFILLER_8_41 VDD VDD VSS VSS gf180mcu_as_sc_mcu7t3v3__fill_1
XFILLER_8_66 VDD VDD VSS VSS gf180mcu_as_sc_mcu7t3v3__fill_1
XFILLER_8_73 VDD VDD VSS VSS gf180mcu_as_sc_mcu7t3v3__fill_1
XFILLER_8_80 VDD VDD VSS VSS gf180mcu_as_sc_mcu7t3v3__fillcap_4
XFILLER_8_90 VDD VDD VSS VSS gf180mcu_as_sc_mcu7t3v3__fillcap_4
XFILLER_9_114 VDD VDD VSS VSS gf180mcu_as_sc_mcu7t3v3__fill_1
XFILLER_9_121 VDD VDD VSS VSS gf180mcu_as_sc_mcu7t3v3__fillcap_16
XFILLER_9_137 VDD VDD VSS VSS gf180mcu_as_sc_mcu7t3v3__fill_2
XFILLER_9_139 VDD VDD VSS VSS gf180mcu_as_sc_mcu7t3v3__fill_1
XFILLER_9_142 VDD VDD VSS VSS gf180mcu_as_sc_mcu7t3v3__fillcap_16
XFILLER_9_158 VDD VDD VSS VSS gf180mcu_as_sc_mcu7t3v3__fill_2
XFILLER_9_18 VDD VDD VSS VSS gf180mcu_as_sc_mcu7t3v3__fillcap_4
XFILLER_9_184 VDD VDD VSS VSS gf180mcu_as_sc_mcu7t3v3__fillcap_4
XFILLER_9_2 VDD VDD VSS VSS gf180mcu_as_sc_mcu7t3v3__fillcap_16
XFILLER_9_206 VDD VDD VSS VSS gf180mcu_as_sc_mcu7t3v3__fillcap_4
XFILLER_9_212 VDD VDD VSS VSS gf180mcu_as_sc_mcu7t3v3__fillcap_16
XFILLER_9_22 VDD VDD VSS VSS gf180mcu_as_sc_mcu7t3v3__fill_2
XFILLER_9_228 VDD VDD VSS VSS gf180mcu_as_sc_mcu7t3v3__fillcap_16
XFILLER_9_24 VDD VDD VSS VSS gf180mcu_as_sc_mcu7t3v3__fill_1
XFILLER_9_244 VDD VDD VSS VSS gf180mcu_as_sc_mcu7t3v3__fill_2
XFILLER_9_267 VDD VDD VSS VSS gf180mcu_as_sc_mcu7t3v3__fillcap_4
XFILLER_9_49 VDD VDD VSS VSS gf180mcu_as_sc_mcu7t3v3__fillcap_8
XFILLER_9_57 VDD VDD VSS VSS gf180mcu_as_sc_mcu7t3v3__fill_1
XPHY_EDGE_ROW_0_Left_39 VDD VSS gf180mcu_as_sc_mcu7t3v3__tap_2
XPHY_EDGE_ROW_0_Right_0 VDD VSS gf180mcu_as_sc_mcu7t3v3__tap_2
XPHY_EDGE_ROW_10_Left_49 VDD VSS gf180mcu_as_sc_mcu7t3v3__tap_2
XPHY_EDGE_ROW_10_Right_10 VDD VSS gf180mcu_as_sc_mcu7t3v3__tap_2
XPHY_EDGE_ROW_11_Left_50 VDD VSS gf180mcu_as_sc_mcu7t3v3__tap_2
XPHY_EDGE_ROW_11_Right_11 VDD VSS gf180mcu_as_sc_mcu7t3v3__tap_2
XPHY_EDGE_ROW_12_Left_51 VDD VSS gf180mcu_as_sc_mcu7t3v3__tap_2
XPHY_EDGE_ROW_12_Right_12 VDD VSS gf180mcu_as_sc_mcu7t3v3__tap_2
XPHY_EDGE_ROW_13_Left_52 VDD VSS gf180mcu_as_sc_mcu7t3v3__tap_2
XPHY_EDGE_ROW_13_Right_13 VDD VSS gf180mcu_as_sc_mcu7t3v3__tap_2
XPHY_EDGE_ROW_14_Left_53 VDD VSS gf180mcu_as_sc_mcu7t3v3__tap_2
XPHY_EDGE_ROW_14_Right_14 VDD VSS gf180mcu_as_sc_mcu7t3v3__tap_2
XPHY_EDGE_ROW_15_Left_54 VDD VSS gf180mcu_as_sc_mcu7t3v3__tap_2
XPHY_EDGE_ROW_15_Right_15 VDD VSS gf180mcu_as_sc_mcu7t3v3__tap_2
XPHY_EDGE_ROW_16_Left_55 VDD VSS gf180mcu_as_sc_mcu7t3v3__tap_2
XPHY_EDGE_ROW_16_Right_16 VDD VSS gf180mcu_as_sc_mcu7t3v3__tap_2
XPHY_EDGE_ROW_17_Left_56 VDD VSS gf180mcu_as_sc_mcu7t3v3__tap_2
XPHY_EDGE_ROW_17_Right_17 VDD VSS gf180mcu_as_sc_mcu7t3v3__tap_2
XPHY_EDGE_ROW_18_Left_57 VDD VSS gf180mcu_as_sc_mcu7t3v3__tap_2
XPHY_EDGE_ROW_18_Right_18 VDD VSS gf180mcu_as_sc_mcu7t3v3__tap_2
XPHY_EDGE_ROW_19_Left_58 VDD VSS gf180mcu_as_sc_mcu7t3v3__tap_2
XPHY_EDGE_ROW_19_Right_19 VDD VSS gf180mcu_as_sc_mcu7t3v3__tap_2
XPHY_EDGE_ROW_1_Left_40 VDD VSS gf180mcu_as_sc_mcu7t3v3__tap_2
XPHY_EDGE_ROW_1_Right_1 VDD VSS gf180mcu_as_sc_mcu7t3v3__tap_2
XPHY_EDGE_ROW_20_Left_59 VDD VSS gf180mcu_as_sc_mcu7t3v3__tap_2
XPHY_EDGE_ROW_20_Right_20 VDD VSS gf180mcu_as_sc_mcu7t3v3__tap_2
XPHY_EDGE_ROW_21_Left_60 VDD VSS gf180mcu_as_sc_mcu7t3v3__tap_2
XPHY_EDGE_ROW_21_Right_21 VDD VSS gf180mcu_as_sc_mcu7t3v3__tap_2
XPHY_EDGE_ROW_22_Left_61 VDD VSS gf180mcu_as_sc_mcu7t3v3__tap_2
XPHY_EDGE_ROW_22_Right_22 VDD VSS gf180mcu_as_sc_mcu7t3v3__tap_2
XPHY_EDGE_ROW_23_Left_62 VDD VSS gf180mcu_as_sc_mcu7t3v3__tap_2
XPHY_EDGE_ROW_23_Right_23 VDD VSS gf180mcu_as_sc_mcu7t3v3__tap_2
XPHY_EDGE_ROW_24_Left_63 VDD VSS gf180mcu_as_sc_mcu7t3v3__tap_2
XPHY_EDGE_ROW_24_Right_24 VDD VSS gf180mcu_as_sc_mcu7t3v3__tap_2
XPHY_EDGE_ROW_25_Left_64 VDD VSS gf180mcu_as_sc_mcu7t3v3__tap_2
XPHY_EDGE_ROW_25_Right_25 VDD VSS gf180mcu_as_sc_mcu7t3v3__tap_2
XPHY_EDGE_ROW_26_Left_65 VDD VSS gf180mcu_as_sc_mcu7t3v3__tap_2
XPHY_EDGE_ROW_26_Right_26 VDD VSS gf180mcu_as_sc_mcu7t3v3__tap_2
XPHY_EDGE_ROW_27_Left_66 VDD VSS gf180mcu_as_sc_mcu7t3v3__tap_2
XPHY_EDGE_ROW_27_Right_27 VDD VSS gf180mcu_as_sc_mcu7t3v3__tap_2
XPHY_EDGE_ROW_28_Left_67 VDD VSS gf180mcu_as_sc_mcu7t3v3__tap_2
XPHY_EDGE_ROW_28_Right_28 VDD VSS gf180mcu_as_sc_mcu7t3v3__tap_2
XPHY_EDGE_ROW_29_Left_68 VDD VSS gf180mcu_as_sc_mcu7t3v3__tap_2
XPHY_EDGE_ROW_29_Right_29 VDD VSS gf180mcu_as_sc_mcu7t3v3__tap_2
XPHY_EDGE_ROW_2_Left_41 VDD VSS gf180mcu_as_sc_mcu7t3v3__tap_2
XPHY_EDGE_ROW_2_Right_2 VDD VSS gf180mcu_as_sc_mcu7t3v3__tap_2
XPHY_EDGE_ROW_30_Left_69 VDD VSS gf180mcu_as_sc_mcu7t3v3__tap_2
XPHY_EDGE_ROW_30_Right_30 VDD VSS gf180mcu_as_sc_mcu7t3v3__tap_2
XPHY_EDGE_ROW_31_Left_70 VDD VSS gf180mcu_as_sc_mcu7t3v3__tap_2
XPHY_EDGE_ROW_31_Right_31 VDD VSS gf180mcu_as_sc_mcu7t3v3__tap_2
XPHY_EDGE_ROW_32_Left_71 VDD VSS gf180mcu_as_sc_mcu7t3v3__tap_2
XPHY_EDGE_ROW_32_Right_32 VDD VSS gf180mcu_as_sc_mcu7t3v3__tap_2
XPHY_EDGE_ROW_33_Left_72 VDD VSS gf180mcu_as_sc_mcu7t3v3__tap_2
XPHY_EDGE_ROW_33_Right_33 VDD VSS gf180mcu_as_sc_mcu7t3v3__tap_2
XPHY_EDGE_ROW_34_Left_73 VDD VSS gf180mcu_as_sc_mcu7t3v3__tap_2
XPHY_EDGE_ROW_34_Right_34 VDD VSS gf180mcu_as_sc_mcu7t3v3__tap_2
XPHY_EDGE_ROW_35_Left_74 VDD VSS gf180mcu_as_sc_mcu7t3v3__tap_2
XPHY_EDGE_ROW_35_Right_35 VDD VSS gf180mcu_as_sc_mcu7t3v3__tap_2
XPHY_EDGE_ROW_36_Left_75 VDD VSS gf180mcu_as_sc_mcu7t3v3__tap_2
XPHY_EDGE_ROW_36_Right_36 VDD VSS gf180mcu_as_sc_mcu7t3v3__tap_2
XPHY_EDGE_ROW_37_Left_76 VDD VSS gf180mcu_as_sc_mcu7t3v3__tap_2
XPHY_EDGE_ROW_37_Right_37 VDD VSS gf180mcu_as_sc_mcu7t3v3__tap_2
XPHY_EDGE_ROW_38_Left_77 VDD VSS gf180mcu_as_sc_mcu7t3v3__tap_2
XPHY_EDGE_ROW_38_Right_38 VDD VSS gf180mcu_as_sc_mcu7t3v3__tap_2
XPHY_EDGE_ROW_3_Left_42 VDD VSS gf180mcu_as_sc_mcu7t3v3__tap_2
XPHY_EDGE_ROW_3_Right_3 VDD VSS gf180mcu_as_sc_mcu7t3v3__tap_2
XPHY_EDGE_ROW_4_Left_43 VDD VSS gf180mcu_as_sc_mcu7t3v3__tap_2
XPHY_EDGE_ROW_4_Right_4 VDD VSS gf180mcu_as_sc_mcu7t3v3__tap_2
XPHY_EDGE_ROW_5_Left_44 VDD VSS gf180mcu_as_sc_mcu7t3v3__tap_2
XPHY_EDGE_ROW_5_Right_5 VDD VSS gf180mcu_as_sc_mcu7t3v3__tap_2
XPHY_EDGE_ROW_6_Left_45 VDD VSS gf180mcu_as_sc_mcu7t3v3__tap_2
XPHY_EDGE_ROW_6_Right_6 VDD VSS gf180mcu_as_sc_mcu7t3v3__tap_2
XPHY_EDGE_ROW_7_Left_46 VDD VSS gf180mcu_as_sc_mcu7t3v3__tap_2
XPHY_EDGE_ROW_7_Right_7 VDD VSS gf180mcu_as_sc_mcu7t3v3__tap_2
XPHY_EDGE_ROW_8_Left_47 VDD VSS gf180mcu_as_sc_mcu7t3v3__tap_2
XPHY_EDGE_ROW_8_Right_8 VDD VSS gf180mcu_as_sc_mcu7t3v3__tap_2
XPHY_EDGE_ROW_9_Left_48 VDD VSS gf180mcu_as_sc_mcu7t3v3__tap_2
XPHY_EDGE_ROW_9_Right_9 VDD VSS gf180mcu_as_sc_mcu7t3v3__tap_2
XTAP_TAPCELL_ROW_0_78 VDD VSS gf180mcu_as_sc_mcu7t3v3__tap_2
XTAP_TAPCELL_ROW_0_79 VDD VSS gf180mcu_as_sc_mcu7t3v3__tap_2
XTAP_TAPCELL_ROW_0_80 VDD VSS gf180mcu_as_sc_mcu7t3v3__tap_2
XTAP_TAPCELL_ROW_0_81 VDD VSS gf180mcu_as_sc_mcu7t3v3__tap_2
XTAP_TAPCELL_ROW_0_82 VDD VSS gf180mcu_as_sc_mcu7t3v3__tap_2
XTAP_TAPCELL_ROW_0_83 VDD VSS gf180mcu_as_sc_mcu7t3v3__tap_2
XTAP_TAPCELL_ROW_0_84 VDD VSS gf180mcu_as_sc_mcu7t3v3__tap_2
XTAP_TAPCELL_ROW_0_85 VDD VSS gf180mcu_as_sc_mcu7t3v3__tap_2
XTAP_TAPCELL_ROW_10_117 VDD VSS gf180mcu_as_sc_mcu7t3v3__tap_2
XTAP_TAPCELL_ROW_10_118 VDD VSS gf180mcu_as_sc_mcu7t3v3__tap_2
XTAP_TAPCELL_ROW_10_119 VDD VSS gf180mcu_as_sc_mcu7t3v3__tap_2
XTAP_TAPCELL_ROW_10_120 VDD VSS gf180mcu_as_sc_mcu7t3v3__tap_2
XTAP_TAPCELL_ROW_11_121 VDD VSS gf180mcu_as_sc_mcu7t3v3__tap_2
XTAP_TAPCELL_ROW_11_122 VDD VSS gf180mcu_as_sc_mcu7t3v3__tap_2
XTAP_TAPCELL_ROW_11_123 VDD VSS gf180mcu_as_sc_mcu7t3v3__tap_2
XTAP_TAPCELL_ROW_12_124 VDD VSS gf180mcu_as_sc_mcu7t3v3__tap_2
XTAP_TAPCELL_ROW_12_125 VDD VSS gf180mcu_as_sc_mcu7t3v3__tap_2
XTAP_TAPCELL_ROW_12_126 VDD VSS gf180mcu_as_sc_mcu7t3v3__tap_2
XTAP_TAPCELL_ROW_12_127 VDD VSS gf180mcu_as_sc_mcu7t3v3__tap_2
XTAP_TAPCELL_ROW_13_128 VDD VSS gf180mcu_as_sc_mcu7t3v3__tap_2
XTAP_TAPCELL_ROW_13_129 VDD VSS gf180mcu_as_sc_mcu7t3v3__tap_2
XTAP_TAPCELL_ROW_13_130 VDD VSS gf180mcu_as_sc_mcu7t3v3__tap_2
XTAP_TAPCELL_ROW_14_131 VDD VSS gf180mcu_as_sc_mcu7t3v3__tap_2
XTAP_TAPCELL_ROW_14_132 VDD VSS gf180mcu_as_sc_mcu7t3v3__tap_2
XTAP_TAPCELL_ROW_14_133 VDD VSS gf180mcu_as_sc_mcu7t3v3__tap_2
XTAP_TAPCELL_ROW_14_134 VDD VSS gf180mcu_as_sc_mcu7t3v3__tap_2
XTAP_TAPCELL_ROW_15_135 VDD VSS gf180mcu_as_sc_mcu7t3v3__tap_2
XTAP_TAPCELL_ROW_15_136 VDD VSS gf180mcu_as_sc_mcu7t3v3__tap_2
XTAP_TAPCELL_ROW_15_137 VDD VSS gf180mcu_as_sc_mcu7t3v3__tap_2
XTAP_TAPCELL_ROW_16_138 VDD VSS gf180mcu_as_sc_mcu7t3v3__tap_2
XTAP_TAPCELL_ROW_16_139 VDD VSS gf180mcu_as_sc_mcu7t3v3__tap_2
XTAP_TAPCELL_ROW_16_140 VDD VSS gf180mcu_as_sc_mcu7t3v3__tap_2
XTAP_TAPCELL_ROW_16_141 VDD VSS gf180mcu_as_sc_mcu7t3v3__tap_2
XTAP_TAPCELL_ROW_17_142 VDD VSS gf180mcu_as_sc_mcu7t3v3__tap_2
XTAP_TAPCELL_ROW_17_143 VDD VSS gf180mcu_as_sc_mcu7t3v3__tap_2
XTAP_TAPCELL_ROW_17_144 VDD VSS gf180mcu_as_sc_mcu7t3v3__tap_2
XTAP_TAPCELL_ROW_18_145 VDD VSS gf180mcu_as_sc_mcu7t3v3__tap_2
XTAP_TAPCELL_ROW_18_146 VDD VSS gf180mcu_as_sc_mcu7t3v3__tap_2
XTAP_TAPCELL_ROW_18_147 VDD VSS gf180mcu_as_sc_mcu7t3v3__tap_2
XTAP_TAPCELL_ROW_18_148 VDD VSS gf180mcu_as_sc_mcu7t3v3__tap_2
XTAP_TAPCELL_ROW_19_149 VDD VSS gf180mcu_as_sc_mcu7t3v3__tap_2
XTAP_TAPCELL_ROW_19_150 VDD VSS gf180mcu_as_sc_mcu7t3v3__tap_2
XTAP_TAPCELL_ROW_19_151 VDD VSS gf180mcu_as_sc_mcu7t3v3__tap_2
XTAP_TAPCELL_ROW_1_86 VDD VSS gf180mcu_as_sc_mcu7t3v3__tap_2
XTAP_TAPCELL_ROW_1_87 VDD VSS gf180mcu_as_sc_mcu7t3v3__tap_2
XTAP_TAPCELL_ROW_1_88 VDD VSS gf180mcu_as_sc_mcu7t3v3__tap_2
XTAP_TAPCELL_ROW_20_152 VDD VSS gf180mcu_as_sc_mcu7t3v3__tap_2
XTAP_TAPCELL_ROW_20_153 VDD VSS gf180mcu_as_sc_mcu7t3v3__tap_2
XTAP_TAPCELL_ROW_20_154 VDD VSS gf180mcu_as_sc_mcu7t3v3__tap_2
XTAP_TAPCELL_ROW_20_155 VDD VSS gf180mcu_as_sc_mcu7t3v3__tap_2
XTAP_TAPCELL_ROW_21_156 VDD VSS gf180mcu_as_sc_mcu7t3v3__tap_2
XTAP_TAPCELL_ROW_21_157 VDD VSS gf180mcu_as_sc_mcu7t3v3__tap_2
XTAP_TAPCELL_ROW_21_158 VDD VSS gf180mcu_as_sc_mcu7t3v3__tap_2
XTAP_TAPCELL_ROW_22_159 VDD VSS gf180mcu_as_sc_mcu7t3v3__tap_2
XTAP_TAPCELL_ROW_22_160 VDD VSS gf180mcu_as_sc_mcu7t3v3__tap_2
XTAP_TAPCELL_ROW_22_161 VDD VSS gf180mcu_as_sc_mcu7t3v3__tap_2
XTAP_TAPCELL_ROW_22_162 VDD VSS gf180mcu_as_sc_mcu7t3v3__tap_2
XTAP_TAPCELL_ROW_23_163 VDD VSS gf180mcu_as_sc_mcu7t3v3__tap_2
XTAP_TAPCELL_ROW_23_164 VDD VSS gf180mcu_as_sc_mcu7t3v3__tap_2
XTAP_TAPCELL_ROW_23_165 VDD VSS gf180mcu_as_sc_mcu7t3v3__tap_2
XTAP_TAPCELL_ROW_24_166 VDD VSS gf180mcu_as_sc_mcu7t3v3__tap_2
XTAP_TAPCELL_ROW_24_167 VDD VSS gf180mcu_as_sc_mcu7t3v3__tap_2
XTAP_TAPCELL_ROW_24_168 VDD VSS gf180mcu_as_sc_mcu7t3v3__tap_2
XTAP_TAPCELL_ROW_24_169 VDD VSS gf180mcu_as_sc_mcu7t3v3__tap_2
XTAP_TAPCELL_ROW_25_170 VDD VSS gf180mcu_as_sc_mcu7t3v3__tap_2
XTAP_TAPCELL_ROW_25_171 VDD VSS gf180mcu_as_sc_mcu7t3v3__tap_2
XTAP_TAPCELL_ROW_25_172 VDD VSS gf180mcu_as_sc_mcu7t3v3__tap_2
XTAP_TAPCELL_ROW_26_173 VDD VSS gf180mcu_as_sc_mcu7t3v3__tap_2
XTAP_TAPCELL_ROW_26_174 VDD VSS gf180mcu_as_sc_mcu7t3v3__tap_2
XTAP_TAPCELL_ROW_26_175 VDD VSS gf180mcu_as_sc_mcu7t3v3__tap_2
XTAP_TAPCELL_ROW_26_176 VDD VSS gf180mcu_as_sc_mcu7t3v3__tap_2
XTAP_TAPCELL_ROW_27_177 VDD VSS gf180mcu_as_sc_mcu7t3v3__tap_2
XTAP_TAPCELL_ROW_27_178 VDD VSS gf180mcu_as_sc_mcu7t3v3__tap_2
XTAP_TAPCELL_ROW_27_179 VDD VSS gf180mcu_as_sc_mcu7t3v3__tap_2
XTAP_TAPCELL_ROW_28_180 VDD VSS gf180mcu_as_sc_mcu7t3v3__tap_2
XTAP_TAPCELL_ROW_28_181 VDD VSS gf180mcu_as_sc_mcu7t3v3__tap_2
XTAP_TAPCELL_ROW_28_182 VDD VSS gf180mcu_as_sc_mcu7t3v3__tap_2
XTAP_TAPCELL_ROW_28_183 VDD VSS gf180mcu_as_sc_mcu7t3v3__tap_2
XTAP_TAPCELL_ROW_29_184 VDD VSS gf180mcu_as_sc_mcu7t3v3__tap_2
XTAP_TAPCELL_ROW_29_185 VDD VSS gf180mcu_as_sc_mcu7t3v3__tap_2
XTAP_TAPCELL_ROW_29_186 VDD VSS gf180mcu_as_sc_mcu7t3v3__tap_2
XTAP_TAPCELL_ROW_2_89 VDD VSS gf180mcu_as_sc_mcu7t3v3__tap_2
XTAP_TAPCELL_ROW_2_90 VDD VSS gf180mcu_as_sc_mcu7t3v3__tap_2
XTAP_TAPCELL_ROW_2_91 VDD VSS gf180mcu_as_sc_mcu7t3v3__tap_2
XTAP_TAPCELL_ROW_2_92 VDD VSS gf180mcu_as_sc_mcu7t3v3__tap_2
XTAP_TAPCELL_ROW_30_187 VDD VSS gf180mcu_as_sc_mcu7t3v3__tap_2
XTAP_TAPCELL_ROW_30_188 VDD VSS gf180mcu_as_sc_mcu7t3v3__tap_2
XTAP_TAPCELL_ROW_30_189 VDD VSS gf180mcu_as_sc_mcu7t3v3__tap_2
XTAP_TAPCELL_ROW_30_190 VDD VSS gf180mcu_as_sc_mcu7t3v3__tap_2
XTAP_TAPCELL_ROW_31_191 VDD VSS gf180mcu_as_sc_mcu7t3v3__tap_2
XTAP_TAPCELL_ROW_31_192 VDD VSS gf180mcu_as_sc_mcu7t3v3__tap_2
XTAP_TAPCELL_ROW_31_193 VDD VSS gf180mcu_as_sc_mcu7t3v3__tap_2
XTAP_TAPCELL_ROW_32_194 VDD VSS gf180mcu_as_sc_mcu7t3v3__tap_2
XTAP_TAPCELL_ROW_32_195 VDD VSS gf180mcu_as_sc_mcu7t3v3__tap_2
XTAP_TAPCELL_ROW_32_196 VDD VSS gf180mcu_as_sc_mcu7t3v3__tap_2
XTAP_TAPCELL_ROW_32_197 VDD VSS gf180mcu_as_sc_mcu7t3v3__tap_2
XTAP_TAPCELL_ROW_33_198 VDD VSS gf180mcu_as_sc_mcu7t3v3__tap_2
XTAP_TAPCELL_ROW_33_199 VDD VSS gf180mcu_as_sc_mcu7t3v3__tap_2
XTAP_TAPCELL_ROW_33_200 VDD VSS gf180mcu_as_sc_mcu7t3v3__tap_2
XTAP_TAPCELL_ROW_34_201 VDD VSS gf180mcu_as_sc_mcu7t3v3__tap_2
XTAP_TAPCELL_ROW_34_202 VDD VSS gf180mcu_as_sc_mcu7t3v3__tap_2
XTAP_TAPCELL_ROW_34_203 VDD VSS gf180mcu_as_sc_mcu7t3v3__tap_2
XTAP_TAPCELL_ROW_34_204 VDD VSS gf180mcu_as_sc_mcu7t3v3__tap_2
XTAP_TAPCELL_ROW_35_205 VDD VSS gf180mcu_as_sc_mcu7t3v3__tap_2
XTAP_TAPCELL_ROW_35_206 VDD VSS gf180mcu_as_sc_mcu7t3v3__tap_2
XTAP_TAPCELL_ROW_35_207 VDD VSS gf180mcu_as_sc_mcu7t3v3__tap_2
XTAP_TAPCELL_ROW_36_208 VDD VSS gf180mcu_as_sc_mcu7t3v3__tap_2
XTAP_TAPCELL_ROW_36_209 VDD VSS gf180mcu_as_sc_mcu7t3v3__tap_2
XTAP_TAPCELL_ROW_36_210 VDD VSS gf180mcu_as_sc_mcu7t3v3__tap_2
XTAP_TAPCELL_ROW_36_211 VDD VSS gf180mcu_as_sc_mcu7t3v3__tap_2
XTAP_TAPCELL_ROW_37_212 VDD VSS gf180mcu_as_sc_mcu7t3v3__tap_2
XTAP_TAPCELL_ROW_37_213 VDD VSS gf180mcu_as_sc_mcu7t3v3__tap_2
XTAP_TAPCELL_ROW_37_214 VDD VSS gf180mcu_as_sc_mcu7t3v3__tap_2
XTAP_TAPCELL_ROW_38_215 VDD VSS gf180mcu_as_sc_mcu7t3v3__tap_2
XTAP_TAPCELL_ROW_38_216 VDD VSS gf180mcu_as_sc_mcu7t3v3__tap_2
XTAP_TAPCELL_ROW_38_217 VDD VSS gf180mcu_as_sc_mcu7t3v3__tap_2
XTAP_TAPCELL_ROW_38_218 VDD VSS gf180mcu_as_sc_mcu7t3v3__tap_2
XTAP_TAPCELL_ROW_38_219 VDD VSS gf180mcu_as_sc_mcu7t3v3__tap_2
XTAP_TAPCELL_ROW_38_220 VDD VSS gf180mcu_as_sc_mcu7t3v3__tap_2
XTAP_TAPCELL_ROW_38_221 VDD VSS gf180mcu_as_sc_mcu7t3v3__tap_2
XTAP_TAPCELL_ROW_38_222 VDD VSS gf180mcu_as_sc_mcu7t3v3__tap_2
XTAP_TAPCELL_ROW_3_93 VDD VSS gf180mcu_as_sc_mcu7t3v3__tap_2
XTAP_TAPCELL_ROW_3_94 VDD VSS gf180mcu_as_sc_mcu7t3v3__tap_2
XTAP_TAPCELL_ROW_3_95 VDD VSS gf180mcu_as_sc_mcu7t3v3__tap_2
XTAP_TAPCELL_ROW_4_96 VDD VSS gf180mcu_as_sc_mcu7t3v3__tap_2
XTAP_TAPCELL_ROW_4_97 VDD VSS gf180mcu_as_sc_mcu7t3v3__tap_2
XTAP_TAPCELL_ROW_4_98 VDD VSS gf180mcu_as_sc_mcu7t3v3__tap_2
XTAP_TAPCELL_ROW_4_99 VDD VSS gf180mcu_as_sc_mcu7t3v3__tap_2
XTAP_TAPCELL_ROW_5_100 VDD VSS gf180mcu_as_sc_mcu7t3v3__tap_2
XTAP_TAPCELL_ROW_5_101 VDD VSS gf180mcu_as_sc_mcu7t3v3__tap_2
XTAP_TAPCELL_ROW_5_102 VDD VSS gf180mcu_as_sc_mcu7t3v3__tap_2
XTAP_TAPCELL_ROW_6_103 VDD VSS gf180mcu_as_sc_mcu7t3v3__tap_2
XTAP_TAPCELL_ROW_6_104 VDD VSS gf180mcu_as_sc_mcu7t3v3__tap_2
XTAP_TAPCELL_ROW_6_105 VDD VSS gf180mcu_as_sc_mcu7t3v3__tap_2
XTAP_TAPCELL_ROW_6_106 VDD VSS gf180mcu_as_sc_mcu7t3v3__tap_2
XTAP_TAPCELL_ROW_7_107 VDD VSS gf180mcu_as_sc_mcu7t3v3__tap_2
XTAP_TAPCELL_ROW_7_108 VDD VSS gf180mcu_as_sc_mcu7t3v3__tap_2
XTAP_TAPCELL_ROW_7_109 VDD VSS gf180mcu_as_sc_mcu7t3v3__tap_2
XTAP_TAPCELL_ROW_8_110 VDD VSS gf180mcu_as_sc_mcu7t3v3__tap_2
XTAP_TAPCELL_ROW_8_111 VDD VSS gf180mcu_as_sc_mcu7t3v3__tap_2
XTAP_TAPCELL_ROW_8_112 VDD VSS gf180mcu_as_sc_mcu7t3v3__tap_2
XTAP_TAPCELL_ROW_8_113 VDD VSS gf180mcu_as_sc_mcu7t3v3__tap_2
XTAP_TAPCELL_ROW_9_114 VDD VSS gf180mcu_as_sc_mcu7t3v3__tap_2
XTAP_TAPCELL_ROW_9_115 VDD VSS gf180mcu_as_sc_mcu7t3v3__tap_2
XTAP_TAPCELL_ROW_9_116 VDD VSS gf180mcu_as_sc_mcu7t3v3__tap_2
X_4_ VDD VDD VSS VSS REF net63 gf180mcu_as_sc_mcu7t3v3__buff_2
X_5_ VDD VDD VSS VSS ring.dff_y.Q net66 gf180mcu_as_sc_mcu7t3v3__buff_2
X_6_ VDD VDD VSS VSS ring.dff_x.Q net67 gf180mcu_as_sc_mcu7t3v3__buff_2
Xinput1 VDD VDD VSS VSS COARSE_MUX[0] net1 gf180mcu_as_sc_mcu7t3v3__buff_2
Xinput10 VDD VDD VSS VSS COARSE_MUX[4] net10 gf180mcu_as_sc_mcu7t3v3__buff_2
Xinput11 VDD VDD VSS VSS COARSE_MUX[5] net11 gf180mcu_as_sc_mcu7t3v3__buff_2
Xinput12 VDD VDD VSS VSS COARSE_MUX[6] net12 gf180mcu_as_sc_mcu7t3v3__buff_2
Xinput13 VDD VDD VSS VSS COARSE_MUX[7] net13 gf180mcu_as_sc_mcu7t3v3__buff_2
Xinput14 VDD VDD VSS VSS COARSE_MUX[8] net14 gf180mcu_as_sc_mcu7t3v3__buff_2
Xinput15 VDD VDD VSS VSS COARSE_MUX[9] net15 gf180mcu_as_sc_mcu7t3v3__buff_2
Xinput16 VDD VDD VSS VSS DCO_EN net16 gf180mcu_as_sc_mcu7t3v3__buff_2
Xinput17 VDD VDD VSS VSS FINE_MUX[0] net17 gf180mcu_as_sc_mcu7t3v3__buff_2
Xinput18 VDD VDD VSS VSS FINE_MUX[10] net18 gf180mcu_as_sc_mcu7t3v3__buff_2
Xinput19 VDD VDD VSS VSS FINE_MUX[11] net19 gf180mcu_as_sc_mcu7t3v3__buff_2
Xinput2 VDD VDD VSS VSS COARSE_MUX[10] net2 gf180mcu_as_sc_mcu7t3v3__buff_2
Xinput20 VDD VDD VSS VSS FINE_MUX[12] net20 gf180mcu_as_sc_mcu7t3v3__buff_2
Xinput21 VDD VDD VSS VSS FINE_MUX[13] net21 gf180mcu_as_sc_mcu7t3v3__buff_2
Xinput22 VDD VDD VSS VSS FINE_MUX[14] net22 gf180mcu_as_sc_mcu7t3v3__buff_2
Xinput23 VDD VDD VSS VSS FINE_MUX[15] net23 gf180mcu_as_sc_mcu7t3v3__buff_2
Xinput24 VDD VDD VSS VSS FINE_MUX[16] net24 gf180mcu_as_sc_mcu7t3v3__buff_2
Xinput25 VDD VDD VSS VSS FINE_MUX[17] net25 gf180mcu_as_sc_mcu7t3v3__buff_2
Xinput26 VDD VDD VSS VSS FINE_MUX[18] net26 gf180mcu_as_sc_mcu7t3v3__buff_2
Xinput27 VDD VDD VSS VSS FINE_MUX[19] net27 gf180mcu_as_sc_mcu7t3v3__buff_2
Xinput28 VDD VDD VSS VSS FINE_MUX[1] net28 gf180mcu_as_sc_mcu7t3v3__buff_2
Xinput29 VDD VDD VSS VSS FINE_MUX[20] net29 gf180mcu_as_sc_mcu7t3v3__buff_2
Xinput3 VDD VDD VSS VSS COARSE_MUX[11] net3 gf180mcu_as_sc_mcu7t3v3__buff_2
Xinput30 VDD VDD VSS VSS FINE_MUX[21] net30 gf180mcu_as_sc_mcu7t3v3__buff_2
Xinput31 VDD VDD VSS VSS FINE_MUX[22] net31 gf180mcu_as_sc_mcu7t3v3__buff_2
Xinput32 VDD VDD VSS VSS FINE_MUX[23] net32 gf180mcu_as_sc_mcu7t3v3__buff_2
Xinput33 VDD VDD VSS VSS FINE_MUX[24] net33 gf180mcu_as_sc_mcu7t3v3__buff_2
Xinput34 VDD VDD VSS VSS FINE_MUX[25] net34 gf180mcu_as_sc_mcu7t3v3__buff_2
Xinput35 VDD VDD VSS VSS FINE_MUX[26] net35 gf180mcu_as_sc_mcu7t3v3__buff_2
Xinput36 VDD VDD VSS VSS FINE_MUX[27] net36 gf180mcu_as_sc_mcu7t3v3__buff_2
Xinput37 VDD VDD VSS VSS FINE_MUX[28] net37 gf180mcu_as_sc_mcu7t3v3__buff_2
Xinput38 VDD VDD VSS VSS FINE_MUX[29] net38 gf180mcu_as_sc_mcu7t3v3__buff_2
Xinput39 VDD VDD VSS VSS FINE_MUX[2] net39 gf180mcu_as_sc_mcu7t3v3__buff_2
Xinput4 VDD VDD VSS VSS COARSE_MUX[12] net4 gf180mcu_as_sc_mcu7t3v3__buff_2
Xinput40 VDD VDD VSS VSS FINE_MUX[30] net40 gf180mcu_as_sc_mcu7t3v3__buff_2
Xinput41 VDD VDD VSS VSS FINE_MUX[3] net41 gf180mcu_as_sc_mcu7t3v3__buff_2
Xinput42 VDD VDD VSS VSS FINE_MUX[4] net42 gf180mcu_as_sc_mcu7t3v3__buff_2
Xinput43 VDD VDD VSS VSS FINE_MUX[5] net43 gf180mcu_as_sc_mcu7t3v3__buff_2
Xinput44 VDD VDD VSS VSS FINE_MUX[6] net44 gf180mcu_as_sc_mcu7t3v3__buff_2
Xinput45 VDD VDD VSS VSS FINE_MUX[7] net45 gf180mcu_as_sc_mcu7t3v3__buff_2
Xinput46 VDD VDD VSS VSS FINE_MUX[8] net46 gf180mcu_as_sc_mcu7t3v3__buff_2
Xinput47 VDD VDD VSS VSS FINE_MUX[9] net47 gf180mcu_as_sc_mcu7t3v3__buff_2
Xinput48 VDD VDD VSS VSS MID_MUX[0] net48 gf180mcu_as_sc_mcu7t3v3__buff_2
Xinput49 VDD VDD VSS VSS MID_MUX[10] net49 gf180mcu_as_sc_mcu7t3v3__buff_2
Xinput5 VDD VDD VSS VSS COARSE_MUX[13] net5 gf180mcu_as_sc_mcu7t3v3__buff_2
Xinput50 VDD VDD VSS VSS MID_MUX[11] net50 gf180mcu_as_sc_mcu7t3v3__buff_2
Xinput51 VDD VDD VSS VSS MID_MUX[12] net51 gf180mcu_as_sc_mcu7t3v3__buff_2
Xinput52 VDD VDD VSS VSS MID_MUX[13] net52 gf180mcu_as_sc_mcu7t3v3__buff_2
Xinput53 VDD VDD VSS VSS MID_MUX[14] net53 gf180mcu_as_sc_mcu7t3v3__buff_2
Xinput54 VDD VDD VSS VSS MID_MUX[1] net54 gf180mcu_as_sc_mcu7t3v3__buff_2
Xinput55 VDD VDD VSS VSS MID_MUX[2] net55 gf180mcu_as_sc_mcu7t3v3__buff_2
Xinput56 VDD VDD VSS VSS MID_MUX[3] net56 gf180mcu_as_sc_mcu7t3v3__buff_2
Xinput57 VDD VDD VSS VSS MID_MUX[4] net57 gf180mcu_as_sc_mcu7t3v3__buff_2
Xinput58 VDD VDD VSS VSS MID_MUX[5] net58 gf180mcu_as_sc_mcu7t3v3__buff_2
Xinput59 VDD VDD VSS VSS MID_MUX[6] net59 gf180mcu_as_sc_mcu7t3v3__buff_2
Xinput6 VDD VDD VSS VSS COARSE_MUX[14] net6 gf180mcu_as_sc_mcu7t3v3__buff_2
Xinput60 VDD VDD VSS VSS MID_MUX[7] net60 gf180mcu_as_sc_mcu7t3v3__buff_2
Xinput61 VDD VDD VSS VSS MID_MUX[8] net61 gf180mcu_as_sc_mcu7t3v3__buff_2
Xinput62 VDD VDD VSS VSS MID_MUX[9] net62 gf180mcu_as_sc_mcu7t3v3__buff_2
Xinput7 VDD VDD VSS VSS COARSE_MUX[1] net7 gf180mcu_as_sc_mcu7t3v3__buff_2
Xinput8 VDD VDD VSS VSS COARSE_MUX[2] net8 gf180mcu_as_sc_mcu7t3v3__buff_2
Xinput9 VDD VDD VSS VSS COARSE_MUX[3] net9 gf180mcu_as_sc_mcu7t3v3__buff_2
Xoutput63 VDD VDD VSS VSS net63 INJ_EDGE gf180mcu_as_sc_mcu7t3v3__buff_2
Xoutput64 VDD VDD VSS VSS net64 MID_OUT gf180mcu_as_sc_mcu7t3v3__buff_2
Xoutput65 VDD VDD VSS VSS net65 OUT gf180mcu_as_sc_mcu7t3v3__buff_2
Xoutput66 VDD VDD VSS VSS net66 SS_BBPD[0] gf180mcu_as_sc_mcu7t3v3__buff_2
Xoutput67 VDD VDD VSS VSS net67 SS_BBPD[1] gf180mcu_as_sc_mcu7t3v3__buff_2
Xring.base_delay.stage\[0\].delay_cell.impl VDD VDD VSS VSS
+ net65 ring.base_delay.stage\[0\].delay_cell.Z gf180mcu_as_sc_mcu7t3v3__buff_2
Xring.base_delay.stage\[100\].delay_cell.impl VDD VDD VSS
+ VSS ring.base_delay.stage\[100\].delay_cell.I ring.base_delay.stage\[100\].delay_cell.Z
+ gf180mcu_as_sc_mcu7t3v3__buff_2
Xring.base_delay.stage\[101\].delay_cell.impl VDD VDD VSS
+ VSS ring.base_delay.stage\[100\].delay_cell.Z ring.base_delay.stage\[101\].delay_cell.Z
+ gf180mcu_as_sc_mcu7t3v3__buff_2
Xring.base_delay.stage\[102\].delay_cell.impl VDD VDD VSS
+ VSS ring.base_delay.stage\[101\].delay_cell.Z ring.base_delay.stage\[102\].delay_cell.Z
+ gf180mcu_as_sc_mcu7t3v3__buff_2
Xring.base_delay.stage\[103\].delay_cell.impl VDD VDD VSS
+ VSS ring.base_delay.stage\[102\].delay_cell.Z ring.base_delay.stage\[103\].delay_cell.Z
+ gf180mcu_as_sc_mcu7t3v3__buff_2
Xring.base_delay.stage\[104\].delay_cell.impl VDD VDD VSS
+ VSS ring.base_delay.stage\[103\].delay_cell.Z ring.base_delay.stage\[104\].delay_cell.Z
+ gf180mcu_as_sc_mcu7t3v3__buff_2
Xring.base_delay.stage\[105\].delay_cell.impl VDD VDD VSS
+ VSS ring.base_delay.stage\[104\].delay_cell.Z ring.base_delay.stage\[105\].delay_cell.Z
+ gf180mcu_as_sc_mcu7t3v3__buff_2
Xring.base_delay.stage\[106\].delay_cell.impl VDD VDD VSS
+ VSS ring.base_delay.stage\[105\].delay_cell.Z ring.base_delay.stage\[106\].delay_cell.Z
+ gf180mcu_as_sc_mcu7t3v3__buff_2
Xring.base_delay.stage\[107\].delay_cell.impl VDD VDD VSS
+ VSS ring.base_delay.stage\[106\].delay_cell.Z ring.base_delay.stage\[107\].delay_cell.Z
+ gf180mcu_as_sc_mcu7t3v3__buff_2
Xring.base_delay.stage\[108\].delay_cell.impl VDD VDD VSS
+ VSS ring.base_delay.stage\[107\].delay_cell.Z ring.base_delay.stage\[108\].delay_cell.Z
+ gf180mcu_as_sc_mcu7t3v3__buff_2
Xring.base_delay.stage\[109\].delay_cell.impl VDD VDD VSS
+ VSS ring.base_delay.stage\[108\].delay_cell.Z ring.base_delay.stage\[109\].delay_cell.Z
+ gf180mcu_as_sc_mcu7t3v3__buff_2
Xring.base_delay.stage\[10\].delay_cell.impl VDD VDD VSS VSS
+ ring.base_delay.stage\[10\].delay_cell.I ring.base_delay.stage\[10\].delay_cell.Z
+ gf180mcu_as_sc_mcu7t3v3__buff_2
Xring.base_delay.stage\[110\].delay_cell.impl VDD VDD VSS
+ VSS ring.base_delay.stage\[109\].delay_cell.Z ring.base_delay.stage\[110\].delay_cell.Z
+ gf180mcu_as_sc_mcu7t3v3__buff_2
Xring.base_delay.stage\[111\].delay_cell.impl VDD VDD VSS
+ VSS ring.base_delay.stage\[110\].delay_cell.Z ring.base_delay.stage\[111\].delay_cell.Z
+ gf180mcu_as_sc_mcu7t3v3__buff_2
Xring.base_delay.stage\[112\].delay_cell.impl VDD VDD VSS
+ VSS ring.base_delay.stage\[111\].delay_cell.Z ring.base_delay.stage\[112\].delay_cell.Z
+ gf180mcu_as_sc_mcu7t3v3__buff_2
Xring.base_delay.stage\[113\].delay_cell.impl VDD VDD VSS
+ VSS ring.base_delay.stage\[112\].delay_cell.Z ring.base_delay.stage\[113\].delay_cell.Z
+ gf180mcu_as_sc_mcu7t3v3__buff_2
Xring.base_delay.stage\[114\].delay_cell.impl VDD VDD VSS
+ VSS ring.base_delay.stage\[113\].delay_cell.Z ring.base_delay.stage\[114\].delay_cell.Z
+ gf180mcu_as_sc_mcu7t3v3__buff_2
Xring.base_delay.stage\[115\].delay_cell.impl VDD VDD VSS
+ VSS ring.base_delay.stage\[114\].delay_cell.Z ring.base_delay.stage\[115\].delay_cell.Z
+ gf180mcu_as_sc_mcu7t3v3__buff_2
Xring.base_delay.stage\[116\].delay_cell.impl VDD VDD VSS
+ VSS ring.base_delay.stage\[115\].delay_cell.Z ring.base_delay.stage\[116\].delay_cell.Z
+ gf180mcu_as_sc_mcu7t3v3__buff_2
Xring.base_delay.stage\[117\].delay_cell.impl VDD VDD VSS
+ VSS ring.base_delay.stage\[116\].delay_cell.Z ring.base_delay.stage\[117\].delay_cell.Z
+ gf180mcu_as_sc_mcu7t3v3__buff_2
Xring.base_delay.stage\[118\].delay_cell.impl VDD VDD VSS
+ VSS ring.base_delay.stage\[117\].delay_cell.Z ring.base_delay.stage\[118\].delay_cell.Z
+ gf180mcu_as_sc_mcu7t3v3__buff_2
Xring.base_delay.stage\[119\].delay_cell.impl VDD VDD VSS
+ VSS ring.base_delay.stage\[118\].delay_cell.Z ring.base_delay.stage\[119\].delay_cell.Z
+ gf180mcu_as_sc_mcu7t3v3__buff_2
Xring.base_delay.stage\[11\].delay_cell.impl VDD VDD VSS VSS
+ ring.base_delay.stage\[10\].delay_cell.Z ring.base_delay.stage\[11\].delay_cell.Z
+ gf180mcu_as_sc_mcu7t3v3__buff_2
Xring.base_delay.stage\[120\].delay_cell.impl VDD VDD VSS
+ VSS ring.base_delay.stage\[119\].delay_cell.Z ring.base_delay.stage\[120\].delay_cell.Z
+ gf180mcu_as_sc_mcu7t3v3__buff_2
Xring.base_delay.stage\[121\].delay_cell.impl VDD VDD VSS
+ VSS ring.base_delay.stage\[120\].delay_cell.Z ring.base_delay.stage\[121\].delay_cell.Z
+ gf180mcu_as_sc_mcu7t3v3__buff_2
Xring.base_delay.stage\[122\].delay_cell.impl VDD VDD VSS
+ VSS ring.base_delay.stage\[121\].delay_cell.Z ring.base_delay.stage\[122\].delay_cell.Z
+ gf180mcu_as_sc_mcu7t3v3__buff_2
Xring.base_delay.stage\[123\].delay_cell.impl VDD VDD VSS
+ VSS ring.base_delay.stage\[122\].delay_cell.Z ring.base_delay.stage\[123\].delay_cell.Z
+ gf180mcu_as_sc_mcu7t3v3__buff_2
Xring.base_delay.stage\[124\].delay_cell.impl VDD VDD VSS
+ VSS ring.base_delay.stage\[123\].delay_cell.Z ring.base_delay.stage\[124\].delay_cell.Z
+ gf180mcu_as_sc_mcu7t3v3__buff_2
Xring.base_delay.stage\[125\].delay_cell.impl VDD VDD VSS
+ VSS ring.base_delay.stage\[124\].delay_cell.Z ring.base_delay.stage\[125\].delay_cell.Z
+ gf180mcu_as_sc_mcu7t3v3__buff_2
Xring.base_delay.stage\[126\].delay_cell.impl VDD VDD VSS
+ VSS ring.base_delay.stage\[125\].delay_cell.Z ring.base_delay.stage\[126\].delay_cell.Z
+ gf180mcu_as_sc_mcu7t3v3__buff_2
Xring.base_delay.stage\[127\].delay_cell.impl VDD VDD VSS
+ VSS ring.base_delay.stage\[126\].delay_cell.Z ring.base_delay.stage\[127\].delay_cell.Z
+ gf180mcu_as_sc_mcu7t3v3__buff_2
Xring.base_delay.stage\[128\].delay_cell.impl VDD VDD VSS
+ VSS ring.base_delay.stage\[127\].delay_cell.Z ring.base_delay.stage\[128\].delay_cell.Z
+ gf180mcu_as_sc_mcu7t3v3__buff_2
Xring.base_delay.stage\[129\].delay_cell.impl VDD VDD VSS
+ VSS ring.base_delay.stage\[128\].delay_cell.Z ring.base_delay.stage\[129\].delay_cell.Z
+ gf180mcu_as_sc_mcu7t3v3__buff_2
Xring.base_delay.stage\[12\].delay_cell.impl VDD VDD VSS VSS
+ ring.base_delay.stage\[11\].delay_cell.Z ring.base_delay.stage\[12\].delay_cell.Z
+ gf180mcu_as_sc_mcu7t3v3__buff_2
Xring.base_delay.stage\[130\].delay_cell.impl VDD VDD VSS
+ VSS ring.base_delay.stage\[129\].delay_cell.Z ring.base_delay.stage\[130\].delay_cell.Z
+ gf180mcu_as_sc_mcu7t3v3__buff_2
Xring.base_delay.stage\[131\].delay_cell.impl VDD VDD VSS
+ VSS ring.base_delay.stage\[130\].delay_cell.Z ring.base_delay.stage\[131\].delay_cell.Z
+ gf180mcu_as_sc_mcu7t3v3__buff_2
Xring.base_delay.stage\[132\].delay_cell.impl VDD VDD VSS
+ VSS ring.base_delay.stage\[131\].delay_cell.Z ring.base_delay.stage\[132\].delay_cell.Z
+ gf180mcu_as_sc_mcu7t3v3__buff_2
Xring.base_delay.stage\[133\].delay_cell.impl VDD VDD VSS
+ VSS ring.base_delay.stage\[132\].delay_cell.Z ring.base_delay.stage\[133\].delay_cell.Z
+ gf180mcu_as_sc_mcu7t3v3__buff_2
Xring.base_delay.stage\[134\].delay_cell.impl VDD VDD VSS
+ VSS ring.base_delay.stage\[133\].delay_cell.Z ring.base_delay.stage\[134\].delay_cell.Z
+ gf180mcu_as_sc_mcu7t3v3__buff_2
Xring.base_delay.stage\[135\].delay_cell.impl VDD VDD VSS
+ VSS ring.base_delay.stage\[134\].delay_cell.Z ring.base_delay.stage\[135\].delay_cell.Z
+ gf180mcu_as_sc_mcu7t3v3__buff_2
Xring.base_delay.stage\[136\].delay_cell.impl VDD VDD VSS
+ VSS ring.base_delay.stage\[135\].delay_cell.Z ring.base_delay.stage\[136\].delay_cell.Z
+ gf180mcu_as_sc_mcu7t3v3__buff_2
Xring.base_delay.stage\[137\].delay_cell.impl VDD VDD VSS
+ VSS ring.base_delay.stage\[136\].delay_cell.Z ring.base_delay.stage\[137\].delay_cell.Z
+ gf180mcu_as_sc_mcu7t3v3__buff_2
Xring.base_delay.stage\[138\].delay_cell.impl VDD VDD VSS
+ VSS ring.base_delay.stage\[137\].delay_cell.Z ring.base_delay.stage\[138\].delay_cell.Z
+ gf180mcu_as_sc_mcu7t3v3__buff_2
Xring.base_delay.stage\[139\].delay_cell.impl VDD VDD VSS
+ VSS ring.base_delay.stage\[138\].delay_cell.Z ring.base_delay.stage\[139\].delay_cell.Z
+ gf180mcu_as_sc_mcu7t3v3__buff_2
Xring.base_delay.stage\[13\].delay_cell.impl VDD VDD VSS VSS
+ ring.base_delay.stage\[12\].delay_cell.Z ring.base_delay.stage\[13\].delay_cell.Z
+ gf180mcu_as_sc_mcu7t3v3__buff_2
Xring.base_delay.stage\[140\].delay_cell.impl VDD VDD VSS
+ VSS ring.base_delay.stage\[139\].delay_cell.Z ring.base_delay.stage\[140\].delay_cell.Z
+ gf180mcu_as_sc_mcu7t3v3__buff_2
Xring.base_delay.stage\[141\].delay_cell.impl VDD VDD VSS
+ VSS ring.base_delay.stage\[140\].delay_cell.Z ring.base_delay.stage\[141\].delay_cell.Z
+ gf180mcu_as_sc_mcu7t3v3__buff_2
Xring.base_delay.stage\[142\].delay_cell.impl VDD VDD VSS
+ VSS ring.base_delay.stage\[141\].delay_cell.Z ring.base_delay.stage\[142\].delay_cell.Z
+ gf180mcu_as_sc_mcu7t3v3__buff_2
Xring.base_delay.stage\[143\].delay_cell.impl VDD VDD VSS
+ VSS ring.base_delay.stage\[142\].delay_cell.Z ring.base_delay.stage\[143\].delay_cell.Z
+ gf180mcu_as_sc_mcu7t3v3__buff_2
Xring.base_delay.stage\[144\].delay_cell.impl VDD VDD VSS
+ VSS ring.base_delay.stage\[143\].delay_cell.Z ring.base_delay.stage\[144\].delay_cell.Z
+ gf180mcu_as_sc_mcu7t3v3__buff_2
Xring.base_delay.stage\[145\].delay_cell.impl VDD VDD VSS
+ VSS ring.base_delay.stage\[144\].delay_cell.Z ring.base_delay.stage\[145\].delay_cell.Z
+ gf180mcu_as_sc_mcu7t3v3__buff_2
Xring.base_delay.stage\[146\].delay_cell.impl VDD VDD VSS
+ VSS ring.base_delay.stage\[145\].delay_cell.Z ring.base_delay.stage\[146\].delay_cell.Z
+ gf180mcu_as_sc_mcu7t3v3__buff_2
Xring.base_delay.stage\[147\].delay_cell.impl VDD VDD VSS
+ VSS ring.base_delay.stage\[146\].delay_cell.Z ring.base_delay.stage\[147\].delay_cell.Z
+ gf180mcu_as_sc_mcu7t3v3__buff_2
Xring.base_delay.stage\[148\].delay_cell.impl VDD VDD VSS
+ VSS ring.base_delay.stage\[147\].delay_cell.Z ring.base_delay.stage\[148\].delay_cell.Z
+ gf180mcu_as_sc_mcu7t3v3__buff_2
Xring.base_delay.stage\[149\].delay_cell.impl VDD VDD VSS
+ VSS ring.base_delay.stage\[148\].delay_cell.Z ring.base_delay.stage\[149\].delay_cell.Z
+ gf180mcu_as_sc_mcu7t3v3__buff_2
Xring.base_delay.stage\[14\].delay_cell.impl VDD VDD VSS VSS
+ ring.base_delay.stage\[13\].delay_cell.Z ring.base_delay.stage\[14\].delay_cell.Z
+ gf180mcu_as_sc_mcu7t3v3__buff_2
Xring.base_delay.stage\[150\].delay_cell.impl VDD VDD VSS
+ VSS ring.base_delay.stage\[149\].delay_cell.Z ring.base_delay.stage\[150\].delay_cell.Z
+ gf180mcu_as_sc_mcu7t3v3__buff_2
Xring.base_delay.stage\[151\].delay_cell.impl VDD VDD VSS
+ VSS ring.base_delay.stage\[150\].delay_cell.Z ring.base_delay.stage\[151\].delay_cell.Z
+ gf180mcu_as_sc_mcu7t3v3__buff_2
Xring.base_delay.stage\[152\].delay_cell.impl VDD VDD VSS
+ VSS ring.base_delay.stage\[151\].delay_cell.Z ring.base_delay.stage\[152\].delay_cell.Z
+ gf180mcu_as_sc_mcu7t3v3__buff_2
Xring.base_delay.stage\[153\].delay_cell.impl VDD VDD VSS
+ VSS ring.base_delay.stage\[152\].delay_cell.Z ring.base_delay.stage\[153\].delay_cell.Z
+ gf180mcu_as_sc_mcu7t3v3__buff_2
Xring.base_delay.stage\[154\].delay_cell.impl VDD VDD VSS
+ VSS ring.base_delay.stage\[153\].delay_cell.Z ring.base_delay.stage\[154\].delay_cell.Z
+ gf180mcu_as_sc_mcu7t3v3__buff_2
Xring.base_delay.stage\[155\].delay_cell.impl VDD VDD VSS
+ VSS ring.base_delay.stage\[154\].delay_cell.Z ring.base_delay.stage\[155\].delay_cell.Z
+ gf180mcu_as_sc_mcu7t3v3__buff_2
Xring.base_delay.stage\[156\].delay_cell.impl VDD VDD VSS
+ VSS ring.base_delay.stage\[155\].delay_cell.Z ring.base_delay.stage\[156\].delay_cell.Z
+ gf180mcu_as_sc_mcu7t3v3__buff_2
Xring.base_delay.stage\[157\].delay_cell.impl VDD VDD VSS
+ VSS ring.base_delay.stage\[156\].delay_cell.Z ring.base_delay.stage\[157\].delay_cell.Z
+ gf180mcu_as_sc_mcu7t3v3__buff_2
Xring.base_delay.stage\[158\].delay_cell.impl VDD VDD VSS
+ VSS ring.base_delay.stage\[157\].delay_cell.Z ring.base_delay.stage\[158\].delay_cell.Z
+ gf180mcu_as_sc_mcu7t3v3__buff_2
Xring.base_delay.stage\[159\].delay_cell.impl VDD VDD VSS
+ VSS ring.base_delay.stage\[158\].delay_cell.Z ring.base_delay.stage\[159\].delay_cell.Z
+ gf180mcu_as_sc_mcu7t3v3__buff_2
Xring.base_delay.stage\[15\].delay_cell.impl VDD VDD VSS VSS
+ ring.base_delay.stage\[14\].delay_cell.Z ring.base_delay.stage\[15\].delay_cell.Z
+ gf180mcu_as_sc_mcu7t3v3__buff_2
Xring.base_delay.stage\[160\].delay_cell.impl VDD VDD VSS
+ VSS ring.base_delay.stage\[159\].delay_cell.Z ring.base_delay.stage\[160\].delay_cell.Z
+ gf180mcu_as_sc_mcu7t3v3__buff_2
Xring.base_delay.stage\[161\].delay_cell.impl VDD VDD VSS
+ VSS ring.base_delay.stage\[160\].delay_cell.Z ring.base_delay.stage\[161\].delay_cell.Z
+ gf180mcu_as_sc_mcu7t3v3__buff_2
Xring.base_delay.stage\[162\].delay_cell.impl VDD VDD VSS
+ VSS ring.base_delay.stage\[161\].delay_cell.Z ring.base_delay.stage\[162\].delay_cell.Z
+ gf180mcu_as_sc_mcu7t3v3__buff_2
Xring.base_delay.stage\[163\].delay_cell.impl VDD VDD VSS
+ VSS ring.base_delay.stage\[162\].delay_cell.Z ring.base_delay.stage\[163\].delay_cell.Z
+ gf180mcu_as_sc_mcu7t3v3__buff_2
Xring.base_delay.stage\[164\].delay_cell.impl VDD VDD VSS
+ VSS ring.base_delay.stage\[163\].delay_cell.Z ring.base_delay.stage\[164\].delay_cell.Z
+ gf180mcu_as_sc_mcu7t3v3__buff_2
Xring.base_delay.stage\[165\].delay_cell.impl VDD VDD VSS
+ VSS ring.base_delay.stage\[164\].delay_cell.Z ring.base_delay.stage\[165\].delay_cell.Z
+ gf180mcu_as_sc_mcu7t3v3__buff_2
Xring.base_delay.stage\[166\].delay_cell.impl VDD VDD VSS
+ VSS ring.base_delay.stage\[165\].delay_cell.Z ring.base_delay.stage\[166\].delay_cell.Z
+ gf180mcu_as_sc_mcu7t3v3__buff_2
Xring.base_delay.stage\[167\].delay_cell.impl VDD VDD VSS
+ VSS ring.base_delay.stage\[166\].delay_cell.Z ring.base_delay.stage\[167\].delay_cell.Z
+ gf180mcu_as_sc_mcu7t3v3__buff_2
Xring.base_delay.stage\[168\].delay_cell.impl VDD VDD VSS
+ VSS ring.base_delay.stage\[167\].delay_cell.Z ring.base_delay.stage\[168\].delay_cell.Z
+ gf180mcu_as_sc_mcu7t3v3__buff_2
Xring.base_delay.stage\[169\].delay_cell.impl VDD VDD VSS
+ VSS ring.base_delay.stage\[168\].delay_cell.Z ring.base_delay.stage\[169\].delay_cell.Z
+ gf180mcu_as_sc_mcu7t3v3__buff_2
Xring.base_delay.stage\[16\].delay_cell.impl VDD VDD VSS VSS
+ ring.base_delay.stage\[15\].delay_cell.Z ring.base_delay.stage\[16\].delay_cell.Z
+ gf180mcu_as_sc_mcu7t3v3__buff_2
Xring.base_delay.stage\[170\].delay_cell.impl VDD VDD VSS
+ VSS ring.base_delay.stage\[169\].delay_cell.Z ring.base_delay.stage\[170\].delay_cell.Z
+ gf180mcu_as_sc_mcu7t3v3__buff_2
Xring.base_delay.stage\[171\].delay_cell.impl VDD VDD VSS
+ VSS ring.base_delay.stage\[170\].delay_cell.Z ring.base_delay.stage\[171\].delay_cell.Z
+ gf180mcu_as_sc_mcu7t3v3__buff_2
Xring.base_delay.stage\[172\].delay_cell.impl VDD VDD VSS
+ VSS ring.base_delay.stage\[171\].delay_cell.Z ring.base_delay.stage\[172\].delay_cell.Z
+ gf180mcu_as_sc_mcu7t3v3__buff_2
Xring.base_delay.stage\[173\].delay_cell.impl VDD VDD VSS
+ VSS ring.base_delay.stage\[172\].delay_cell.Z ring.base_delay.stage\[173\].delay_cell.Z
+ gf180mcu_as_sc_mcu7t3v3__buff_2
Xring.base_delay.stage\[174\].delay_cell.impl VDD VDD VSS
+ VSS ring.base_delay.stage\[173\].delay_cell.Z ring.base_delay.stage\[174\].delay_cell.Z
+ gf180mcu_as_sc_mcu7t3v3__buff_2
Xring.base_delay.stage\[175\].delay_cell.impl VDD VDD VSS
+ VSS ring.base_delay.stage\[174\].delay_cell.Z ring.base_delay.stage\[175\].delay_cell.Z
+ gf180mcu_as_sc_mcu7t3v3__buff_2
Xring.base_delay.stage\[176\].delay_cell.impl VDD VDD VSS
+ VSS ring.base_delay.stage\[175\].delay_cell.Z ring.base_delay.stage\[176\].delay_cell.Z
+ gf180mcu_as_sc_mcu7t3v3__buff_2
Xring.base_delay.stage\[177\].delay_cell.impl VDD VDD VSS
+ VSS ring.base_delay.stage\[176\].delay_cell.Z ring.base_delay.stage\[177\].delay_cell.Z
+ gf180mcu_as_sc_mcu7t3v3__buff_2
Xring.base_delay.stage\[178\].delay_cell.impl VDD VDD VSS
+ VSS ring.base_delay.stage\[177\].delay_cell.Z ring.base_delay.stage\[178\].delay_cell.Z
+ gf180mcu_as_sc_mcu7t3v3__buff_2
Xring.base_delay.stage\[179\].delay_cell.impl VDD VDD VSS
+ VSS ring.base_delay.stage\[178\].delay_cell.Z ring.base_delay.stage\[179\].delay_cell.Z
+ gf180mcu_as_sc_mcu7t3v3__buff_2
Xring.base_delay.stage\[17\].delay_cell.impl VDD VDD VSS VSS
+ ring.base_delay.stage\[16\].delay_cell.Z ring.base_delay.stage\[17\].delay_cell.Z
+ gf180mcu_as_sc_mcu7t3v3__buff_2
Xring.base_delay.stage\[180\].delay_cell.impl VDD VDD VSS
+ VSS ring.base_delay.stage\[179\].delay_cell.Z ring.base_delay.stage\[180\].delay_cell.Z
+ gf180mcu_as_sc_mcu7t3v3__buff_2
Xring.base_delay.stage\[181\].delay_cell.impl VDD VDD VSS
+ VSS ring.base_delay.stage\[180\].delay_cell.Z ring.base_delay.stage\[181\].delay_cell.Z
+ gf180mcu_as_sc_mcu7t3v3__buff_2
Xring.base_delay.stage\[182\].delay_cell.impl VDD VDD VSS
+ VSS ring.base_delay.stage\[181\].delay_cell.Z ring.base_delay.stage\[182\].delay_cell.Z
+ gf180mcu_as_sc_mcu7t3v3__buff_2
Xring.base_delay.stage\[183\].delay_cell.impl VDD VDD VSS
+ VSS ring.base_delay.stage\[182\].delay_cell.Z ring.base_delay.stage\[183\].delay_cell.Z
+ gf180mcu_as_sc_mcu7t3v3__buff_2
Xring.base_delay.stage\[184\].delay_cell.impl VDD VDD VSS
+ VSS ring.base_delay.stage\[183\].delay_cell.Z ring.base_delay.stage\[184\].delay_cell.Z
+ gf180mcu_as_sc_mcu7t3v3__buff_2
Xring.base_delay.stage\[185\].delay_cell.impl VDD VDD VSS
+ VSS ring.base_delay.stage\[184\].delay_cell.Z ring.base_delay.stage\[185\].delay_cell.Z
+ gf180mcu_as_sc_mcu7t3v3__buff_2
Xring.base_delay.stage\[186\].delay_cell.impl VDD VDD VSS
+ VSS ring.base_delay.stage\[185\].delay_cell.Z ring.base_delay.stage\[186\].delay_cell.Z
+ gf180mcu_as_sc_mcu7t3v3__buff_2
Xring.base_delay.stage\[187\].delay_cell.impl VDD VDD VSS
+ VSS ring.base_delay.stage\[186\].delay_cell.Z ring.base_delay.stage\[187\].delay_cell.Z
+ gf180mcu_as_sc_mcu7t3v3__buff_2
Xring.base_delay.stage\[188\].delay_cell.impl VDD VDD VSS
+ VSS ring.base_delay.stage\[187\].delay_cell.Z ring.base_delay.stage\[188\].delay_cell.Z
+ gf180mcu_as_sc_mcu7t3v3__buff_2
Xring.base_delay.stage\[189\].delay_cell.impl VDD VDD VSS
+ VSS ring.base_delay.stage\[188\].delay_cell.Z ring.base_delay.stage\[189\].delay_cell.Z
+ gf180mcu_as_sc_mcu7t3v3__buff_2
Xring.base_delay.stage\[18\].delay_cell.impl VDD VDD VSS VSS
+ ring.base_delay.stage\[17\].delay_cell.Z ring.base_delay.stage\[18\].delay_cell.Z
+ gf180mcu_as_sc_mcu7t3v3__buff_2
Xring.base_delay.stage\[190\].delay_cell.impl VDD VDD VSS
+ VSS ring.base_delay.stage\[189\].delay_cell.Z ring.base_delay.stage\[190\].delay_cell.Z
+ gf180mcu_as_sc_mcu7t3v3__buff_2
Xring.base_delay.stage\[191\].delay_cell.impl VDD VDD VSS
+ VSS ring.base_delay.stage\[190\].delay_cell.Z ring.base_delay.stage\[191\].delay_cell.Z
+ gf180mcu_as_sc_mcu7t3v3__buff_2
Xring.base_delay.stage\[192\].delay_cell.impl VDD VDD VSS
+ VSS ring.base_delay.stage\[191\].delay_cell.Z ring.base_delay.stage\[192\].delay_cell.Z
+ gf180mcu_as_sc_mcu7t3v3__buff_2
Xring.base_delay.stage\[193\].delay_cell.impl VDD VDD VSS
+ VSS ring.base_delay.stage\[192\].delay_cell.Z ring.base_delay.stage\[193\].delay_cell.Z
+ gf180mcu_as_sc_mcu7t3v3__buff_2
Xring.base_delay.stage\[194\].delay_cell.impl VDD VDD VSS
+ VSS ring.base_delay.stage\[193\].delay_cell.Z ring.base_delay.stage\[194\].delay_cell.Z
+ gf180mcu_as_sc_mcu7t3v3__buff_2
Xring.base_delay.stage\[195\].delay_cell.impl VDD VDD VSS
+ VSS ring.base_delay.stage\[194\].delay_cell.Z ring.base_delay.stage\[195\].delay_cell.Z
+ gf180mcu_as_sc_mcu7t3v3__buff_2
Xring.base_delay.stage\[196\].delay_cell.impl VDD VDD VSS
+ VSS ring.base_delay.stage\[195\].delay_cell.Z ring.base_delay.stage\[196\].delay_cell.Z
+ gf180mcu_as_sc_mcu7t3v3__buff_2
Xring.base_delay.stage\[197\].delay_cell.impl VDD VDD VSS
+ VSS ring.base_delay.stage\[196\].delay_cell.Z ring.base_delay.stage\[197\].delay_cell.Z
+ gf180mcu_as_sc_mcu7t3v3__buff_2
Xring.base_delay.stage\[198\].delay_cell.impl VDD VDD VSS
+ VSS ring.base_delay.stage\[197\].delay_cell.Z ring.base_delay.stage\[198\].delay_cell.Z
+ gf180mcu_as_sc_mcu7t3v3__buff_2
Xring.base_delay.stage\[199\].delay_cell.impl VDD VDD VSS
+ VSS ring.base_delay.stage\[198\].delay_cell.Z ring.base_delay.stage\[199\].delay_cell.Z
+ gf180mcu_as_sc_mcu7t3v3__buff_2
Xring.base_delay.stage\[19\].delay_cell.impl VDD VDD VSS VSS
+ ring.base_delay.stage\[18\].delay_cell.Z ring.base_delay.stage\[19\].delay_cell.Z
+ gf180mcu_as_sc_mcu7t3v3__buff_2
Xring.base_delay.stage\[1\].delay_cell.impl VDD VDD VSS VSS
+ ring.base_delay.stage\[0\].delay_cell.Z ring.base_delay.stage\[1\].delay_cell.Z
+ gf180mcu_as_sc_mcu7t3v3__buff_2
Xring.base_delay.stage\[200\].delay_cell.impl VDD VDD VSS
+ VSS ring.base_delay.stage\[199\].delay_cell.Z ring.base_delay.stage\[200\].delay_cell.Z
+ gf180mcu_as_sc_mcu7t3v3__buff_2
Xring.base_delay.stage\[201\].delay_cell.impl VDD VDD VSS
+ VSS ring.base_delay.stage\[200\].delay_cell.Z ring.base_delay.stage\[201\].delay_cell.Z
+ gf180mcu_as_sc_mcu7t3v3__buff_2
Xring.base_delay.stage\[202\].delay_cell.impl VDD VDD VSS
+ VSS ring.base_delay.stage\[201\].delay_cell.Z ring.base_delay.stage\[202\].delay_cell.Z
+ gf180mcu_as_sc_mcu7t3v3__buff_2
Xring.base_delay.stage\[203\].delay_cell.impl VDD VDD VSS
+ VSS ring.base_delay.stage\[202\].delay_cell.Z ring.base_delay.stage\[203\].delay_cell.Z
+ gf180mcu_as_sc_mcu7t3v3__buff_2
Xring.base_delay.stage\[204\].delay_cell.impl VDD VDD VSS
+ VSS ring.base_delay.stage\[203\].delay_cell.Z ring.base_delay.stage\[204\].delay_cell.Z
+ gf180mcu_as_sc_mcu7t3v3__buff_2
Xring.base_delay.stage\[205\].delay_cell.impl VDD VDD VSS
+ VSS ring.base_delay.stage\[204\].delay_cell.Z ring.base_delay.stage\[205\].delay_cell.Z
+ gf180mcu_as_sc_mcu7t3v3__buff_2
Xring.base_delay.stage\[206\].delay_cell.impl VDD VDD VSS
+ VSS ring.base_delay.stage\[205\].delay_cell.Z ring.base_delay.stage\[206\].delay_cell.Z
+ gf180mcu_as_sc_mcu7t3v3__buff_2
Xring.base_delay.stage\[207\].delay_cell.impl VDD VDD VSS
+ VSS ring.base_delay.stage\[206\].delay_cell.Z ring.base_delay.stage\[207\].delay_cell.Z
+ gf180mcu_as_sc_mcu7t3v3__buff_2
Xring.base_delay.stage\[208\].delay_cell.impl VDD VDD VSS
+ VSS ring.base_delay.stage\[207\].delay_cell.Z ring.base_delay.stage\[208\].delay_cell.Z
+ gf180mcu_as_sc_mcu7t3v3__buff_2
Xring.base_delay.stage\[209\].delay_cell.impl VDD VDD VSS
+ VSS ring.base_delay.stage\[208\].delay_cell.Z ring.base_delay.stage\[209\].delay_cell.Z
+ gf180mcu_as_sc_mcu7t3v3__buff_2
Xring.base_delay.stage\[20\].delay_cell.impl VDD VDD VSS VSS
+ ring.base_delay.stage\[19\].delay_cell.Z ring.base_delay.stage\[20\].delay_cell.Z
+ gf180mcu_as_sc_mcu7t3v3__buff_2
Xring.base_delay.stage\[210\].delay_cell.impl VDD VDD VSS
+ VSS ring.base_delay.stage\[209\].delay_cell.Z ring.base_delay.stage\[210\].delay_cell.Z
+ gf180mcu_as_sc_mcu7t3v3__buff_2
Xring.base_delay.stage\[211\].delay_cell.impl VDD VDD VSS
+ VSS ring.base_delay.stage\[210\].delay_cell.Z ring.base_delay.stage\[211\].delay_cell.Z
+ gf180mcu_as_sc_mcu7t3v3__buff_2
Xring.base_delay.stage\[212\].delay_cell.impl VDD VDD VSS
+ VSS ring.base_delay.stage\[211\].delay_cell.Z ring.base_delay.stage\[212\].delay_cell.Z
+ gf180mcu_as_sc_mcu7t3v3__buff_2
Xring.base_delay.stage\[213\].delay_cell.impl VDD VDD VSS
+ VSS ring.base_delay.stage\[212\].delay_cell.Z ring.base_delay.stage\[213\].delay_cell.Z
+ gf180mcu_as_sc_mcu7t3v3__buff_2
Xring.base_delay.stage\[214\].delay_cell.impl VDD VDD VSS
+ VSS ring.base_delay.stage\[213\].delay_cell.Z ring.base_delay.stage\[214\].delay_cell.Z
+ gf180mcu_as_sc_mcu7t3v3__buff_2
Xring.base_delay.stage\[215\].delay_cell.impl VDD VDD VSS
+ VSS ring.base_delay.stage\[214\].delay_cell.Z ring.base_delay.stage\[215\].delay_cell.Z
+ gf180mcu_as_sc_mcu7t3v3__buff_2
Xring.base_delay.stage\[216\].delay_cell.impl VDD VDD VSS
+ VSS ring.base_delay.stage\[215\].delay_cell.Z ring.base_delay.stage\[216\].delay_cell.Z
+ gf180mcu_as_sc_mcu7t3v3__buff_2
Xring.base_delay.stage\[217\].delay_cell.impl VDD VDD VSS
+ VSS ring.base_delay.stage\[216\].delay_cell.Z ring.base_delay.stage\[217\].delay_cell.Z
+ gf180mcu_as_sc_mcu7t3v3__buff_2
Xring.base_delay.stage\[218\].delay_cell.impl VDD VDD VSS
+ VSS ring.base_delay.stage\[217\].delay_cell.Z ring.base_delay.stage\[218\].delay_cell.Z
+ gf180mcu_as_sc_mcu7t3v3__buff_2
Xring.base_delay.stage\[219\].delay_cell.impl VDD VDD VSS
+ VSS ring.base_delay.stage\[218\].delay_cell.Z ring.base_delay.stage\[219\].delay_cell.Z
+ gf180mcu_as_sc_mcu7t3v3__buff_2
Xring.base_delay.stage\[21\].delay_cell.impl VDD VDD VSS VSS
+ ring.base_delay.stage\[20\].delay_cell.Z ring.base_delay.stage\[21\].delay_cell.Z
+ gf180mcu_as_sc_mcu7t3v3__buff_2
Xring.base_delay.stage\[220\].delay_cell.impl VDD VDD VSS
+ VSS ring.base_delay.stage\[219\].delay_cell.Z ring.base_delay.stage\[220\].delay_cell.Z
+ gf180mcu_as_sc_mcu7t3v3__buff_2
Xring.base_delay.stage\[221\].delay_cell.impl VDD VDD VSS
+ VSS ring.base_delay.stage\[220\].delay_cell.Z ring.base_delay.stage\[221\].delay_cell.Z
+ gf180mcu_as_sc_mcu7t3v3__buff_2
Xring.base_delay.stage\[222\].delay_cell.impl VDD VDD VSS
+ VSS ring.base_delay.stage\[221\].delay_cell.Z ring.base_delay.stage\[222\].delay_cell.Z
+ gf180mcu_as_sc_mcu7t3v3__buff_2
Xring.base_delay.stage\[223\].delay_cell.impl VDD VDD VSS
+ VSS ring.base_delay.stage\[222\].delay_cell.Z ring.base_delay.stage\[223\].delay_cell.Z
+ gf180mcu_as_sc_mcu7t3v3__buff_2
Xring.base_delay.stage\[224\].delay_cell.impl VDD VDD VSS
+ VSS ring.base_delay.stage\[223\].delay_cell.Z ring.base_delay.stage\[224\].delay_cell.Z
+ gf180mcu_as_sc_mcu7t3v3__buff_2
Xring.base_delay.stage\[225\].delay_cell.impl VDD VDD VSS
+ VSS ring.base_delay.stage\[224\].delay_cell.Z ring.base_delay.stage\[225\].delay_cell.Z
+ gf180mcu_as_sc_mcu7t3v3__buff_2
Xring.base_delay.stage\[226\].delay_cell.impl VDD VDD VSS
+ VSS ring.base_delay.stage\[225\].delay_cell.Z ring.base_delay.stage\[226\].delay_cell.Z
+ gf180mcu_as_sc_mcu7t3v3__buff_2
Xring.base_delay.stage\[227\].delay_cell.impl VDD VDD VSS
+ VSS ring.base_delay.stage\[226\].delay_cell.Z ring.base_delay.stage\[227\].delay_cell.Z
+ gf180mcu_as_sc_mcu7t3v3__buff_2
Xring.base_delay.stage\[228\].delay_cell.impl VDD VDD VSS
+ VSS ring.base_delay.stage\[227\].delay_cell.Z ring.base_delay.stage\[228\].delay_cell.Z
+ gf180mcu_as_sc_mcu7t3v3__buff_2
Xring.base_delay.stage\[229\].delay_cell.impl VDD VDD VSS
+ VSS ring.base_delay.stage\[228\].delay_cell.Z ring.base_delay.stage\[229\].delay_cell.Z
+ gf180mcu_as_sc_mcu7t3v3__buff_2
Xring.base_delay.stage\[22\].delay_cell.impl VDD VDD VSS VSS
+ ring.base_delay.stage\[21\].delay_cell.Z ring.base_delay.stage\[22\].delay_cell.Z
+ gf180mcu_as_sc_mcu7t3v3__buff_2
Xring.base_delay.stage\[230\].delay_cell.impl VDD VDD VSS
+ VSS ring.base_delay.stage\[229\].delay_cell.Z ring.base_delay.stage\[230\].delay_cell.Z
+ gf180mcu_as_sc_mcu7t3v3__buff_2
Xring.base_delay.stage\[231\].delay_cell.impl VDD VDD VSS
+ VSS ring.base_delay.stage\[230\].delay_cell.Z ring.base_delay.stage\[231\].delay_cell.Z
+ gf180mcu_as_sc_mcu7t3v3__buff_2
Xring.base_delay.stage\[232\].delay_cell.impl VDD VDD VSS
+ VSS ring.base_delay.stage\[231\].delay_cell.Z ring.base_delay.stage\[232\].delay_cell.Z
+ gf180mcu_as_sc_mcu7t3v3__buff_2
Xring.base_delay.stage\[233\].delay_cell.impl VDD VDD VSS
+ VSS ring.base_delay.stage\[232\].delay_cell.Z ring.base_delay.stage\[233\].delay_cell.Z
+ gf180mcu_as_sc_mcu7t3v3__buff_2
Xring.base_delay.stage\[234\].delay_cell.impl VDD VDD VSS
+ VSS ring.base_delay.stage\[233\].delay_cell.Z ring.base_delay.stage\[234\].delay_cell.Z
+ gf180mcu_as_sc_mcu7t3v3__buff_2
Xring.base_delay.stage\[235\].delay_cell.impl VDD VDD VSS
+ VSS ring.base_delay.stage\[234\].delay_cell.Z ring.base_delay.stage\[235\].delay_cell.Z
+ gf180mcu_as_sc_mcu7t3v3__buff_2
Xring.base_delay.stage\[236\].delay_cell.impl VDD VDD VSS
+ VSS ring.base_delay.stage\[235\].delay_cell.Z ring.base_delay.stage\[236\].delay_cell.Z
+ gf180mcu_as_sc_mcu7t3v3__buff_2
Xring.base_delay.stage\[237\].delay_cell.impl VDD VDD VSS
+ VSS ring.base_delay.stage\[236\].delay_cell.Z ring.base_delay.stage\[237\].delay_cell.Z
+ gf180mcu_as_sc_mcu7t3v3__buff_2
Xring.base_delay.stage\[238\].delay_cell.impl VDD VDD VSS
+ VSS ring.base_delay.stage\[237\].delay_cell.Z ring.base_delay.stage\[238\].delay_cell.Z
+ gf180mcu_as_sc_mcu7t3v3__buff_2
Xring.base_delay.stage\[239\].delay_cell.impl VDD VDD VSS
+ VSS ring.base_delay.stage\[238\].delay_cell.Z ring.base_delay.stage\[239\].delay_cell.Z
+ gf180mcu_as_sc_mcu7t3v3__buff_2
Xring.base_delay.stage\[23\].delay_cell.impl VDD VDD VSS VSS
+ ring.base_delay.stage\[22\].delay_cell.Z ring.base_delay.stage\[23\].delay_cell.Z
+ gf180mcu_as_sc_mcu7t3v3__buff_2
Xring.base_delay.stage\[240\].delay_cell.impl VDD VDD VSS
+ VSS ring.base_delay.stage\[239\].delay_cell.Z ring.base_delay.stage\[240\].delay_cell.Z
+ gf180mcu_as_sc_mcu7t3v3__buff_2
Xring.base_delay.stage\[241\].delay_cell.impl VDD VDD VSS
+ VSS ring.base_delay.stage\[240\].delay_cell.Z ring.base_delay.stage\[241\].delay_cell.Z
+ gf180mcu_as_sc_mcu7t3v3__buff_2
Xring.base_delay.stage\[242\].delay_cell.impl VDD VDD VSS
+ VSS ring.base_delay.stage\[241\].delay_cell.Z ring.base_delay.stage\[242\].delay_cell.Z
+ gf180mcu_as_sc_mcu7t3v3__buff_2
Xring.base_delay.stage\[243\].delay_cell.impl VDD VDD VSS
+ VSS ring.base_delay.stage\[242\].delay_cell.Z ring.base_delay.stage\[243\].delay_cell.Z
+ gf180mcu_as_sc_mcu7t3v3__buff_2
Xring.base_delay.stage\[244\].delay_cell.impl VDD VDD VSS
+ VSS ring.base_delay.stage\[243\].delay_cell.Z ring.base_delay.stage\[244\].delay_cell.Z
+ gf180mcu_as_sc_mcu7t3v3__buff_2
Xring.base_delay.stage\[245\].delay_cell.impl VDD VDD VSS
+ VSS ring.base_delay.stage\[244\].delay_cell.Z ring.base_delay.stage\[245\].delay_cell.Z
+ gf180mcu_as_sc_mcu7t3v3__buff_2
Xring.base_delay.stage\[246\].delay_cell.impl VDD VDD VSS
+ VSS ring.base_delay.stage\[245\].delay_cell.Z ring.base_delay.stage\[246\].delay_cell.Z
+ gf180mcu_as_sc_mcu7t3v3__buff_2
Xring.base_delay.stage\[247\].delay_cell.impl VDD VDD VSS
+ VSS ring.base_delay.stage\[246\].delay_cell.Z ring.base_delay.stage\[247\].delay_cell.Z
+ gf180mcu_as_sc_mcu7t3v3__buff_2
Xring.base_delay.stage\[248\].delay_cell.impl VDD VDD VSS
+ VSS ring.base_delay.stage\[247\].delay_cell.Z ring.base_delay.stage\[248\].delay_cell.Z
+ gf180mcu_as_sc_mcu7t3v3__buff_2
Xring.base_delay.stage\[249\].delay_cell.impl VDD VDD VSS
+ VSS ring.base_delay.stage\[248\].delay_cell.Z ring.base_delay.stage\[249\].delay_cell.Z
+ gf180mcu_as_sc_mcu7t3v3__buff_2
Xring.base_delay.stage\[24\].delay_cell.impl VDD VDD VSS VSS
+ ring.base_delay.stage\[23\].delay_cell.Z ring.base_delay.stage\[24\].delay_cell.Z
+ gf180mcu_as_sc_mcu7t3v3__buff_2
Xring.base_delay.stage\[250\].delay_cell.impl VDD VDD VSS
+ VSS ring.base_delay.stage\[249\].delay_cell.Z ring.base_delay.stage\[250\].delay_cell.Z
+ gf180mcu_as_sc_mcu7t3v3__buff_2
Xring.base_delay.stage\[251\].delay_cell.impl VDD VDD VSS
+ VSS ring.base_delay.stage\[250\].delay_cell.Z ring.base_delay.stage\[251\].delay_cell.Z
+ gf180mcu_as_sc_mcu7t3v3__buff_2
Xring.base_delay.stage\[252\].delay_cell.impl VDD VDD VSS
+ VSS ring.base_delay.stage\[251\].delay_cell.Z ring.base_delay.stage\[252\].delay_cell.Z
+ gf180mcu_as_sc_mcu7t3v3__buff_2
Xring.base_delay.stage\[253\].delay_cell.impl VDD VDD VSS
+ VSS ring.base_delay.stage\[252\].delay_cell.Z ring.base_delay.stage\[253\].delay_cell.Z
+ gf180mcu_as_sc_mcu7t3v3__buff_2
Xring.base_delay.stage\[254\].delay_cell.impl VDD VDD VSS
+ VSS ring.base_delay.stage\[253\].delay_cell.Z ring.base_delay.stage\[254\].delay_cell.Z
+ gf180mcu_as_sc_mcu7t3v3__buff_2
Xring.base_delay.stage\[255\].delay_cell.impl VDD VDD VSS
+ VSS ring.base_delay.stage\[254\].delay_cell.Z ring.DCO_IN
+ gf180mcu_as_sc_mcu7t3v3__buff_2
Xring.base_delay.stage\[25\].delay_cell.impl VDD VDD VSS VSS
+ ring.base_delay.stage\[24\].delay_cell.Z ring.base_delay.stage\[25\].delay_cell.Z
+ gf180mcu_as_sc_mcu7t3v3__buff_2
Xring.base_delay.stage\[26\].delay_cell.impl VDD VDD VSS VSS
+ ring.base_delay.stage\[25\].delay_cell.Z ring.base_delay.stage\[26\].delay_cell.Z
+ gf180mcu_as_sc_mcu7t3v3__buff_2
Xring.base_delay.stage\[27\].delay_cell.impl VDD VDD VSS VSS
+ ring.base_delay.stage\[26\].delay_cell.Z ring.base_delay.stage\[27\].delay_cell.Z
+ gf180mcu_as_sc_mcu7t3v3__buff_2
Xring.base_delay.stage\[28\].delay_cell.impl VDD VDD VSS VSS
+ ring.base_delay.stage\[27\].delay_cell.Z ring.base_delay.stage\[28\].delay_cell.Z
+ gf180mcu_as_sc_mcu7t3v3__buff_2
Xring.base_delay.stage\[29\].delay_cell.impl VDD VDD VSS VSS
+ ring.base_delay.stage\[28\].delay_cell.Z ring.base_delay.stage\[29\].delay_cell.Z
+ gf180mcu_as_sc_mcu7t3v3__buff_2
Xring.base_delay.stage\[2\].delay_cell.impl VDD VDD VSS VSS
+ ring.base_delay.stage\[1\].delay_cell.Z ring.base_delay.stage\[2\].delay_cell.Z
+ gf180mcu_as_sc_mcu7t3v3__buff_2
Xring.base_delay.stage\[30\].delay_cell.impl VDD VDD VSS VSS
+ ring.base_delay.stage\[29\].delay_cell.Z ring.base_delay.stage\[30\].delay_cell.Z
+ gf180mcu_as_sc_mcu7t3v3__buff_2
Xring.base_delay.stage\[31\].delay_cell.impl VDD VDD VSS VSS
+ ring.base_delay.stage\[30\].delay_cell.Z ring.base_delay.stage\[31\].delay_cell.Z
+ gf180mcu_as_sc_mcu7t3v3__buff_2
Xring.base_delay.stage\[32\].delay_cell.impl VDD VDD VSS VSS
+ ring.base_delay.stage\[31\].delay_cell.Z ring.base_delay.stage\[32\].delay_cell.Z
+ gf180mcu_as_sc_mcu7t3v3__buff_2
Xring.base_delay.stage\[33\].delay_cell.impl VDD VDD VSS VSS
+ ring.base_delay.stage\[32\].delay_cell.Z ring.base_delay.stage\[33\].delay_cell.Z
+ gf180mcu_as_sc_mcu7t3v3__buff_2
Xring.base_delay.stage\[34\].delay_cell.impl VDD VDD VSS VSS
+ ring.base_delay.stage\[33\].delay_cell.Z ring.base_delay.stage\[34\].delay_cell.Z
+ gf180mcu_as_sc_mcu7t3v3__buff_2
Xring.base_delay.stage\[35\].delay_cell.impl VDD VDD VSS VSS
+ ring.base_delay.stage\[34\].delay_cell.Z ring.base_delay.stage\[35\].delay_cell.Z
+ gf180mcu_as_sc_mcu7t3v3__buff_2
Xring.base_delay.stage\[36\].delay_cell.impl VDD VDD VSS VSS
+ ring.base_delay.stage\[35\].delay_cell.Z ring.base_delay.stage\[36\].delay_cell.Z
+ gf180mcu_as_sc_mcu7t3v3__buff_2
Xring.base_delay.stage\[37\].delay_cell.impl VDD VDD VSS VSS
+ ring.base_delay.stage\[36\].delay_cell.Z ring.base_delay.stage\[37\].delay_cell.Z
+ gf180mcu_as_sc_mcu7t3v3__buff_2
Xring.base_delay.stage\[38\].delay_cell.impl VDD VDD VSS VSS
+ ring.base_delay.stage\[37\].delay_cell.Z ring.base_delay.stage\[38\].delay_cell.Z
+ gf180mcu_as_sc_mcu7t3v3__buff_2
Xring.base_delay.stage\[39\].delay_cell.impl VDD VDD VSS VSS
+ ring.base_delay.stage\[38\].delay_cell.Z ring.base_delay.stage\[39\].delay_cell.Z
+ gf180mcu_as_sc_mcu7t3v3__buff_2
Xring.base_delay.stage\[3\].delay_cell.impl VDD VDD VSS VSS
+ ring.base_delay.stage\[2\].delay_cell.Z ring.base_delay.stage\[3\].delay_cell.Z
+ gf180mcu_as_sc_mcu7t3v3__buff_2
Xring.base_delay.stage\[40\].delay_cell.impl VDD VDD VSS VSS
+ ring.base_delay.stage\[39\].delay_cell.Z ring.base_delay.stage\[40\].delay_cell.Z
+ gf180mcu_as_sc_mcu7t3v3__buff_2
Xring.base_delay.stage\[41\].delay_cell.impl VDD VDD VSS VSS
+ ring.base_delay.stage\[40\].delay_cell.Z ring.base_delay.stage\[41\].delay_cell.Z
+ gf180mcu_as_sc_mcu7t3v3__buff_2
Xring.base_delay.stage\[42\].delay_cell.impl VDD VDD VSS VSS
+ ring.base_delay.stage\[41\].delay_cell.Z ring.base_delay.stage\[42\].delay_cell.Z
+ gf180mcu_as_sc_mcu7t3v3__buff_2
Xring.base_delay.stage\[43\].delay_cell.impl VDD VDD VSS VSS
+ ring.base_delay.stage\[42\].delay_cell.Z ring.base_delay.stage\[43\].delay_cell.Z
+ gf180mcu_as_sc_mcu7t3v3__buff_2
Xring.base_delay.stage\[44\].delay_cell.impl VDD VDD VSS VSS
+ ring.base_delay.stage\[43\].delay_cell.Z ring.base_delay.stage\[44\].delay_cell.Z
+ gf180mcu_as_sc_mcu7t3v3__buff_2
Xring.base_delay.stage\[45\].delay_cell.impl VDD VDD VSS VSS
+ ring.base_delay.stage\[44\].delay_cell.Z ring.base_delay.stage\[45\].delay_cell.Z
+ gf180mcu_as_sc_mcu7t3v3__buff_2
Xring.base_delay.stage\[46\].delay_cell.impl VDD VDD VSS VSS
+ ring.base_delay.stage\[45\].delay_cell.Z ring.base_delay.stage\[46\].delay_cell.Z
+ gf180mcu_as_sc_mcu7t3v3__buff_2
Xring.base_delay.stage\[47\].delay_cell.impl VDD VDD VSS VSS
+ ring.base_delay.stage\[46\].delay_cell.Z ring.base_delay.stage\[47\].delay_cell.Z
+ gf180mcu_as_sc_mcu7t3v3__buff_2
Xring.base_delay.stage\[48\].delay_cell.impl VDD VDD VSS VSS
+ ring.base_delay.stage\[47\].delay_cell.Z ring.base_delay.stage\[48\].delay_cell.Z
+ gf180mcu_as_sc_mcu7t3v3__buff_2
Xring.base_delay.stage\[49\].delay_cell.impl VDD VDD VSS VSS
+ ring.base_delay.stage\[48\].delay_cell.Z ring.base_delay.stage\[49\].delay_cell.Z
+ gf180mcu_as_sc_mcu7t3v3__buff_2
Xring.base_delay.stage\[4\].delay_cell.impl VDD VDD VSS VSS
+ ring.base_delay.stage\[3\].delay_cell.Z ring.base_delay.stage\[4\].delay_cell.Z
+ gf180mcu_as_sc_mcu7t3v3__buff_2
Xring.base_delay.stage\[50\].delay_cell.impl VDD VDD VSS VSS
+ ring.base_delay.stage\[49\].delay_cell.Z ring.base_delay.stage\[50\].delay_cell.Z
+ gf180mcu_as_sc_mcu7t3v3__buff_2
Xring.base_delay.stage\[51\].delay_cell.impl VDD VDD VSS VSS
+ ring.base_delay.stage\[50\].delay_cell.Z ring.base_delay.stage\[51\].delay_cell.Z
+ gf180mcu_as_sc_mcu7t3v3__buff_2
Xring.base_delay.stage\[52\].delay_cell.impl VDD VDD VSS VSS
+ ring.base_delay.stage\[51\].delay_cell.Z ring.base_delay.stage\[52\].delay_cell.Z
+ gf180mcu_as_sc_mcu7t3v3__buff_2
Xring.base_delay.stage\[53\].delay_cell.impl VDD VDD VSS VSS
+ ring.base_delay.stage\[52\].delay_cell.Z ring.base_delay.stage\[53\].delay_cell.Z
+ gf180mcu_as_sc_mcu7t3v3__buff_2
Xring.base_delay.stage\[54\].delay_cell.impl VDD VDD VSS VSS
+ ring.base_delay.stage\[53\].delay_cell.Z ring.base_delay.stage\[54\].delay_cell.Z
+ gf180mcu_as_sc_mcu7t3v3__buff_2
Xring.base_delay.stage\[55\].delay_cell.impl VDD VDD VSS VSS
+ ring.base_delay.stage\[54\].delay_cell.Z ring.base_delay.stage\[55\].delay_cell.Z
+ gf180mcu_as_sc_mcu7t3v3__buff_2
Xring.base_delay.stage\[56\].delay_cell.impl VDD VDD VSS VSS
+ ring.base_delay.stage\[55\].delay_cell.Z ring.base_delay.stage\[56\].delay_cell.Z
+ gf180mcu_as_sc_mcu7t3v3__buff_2
Xring.base_delay.stage\[57\].delay_cell.impl VDD VDD VSS VSS
+ ring.base_delay.stage\[56\].delay_cell.Z ring.base_delay.stage\[57\].delay_cell.Z
+ gf180mcu_as_sc_mcu7t3v3__buff_2
Xring.base_delay.stage\[58\].delay_cell.impl VDD VDD VSS VSS
+ ring.base_delay.stage\[57\].delay_cell.Z ring.base_delay.stage\[58\].delay_cell.Z
+ gf180mcu_as_sc_mcu7t3v3__buff_2
Xring.base_delay.stage\[59\].delay_cell.impl VDD VDD VSS VSS
+ ring.base_delay.stage\[58\].delay_cell.Z ring.base_delay.stage\[59\].delay_cell.Z
+ gf180mcu_as_sc_mcu7t3v3__buff_2
Xring.base_delay.stage\[5\].delay_cell.impl VDD VDD VSS VSS
+ ring.base_delay.stage\[4\].delay_cell.Z ring.base_delay.stage\[5\].delay_cell.Z
+ gf180mcu_as_sc_mcu7t3v3__buff_2
Xring.base_delay.stage\[60\].delay_cell.impl VDD VDD VSS VSS
+ ring.base_delay.stage\[59\].delay_cell.Z ring.base_delay.stage\[60\].delay_cell.Z
+ gf180mcu_as_sc_mcu7t3v3__buff_2
Xring.base_delay.stage\[61\].delay_cell.impl VDD VDD VSS VSS
+ ring.base_delay.stage\[60\].delay_cell.Z ring.base_delay.stage\[61\].delay_cell.Z
+ gf180mcu_as_sc_mcu7t3v3__buff_2
Xring.base_delay.stage\[62\].delay_cell.impl VDD VDD VSS VSS
+ ring.base_delay.stage\[61\].delay_cell.Z ring.base_delay.stage\[62\].delay_cell.Z
+ gf180mcu_as_sc_mcu7t3v3__buff_2
Xring.base_delay.stage\[63\].delay_cell.impl VDD VDD VSS VSS
+ ring.base_delay.stage\[62\].delay_cell.Z ring.base_delay.stage\[63\].delay_cell.Z
+ gf180mcu_as_sc_mcu7t3v3__buff_2
Xring.base_delay.stage\[64\].delay_cell.impl VDD VDD VSS VSS
+ ring.base_delay.stage\[63\].delay_cell.Z ring.base_delay.stage\[64\].delay_cell.Z
+ gf180mcu_as_sc_mcu7t3v3__buff_2
Xring.base_delay.stage\[65\].delay_cell.impl VDD VDD VSS VSS
+ ring.base_delay.stage\[64\].delay_cell.Z ring.base_delay.stage\[65\].delay_cell.Z
+ gf180mcu_as_sc_mcu7t3v3__buff_2
Xring.base_delay.stage\[66\].delay_cell.impl VDD VDD VSS VSS
+ ring.base_delay.stage\[65\].delay_cell.Z ring.base_delay.stage\[66\].delay_cell.Z
+ gf180mcu_as_sc_mcu7t3v3__buff_2
Xring.base_delay.stage\[67\].delay_cell.impl VDD VDD VSS VSS
+ ring.base_delay.stage\[66\].delay_cell.Z ring.base_delay.stage\[67\].delay_cell.Z
+ gf180mcu_as_sc_mcu7t3v3__buff_2
Xring.base_delay.stage\[68\].delay_cell.impl VDD VDD VSS VSS
+ ring.base_delay.stage\[67\].delay_cell.Z ring.base_delay.stage\[68\].delay_cell.Z
+ gf180mcu_as_sc_mcu7t3v3__buff_2
Xring.base_delay.stage\[69\].delay_cell.impl VDD VDD VSS VSS
+ ring.base_delay.stage\[68\].delay_cell.Z ring.base_delay.stage\[69\].delay_cell.Z
+ gf180mcu_as_sc_mcu7t3v3__buff_2
Xring.base_delay.stage\[6\].delay_cell.impl VDD VDD VSS VSS
+ ring.base_delay.stage\[5\].delay_cell.Z ring.base_delay.stage\[6\].delay_cell.Z
+ gf180mcu_as_sc_mcu7t3v3__buff_2
Xring.base_delay.stage\[70\].delay_cell.impl VDD VDD VSS VSS
+ ring.base_delay.stage\[69\].delay_cell.Z ring.base_delay.stage\[70\].delay_cell.Z
+ gf180mcu_as_sc_mcu7t3v3__buff_2
Xring.base_delay.stage\[71\].delay_cell.impl VDD VDD VSS VSS
+ ring.base_delay.stage\[70\].delay_cell.Z ring.base_delay.stage\[71\].delay_cell.Z
+ gf180mcu_as_sc_mcu7t3v3__buff_2
Xring.base_delay.stage\[72\].delay_cell.impl VDD VDD VSS VSS
+ ring.base_delay.stage\[71\].delay_cell.Z ring.base_delay.stage\[72\].delay_cell.Z
+ gf180mcu_as_sc_mcu7t3v3__buff_2
Xring.base_delay.stage\[73\].delay_cell.impl VDD VDD VSS VSS
+ ring.base_delay.stage\[72\].delay_cell.Z ring.base_delay.stage\[73\].delay_cell.Z
+ gf180mcu_as_sc_mcu7t3v3__buff_2
Xring.base_delay.stage\[74\].delay_cell.impl VDD VDD VSS VSS
+ ring.base_delay.stage\[73\].delay_cell.Z ring.base_delay.stage\[74\].delay_cell.Z
+ gf180mcu_as_sc_mcu7t3v3__buff_2
Xring.base_delay.stage\[75\].delay_cell.impl VDD VDD VSS VSS
+ ring.base_delay.stage\[74\].delay_cell.Z ring.base_delay.stage\[75\].delay_cell.Z
+ gf180mcu_as_sc_mcu7t3v3__buff_2
Xring.base_delay.stage\[76\].delay_cell.impl VDD VDD VSS VSS
+ ring.base_delay.stage\[75\].delay_cell.Z ring.base_delay.stage\[76\].delay_cell.Z
+ gf180mcu_as_sc_mcu7t3v3__buff_2
Xring.base_delay.stage\[77\].delay_cell.impl VDD VDD VSS VSS
+ ring.base_delay.stage\[76\].delay_cell.Z ring.base_delay.stage\[77\].delay_cell.Z
+ gf180mcu_as_sc_mcu7t3v3__buff_2
Xring.base_delay.stage\[78\].delay_cell.impl VDD VDD VSS VSS
+ ring.base_delay.stage\[77\].delay_cell.Z ring.base_delay.stage\[78\].delay_cell.Z
+ gf180mcu_as_sc_mcu7t3v3__buff_2
Xring.base_delay.stage\[79\].delay_cell.impl VDD VDD VSS VSS
+ ring.base_delay.stage\[78\].delay_cell.Z ring.base_delay.stage\[79\].delay_cell.Z
+ gf180mcu_as_sc_mcu7t3v3__buff_2
Xring.base_delay.stage\[7\].delay_cell.impl VDD VDD VSS VSS
+ ring.base_delay.stage\[6\].delay_cell.Z ring.base_delay.stage\[7\].delay_cell.Z
+ gf180mcu_as_sc_mcu7t3v3__buff_2
Xring.base_delay.stage\[80\].delay_cell.impl VDD VDD VSS VSS
+ ring.base_delay.stage\[79\].delay_cell.Z ring.base_delay.stage\[80\].delay_cell.Z
+ gf180mcu_as_sc_mcu7t3v3__buff_2
Xring.base_delay.stage\[81\].delay_cell.impl VDD VDD VSS VSS
+ ring.base_delay.stage\[80\].delay_cell.Z ring.base_delay.stage\[81\].delay_cell.Z
+ gf180mcu_as_sc_mcu7t3v3__buff_2
Xring.base_delay.stage\[82\].delay_cell.impl VDD VDD VSS VSS
+ ring.base_delay.stage\[81\].delay_cell.Z ring.base_delay.stage\[82\].delay_cell.Z
+ gf180mcu_as_sc_mcu7t3v3__buff_2
Xring.base_delay.stage\[83\].delay_cell.impl VDD VDD VSS VSS
+ ring.base_delay.stage\[82\].delay_cell.Z ring.base_delay.stage\[83\].delay_cell.Z
+ gf180mcu_as_sc_mcu7t3v3__buff_2
Xring.base_delay.stage\[84\].delay_cell.impl VDD VDD VSS VSS
+ ring.base_delay.stage\[83\].delay_cell.Z ring.base_delay.stage\[84\].delay_cell.Z
+ gf180mcu_as_sc_mcu7t3v3__buff_2
Xring.base_delay.stage\[85\].delay_cell.impl VDD VDD VSS VSS
+ ring.base_delay.stage\[84\].delay_cell.Z ring.base_delay.stage\[85\].delay_cell.Z
+ gf180mcu_as_sc_mcu7t3v3__buff_2
Xring.base_delay.stage\[86\].delay_cell.impl VDD VDD VSS VSS
+ ring.base_delay.stage\[85\].delay_cell.Z ring.base_delay.stage\[86\].delay_cell.Z
+ gf180mcu_as_sc_mcu7t3v3__buff_2
Xring.base_delay.stage\[87\].delay_cell.impl VDD VDD VSS VSS
+ ring.base_delay.stage\[86\].delay_cell.Z ring.base_delay.stage\[87\].delay_cell.Z
+ gf180mcu_as_sc_mcu7t3v3__buff_2
Xring.base_delay.stage\[88\].delay_cell.impl VDD VDD VSS VSS
+ ring.base_delay.stage\[87\].delay_cell.Z ring.base_delay.stage\[88\].delay_cell.Z
+ gf180mcu_as_sc_mcu7t3v3__buff_2
Xring.base_delay.stage\[89\].delay_cell.impl VDD VDD VSS VSS
+ ring.base_delay.stage\[88\].delay_cell.Z ring.base_delay.stage\[89\].delay_cell.Z
+ gf180mcu_as_sc_mcu7t3v3__buff_2
Xring.base_delay.stage\[8\].delay_cell.impl VDD VDD VSS VSS
+ ring.base_delay.stage\[7\].delay_cell.Z ring.base_delay.stage\[8\].delay_cell.Z
+ gf180mcu_as_sc_mcu7t3v3__buff_2
Xring.base_delay.stage\[90\].delay_cell.impl VDD VDD VSS VSS
+ ring.base_delay.stage\[89\].delay_cell.Z ring.base_delay.stage\[90\].delay_cell.Z
+ gf180mcu_as_sc_mcu7t3v3__buff_2
Xring.base_delay.stage\[91\].delay_cell.impl VDD VDD VSS VSS
+ ring.base_delay.stage\[90\].delay_cell.Z ring.base_delay.stage\[91\].delay_cell.Z
+ gf180mcu_as_sc_mcu7t3v3__buff_2
Xring.base_delay.stage\[92\].delay_cell.impl VDD VDD VSS VSS
+ ring.base_delay.stage\[91\].delay_cell.Z ring.base_delay.stage\[92\].delay_cell.Z
+ gf180mcu_as_sc_mcu7t3v3__buff_2
Xring.base_delay.stage\[93\].delay_cell.impl VDD VDD VSS VSS
+ ring.base_delay.stage\[92\].delay_cell.Z ring.base_delay.stage\[93\].delay_cell.Z
+ gf180mcu_as_sc_mcu7t3v3__buff_2
Xring.base_delay.stage\[94\].delay_cell.impl VDD VDD VSS VSS
+ ring.base_delay.stage\[93\].delay_cell.Z ring.base_delay.stage\[94\].delay_cell.Z
+ gf180mcu_as_sc_mcu7t3v3__buff_2
Xring.base_delay.stage\[95\].delay_cell.impl VDD VDD VSS VSS
+ ring.base_delay.stage\[94\].delay_cell.Z ring.base_delay.stage\[95\].delay_cell.Z
+ gf180mcu_as_sc_mcu7t3v3__buff_2
Xring.base_delay.stage\[96\].delay_cell.impl VDD VDD VSS VSS
+ ring.base_delay.stage\[95\].delay_cell.Z ring.base_delay.stage\[96\].delay_cell.Z
+ gf180mcu_as_sc_mcu7t3v3__buff_2
Xring.base_delay.stage\[97\].delay_cell.impl VDD VDD VSS VSS
+ ring.base_delay.stage\[96\].delay_cell.Z ring.base_delay.stage\[97\].delay_cell.Z
+ gf180mcu_as_sc_mcu7t3v3__buff_2
Xring.base_delay.stage\[98\].delay_cell.impl VDD VDD VSS VSS
+ ring.base_delay.stage\[97\].delay_cell.Z ring.base_delay.stage\[98\].delay_cell.Z
+ gf180mcu_as_sc_mcu7t3v3__buff_2
Xring.base_delay.stage\[99\].delay_cell.impl VDD VDD VSS VSS
+ ring.base_delay.stage\[98\].delay_cell.Z ring.base_delay.stage\[100\].delay_cell.I
+ gf180mcu_as_sc_mcu7t3v3__buff_2
Xring.base_delay.stage\[9\].delay_cell.impl VDD VDD VSS VSS
+ ring.base_delay.stage\[8\].delay_cell.Z ring.base_delay.stage\[10\].delay_cell.I
+ gf180mcu_as_sc_mcu7t3v3__buff_2
Xring.coarse.impl_last.impl VDD VDD VSS VSS ring.coarse.impl_last.I
+ ring.coarse.impl_last.Z gf180mcu_as_sc_mcu7t3v3__buff_2
Xring.coarse.stage\[0\].impl.dwn.impl VDD VDD VSS VSS ring.COARSE_OUT
+ ring.coarse.stage\[0\].impl.CHAIN_IN ring.coarse.stage\[0\].impl.PATH_0
+ gf180mcu_as_sc_mcu7t3v3__nand2_2
Xring.coarse.stage\[0\].impl.mid.impl VDD VDD VSS VSS ring.coarse.stage\[0\].impl.PATH_0
+ ring.DCO_IN net1 gf180mcu_as_sc_mcu7t3v3__nand2b_2
Xring.coarse.stage\[0\].impl.upp.impl VDD VDD VSS VSS ring.coarse.stage\[0\].impl.CHAIN_OUT
+ ring.DCO_IN net1 gf180mcu_as_sc_mcu7t3v3__nand2_2
Xring.coarse.stage\[10\].impl.dwn.impl VDD VDD VSS VSS ring.coarse.stage\[10\].impl.OUT
+ ring.coarse.stage\[10\].impl.CHAIN_IN ring.coarse.stage\[10\].impl.PATH_0
+ gf180mcu_as_sc_mcu7t3v3__nand2_2
Xring.coarse.stage\[10\].impl.mid.impl VDD VDD VSS VSS ring.coarse.stage\[10\].impl.PATH_0
+ ring.coarse.stage\[10\].impl.IN net2 gf180mcu_as_sc_mcu7t3v3__nand2b_2
Xring.coarse.stage\[10\].impl.upp.impl VDD VDD VSS VSS ring.coarse.stage\[10\].impl.CHAIN_OUT
+ ring.coarse.stage\[10\].impl.IN net2 gf180mcu_as_sc_mcu7t3v3__nand2_2
Xring.coarse.stage\[11\].impl.dwn.impl VDD VDD VSS VSS ring.coarse.stage\[10\].impl.CHAIN_IN
+ ring.coarse.stage\[11\].impl.CHAIN_IN ring.coarse.stage\[11\].impl.PATH_0
+ gf180mcu_as_sc_mcu7t3v3__nand2_2
Xring.coarse.stage\[11\].impl.mid.impl VDD VDD VSS VSS ring.coarse.stage\[11\].impl.PATH_0
+ ring.coarse.stage\[10\].impl.CHAIN_OUT net3 gf180mcu_as_sc_mcu7t3v3__nand2b_2
Xring.coarse.stage\[11\].impl.upp.impl VDD VDD VSS VSS ring.coarse.stage\[11\].impl.CHAIN_OUT
+ ring.coarse.stage\[10\].impl.CHAIN_OUT net3 gf180mcu_as_sc_mcu7t3v3__nand2_2
Xring.coarse.stage\[12\].impl.dwn.impl VDD VDD VSS VSS ring.coarse.stage\[11\].impl.CHAIN_IN
+ ring.coarse.stage\[12\].impl.CHAIN_IN ring.coarse.stage\[12\].impl.PATH_0
+ gf180mcu_as_sc_mcu7t3v3__nand2_2
Xring.coarse.stage\[12\].impl.mid.impl VDD VDD VSS VSS ring.coarse.stage\[12\].impl.PATH_0
+ ring.coarse.stage\[11\].impl.CHAIN_OUT net4 gf180mcu_as_sc_mcu7t3v3__nand2b_2
Xring.coarse.stage\[12\].impl.upp.impl VDD VDD VSS VSS ring.coarse.stage\[12\].impl.CHAIN_OUT
+ ring.coarse.stage\[11\].impl.CHAIN_OUT net4 gf180mcu_as_sc_mcu7t3v3__nand2_2
Xring.coarse.stage\[13\].impl.dwn.impl VDD VDD VSS VSS ring.coarse.stage\[12\].impl.CHAIN_IN
+ ring.coarse.stage\[13\].impl.CHAIN_IN ring.coarse.stage\[13\].impl.PATH_0
+ gf180mcu_as_sc_mcu7t3v3__nand2_2
Xring.coarse.stage\[13\].impl.mid.impl VDD VDD VSS VSS ring.coarse.stage\[13\].impl.PATH_0
+ ring.coarse.stage\[12\].impl.CHAIN_OUT net5 gf180mcu_as_sc_mcu7t3v3__nand2b_2
Xring.coarse.stage\[13\].impl.upp.impl VDD VDD VSS VSS ring.coarse.stage\[13\].impl.CHAIN_OUT
+ ring.coarse.stage\[12\].impl.CHAIN_OUT net5 gf180mcu_as_sc_mcu7t3v3__nand2_2
Xring.coarse.stage\[14\].impl.dwn.impl VDD VDD VSS VSS ring.coarse.stage\[13\].impl.CHAIN_IN
+ ring.coarse.impl_last.Z ring.coarse.stage\[14\].impl.PATH_0
+ gf180mcu_as_sc_mcu7t3v3__nand2_2
Xring.coarse.stage\[14\].impl.mid.impl VDD VDD VSS VSS ring.coarse.stage\[14\].impl.PATH_0
+ ring.coarse.stage\[13\].impl.CHAIN_OUT net6 gf180mcu_as_sc_mcu7t3v3__nand2b_2
Xring.coarse.stage\[14\].impl.upp.impl VDD VDD VSS VSS ring.coarse.impl_last.I
+ ring.coarse.stage\[13\].impl.CHAIN_OUT net6 gf180mcu_as_sc_mcu7t3v3__nand2_2
Xring.coarse.stage\[1\].impl.dwn.impl VDD VDD VSS VSS ring.coarse.stage\[0\].impl.CHAIN_IN
+ ring.coarse.stage\[1\].impl.CHAIN_IN ring.coarse.stage\[1\].impl.PATH_0
+ gf180mcu_as_sc_mcu7t3v3__nand2_2
Xring.coarse.stage\[1\].impl.mid.impl VDD VDD VSS VSS ring.coarse.stage\[1\].impl.PATH_0
+ ring.coarse.stage\[0\].impl.CHAIN_OUT net7 gf180mcu_as_sc_mcu7t3v3__nand2b_2
Xring.coarse.stage\[1\].impl.upp.impl VDD VDD VSS VSS ring.coarse.stage\[1\].impl.CHAIN_OUT
+ ring.coarse.stage\[0\].impl.CHAIN_OUT net7 gf180mcu_as_sc_mcu7t3v3__nand2_2
Xring.coarse.stage\[2\].impl.dwn.impl VDD VDD VSS VSS ring.coarse.stage\[1\].impl.CHAIN_IN
+ ring.coarse.stage\[2\].impl.CHAIN_IN ring.coarse.stage\[2\].impl.PATH_0
+ gf180mcu_as_sc_mcu7t3v3__nand2_2
Xring.coarse.stage\[2\].impl.mid.impl VDD VDD VSS VSS ring.coarse.stage\[2\].impl.PATH_0
+ ring.coarse.stage\[1\].impl.CHAIN_OUT net8 gf180mcu_as_sc_mcu7t3v3__nand2b_2
Xring.coarse.stage\[2\].impl.upp.impl VDD VDD VSS VSS ring.coarse.stage\[2\].impl.CHAIN_OUT
+ ring.coarse.stage\[1\].impl.CHAIN_OUT net8 gf180mcu_as_sc_mcu7t3v3__nand2_2
Xring.coarse.stage\[3\].impl.dwn.impl VDD VDD VSS VSS ring.coarse.stage\[2\].impl.CHAIN_IN
+ ring.coarse.stage\[3\].impl.CHAIN_IN ring.coarse.stage\[3\].impl.PATH_0
+ gf180mcu_as_sc_mcu7t3v3__nand2_2
Xring.coarse.stage\[3\].impl.mid.impl VDD VDD VSS VSS ring.coarse.stage\[3\].impl.PATH_0
+ ring.coarse.stage\[2\].impl.CHAIN_OUT net9 gf180mcu_as_sc_mcu7t3v3__nand2b_2
Xring.coarse.stage\[3\].impl.upp.impl VDD VDD VSS VSS ring.coarse.stage\[3\].impl.CHAIN_OUT
+ ring.coarse.stage\[2\].impl.CHAIN_OUT net9 gf180mcu_as_sc_mcu7t3v3__nand2_2
Xring.coarse.stage\[4\].impl.dwn.impl VDD VDD VSS VSS ring.coarse.stage\[3\].impl.CHAIN_IN
+ ring.coarse.stage\[4\].impl.CHAIN_IN ring.coarse.stage\[4\].impl.PATH_0
+ gf180mcu_as_sc_mcu7t3v3__nand2_2
Xring.coarse.stage\[4\].impl.mid.impl VDD VDD VSS VSS ring.coarse.stage\[4\].impl.PATH_0
+ ring.coarse.stage\[3\].impl.CHAIN_OUT net10 gf180mcu_as_sc_mcu7t3v3__nand2b_2
Xring.coarse.stage\[4\].impl.upp.impl VDD VDD VSS VSS ring.coarse.stage\[4\].impl.CHAIN_OUT
+ ring.coarse.stage\[3\].impl.CHAIN_OUT net10 gf180mcu_as_sc_mcu7t3v3__nand2_2
Xring.coarse.stage\[5\].impl.dwn.impl VDD VDD VSS VSS ring.coarse.stage\[4\].impl.CHAIN_IN
+ ring.coarse.stage\[5\].impl.CHAIN_IN ring.coarse.stage\[5\].impl.PATH_0
+ gf180mcu_as_sc_mcu7t3v3__nand2_2
Xring.coarse.stage\[5\].impl.mid.impl VDD VDD VSS VSS ring.coarse.stage\[5\].impl.PATH_0
+ ring.coarse.stage\[4\].impl.CHAIN_OUT net11 gf180mcu_as_sc_mcu7t3v3__nand2b_2
Xring.coarse.stage\[5\].impl.upp.impl VDD VDD VSS VSS ring.coarse.stage\[5\].impl.CHAIN_OUT
+ ring.coarse.stage\[4\].impl.CHAIN_OUT net11 gf180mcu_as_sc_mcu7t3v3__nand2_2
Xring.coarse.stage\[6\].impl.dwn.impl VDD VDD VSS VSS ring.coarse.stage\[5\].impl.CHAIN_IN
+ ring.coarse.stage\[6\].impl.CHAIN_IN ring.coarse.stage\[6\].impl.PATH_0
+ gf180mcu_as_sc_mcu7t3v3__nand2_2
Xring.coarse.stage\[6\].impl.mid.impl VDD VDD VSS VSS ring.coarse.stage\[6\].impl.PATH_0
+ ring.coarse.stage\[5\].impl.CHAIN_OUT net12 gf180mcu_as_sc_mcu7t3v3__nand2b_2
Xring.coarse.stage\[6\].impl.upp.impl VDD VDD VSS VSS ring.coarse.stage\[6\].impl.CHAIN_OUT
+ ring.coarse.stage\[5\].impl.CHAIN_OUT net12 gf180mcu_as_sc_mcu7t3v3__nand2_2
Xring.coarse.stage\[7\].impl.dwn.impl VDD VDD VSS VSS ring.coarse.stage\[6\].impl.CHAIN_IN
+ ring.coarse.stage\[7\].impl.CHAIN_IN ring.coarse.stage\[7\].impl.PATH_0
+ gf180mcu_as_sc_mcu7t3v3__nand2_2
Xring.coarse.stage\[7\].impl.mid.impl VDD VDD VSS VSS ring.coarse.stage\[7\].impl.PATH_0
+ ring.coarse.stage\[6\].impl.CHAIN_OUT net13 gf180mcu_as_sc_mcu7t3v3__nand2b_2
Xring.coarse.stage\[7\].impl.upp.impl VDD VDD VSS VSS ring.coarse.stage\[7\].impl.CHAIN_OUT
+ ring.coarse.stage\[6\].impl.CHAIN_OUT net13 gf180mcu_as_sc_mcu7t3v3__nand2_2
Xring.coarse.stage\[8\].impl.dwn.impl VDD VDD VSS VSS ring.coarse.stage\[7\].impl.CHAIN_IN
+ ring.coarse.stage\[8\].impl.CHAIN_IN ring.coarse.stage\[8\].impl.PATH_0
+ gf180mcu_as_sc_mcu7t3v3__nand2_2
Xring.coarse.stage\[8\].impl.mid.impl VDD VDD VSS VSS ring.coarse.stage\[8\].impl.PATH_0
+ ring.coarse.stage\[7\].impl.CHAIN_OUT net14 gf180mcu_as_sc_mcu7t3v3__nand2b_2
Xring.coarse.stage\[8\].impl.upp.impl VDD VDD VSS VSS ring.coarse.stage\[8\].impl.CHAIN_OUT
+ ring.coarse.stage\[7\].impl.CHAIN_OUT net14 gf180mcu_as_sc_mcu7t3v3__nand2_2
Xring.coarse.stage\[9\].impl.dwn.impl VDD VDD VSS VSS ring.coarse.stage\[8\].impl.CHAIN_IN
+ ring.coarse.stage\[10\].impl.OUT ring.coarse.stage\[9\].impl.PATH_0
+ gf180mcu_as_sc_mcu7t3v3__nand2_2
Xring.coarse.stage\[9\].impl.mid.impl VDD VDD VSS VSS ring.coarse.stage\[9\].impl.PATH_0
+ ring.coarse.stage\[8\].impl.CHAIN_OUT net15 gf180mcu_as_sc_mcu7t3v3__nand2b_2
Xring.coarse.stage\[9\].impl.upp.impl VDD VDD VSS VSS ring.coarse.stage\[10\].impl.IN
+ ring.coarse.stage\[8\].impl.CHAIN_OUT net15 gf180mcu_as_sc_mcu7t3v3__nand2_2
Xring.dff_x.impl VDD VDD VSS VSS REF ring.dff_x.D ring.dff_x.Q
+ gf180mcu_as_sc_mcu7t3v3__dfxtn_2
Xring.dff_y.impl VDD VDD VSS VSS REF ring.dff_y.D ring.dff_y.Q
+ gf180mcu_as_sc_mcu7t3v3__dfxtn_2
Xring.fine.inv_0.impl VDD VDD VSS VSS ring.fine.LOAD net64
+ gf180mcu_as_sc_mcu7t3v3__inv_6
Xring.fine.inv_1.impl VDD VDD VSS VSS ring.FINE_OUT ring.fine.LOAD
+ gf180mcu_as_sc_mcu7t3v3__inv_6
Xring.fine.stage\[0\].dyn.impl VDD VDD VSS VSS net17 ring.fine.LOAD
+ ring.fine.stage\[0\].dyn.A2 ring.fine.stage\[0\].dyn.ZN gf180mcu_as_sc_mcu7t3v3__nand3_2
Xring.fine.stage\[0\].inv_b.impl VDD VDD VSS VSS ring.fine.stage\[0\].dyn.A2
+ net17 gf180mcu_as_sc_mcu7t3v3__inv_2
Xring.fine.stage\[10\].dyn.impl VDD VDD VSS VSS net18 ring.fine.LOAD
+ ring.fine.stage\[10\].dyn.A2 ring.fine.stage\[10\].dyn.ZN
+ gf180mcu_as_sc_mcu7t3v3__nand3_2
Xring.fine.stage\[10\].inv_b.impl VDD VDD VSS VSS ring.fine.stage\[10\].dyn.A2
+ net18 gf180mcu_as_sc_mcu7t3v3__inv_2
Xring.fine.stage\[11\].dyn.impl VDD VDD VSS VSS net19 ring.fine.LOAD
+ ring.fine.stage\[11\].dyn.A2 ring.fine.stage\[11\].dyn.ZN
+ gf180mcu_as_sc_mcu7t3v3__nand3_2
Xring.fine.stage\[11\].inv_b.impl VDD VDD VSS VSS ring.fine.stage\[11\].dyn.A2
+ net19 gf180mcu_as_sc_mcu7t3v3__inv_2
Xring.fine.stage\[12\].dyn.impl VDD VDD VSS VSS net20 ring.fine.LOAD
+ ring.fine.stage\[12\].dyn.A2 ring.fine.stage\[12\].dyn.ZN
+ gf180mcu_as_sc_mcu7t3v3__nand3_2
Xring.fine.stage\[12\].inv_b.impl VDD VDD VSS VSS ring.fine.stage\[12\].dyn.A2
+ net20 gf180mcu_as_sc_mcu7t3v3__inv_2
Xring.fine.stage\[13\].dyn.impl VDD VDD VSS VSS net21 ring.fine.LOAD
+ ring.fine.stage\[13\].dyn.A2 ring.fine.stage\[13\].dyn.ZN
+ gf180mcu_as_sc_mcu7t3v3__nand3_2
Xring.fine.stage\[13\].inv_b.impl VDD VDD VSS VSS ring.fine.stage\[13\].dyn.A2
+ net21 gf180mcu_as_sc_mcu7t3v3__inv_2
Xring.fine.stage\[14\].dyn.impl VDD VDD VSS VSS net22 ring.fine.LOAD
+ ring.fine.stage\[14\].dyn.A2 ring.fine.stage\[14\].dyn.ZN
+ gf180mcu_as_sc_mcu7t3v3__nand3_2
Xring.fine.stage\[14\].inv_b.impl VDD VDD VSS VSS ring.fine.stage\[14\].dyn.A2
+ net22 gf180mcu_as_sc_mcu7t3v3__inv_2
Xring.fine.stage\[15\].dyn.impl VDD VDD VSS VSS net23 ring.fine.LOAD
+ ring.fine.stage\[15\].dyn.A2 ring.fine.stage\[15\].dyn.ZN
+ gf180mcu_as_sc_mcu7t3v3__nand3_2
Xring.fine.stage\[15\].inv_b.impl VDD VDD VSS VSS ring.fine.stage\[15\].dyn.A2
+ net23 gf180mcu_as_sc_mcu7t3v3__inv_2
Xring.fine.stage\[16\].dyn.impl VDD VDD VSS VSS net24 ring.fine.LOAD
+ ring.fine.stage\[16\].dyn.A2 ring.fine.stage\[16\].dyn.ZN
+ gf180mcu_as_sc_mcu7t3v3__nand3_2
Xring.fine.stage\[16\].inv_b.impl VDD VDD VSS VSS ring.fine.stage\[16\].dyn.A2
+ net24 gf180mcu_as_sc_mcu7t3v3__inv_2
Xring.fine.stage\[17\].dyn.impl VDD VDD VSS VSS net25 ring.fine.LOAD
+ ring.fine.stage\[17\].dyn.A2 ring.fine.stage\[17\].dyn.ZN
+ gf180mcu_as_sc_mcu7t3v3__nand3_2
Xring.fine.stage\[17\].inv_b.impl VDD VDD VSS VSS ring.fine.stage\[17\].dyn.A2
+ net25 gf180mcu_as_sc_mcu7t3v3__inv_2
Xring.fine.stage\[18\].dyn.impl VDD VDD VSS VSS net26 ring.fine.LOAD
+ ring.fine.stage\[18\].dyn.A2 ring.fine.stage\[18\].dyn.ZN
+ gf180mcu_as_sc_mcu7t3v3__nand3_2
Xring.fine.stage\[18\].inv_b.impl VDD VDD VSS VSS ring.fine.stage\[18\].dyn.A2
+ net26 gf180mcu_as_sc_mcu7t3v3__inv_2
Xring.fine.stage\[19\].dyn.impl VDD VDD VSS VSS net27 ring.fine.LOAD
+ ring.fine.stage\[19\].dyn.A2 ring.fine.stage\[19\].dyn.ZN
+ gf180mcu_as_sc_mcu7t3v3__nand3_2
Xring.fine.stage\[19\].inv_b.impl VDD VDD VSS VSS ring.fine.stage\[19\].dyn.A2
+ net27 gf180mcu_as_sc_mcu7t3v3__inv_2
Xring.fine.stage\[1\].dyn.impl VDD VDD VSS VSS net28 ring.fine.LOAD
+ ring.fine.stage\[1\].dyn.A2 ring.fine.stage\[1\].dyn.ZN gf180mcu_as_sc_mcu7t3v3__nand3_2
Xring.fine.stage\[1\].inv_b.impl VDD VDD VSS VSS ring.fine.stage\[1\].dyn.A2
+ net28 gf180mcu_as_sc_mcu7t3v3__inv_2
Xring.fine.stage\[20\].dyn.impl VDD VDD VSS VSS net29 ring.fine.LOAD
+ ring.fine.stage\[20\].dyn.A2 ring.fine.stage\[20\].dyn.ZN
+ gf180mcu_as_sc_mcu7t3v3__nand3_2
Xring.fine.stage\[20\].inv_b.impl VDD VDD VSS VSS ring.fine.stage\[20\].dyn.A2
+ net29 gf180mcu_as_sc_mcu7t3v3__inv_2
Xring.fine.stage\[21\].dyn.impl VDD VDD VSS VSS net30 ring.fine.LOAD
+ ring.fine.stage\[21\].dyn.A2 ring.fine.stage\[21\].dyn.ZN
+ gf180mcu_as_sc_mcu7t3v3__nand3_2
Xring.fine.stage\[21\].inv_b.impl VDD VDD VSS VSS ring.fine.stage\[21\].dyn.A2
+ net30 gf180mcu_as_sc_mcu7t3v3__inv_2
Xring.fine.stage\[22\].dyn.impl VDD VDD VSS VSS net31 ring.fine.LOAD
+ ring.fine.stage\[22\].dyn.A2 ring.fine.stage\[22\].dyn.ZN
+ gf180mcu_as_sc_mcu7t3v3__nand3_2
Xring.fine.stage\[22\].inv_b.impl VDD VDD VSS VSS ring.fine.stage\[22\].dyn.A2
+ net31 gf180mcu_as_sc_mcu7t3v3__inv_2
Xring.fine.stage\[23\].dyn.impl VDD VDD VSS VSS net32 ring.fine.LOAD
+ ring.fine.stage\[23\].dyn.A2 ring.fine.stage\[23\].dyn.ZN
+ gf180mcu_as_sc_mcu7t3v3__nand3_2
Xring.fine.stage\[23\].inv_b.impl VDD VDD VSS VSS ring.fine.stage\[23\].dyn.A2
+ net32 gf180mcu_as_sc_mcu7t3v3__inv_2
Xring.fine.stage\[24\].dyn.impl VDD VDD VSS VSS net33 ring.fine.LOAD
+ ring.fine.stage\[24\].dyn.A2 ring.fine.stage\[24\].dyn.ZN
+ gf180mcu_as_sc_mcu7t3v3__nand3_2
Xring.fine.stage\[24\].inv_b.impl VDD VDD VSS VSS ring.fine.stage\[24\].dyn.A2
+ net33 gf180mcu_as_sc_mcu7t3v3__inv_2
Xring.fine.stage\[25\].dyn.impl VDD VDD VSS VSS net34 ring.fine.LOAD
+ ring.fine.stage\[25\].dyn.A2 ring.fine.stage\[25\].dyn.ZN
+ gf180mcu_as_sc_mcu7t3v3__nand3_2
Xring.fine.stage\[25\].inv_b.impl VDD VDD VSS VSS ring.fine.stage\[25\].dyn.A2
+ net34 gf180mcu_as_sc_mcu7t3v3__inv_2
Xring.fine.stage\[26\].dyn.impl VDD VDD VSS VSS net35 ring.fine.LOAD
+ ring.fine.stage\[26\].dyn.A2 ring.fine.stage\[26\].dyn.ZN
+ gf180mcu_as_sc_mcu7t3v3__nand3_2
Xring.fine.stage\[26\].inv_b.impl VDD VDD VSS VSS ring.fine.stage\[26\].dyn.A2
+ net35 gf180mcu_as_sc_mcu7t3v3__inv_2
Xring.fine.stage\[27\].dyn.impl VDD VDD VSS VSS net36 ring.fine.LOAD
+ ring.fine.stage\[27\].dyn.A2 ring.fine.stage\[27\].dyn.ZN
+ gf180mcu_as_sc_mcu7t3v3__nand3_2
Xring.fine.stage\[27\].inv_b.impl VDD VDD VSS VSS ring.fine.stage\[27\].dyn.A2
+ net36 gf180mcu_as_sc_mcu7t3v3__inv_2
Xring.fine.stage\[28\].dyn.impl VDD VDD VSS VSS net37 ring.fine.LOAD
+ ring.fine.stage\[28\].dyn.A2 ring.fine.stage\[28\].dyn.ZN
+ gf180mcu_as_sc_mcu7t3v3__nand3_2
Xring.fine.stage\[28\].inv_b.impl VDD VDD VSS VSS ring.fine.stage\[28\].dyn.A2
+ net37 gf180mcu_as_sc_mcu7t3v3__inv_2
Xring.fine.stage\[29\].dyn.impl VDD VDD VSS VSS net38 ring.fine.LOAD
+ ring.fine.stage\[29\].dyn.A2 ring.fine.stage\[29\].dyn.ZN
+ gf180mcu_as_sc_mcu7t3v3__nand3_2
Xring.fine.stage\[29\].inv_b.impl VDD VDD VSS VSS ring.fine.stage\[29\].dyn.A2
+ net38 gf180mcu_as_sc_mcu7t3v3__inv_2
Xring.fine.stage\[2\].dyn.impl VDD VDD VSS VSS net39 ring.fine.LOAD
+ ring.fine.stage\[2\].dyn.A2 ring.fine.stage\[2\].dyn.ZN gf180mcu_as_sc_mcu7t3v3__nand3_2
Xring.fine.stage\[2\].inv_b.impl VDD VDD VSS VSS ring.fine.stage\[2\].dyn.A2
+ net39 gf180mcu_as_sc_mcu7t3v3__inv_2
Xring.fine.stage\[30\].dyn.impl VDD VDD VSS VSS net40 ring.fine.LOAD
+ ring.fine.stage\[30\].dyn.A2 ring.fine.stage\[30\].dyn.ZN
+ gf180mcu_as_sc_mcu7t3v3__nand3_2
Xring.fine.stage\[30\].inv_b.impl VDD VDD VSS VSS ring.fine.stage\[30\].dyn.A2
+ net40 gf180mcu_as_sc_mcu7t3v3__inv_2
Xring.fine.stage\[3\].dyn.impl VDD VDD VSS VSS net41 ring.fine.LOAD
+ ring.fine.stage\[3\].dyn.A2 ring.fine.stage\[3\].dyn.ZN gf180mcu_as_sc_mcu7t3v3__nand3_2
Xring.fine.stage\[3\].inv_b.impl VDD VDD VSS VSS ring.fine.stage\[3\].dyn.A2
+ net41 gf180mcu_as_sc_mcu7t3v3__inv_2
Xring.fine.stage\[4\].dyn.impl VDD VDD VSS VSS net42 ring.fine.LOAD
+ ring.fine.stage\[4\].dyn.A2 ring.fine.stage\[4\].dyn.ZN gf180mcu_as_sc_mcu7t3v3__nand3_2
Xring.fine.stage\[4\].inv_b.impl VDD VDD VSS VSS ring.fine.stage\[4\].dyn.A2
+ net42 gf180mcu_as_sc_mcu7t3v3__inv_2
Xring.fine.stage\[5\].dyn.impl VDD VDD VSS VSS net43 ring.fine.LOAD
+ ring.fine.stage\[5\].dyn.A2 ring.fine.stage\[5\].dyn.ZN gf180mcu_as_sc_mcu7t3v3__nand3_2
Xring.fine.stage\[5\].inv_b.impl VDD VDD VSS VSS ring.fine.stage\[5\].dyn.A2
+ net43 gf180mcu_as_sc_mcu7t3v3__inv_2
Xring.fine.stage\[6\].dyn.impl VDD VDD VSS VSS net44 ring.fine.LOAD
+ ring.fine.stage\[6\].dyn.A2 ring.fine.stage\[6\].dyn.ZN gf180mcu_as_sc_mcu7t3v3__nand3_2
Xring.fine.stage\[6\].inv_b.impl VDD VDD VSS VSS ring.fine.stage\[6\].dyn.A2
+ net44 gf180mcu_as_sc_mcu7t3v3__inv_2
Xring.fine.stage\[7\].dyn.impl VDD VDD VSS VSS net45 ring.fine.LOAD
+ ring.fine.stage\[7\].dyn.A2 ring.fine.stage\[7\].dyn.ZN gf180mcu_as_sc_mcu7t3v3__nand3_2
Xring.fine.stage\[7\].inv_b.impl VDD VDD VSS VSS ring.fine.stage\[7\].dyn.A2
+ net45 gf180mcu_as_sc_mcu7t3v3__inv_2
Xring.fine.stage\[8\].dyn.impl VDD VDD VSS VSS net46 ring.fine.LOAD
+ ring.fine.stage\[8\].dyn.A2 ring.fine.stage\[8\].dyn.ZN gf180mcu_as_sc_mcu7t3v3__nand3_2
Xring.fine.stage\[8\].inv_b.impl VDD VDD VSS VSS ring.fine.stage\[8\].dyn.A2
+ net46 gf180mcu_as_sc_mcu7t3v3__inv_2
Xring.fine.stage\[9\].dyn.impl VDD VDD VSS VSS net47 ring.fine.LOAD
+ ring.fine.stage\[9\].dyn.A2 ring.fine.stage\[9\].dyn.ZN gf180mcu_as_sc_mcu7t3v3__nand3_2
Xring.fine.stage\[9\].inv_b.impl VDD VDD VSS VSS ring.fine.stage\[9\].dyn.A2
+ net47 gf180mcu_as_sc_mcu7t3v3__inv_2
Xring.mid.inv_0.impl VDD VDD VSS VSS ring.mid.LOAD ring.COARSE_OUT
+ gf180mcu_as_sc_mcu7t3v3__inv_4
Xring.mid.inv_1.impl VDD VDD VSS VSS net64 ring.mid.LOAD gf180mcu_as_sc_mcu7t3v3__inv_4
Xring.mid.stage\[0\].dyn.impl VDD VDD VSS VSS net48 ring.mid.LOAD
+ ring.mid.stage\[0\].dyn.A2 ring.mid.stage\[0\].dyn.ZN gf180mcu_as_sc_mcu7t3v3__nand3_2
Xring.mid.stage\[0\].inv_b.impl VDD VDD VSS VSS ring.mid.stage\[0\].dyn.A2
+ net48 gf180mcu_as_sc_mcu7t3v3__inv_2
Xring.mid.stage\[10\].dyn.impl VDD VDD VSS VSS net49 ring.mid.LOAD
+ ring.mid.stage\[10\].dyn.A2 ring.mid.stage\[10\].dyn.ZN gf180mcu_as_sc_mcu7t3v3__nand3_2
Xring.mid.stage\[10\].inv_b.impl VDD VDD VSS VSS ring.mid.stage\[10\].dyn.A2
+ net49 gf180mcu_as_sc_mcu7t3v3__inv_2
Xring.mid.stage\[11\].dyn.impl VDD VDD VSS VSS net50 ring.mid.LOAD
+ ring.mid.stage\[11\].dyn.A2 ring.mid.stage\[11\].dyn.ZN gf180mcu_as_sc_mcu7t3v3__nand3_2
Xring.mid.stage\[11\].inv_b.impl VDD VDD VSS VSS ring.mid.stage\[11\].dyn.A2
+ net50 gf180mcu_as_sc_mcu7t3v3__inv_2
Xring.mid.stage\[12\].dyn.impl VDD VDD VSS VSS net51 ring.mid.LOAD
+ ring.mid.stage\[12\].dyn.A2 ring.mid.stage\[12\].dyn.ZN gf180mcu_as_sc_mcu7t3v3__nand3_2
Xring.mid.stage\[12\].inv_b.impl VDD VDD VSS VSS ring.mid.stage\[12\].dyn.A2
+ net51 gf180mcu_as_sc_mcu7t3v3__inv_2
Xring.mid.stage\[13\].dyn.impl VDD VDD VSS VSS net52 ring.mid.LOAD
+ ring.mid.stage\[13\].dyn.A2 ring.mid.stage\[13\].dyn.ZN gf180mcu_as_sc_mcu7t3v3__nand3_2
Xring.mid.stage\[13\].inv_b.impl VDD VDD VSS VSS ring.mid.stage\[13\].dyn.A2
+ net52 gf180mcu_as_sc_mcu7t3v3__inv_2
Xring.mid.stage\[14\].dyn.impl VDD VDD VSS VSS net53 ring.mid.LOAD
+ ring.mid.stage\[14\].dyn.A2 ring.mid.stage\[14\].dyn.ZN gf180mcu_as_sc_mcu7t3v3__nand3_2
Xring.mid.stage\[14\].inv_b.impl VDD VDD VSS VSS ring.mid.stage\[14\].dyn.A2
+ net53 gf180mcu_as_sc_mcu7t3v3__inv_2
Xring.mid.stage\[1\].dyn.impl VDD VDD VSS VSS net54 ring.mid.LOAD
+ ring.mid.stage\[1\].dyn.A2 ring.mid.stage\[1\].dyn.ZN gf180mcu_as_sc_mcu7t3v3__nand3_2
Xring.mid.stage\[1\].inv_b.impl VDD VDD VSS VSS ring.mid.stage\[1\].dyn.A2
+ net54 gf180mcu_as_sc_mcu7t3v3__inv_2
Xring.mid.stage\[2\].dyn.impl VDD VDD VSS VSS net55 ring.mid.LOAD
+ ring.mid.stage\[2\].dyn.A2 ring.mid.stage\[2\].dyn.ZN gf180mcu_as_sc_mcu7t3v3__nand3_2
Xring.mid.stage\[2\].inv_b.impl VDD VDD VSS VSS ring.mid.stage\[2\].dyn.A2
+ net55 gf180mcu_as_sc_mcu7t3v3__inv_2
Xring.mid.stage\[3\].dyn.impl VDD VDD VSS VSS net56 ring.mid.LOAD
+ ring.mid.stage\[3\].dyn.A2 ring.mid.stage\[3\].dyn.ZN gf180mcu_as_sc_mcu7t3v3__nand3_2
Xring.mid.stage\[3\].inv_b.impl VDD VDD VSS VSS ring.mid.stage\[3\].dyn.A2
+ net56 gf180mcu_as_sc_mcu7t3v3__inv_2
Xring.mid.stage\[4\].dyn.impl VDD VDD VSS VSS net57 ring.mid.LOAD
+ ring.mid.stage\[4\].dyn.A2 ring.mid.stage\[4\].dyn.ZN gf180mcu_as_sc_mcu7t3v3__nand3_2
Xring.mid.stage\[4\].inv_b.impl VDD VDD VSS VSS ring.mid.stage\[4\].dyn.A2
+ net57 gf180mcu_as_sc_mcu7t3v3__inv_2
Xring.mid.stage\[5\].dyn.impl VDD VDD VSS VSS net58 ring.mid.LOAD
+ ring.mid.stage\[5\].dyn.A2 ring.mid.stage\[5\].dyn.ZN gf180mcu_as_sc_mcu7t3v3__nand3_2
Xring.mid.stage\[5\].inv_b.impl VDD VDD VSS VSS ring.mid.stage\[5\].dyn.A2
+ net58 gf180mcu_as_sc_mcu7t3v3__inv_2
Xring.mid.stage\[6\].dyn.impl VDD VDD VSS VSS net59 ring.mid.LOAD
+ ring.mid.stage\[6\].dyn.A2 ring.mid.stage\[6\].dyn.ZN gf180mcu_as_sc_mcu7t3v3__nand3_2
Xring.mid.stage\[6\].inv_b.impl VDD VDD VSS VSS ring.mid.stage\[6\].dyn.A2
+ net59 gf180mcu_as_sc_mcu7t3v3__inv_2
Xring.mid.stage\[7\].dyn.impl VDD VDD VSS VSS net60 ring.mid.LOAD
+ ring.mid.stage\[7\].dyn.A2 ring.mid.stage\[7\].dyn.ZN gf180mcu_as_sc_mcu7t3v3__nand3_2
Xring.mid.stage\[7\].inv_b.impl VDD VDD VSS VSS ring.mid.stage\[7\].dyn.A2
+ net60 gf180mcu_as_sc_mcu7t3v3__inv_2
Xring.mid.stage\[8\].dyn.impl VDD VDD VSS VSS net61 ring.mid.LOAD
+ ring.mid.stage\[8\].dyn.A2 ring.mid.stage\[8\].dyn.ZN gf180mcu_as_sc_mcu7t3v3__nand3_2
Xring.mid.stage\[8\].inv_b.impl VDD VDD VSS VSS ring.mid.stage\[8\].dyn.A2
+ net61 gf180mcu_as_sc_mcu7t3v3__inv_2
Xring.mid.stage\[9\].dyn.impl VDD VDD VSS VSS net62 ring.mid.LOAD
+ ring.mid.stage\[9\].dyn.A2 ring.mid.stage\[9\].dyn.ZN gf180mcu_as_sc_mcu7t3v3__nand3_2
Xring.mid.stage\[9\].inv_b.impl VDD VDD VSS VSS ring.mid.stage\[9\].dyn.A2
+ net62 gf180mcu_as_sc_mcu7t3v3__inv_2
Xring.sym.inj_dummy_inv.impl VDD VDD VSS VSS ring.sym.INJ_DUMMY
+ ring.sym.INJ_EDGE_BALANCED gf180mcu_as_sc_mcu7t3v3__inv_2
Xring.sym.inj_slope_balancer.impl VDD VDD VSS VSS ring.sym.INJ_EDGE_BALANCED
+ REF gf180mcu_as_sc_mcu7t3v3__inv_2
Xring.sym.osc_dummy_inv.impl VDD VDD VSS VSS ring.sym.OSC_DUMMY
+ ring.sym.OSC_BALANCED gf180mcu_as_sc_mcu7t3v3__inv_2
Xring.sym.osc_slope_balancer.impl VDD VDD VSS VSS ring.sym.OSC_BALANCED
+ ring.FINE_OUT gf180mcu_as_sc_mcu7t3v3__inv_2
Xring.sym.ssbbpd_impl.buf_nand_x.impl VDD VDD VSS VSS ring.sym.ssbbpd_impl.OUT_NANDX
+ ring.dff_x.D gf180mcu_as_sc_mcu7t3v3__buff_2
Xring.sym.ssbbpd_impl.buf_nand_y.impl VDD VDD VSS VSS ring.sym.ssbbpd_impl.OUT_NANDY
+ ring.dff_y.D gf180mcu_as_sc_mcu7t3v3__buff_2
Xring.sym.ssbbpd_impl.nand_x.impl VDD VDD VSS VSS ring.sym.ssbbpd_impl.OUT_NANDX
+ ring.sym.ssbbpd_impl.OUT_NANDY ring.sym.OSC_BALANCED gf180mcu_as_sc_mcu7t3v3__nand2_2
Xring.sym.ssbbpd_impl.nand_y.impl VDD VDD VSS VSS ring.sym.ssbbpd_impl.OUT_NANDY
+ ring.sym.ssbbpd_impl.OUT_NANDX ring.sym.INJ_EDGE_BALANCED
+ gf180mcu_as_sc_mcu7t3v3__nand2_2
Xring.sym.sym_mux.nand_inj.impl VDD VDD VSS VSS ring.sym.sym_mux.OSC_INJ
+ ring.sym.sym_mux.DCO_EN_INJ_WIN ring.sym.OSC_BALANCED gf180mcu_as_sc_mcu7t3v3__nand2_2
Xring.sym.sym_mux.nand_pll.impl VDD VDD VSS VSS net65 ring.sym.sym_mux.OSC_INJ
+ ring.sym.sym_mux.REF_INJ gf180mcu_as_sc_mcu7t3v3__nand2_2
Xring.sym.sym_mux.nand_ref.impl VDD VDD VSS VSS ring.sym.sym_mux.REF_INJ
+ net ring.sym.INJ_EDGE_BALANCED gf180mcu_as_sc_mcu7t3v3__nand2b_2
Xring.sym.sym_mux.nand_ref.impl_68 VDD VDD VSS VSS net gf180mcu_as_sc_mcu7t3v3__tiel_4
Xring.sym.sym_mux.norb_en_inj.impl VDD VDD VSS VSS ring.sym.sym_mux.DCO_EN_INJ_WIN
+ net68 net16 gf180mcu_as_sc_mcu7t3v3__nor2b_2
Xring.sym.sym_mux.norb_en_inj.impl_69 VDD VDD VSS VSS net68
+ gf180mcu_as_sc_mcu7t3v3__tiel_4
.ENDS PLL_RING_DCO_PHYS
