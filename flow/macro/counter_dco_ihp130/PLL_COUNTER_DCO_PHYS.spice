************************************************************************
*
* Copyright 2023 IHP PDK Authors
*
* Licensed under the Apache License, Version 2.0 (the "License");
* you may not use this file except in compliance with the License.
* You may obtain a copy of the License at
*
*    https://www.apache.org/licenses/LICENSE-2.0
*
* Unless required by applicable law or agreed to in writing, software
* distributed under the License is distributed on an "AS IS" BASIS,
* WITHOUT WARRANTIES OR CONDITIONS OF ANY KIND, either express or implied.
* See the License for the specific language governing permissions and
* limitations under the License.
*
************************************************************************

************************************************************************
* Library Name: sg13g2_stdcell
* Cell Name:    sg13g2_a21o_1
* View Name:    schematic
************************************************************************

.SUBCKT sg13g2_a21o_1 X A1 A2 B1 VDD VSS
*.PININFO A1:I A2:I B1:I X:O VDD:B VSS:B
MN0 net1 A1 net2 VSS sg13_lv_nmos m=1 w=640.00n l=130.00n ng=1
MN1 net2 A2 VSS VSS sg13_lv_nmos m=1 w=640.00n l=130.00n ng=1
MN2 net1 B1 VSS VSS sg13_lv_nmos m=1 w=640.00n l=130.00n ng=1
MN3 X net1 VSS VSS sg13_lv_nmos m=1 w=740.00n l=130.00n ng=1
MP2 net1 B1 net3 VDD sg13_lv_pmos m=1 w=1.000u l=130.00n ng=1
MP0 net3 A1 VDD VDD sg13_lv_pmos m=1 w=1.000u l=130.00n ng=1
MP1 net3 A2 VDD VDD sg13_lv_pmos m=1 w=1.000u l=130.00n ng=1
MP3 X net1 VDD VDD sg13_lv_pmos m=1 w=1.12u l=130.00n ng=1
.ENDS

************************************************************************
* Library Name: sg13g2_stdcell
* Cell Name:    sg13g2_a21o_2
* View Name:    schematic
************************************************************************

.SUBCKT sg13g2_a21o_2 X A1 A2 B1 VDD VSS
*.PININFO A1:I A2:I B1:I X:O VDD:B VSS:B
MN0 net1 A1 net2 VSS sg13_lv_nmos m=1 w=740.00n l=130.00n ng=1
MN1 net2 A2 VSS VSS sg13_lv_nmos m=1 w=740.00n l=130.00n ng=1
MN2 net1 B1 VSS VSS sg13_lv_nmos m=1 w=740.00n l=130.00n ng=1
MN3 X net1 VSS VSS sg13_lv_nmos m=1 w=1.48u l=130.00n ng=2
MP2 net1 B1 net3 VDD sg13_lv_pmos m=1 w=1.000u l=130.00n ng=1
MP0 net3 A1 VDD VDD sg13_lv_pmos m=1 w=1.000u l=130.00n ng=1
MP1 net3 A2 VDD VDD sg13_lv_pmos m=1 w=1.000u l=130.00n ng=1
MP3 X net1 VDD VDD sg13_lv_pmos m=1 w=2.24u l=130.00n ng=2
.ENDS

************************************************************************
* Library Name: sg13g2_stdcell
* Cell Name:    sg13g2_a21oi_1
* View Name:    schematic
************************************************************************

.SUBCKT sg13g2_a21oi_1 Y A1 A2 B1 VDD VSS
*.PININFO A1:I A2:I B1:I Y:O VDD:B VSS:B
MN0 Y B1 VSS VSS sg13_lv_nmos m=1 w=740.00n l=130.00n ng=1
MN2 net1 A2 VSS VSS sg13_lv_nmos m=1 w=740.00n l=130.00n ng=1
MN1 Y A1 net1 VSS sg13_lv_nmos m=1 w=740.00n l=130.00n ng=1
MP2 Y B1 net2 VDD sg13_lv_pmos m=1 w=1.12u l=130.00n ng=1
MP1 net2 A2 VDD VDD sg13_lv_pmos m=1 w=1.12u l=130.00n ng=1
MP0 net2 A1 VDD VDD sg13_lv_pmos m=1 w=1.12u l=130.00n ng=1
.ENDS

************************************************************************
* Library Name: sg13g2_stdcell
* Cell Name:    sg13g2_a21oi_2
* View Name:    schematic
************************************************************************

.SUBCKT sg13g2_a21oi_2 Y A1 A2 B1 VDD VSS
*.PININFO A1:I A2:I B1:I Y:O VDD:B VSS:B
MN0 Y B1 VSS VSS sg13_lv_nmos m=1 w=1.48u l=130.00n ng=2
MN2 net2 A2 VSS VSS sg13_lv_nmos m=1 w=1.48u l=130.00n ng=2
MN1 Y A1 net2 VSS sg13_lv_nmos m=1 w=1.48u l=130.00n ng=2
MP2 Y B1 net1 VDD sg13_lv_pmos m=1 w=2.24u l=130.00n ng=2
MP1 net1 A2 VDD VDD sg13_lv_pmos m=1 w=2.24u l=130.00n ng=2
MP0 net1 A1 VDD VDD sg13_lv_pmos m=1 w=2.24u l=130.00n ng=2
.ENDS

************************************************************************
* Library Name: sg13g2_stdcell
* Cell Name:    sg13g2_a221oi_1
* View Name:    schematic
************************************************************************

.SUBCKT sg13g2_a221oi_1 Y A1 A2 B1 B2 C1 VDD VSS
*.PININFO A1:I A2:I B1:I B2:I C1:I Y:O VDD:B VSS:B
MP2 Y C1 net3 VDD sg13_lv_pmos m=1 w=1.12u l=130.00n ng=1
MP4 net3 B2 net1 VDD sg13_lv_pmos m=1 w=1.12u l=130.00n ng=1
MP1 net3 B1 net1 VDD sg13_lv_pmos m=1 w=1.12u l=130.00n ng=1
MP3 net1 A2 VDD VDD sg13_lv_pmos m=1 w=1.12u l=130.00n ng=1
MP0 net1 A1 VDD VDD sg13_lv_pmos m=1 w=1.12u l=130.00n ng=1
MN4 Y C1 VSS VSS sg13_lv_nmos m=1 w=740.00n l=130.00n ng=1
MN3 net4 B2 VSS VSS sg13_lv_nmos m=1 w=740.00n l=130.00n ng=1
MN2 Y B1 net4 VSS sg13_lv_nmos m=1 w=740.00n l=130.00n ng=1
MN1 net2 A2 VSS VSS sg13_lv_nmos m=1 w=740.00n l=130.00n ng=1
MN0 Y A1 net2 VSS sg13_lv_nmos m=1 w=740.00n l=130.00n ng=1
.ENDS

************************************************************************
* Library Name: sg13g2_stdcell
* Cell Name:    sg13g2_and2_1
* View Name:    schematic
************************************************************************

.SUBCKT sg13g2_and2_1 X A B VDD VSS
*.PININFO A:I B:I X:O VDD:B VSS:B
MN0 net4 A net2 VSS sg13_lv_nmos m=1 w=640.00n l=130.00n ng=1
MN2 X net4 VSS VSS sg13_lv_nmos m=1 w=740.00n l=130.00n ng=1
MN1 net2 B VSS VSS sg13_lv_nmos m=1 w=640.00n l=130.00n ng=1
MP0 net4 B VDD VDD sg13_lv_pmos m=1 w=840.00n l=130.00n ng=1
MP2 X net4 VDD VDD sg13_lv_pmos m=1 w=1.12u l=130.00n ng=1
MP1 net4 A VDD VDD sg13_lv_pmos m=1 w=840.00n l=130.00n ng=1
.ENDS

************************************************************************
* Library Name: sg13g2_stdcell
* Cell Name:    sg13g2_and2_2
* View Name:    schematic
************************************************************************

.SUBCKT sg13g2_and2_2 X A B VDD VSS
*.PININFO A:I B:I X:O VDD:B VSS:B
MN0 net1 A net2 VSS sg13_lv_nmos m=1 w=640.00n l=130.00n ng=1
MN2 X net1 VSS VSS sg13_lv_nmos m=1 w=1.48u l=130.00n ng=2
MN1 net2 B VSS VSS sg13_lv_nmos m=1 w=640.00n l=130.00n ng=1
MP0 net1 B VDD VDD sg13_lv_pmos m=1 w=840.00n l=130.00n ng=1
MP2 X net1 VDD VDD sg13_lv_pmos m=1 w=2.24u l=130.00n ng=2
MP1 net1 A VDD VDD sg13_lv_pmos m=1 w=840.00n l=130.00n ng=1
.ENDS

************************************************************************
* Library Name: sg13g2_stdcell
* Cell Name:    sg13g2_and3_1
* View Name:    schematic
************************************************************************

.SUBCKT sg13g2_and3_1 X A B C VDD VSS
*.PININFO A:I B:I C:I X:O VDD:B VSS:B
MN2 net3 C VSS VSS sg13_lv_nmos m=1 w=640.00n l=130.00n ng=1
MN3 X net2 VSS VSS sg13_lv_nmos m=1 w=740.00n l=130.00n ng=1
MN0 net2 A net1 VSS sg13_lv_nmos m=1 w=640.00n l=130.00n ng=1
MN1 net1 B net3 VSS sg13_lv_nmos m=1 w=640.00n l=130.00n ng=1
MP3 X net2 VDD VDD sg13_lv_pmos m=1 w=1.12u l=130.00n ng=1
MP1 net2 B VDD VDD sg13_lv_pmos m=1 w=840.00n l=130.00n ng=1
MP2 net2 A VDD VDD sg13_lv_pmos m=1 w=840.00n l=130.00n ng=1
MP0 net2 C VDD VDD sg13_lv_pmos m=1 w=840.00n l=130.00n ng=1
.ENDS

************************************************************************
* Library Name: sg13g2_stdcell
* Cell Name:    sg13g2_and3_2
* View Name:    schematic
************************************************************************

.SUBCKT sg13g2_and3_2 X A B C VDD VSS
*.PININFO A:I B:I C:I X:O VDD:B VSS:B
MN2 net3 C VSS VSS sg13_lv_nmos m=1 w=640.00n l=130.00n ng=1
MN3 X net2 VSS VSS sg13_lv_nmos m=1 w=1.48u l=130.00n ng=2
MN0 net2 A net1 VSS sg13_lv_nmos m=1 w=640.00n l=130.00n ng=1
MN1 net1 B net3 VSS sg13_lv_nmos m=1 w=640.00n l=130.00n ng=1
MP3 X net2 VDD VDD sg13_lv_pmos m=1 w=2.24u l=130.00n ng=2
MP1 net2 B VDD VDD sg13_lv_pmos m=1 w=840.00n l=130.00n ng=1
MP2 net2 A VDD VDD sg13_lv_pmos m=1 w=840.00n l=130.00n ng=1
MP0 net2 C VDD VDD sg13_lv_pmos m=1 w=840.00n l=130.00n ng=1
.ENDS

************************************************************************
* Library Name: sg13g2_stdcell
* Cell Name:    sg13g2_and4_1
* View Name:    schematic
************************************************************************

.SUBCKT sg13g2_and4_1 X A B C D VDD VSS
*.PININFO A:I B:I C:I D:I X:O VDD:B VSS:B
MN3 net17 D VSS VSS sg13_lv_nmos m=1 w=640.00n l=130.00n ng=1
MN2 net16 C net17 VSS sg13_lv_nmos m=1 w=640.00n l=130.00n ng=1
MN1 net15 B net16 VSS sg13_lv_nmos m=1 w=640.00n l=130.00n ng=1
MN0 net1 A net15 VSS sg13_lv_nmos m=1 w=640.00n l=130.00n ng=1
MN4 X net1 VSS VSS sg13_lv_nmos m=1 w=740.00n l=130.00n ng=1
MP3 net1 A VDD VDD sg13_lv_pmos m=1 w=840.00n l=130.00n ng=1
MP4 X net1 VDD VDD sg13_lv_pmos m=1 w=1.12u l=130.00n ng=1
MP0 net1 D VDD VDD sg13_lv_pmos m=1 w=840.00n l=130.00n ng=1
MP1 net1 C VDD VDD sg13_lv_pmos m=1 w=840.00n l=130.00n ng=1
MP2 net1 B VDD VDD sg13_lv_pmos m=1 w=840.00n l=130.00n ng=1
.ENDS

************************************************************************
* Library Name: sg13g2_stdcell
* Cell Name:    sg13g2_and4_2
* View Name:    schematic
************************************************************************

.SUBCKT sg13g2_and4_2 X A B C D VDD VSS
*.PININFO A:I B:I C:I D:I X:O VDD:B VSS:B
MN3 net17 D VSS VSS sg13_lv_nmos m=1 w=640.00n l=130.00n ng=1
MN2 net16 C net17 VSS sg13_lv_nmos m=1 w=640.00n l=130.00n ng=1
MN1 net15 B net16 VSS sg13_lv_nmos m=1 w=640.00n l=130.00n ng=1
MN0 net1 A net15 VSS sg13_lv_nmos m=1 w=640.00n l=130.00n ng=1
MN4 X net1 VSS VSS sg13_lv_nmos m=1 w=1.48u l=130.00n ng=2
MP3 net1 A VDD VDD sg13_lv_pmos m=1 w=840.00n l=130.00n ng=1
MP4 X net1 VDD VDD sg13_lv_pmos m=1 w=2.24u l=130.00n ng=2
MP0 net1 D VDD VDD sg13_lv_pmos m=1 w=840.00n l=130.00n ng=1
MP1 net1 C VDD VDD sg13_lv_pmos m=1 w=840.00n l=130.00n ng=1
MP2 net1 B VDD VDD sg13_lv_pmos m=1 w=840.00n l=130.00n ng=1
.ENDS

************************************************************************
* Library Name: sg13g2_stdcell
* Cell Name:    sg13g2_antennanp
* View Name:    schematic
************************************************************************

.SUBCKT sg13g2_antennanp A VDD VSS
*.PININFO A:I VDD:B VSS:B
DD1 VSS A dantenna m=1 w=780n l=780n a=608.4f p=3.12u
DD0 A VDD dpantenna m=1 w=1.05u l=1.34u a=1.407p p=4.78u
.ENDS

************************************************************************
* Library Name: sg13g2_stdcell
* Cell Name:    sg13g2_buf_1
* View Name:    schematic
************************************************************************

.SUBCKT sg13g2_buf_1 X A VDD VSS
*.PININFO A:I X:O VDD:B VSS:B
MN0 net1 A VSS VSS sg13_lv_nmos m=1 w=550.00n l=130.00n ng=1
MN1 X net1 VSS VSS sg13_lv_nmos m=1 w=740.00n l=130.00n ng=1
MP1 X net1 VDD VDD sg13_lv_pmos m=1 w=1.12u l=130.00n ng=1
MP0 net1 A VDD VDD sg13_lv_pmos m=1 w=840.00n l=130.00n ng=1
.ENDS

************************************************************************
* Library Name: sg13g2_stdcell
* Cell Name:    sg13g2_buf_16
* View Name:    schematic
************************************************************************

.SUBCKT sg13g2_buf_16 X A VDD VSS
*.PININFO A:I X:O VDD:B VSS:B
MN0 net1 A VSS VSS sg13_lv_nmos m=1 w=4.44u l=130.00n ng=6
MN1 X net1 VSS VSS sg13_lv_nmos m=1 w=11.84u l=130.00n ng=16
MP1 X net1 VDD VDD sg13_lv_pmos m=1 w=17.92u l=130.00n ng=16
MP0 net1 A VDD VDD sg13_lv_pmos m=1 w=6.72u l=130.00n ng=6
.ENDS

************************************************************************
* Library Name: sg13g2_stdcell
* Cell Name:    sg13g2_buf_2
* View Name:    schematic
************************************************************************

.SUBCKT sg13g2_buf_2 X A VDD VSS
*.PININFO A:I X:O VDD:B VSS:B
MN0 net1 A VSS VSS sg13_lv_nmos m=1 w=640.00n l=130.00n ng=1
MN1 X net1 VSS VSS sg13_lv_nmos m=1 w=1.48u l=130.00n ng=2
MP1 X net1 VDD VDD sg13_lv_pmos m=1 w=2.24u l=130.00n ng=2
MP0 net1 A VDD VDD sg13_lv_pmos m=1 w=1.000u l=130.00n ng=1
.ENDS

************************************************************************
* Library Name: sg13g2_stdcell
* Cell Name:    sg13g2_buf_4
* View Name:    schematic
************************************************************************

.SUBCKT sg13g2_buf_4 X A VDD VSS
*.PININFO A:I X:O VDD:B VSS:B
MN0 net1 A VSS VSS sg13_lv_nmos m=1 w=740.00n l=130.00n ng=1
MN1 X net1 VSS VSS sg13_lv_nmos m=1 w=2.96u l=130.00n ng=4
MP1 X net1 VDD VDD sg13_lv_pmos m=1 w=4.48u l=130.00n ng=4
MP0 net1 A VDD VDD sg13_lv_pmos m=1 w=1.68u l=130.00n ng=2
.ENDS

************************************************************************
* Library Name: sg13g2_stdcell
* Cell Name:    sg13g2_buf_8
* View Name:    schematic
************************************************************************

.SUBCKT sg13g2_buf_8 X A VDD VSS
*.PININFO A:I X:O VDD:B VSS:B
MN0 net1 A VSS VSS sg13_lv_nmos m=1 w=2.22u l=130.00n ng=3
MN1 X net1 VSS VSS sg13_lv_nmos m=1 w=5.92u l=130.00n ng=8
MP1 X net1 VDD VDD sg13_lv_pmos m=1 w=8.96u l=130.00n ng=8
MP0 net1 A VDD VDD sg13_lv_pmos m=1 w=3.36u l=130.00n ng=3
.ENDS

************************************************************************
* Library Name: sg13g2_stdcell
* Cell Name:    sg13g2_decap_4
* View Name:    schematic
************************************************************************

.SUBCKT sg13g2_decap_4 VDD VSS
*.PININFO VDD:B VSS:B
MN0 VSS VDD VSS VSS sg13_lv_nmos m=1 w=420.00n l=1.000u ng=1
MP0 VDD VSS VDD VDD sg13_lv_pmos m=1 w=1.000u l=1.000u ng=1
.ENDS

************************************************************************
* Library Name: sg13g2_stdcell
* Cell Name:    sg13g2_decap_8
* View Name:    schematic
************************************************************************

.SUBCKT sg13g2_decap_8 VDD VSS
*.PININFO VDD:B VSS:B
MN0 VSS VDD VSS VSS sg13_lv_nmos m=1 w=840.00n l=1.000u ng=2
MP0 VDD VSS VDD VDD sg13_lv_pmos m=1 w=2.000u l=1.000u ng=2
.ENDS

************************************************************************
* Library Name: sg13g2_stdcell
* Cell Name:    sg13g2_dfrbp_1
* View Name:    schematic
************************************************************************

.SUBCKT sg13g2_dfrbp_1 Q Q_N CLK D RESET_B VDD VSS
*.PININFO CLK:I D:I RESET_B:I Q:O Q_N:O VDD:B VSS:B
MN11 net12 net2 VSS VSS sg13_lv_nmos m=1 w=420.00n l=130.00n ng=1
MN10 net5 clkneg net12 VSS sg13_lv_nmos m=1 w=420.00n l=130.00n ng=1
MN12 net2 net5 net11 VSS sg13_lv_nmos m=1 w=420.00n l=130.00n ng=1
MN13 net11 RESET_B VSS VSS sg13_lv_nmos m=1 w=420.00n l=130.00n ng=1
MN14 Q_N net5 VSS VSS sg13_lv_nmos m=1 w=740.00n l=130.00n ng=1
MN0 Db D net10 VSS sg13_lv_nmos m=1 w=420.00n l=130.00n ng=1
MN1 net10 RESET_B VSS VSS sg13_lv_nmos m=1 w=420.00n l=130.00n ng=1
MN4 Db clkneg net6 VSS sg13_lv_nmos m=1 w=420.00n l=130.00n ng=1
MN5 net6 clkpos net9 VSS sg13_lv_nmos m=1 w=420.00n l=130.00n ng=1
MN6 net9 net4 net8 VSS sg13_lv_nmos m=1 w=420.00n l=130.00n ng=1
MN7 net8 RESET_B VSS VSS sg13_lv_nmos m=1 w=420.00n l=130.00n ng=1
MN8 net4 net6 VSS VSS sg13_lv_nmos m=1 w=740.00n l=130.00n ng=1
MN2 clkneg CLK VSS VSS sg13_lv_nmos m=1 w=740.00n l=130.00n ng=1
MN9 net4 clkpos net5 VSS sg13_lv_nmos m=1 w=740.00n l=130.00n ng=1
MN3 clkpos clkneg VSS VSS sg13_lv_nmos m=1 w=740.00n l=130.00n ng=1
MN16 Q net1 VSS VSS sg13_lv_nmos m=1 w=740.00n l=130.00n ng=1
MN15 net1 net5 VSS VSS sg13_lv_nmos m=1 w=740.00n l=130.00n ng=1
MP11 net5 clkpos net3 VDD sg13_lv_pmos m=1 w=420.00n l=130.00n ng=1
MP12 net2 net5 VDD VDD sg13_lv_pmos m=1 w=420.00n l=130.00n ng=1
MP13 net2 RESET_B VDD VDD sg13_lv_pmos m=1 w=420.00n l=130.00n ng=1
MP14 Q_N net5 VDD VDD sg13_lv_pmos m=1 w=1.12u l=130.00n ng=1
MP4 Db clkpos net6 VDD sg13_lv_pmos m=1 w=420.00n l=130.00n ng=1
MP0 Db RESET_B VDD VDD sg13_lv_pmos m=1 w=420.00n l=130.00n ng=1
MP1 Db D VDD VDD sg13_lv_pmos m=1 w=420.00n l=130.00n ng=1
MP5 net7 net4 VDD VDD sg13_lv_pmos m=1 w=420.00n l=130.00n ng=1
MP6 net6 clkneg net7 VDD sg13_lv_pmos m=1 w=420.00n l=130.00n ng=1
MP7 net6 RESET_B VDD VDD sg13_lv_pmos m=1 w=420.00n l=130.00n ng=1
MP2 clkneg CLK VDD VDD sg13_lv_pmos m=1 w=1.12u l=130.00n ng=1
MP3 clkpos clkneg VDD VDD sg13_lv_pmos m=1 w=1.12u l=130.00n ng=1
MP8 net4 net6 VDD VDD sg13_lv_pmos m=1 w=1.000u l=130.00n ng=1
MP9 net4 clkneg net5 VDD sg13_lv_pmos m=1 w=1.000u l=130.00n ng=1
MP16 Q net1 VDD VDD sg13_lv_pmos m=1 w=1.12u l=130.00n ng=1
MP10 net3 net2 VDD VDD sg13_lv_pmos m=1 w=420.00n l=130.00n ng=1
MP15 net1 net5 VDD VDD sg13_lv_pmos m=1 w=1.12u l=130.00n ng=1
.ENDS

************************************************************************
* Library Name: sg13g2_stdcell
* Cell Name:    sg13g2_dfrbp_2
* View Name:    schematic
************************************************************************

.SUBCKT sg13g2_dfrbp_2 Q Q_N CLK D RESET_B VDD VSS
*.PININFO CLK:I D:I RESET_B:I Q:O Q_N:O VDD:B VSS:B
MN11 net12 net2 VSS VSS sg13_lv_nmos m=1 w=420.00n l=130.00n ng=1
MN10 net5 clkneg net12 VSS sg13_lv_nmos m=1 w=420.00n l=130.00n ng=1
MN12 net2 net5 net11 VSS sg13_lv_nmos m=1 w=420.00n l=130.00n ng=1
MN13 net11 RESET_B VSS VSS sg13_lv_nmos m=1 w=420.00n l=130.00n ng=1
MN14 Q_N net5 VSS VSS sg13_lv_nmos m=1 w=1.48u l=130.00n ng=2
MN0 Db D net10 VSS sg13_lv_nmos m=1 w=420.00n l=130.00n ng=1
MN1 net10 RESET_B VSS VSS sg13_lv_nmos m=1 w=420.00n l=130.00n ng=1
MN4 Db clkneg net6 VSS sg13_lv_nmos m=1 w=420.00n l=130.00n ng=1
MN5 net6 clkpos net9 VSS sg13_lv_nmos m=1 w=420.00n l=130.00n ng=1
MN6 net9 net4 net8 VSS sg13_lv_nmos m=1 w=420.00n l=130.00n ng=1
MN7 net8 RESET_B VSS VSS sg13_lv_nmos m=1 w=420.00n l=130.00n ng=1
MN8 net4 net6 VSS VSS sg13_lv_nmos m=1 w=740.00n l=130.00n ng=1
MN2 clkneg CLK VSS VSS sg13_lv_nmos m=1 w=740.00n l=130.00n ng=1
MN9 net4 clkpos net5 VSS sg13_lv_nmos m=1 w=740.00n l=130.00n ng=1
MN3 clkpos clkneg VSS VSS sg13_lv_nmos m=1 w=740.00n l=130.00n ng=1
MN16 Q net1 VSS VSS sg13_lv_nmos m=1 w=1.48u l=130.00n ng=2
MN15 net1 net5 VSS VSS sg13_lv_nmos m=1 w=640.00n l=130.00n ng=1
MP11 net5 clkpos net3 VDD sg13_lv_pmos m=1 w=420.00n l=130.00n ng=1
MP12 net2 net5 VDD VDD sg13_lv_pmos m=1 w=420.00n l=130.00n ng=1
MP13 net2 RESET_B VDD VDD sg13_lv_pmos m=1 w=420.00n l=130.00n ng=1
MP14 Q_N net5 VDD VDD sg13_lv_pmos m=1 w=2.24u l=130.00n ng=2
MP4 Db clkpos net6 VDD sg13_lv_pmos m=1 w=420.00n l=130.00n ng=1
MP0 Db RESET_B VDD VDD sg13_lv_pmos m=1 w=420.00n l=130.00n ng=1
MP1 Db D VDD VDD sg13_lv_pmos m=1 w=420.00n l=130.00n ng=1
MP5 net7 net4 VDD VDD sg13_lv_pmos m=1 w=420.00n l=130.00n ng=1
MP6 net6 clkneg net7 VDD sg13_lv_pmos m=1 w=420.00n l=130.00n ng=1
MP7 net6 RESET_B VDD VDD sg13_lv_pmos m=1 w=420.00n l=130.00n ng=1
MP2 clkneg CLK VDD VDD sg13_lv_pmos m=1 w=1.12u l=130.00n ng=1
MP3 clkpos clkneg VDD VDD sg13_lv_pmos m=1 w=1.12u l=130.00n ng=1
MP8 net4 net6 VDD VDD sg13_lv_pmos m=1 w=1.000u l=130.00n ng=1
MP9 net4 clkneg net5 VDD sg13_lv_pmos m=1 w=1.000u l=130.00n ng=1
MP16 Q net1 VDD VDD sg13_lv_pmos m=1 w=2.24u l=130.00n ng=2
MP10 net3 net2 VDD VDD sg13_lv_pmos m=1 w=420.00n l=130.00n ng=1
MP15 net1 net5 VDD VDD sg13_lv_pmos m=1 w=1.000u l=130.00n ng=1
.ENDS

************************************************************************
* Library Name: sg13g2_stdcell
* Cell Name:    sg13g2_dlhq_1
* View Name:    schematic
************************************************************************

.SUBCKT sg13g2_dlhq_1 Q D GATE VDD VSS
*.PININFO D:I GATE:I Q:O VDD:B VSS:B
MP8 Q qint_b VDD VDD sg13_lv_pmos m=1 w=1.12u l=130.00n ng=1
MP6 qint GATE_BB net8 VDD sg13_lv_pmos m=1 w=420.00n l=130.00n ng=1
MP7 qint_b qint VDD VDD sg13_lv_pmos m=1 w=1.12u l=130.00n ng=1
MP2 Db D VDD VDD sg13_lv_pmos m=1 w=840.00n l=130.00n ng=1
MP0 GATE_B GATE VDD VDD sg13_lv_pmos m=1 w=840.00n l=130.00n ng=1
MP1 GATE_BB GATE_B VDD VDD sg13_lv_pmos m=1 w=840.00n l=130.00n ng=1
MP5 net8 qint_b VDD VDD sg13_lv_pmos m=1 w=420.00n l=130.00n ng=1
MP4 net4 GATE_B qint VDD sg13_lv_pmos m=1 w=1.000u l=130.00n ng=1
MP3 net4 Db VDD VDD sg13_lv_pmos m=1 w=1.000u l=130.00n ng=1
MN0 GATE_B GATE VSS VSS sg13_lv_nmos m=1 w=740.00n l=130.00n ng=1
MN1 GATE_BB GATE_B VSS VSS sg13_lv_nmos m=1 w=740.00n l=130.00n ng=1
MN5 qint GATE_B net9 VSS sg13_lv_nmos m=1 w=420.00n l=130.00n ng=1
MN8 Q qint_b VSS VSS sg13_lv_nmos m=1 w=740.00n l=130.00n ng=1
MN4 net7 Db VSS VSS sg13_lv_nmos m=1 w=740.00n l=130.00n ng=1
MN6 net9 qint_b VSS VSS sg13_lv_nmos m=1 w=420.00n l=130.00n ng=1
MN7 qint_b qint VSS VSS sg13_lv_nmos m=1 w=740.00n l=130.00n ng=1
MN3 qint GATE_BB net7 VSS sg13_lv_nmos m=1 w=740.00n l=130.00n ng=1
MN2 Db D VSS VSS sg13_lv_nmos m=1 w=550.00n l=130.00n ng=1
.ENDS

************************************************************************
* Library Name: sg13g2_stdcell
* Cell Name:    sg13g2_dlhr_1
* View Name:    schematic
************************************************************************

.SUBCKT sg13g2_dlhr_1 Q Q_N D GATE RESET_B VDD VSS
*.PININFO D:I GATE:I RESET_B:I Q:O Q_N:O VDD:B VSS:B
MP8 qint_b RESET_B VDD VDD sg13_lv_pmos m=1 w=1.12u l=130.00n ng=1
MP9 Q qint_b VDD VDD sg13_lv_pmos m=1 w=1.12u l=130.00n ng=1
MP6 qint GATE_BB net11 VDD sg13_lv_pmos m=1 w=420.00n l=130.00n ng=1
MP5 net11 qint_b VDD VDD sg13_lv_pmos m=1 w=420.00n l=130.00n ng=1
MP4 qint GATE_B net2 VDD sg13_lv_pmos m=1 w=1.000u l=130.00n ng=1
MP3 net2 Db VDD VDD sg13_lv_pmos m=1 w=1.000u l=130.00n ng=1
MP2 Db D VDD VDD sg13_lv_pmos m=1 w=840.00n l=130.00n ng=1
MP0 GATE_B GATE VDD VDD sg13_lv_pmos m=1 w=840.00n l=130.00n ng=1
MP11 Q_N qintn_b VDD VDD sg13_lv_pmos m=1 w=1.12u l=130.00n ng=1
MP7 qint_b qint VDD VDD sg13_lv_pmos m=1 w=1.12u l=130.00n ng=1
MP1 GATE_BB GATE_B VDD VDD sg13_lv_pmos m=1 w=840.00n l=130.00n ng=1
MP10 qintn_b qint_b VDD VDD sg13_lv_pmos m=1 w=840.00n l=130.00n ng=1
MN7 qint_b qint net9 VSS sg13_lv_nmos m=1 w=740.00n l=130.00n ng=1
MN8 net9 RESET_B VSS VSS sg13_lv_nmos m=1 w=740.00n l=130.00n ng=1
MN5 qint GATE_B net7 VSS sg13_lv_nmos m=1 w=420.00n l=130.00n ng=1
MN6 net7 qint_b VSS VSS sg13_lv_nmos m=1 w=420.00n l=130.00n ng=1
MN9 Q qint_b VSS VSS sg13_lv_nmos m=1 w=740.00n l=130.00n ng=1
MN3 qint GATE_BB net1 VSS sg13_lv_nmos m=1 w=640.00n l=130.00n ng=1
MN4 net1 Db VSS VSS sg13_lv_nmos m=1 w=640.00n l=130.00n ng=1
MN2 Db D VSS VSS sg13_lv_nmos m=1 w=550.00n l=130.00n ng=1
MN0 GATE_B GATE VSS VSS sg13_lv_nmos m=1 w=740.00n l=130.00n ng=1
MN11 Q_N qintn_b VSS VSS sg13_lv_nmos m=1 w=740.00n l=130.00n ng=1
MN1 GATE_BB GATE_B VSS VSS sg13_lv_nmos m=1 w=740.00n l=130.00n ng=1
MN10 qintn_b qint_b VSS VSS sg13_lv_nmos m=1 w=550.00n l=130.00n ng=1
.ENDS

************************************************************************
* Library Name: sg13g2_stdcell
* Cell Name:    sg13g2_dlhrq_1
* View Name:    schematic
************************************************************************

.SUBCKT sg13g2_dlhrq_1 Q D GATE RESET_B VDD VSS
*.PININFO D:I GATE:I RESET_B:I Q:O VDD:B VSS:B
MN8 net116 RESET_B VSS VSS sg13_lv_nmos m=1 w=740.00n l=130.00n ng=1
MN9 Q qint_b VSS VSS sg13_lv_nmos m=1 w=740.00n l=130.00n ng=1
MN1 GATE_BB GATE_B VSS VSS sg13_lv_nmos m=1 w=740.00n l=130.00n ng=1
MN5 qint GATE_B net89 VSS sg13_lv_nmos m=1 w=420.00n l=130.00n ng=1
MN7 qint_b qint net116 VSS sg13_lv_nmos m=1 w=740.00n l=130.00n ng=1
MN2 Db D VSS VSS sg13_lv_nmos m=1 w=550.00n l=130.00n ng=1
MN4 net61 Db VSS VSS sg13_lv_nmos m=1 w=640.00n l=130.00n ng=1
MN3 qint GATE_BB net61 VSS sg13_lv_nmos m=1 w=640.00n l=130.00n ng=1
MN6 net89 qint_b VSS VSS sg13_lv_nmos m=1 w=420.00n l=130.00n ng=1
MN0 GATE_B GATE VSS VSS sg13_lv_nmos m=1 w=740.00n l=130.00n ng=1
MP3 net60 Db VDD VDD sg13_lv_pmos m=1 w=1.000u l=130.00n ng=1
MP8 qint_b RESET_B VDD VDD sg13_lv_pmos m=1 w=1.000u l=130.00n ng=1
MP6 qint GATE_BB net92 VDD sg13_lv_pmos m=1 w=420.00n l=130.00n ng=1
MP9 Q qint_b VDD VDD sg13_lv_pmos m=1 w=1.12u l=130.00n ng=1
MP5 net92 qint_b VDD VDD sg13_lv_pmos m=1 w=420.00n l=130.00n ng=1
MP0 GATE_B GATE VDD VDD sg13_lv_pmos m=1 w=840.00n l=130.00n ng=1
MP2 Db D VDD VDD sg13_lv_pmos m=1 w=840.00n l=130.00n ng=1
MP4 qint GATE_B net60 VDD sg13_lv_pmos m=1 w=1.000u l=130.00n ng=1
MP1 GATE_BB GATE_B VDD VDD sg13_lv_pmos m=1 w=840.00n l=130.00n ng=1
MP7 qint_b qint VDD VDD sg13_lv_pmos m=1 w=1.000u l=130.00n ng=1
.ENDS

************************************************************************
* Library Name: sg13g2_stdcell
* Cell Name:    sg13g2_dllr_1
* View Name:    schematic
************************************************************************

.SUBCKT sg13g2_dllr_1 Q Q_N D GATE_N RESET_B VDD VSS
*.PININFO D:I GATE_N:I RESET_B:I Q:O Q_N:O VDD:B VSS:B
MN2 Db D VSS VSS sg13_lv_nmos m=1 w=550.00n l=130.00n ng=1
MN0 gnb GATE_N VSS VSS sg13_lv_nmos m=1 w=740.00n l=130.00n ng=1
MN1 gnbb gnb VSS VSS sg13_lv_nmos m=1 w=740.00n l=130.00n ng=1
MN6 net89 qint_b VSS VSS sg13_lv_nmos m=1 w=420.00n l=130.00n ng=1
MN7 qint_b qint net116 VSS sg13_lv_nmos m=1 w=740.00n l=130.00n ng=1
MN8 net116 RESET_B VSS VSS sg13_lv_nmos m=1 w=740.00n l=130.00n ng=1
MN5 qint gnbb net89 VSS sg13_lv_nmos m=1 w=420.00n l=130.00n ng=1
MN11 Q_N qintn_b VSS VSS sg13_lv_nmos m=1 w=740.00n l=130.00n ng=1
MN3 qint gnb net61 VSS sg13_lv_nmos m=1 w=640.00n l=130.00n ng=1
MN10 qintn_b qint_b VSS VSS sg13_lv_nmos m=1 w=550.00n l=130.00n ng=1
MN4 net61 Db VSS VSS sg13_lv_nmos m=1 w=640.00n l=130.00n ng=1
MN9 Q qint_b VSS VSS sg13_lv_nmos m=1 w=740.00n l=130.00n ng=1
MP1 gnbb gnb VDD VDD sg13_lv_pmos m=1 w=840.00n l=130.00n ng=1
MP4 qint gnbb net60 VDD sg13_lv_pmos m=1 w=1.000u l=130.00n ng=1
MP10 qintn_b qint_b VDD VDD sg13_lv_pmos m=1 w=840.00n l=130.00n ng=1
MP11 Q_N qintn_b VDD VDD sg13_lv_pmos m=1 w=1.12u l=130.00n ng=1
MP3 net60 Db VDD VDD sg13_lv_pmos m=1 w=1.000u l=130.00n ng=1
MP5 net92 qint_b VDD VDD sg13_lv_pmos m=1 w=420.00n l=130.00n ng=1
MP8 qint_b RESET_B VDD VDD sg13_lv_pmos m=1 w=1.12u l=130.00n ng=1
MP2 Db D VDD VDD sg13_lv_pmos m=1 w=840.00n l=130.00n ng=1
MP0 gnb GATE_N VDD VDD sg13_lv_pmos m=1 w=840.00n l=130.00n ng=1
MP9 Q qint_b VDD VDD sg13_lv_pmos m=1 w=1.12u l=130.00n ng=1
MP6 qint gnb net92 VDD sg13_lv_pmos m=1 w=420.00n l=130.00n ng=1
MP7 qint_b qint VDD VDD sg13_lv_pmos m=1 w=1.12u l=130.00n ng=1
.ENDS

************************************************************************
* Library Name: sg13g2_stdcell
* Cell Name:    sg13g2_dllrq_1
* View Name:    schematic
************************************************************************

.SUBCKT sg13g2_dllrq_1 Q D GATE_N RESET_B VDD VSS
*.PININFO D:I GATE_N:I RESET_B:I Q:O VDD:B VSS:B
MN5 qint gnbb net89 VSS sg13_lv_nmos m=1 w=420.00n l=130.00n ng=1
MN3 qint gnb net61 VSS sg13_lv_nmos m=1 w=640.00n l=130.00n ng=1
MN8 net116 RESET_B VSS VSS sg13_lv_nmos m=1 w=740.00n l=130.00n ng=1
MN9 Q qint_b VSS VSS sg13_lv_nmos m=1 w=740.00n l=130.00n ng=1
MN4 net61 Db VSS VSS sg13_lv_nmos m=1 w=640.00n l=130.00n ng=1
MN6 net89 qint_b VSS VSS sg13_lv_nmos m=1 w=420.00n l=130.00n ng=1
MN7 qint_b qint net116 VSS sg13_lv_nmos m=1 w=740.00n l=130.00n ng=1
MN2 Db D VSS VSS sg13_lv_nmos m=1 w=550.00n l=130.00n ng=1
MN0 gnb GATE_N VSS VSS sg13_lv_nmos m=1 w=740.00n l=130.00n ng=1
MN1 gnbb gnb VSS VSS sg13_lv_nmos m=1 w=740.00n l=130.00n ng=1
MP3 net59 Db VDD VDD sg13_lv_pmos m=1 w=1.000u l=130.00n ng=1
MP8 qint_b RESET_B VDD VDD sg13_lv_pmos m=1 w=1.000u l=130.00n ng=1
MP0 gnb GATE_N VDD VDD sg13_lv_pmos m=1 w=840.00n l=130.00n ng=1
MP5 net92 qint_b VDD VDD sg13_lv_pmos m=1 w=420.00n l=130.00n ng=1
MP7 qint_b qint VDD VDD sg13_lv_pmos m=1 w=1.000u l=130.00n ng=1
MP9 Q qint_b VDD VDD sg13_lv_pmos m=1 w=1.12u l=130.00n ng=1
MP4 qint gnbb net59 VDD sg13_lv_pmos m=1 w=1.000u l=130.00n ng=1
MP2 Db D VDD VDD sg13_lv_pmos m=1 w=840.00n l=130.00n ng=1
MP1 gnbb gnb VDD VDD sg13_lv_pmos m=1 w=840.00n l=130.00n ng=1
MP6 qint gnb net92 VDD sg13_lv_pmos m=1 w=420.00n l=130.00n ng=1
.ENDS

************************************************************************
* Library Name: sg13g2_stdcell
* Cell Name:    sg13g2_dlygate4sd1_1
* View Name:    schematic
************************************************************************

.SUBCKT sg13g2_dlygate4sd1_1 X A VDD VSS
*.PININFO A:I X:O VDD:B VSS:B
MP3 X net3 VDD VDD sg13_lv_pmos m=1 w=1.12u l=130.00n ng=1
MP2 net3 net2 VDD VDD sg13_lv_pmos m=1 w=1.000u l=130.00n ng=1
MP1 net2 net1 VDD VDD sg13_lv_pmos m=1 w=1.000u l=130.00n ng=1
MP0 net1 A VDD VDD sg13_lv_pmos m=1 w=420.00n l=130.00n ng=1
MN3 X net3 VSS VSS sg13_lv_nmos m=1 w=740.00n l=130.00n ng=1
MN2 net3 net2 VSS VSS sg13_lv_nmos m=1 w=420.00n l=130.00n ng=1
MN1 net2 net1 VSS VSS sg13_lv_nmos m=1 w=420.00n l=130.00n ng=1
MN0 net1 A VSS VSS sg13_lv_nmos m=1 w=420.00n l=130.00n ng=1
.ENDS

************************************************************************
* Library Name: sg13g2_stdcell
* Cell Name:    sg13g2_dlygate4sd2_1
* View Name:    schematic
************************************************************************

.SUBCKT sg13g2_dlygate4sd2_1 X A VDD VSS
*.PININFO A:I X:O VDD:B VSS:B
MP3 X net3 VDD VDD sg13_lv_pmos m=1 w=1.12u l=130.00n ng=1
MP2 net3 net2 VDD VDD sg13_lv_pmos m=1 w=1.000u l=250.00n ng=1
MP1 net2 net1 VDD VDD sg13_lv_pmos m=1 w=1.000u l=250.00n ng=1
MP0 net1 A VDD VDD sg13_lv_pmos m=1 w=420.00n l=130.00n ng=1
MN3 X net3 VSS VSS sg13_lv_nmos m=1 w=740.00n l=130.00n ng=1
MN2 net3 net2 VSS VSS sg13_lv_nmos m=1 w=420.00n l=180.00n ng=1
MN1 net2 net1 VSS VSS sg13_lv_nmos m=1 w=420.00n l=180.00n ng=1
MN0 net1 A VSS VSS sg13_lv_nmos m=1 w=420.00n l=130.00n ng=1
.ENDS

************************************************************************
* Library Name: sg13g2_stdcell
* Cell Name:    sg13g2_dlygate4sd3_1
* View Name:    schematic
************************************************************************

.SUBCKT sg13g2_dlygate4sd3_1 X A VDD VSS
*.PININFO A:I X:O VDD:B VSS:B
MP3 X net3 VDD VDD sg13_lv_pmos m=1 w=1.12u l=130.00n ng=1
MP2 net3 net2 VDD VDD sg13_lv_pmos m=1 w=1.000u l=500.0n ng=1
MP1 net2 net1 VDD VDD sg13_lv_pmos m=1 w=1.000u l=500.0n ng=1
MP0 net1 A VDD VDD sg13_lv_pmos m=1 w=420.00n l=130.00n ng=1
MN3 X net3 VSS VSS sg13_lv_nmos m=1 w=740.00n l=130.00n ng=1
MN2 net3 net2 VSS VSS sg13_lv_nmos m=1 w=420.00n l=500.0n ng=1
MN1 net2 net1 VSS VSS sg13_lv_nmos m=1 w=420.00n l=500.0n ng=1
MN0 net1 A VSS VSS sg13_lv_nmos m=1 w=420.00n l=130.00n ng=1
.ENDS

************************************************************************
* Library Name: sg13g2_stdcell
* Cell Name:    sg13g2_ebufn_2
* View Name:    schematic
************************************************************************

.SUBCKT sg13g2_ebufn_2 Z A TE_B VDD VSS
*.PININFO A:I TE_B:I Z:O VDD:B VSS:B
MN3 net4 net3 VSS VSS sg13_lv_nmos m=1 w=1.48u l=130.00n ng=2
MN2 Z net1 net4 VSS sg13_lv_nmos m=1 w=1.48u l=130.00n ng=2
MN1 net3 TE_B VSS VSS sg13_lv_nmos m=1 w=640.00n l=130.00n ng=1
MN0 net1 A VSS VSS sg13_lv_nmos m=1 w=640.00n l=130.00n ng=1
MP2 net2 TE_B VDD VDD sg13_lv_pmos m=1 w=2.24u l=130.00n ng=2
MP3 Z net1 net2 VDD sg13_lv_pmos m=1 w=2.24u l=130.00n ng=2
MP1 net3 TE_B VDD VDD sg13_lv_pmos m=1 w=1.000u l=130.00n ng=1
MP0 net1 A VDD VDD sg13_lv_pmos m=1 w=1.000u l=130.00n ng=1
.ENDS

************************************************************************
* Library Name: sg13g2_stdcell
* Cell Name:    sg13g2_ebufn_4
* View Name:    schematic
************************************************************************

.SUBCKT sg13g2_ebufn_4 Z A TE_B VDD VSS
*.PININFO A:I TE_B:I Z:O VDD:B VSS:B
MN0 net23 A VSS VSS sg13_lv_nmos m=1 w=740.00n l=130.00n ng=1
MN1 net21 TE_B VSS VSS sg13_lv_nmos m=1 w=740.00n l=130.00n ng=1
MN2 Z net23 net22 VSS sg13_lv_nmos m=1 w=2.96u l=130.00n ng=4
MN3 net22 net21 VSS VSS sg13_lv_nmos m=1 w=2.96u l=130.00n ng=4
MP0 net23 A VDD VDD sg13_lv_pmos m=1 w=1.12u l=130.00n ng=1
MP1 net21 TE_B VDD VDD sg13_lv_pmos m=1 w=1.12u l=130.00n ng=1
MP3 Z net23 net24 VDD sg13_lv_pmos m=1 w=4.48u l=130.00n ng=4
MP2 net24 TE_B VDD VDD sg13_lv_pmos m=1 w=4.48u l=130.00n ng=4
.ENDS

************************************************************************
* Library Name: sg13g2_stdcell
* Cell Name:    sg13g2_ebufn_8
* View Name:    schematic
************************************************************************

.SUBCKT sg13g2_ebufn_8 Z A TE_B VDD VSS
*.PININFO A:I TE_B:I Z:O VDD:B VSS:B
MN3 net23 net22 VSS VSS sg13_lv_nmos m=1 w=5.92u l=130.00n ng=8
MN2 Z net21 net23 VSS sg13_lv_nmos m=1 w=5.92u l=130.00n ng=8
MN1 net22 TE_B VSS VSS sg13_lv_nmos m=1 w=740.00n l=130.00n ng=1
MN0 net21 A VSS VSS sg13_lv_nmos m=1 w=1.48u l=130.00n ng=2
MP2 net24 TE_B VDD VDD sg13_lv_pmos m=1 w=8.96u l=130.00n ng=8
MP3 Z net21 net24 VDD sg13_lv_pmos m=1 w=8.96u l=130.00n ng=8
MP1 net22 TE_B VDD VDD sg13_lv_pmos m=1 w=1.12u l=130.00n ng=1
MP0 net21 A VDD VDD sg13_lv_pmos m=1 w=2.24u l=130.00n ng=2
.ENDS

************************************************************************
* Library Name: sg13g2_stdcell
* Cell Name:    sg13g2_einvn_2
* View Name:    schematic
************************************************************************

.SUBCKT sg13g2_einvn_2 Z A TE_B VDD VSS
*.PININFO A:I TE_B:I Z:O VDD:B VSS:B
MN0 TE TE_B VSS VSS sg13_lv_nmos m=1 w=420.00n l=130.00n ng=1
MN2 net1 TE VSS VSS sg13_lv_nmos m=1 w=1.48u l=130.00n ng=2
MN1 Z A net1 VSS sg13_lv_nmos m=1 w=1.48u l=130.00n ng=2
MP0 TE TE_B VDD VDD sg13_lv_pmos m=1 w=640.00n l=130.00n ng=1
MP1 net2 TE_B VDD VDD sg13_lv_pmos m=1 w=2.24u l=130.00n ng=2
MP2 Z A net2 VDD sg13_lv_pmos m=1 w=2.24u l=130.00n ng=2
.ENDS

************************************************************************
* Library Name: sg13g2_stdcell
* Cell Name:    sg13g2_einvn_4
* View Name:    schematic
************************************************************************

.SUBCKT sg13g2_einvn_4 Z A TE_B VDD VSS
*.PININFO A:I TE_B:I Z:O VDD:B VSS:B
MN2 net16 TE VSS VSS sg13_lv_nmos m=1 w=2.96u l=130.00n ng=4
MN0 TE TE_B VSS VSS sg13_lv_nmos m=1 w=740.00n l=130.00n ng=1
MN1 Z A net16 VSS sg13_lv_nmos m=1 w=2.96u l=130.00n ng=4
MP0 TE TE_B VDD VDD sg13_lv_pmos m=1 w=1.12u l=130.00n ng=1
MP1 net17 TE_B VDD VDD sg13_lv_pmos m=1 w=4.48u l=130.00n ng=4
MP2 Z A net17 VDD sg13_lv_pmos m=1 w=4.48u l=130.00n ng=4
.ENDS

************************************************************************
* Library Name: sg13g2_stdcell
* Cell Name:    sg13g2_einvn_8
* View Name:    schematic
************************************************************************

.SUBCKT sg13g2_einvn_8 Z A TE_B VDD VSS
*.PININFO A:I TE_B:I Z:O VDD:B VSS:B
MN1 Z A net29 VSS sg13_lv_nmos m=1 w=5.92u l=130.00n ng=8
MN0 TE TE_B VSS VSS sg13_lv_nmos m=1 w=740.00n l=130.00n ng=1
MN2 net29 TE VSS VSS sg13_lv_nmos m=1 w=5.92u l=130.00n ng=8
MP1 net28 TE_B VDD VDD sg13_lv_pmos m=1 w=8.96u l=130.00n ng=8
MP2 Z A net28 VDD sg13_lv_pmos m=1 w=8.96u l=130.00n ng=8
MP0 TE TE_B VDD VDD sg13_lv_pmos m=1 w=1.12u l=130.00n ng=1
.ENDS

************************************************************************
* Library Name: sg13g2_stdcell
* Cell Name:    sg13g2_inv_1
* View Name:    schematic
************************************************************************

.SUBCKT sg13g2_inv_1 Y A VDD VSS
*.PININFO A:I Y:O VDD:B VSS:B
MN0 Y A VSS VSS sg13_lv_nmos m=1 w=740.00n l=130.00n ng=1
MP0 Y A VDD VDD sg13_lv_pmos m=1 w=1.12u l=130.00n ng=1
.ENDS

************************************************************************
* Library Name: sg13g2_stdcell
* Cell Name:    sg13g2_inv_16
* View Name:    schematic
************************************************************************

.SUBCKT sg13g2_inv_16 Y A VDD VSS
*.PININFO A:I Y:O VDD:B VSS:B
MN0 Y A VSS VSS sg13_lv_nmos m=1 w=11.84u l=130.00n ng=16
MP0 Y A VDD VDD sg13_lv_pmos m=1 w=17.92u l=130.00n ng=16
.ENDS

************************************************************************
* Library Name: sg13g2_stdcell
* Cell Name:    sg13g2_inv_2
* View Name:    schematic
************************************************************************

.SUBCKT sg13g2_inv_2 Y A VDD VSS
*.PININFO A:I Y:O VDD:B VSS:B
MN0 Y A VSS VSS sg13_lv_nmos m=1 w=1.48u l=130.00n ng=2
MP0 Y A VDD VDD sg13_lv_pmos m=1 w=2.24u l=130.00n ng=2
.ENDS

************************************************************************
* Library Name: sg13g2_stdcell
* Cell Name:    sg13g2_inv_4
* View Name:    schematic
************************************************************************

.SUBCKT sg13g2_inv_4 Y A VDD VSS
*.PININFO A:I Y:O VDD:B VSS:B
MP0 Y A VDD VDD sg13_lv_pmos m=1 w=4.48u l=130.00n ng=4
MN0 Y A VSS VSS sg13_lv_nmos m=1 w=2.96u l=130.00n ng=4
.ENDS

************************************************************************
* Library Name: sg13g2_stdcell
* Cell Name:    sg13g2_inv_8
* View Name:    schematic
************************************************************************

.SUBCKT sg13g2_inv_8 Y A VDD VSS
*.PININFO A:I Y:O VDD:B VSS:B
MN0 Y A VSS VSS sg13_lv_nmos m=1 w=5.92u l=130.00n ng=8
MP0 Y A VDD VDD sg13_lv_pmos m=1 w=8.96u l=130.00n ng=8
.ENDS

************************************************************************
* Library Name: sg13g2_stdcell
* Cell Name:    sg13g2_lgcp_1
* View Name:    schematic
************************************************************************

.SUBCKT sg13g2_lgcp_1 GCLK CLK GATE VDD VSS
*.PININFO CLK:I GATE:I GCLK:O VDD:B VSS:B
MP1 CLKBB CLKB VDD VDD sg13_lv_pmos m=1 w=840.00n l=130.00n ng=1
MP3 net1 CLKBB net4 VDD sg13_lv_pmos m=1 w=1.000u l=130.00n ng=1
MP4 int_GATE net1 VDD VDD sg13_lv_pmos m=1 w=1.12u l=130.00n ng=1
MP2 net4 GATE VDD VDD sg13_lv_pmos m=1 w=1.000u l=130.00n ng=1
MP8 net3 int_GATE VDD VDD sg13_lv_pmos m=1 w=840.00n l=130.00n ng=1
MP9 GCLK net3 VDD VDD sg13_lv_pmos m=1 w=1.12u l=130.00n ng=1
MP6 net1 CLKB net6 VDD sg13_lv_pmos m=1 w=420.00n l=130.00n ng=1
MP0 CLKB CLK VDD VDD sg13_lv_pmos m=1 w=840.00n l=130.00n ng=1
MP7 net3 CLK VDD VDD sg13_lv_pmos m=1 w=840.00n l=130.00n ng=1
MP5 net6 int_GATE VDD VDD sg13_lv_pmos m=1 w=420.00n l=130.00n ng=1
MN9 GCLK net3 VSS VSS sg13_lv_nmos m=1 w=740.00n l=130.00n ng=1
MN7 net3 int_GATE net5 VSS sg13_lv_nmos m=1 w=640.00n l=130.00n ng=1
MN4 int_GATE net1 VSS VSS sg13_lv_nmos m=1 w=740.00n l=130.00n ng=1
MN1 CLKBB CLKB VSS VSS sg13_lv_nmos m=1 w=740.00n l=130.00n ng=1
MN6 net7 int_GATE VSS VSS sg13_lv_nmos m=1 w=420.00n l=130.00n ng=1
MN3 net2 GATE VSS VSS sg13_lv_nmos m=1 w=640.00n l=130.00n ng=1
MN5 net1 CLKBB net7 VSS sg13_lv_nmos m=1 w=420.00n l=130.00n ng=1
MN0 CLKB CLK VSS VSS sg13_lv_nmos m=1 w=740.00n l=130.00n ng=1
MN8 net5 CLK VSS VSS sg13_lv_nmos m=1 w=640.00n l=130.00n ng=1
MN2 net1 CLKB net2 VSS sg13_lv_nmos m=1 w=640.00n l=130.00n ng=1
.ENDS

************************************************************************
* Library Name: sg13g2_stdcell
* Cell Name:    sg13g2_mux2_1
* View Name:    schematic
************************************************************************

.SUBCKT sg13g2_mux2_1 X A0 A1 S VDD VSS
*.PININFO A0:I A1:I S:I X:O VDD:B VSS:B
MP1 net4 S VDD VDD sg13_lv_pmos m=1 w=1.000u l=130.00n ng=1
MP5 X net6 VDD VDD sg13_lv_pmos m=1 w=1.12u l=130.00n ng=1
MP4 net6 A1 net5 VDD sg13_lv_pmos m=1 w=1.000u l=130.00n ng=1
MP0 Sb S VDD VDD sg13_lv_pmos m=1 w=840.00n l=130.00n ng=1
MP3 net5 Sb VDD VDD sg13_lv_pmos m=1 w=1.000u l=130.00n ng=1
MP2 net6 A0 net4 VDD sg13_lv_pmos m=1 w=1.000u l=130.00n ng=1
MN4 net3 S VSS VSS sg13_lv_nmos m=1 w=740.00n l=130.00n ng=1
MN2 net1 Sb VSS VSS sg13_lv_nmos m=1 w=740.00n l=130.00n ng=1
MN5 X net6 VSS VSS sg13_lv_nmos m=1 w=740.00n l=130.00n ng=1
MN0 Sb S VSS VSS sg13_lv_nmos m=1 w=550.00n l=130.00n ng=1
MN3 net6 A1 net3 VSS sg13_lv_nmos m=1 w=740.00n l=130.00n ng=1
MN1 net6 A0 net1 VSS sg13_lv_nmos m=1 w=740.00n l=130.00n ng=1
.ENDS

************************************************************************
* Library Name: sg13g2_stdcell
* Cell Name:    sg13g2_mux2_2
* View Name:    schematic
************************************************************************

.SUBCKT sg13g2_mux2_2 X A0 A1 S VDD VSS
*.PININFO A0:I A1:I S:I X:O VDD:B VSS:B
MP1 net4 S VDD VDD sg13_lv_pmos m=1 w=1.000u l=130.00n ng=1
MP5 X net6 VDD VDD sg13_lv_pmos m=1 w=2.24u l=130.00n ng=2
MP4 net6 A1 net5 VDD sg13_lv_pmos m=1 w=1.000u l=130.00n ng=1
MP0 Sb S VDD VDD sg13_lv_pmos m=1 w=840.00n l=130.00n ng=1
MP3 net5 Sb VDD VDD sg13_lv_pmos m=1 w=1.000u l=130.00n ng=1
MP2 net6 A0 net4 VDD sg13_lv_pmos m=1 w=1.000u l=130.00n ng=1
MN4 net3 S VSS VSS sg13_lv_nmos m=1 w=740.00n l=130.00n ng=1
MN2 net1 Sb VSS VSS sg13_lv_nmos m=1 w=740.00n l=130.00n ng=1
MN5 X net6 VSS VSS sg13_lv_nmos m=1 w=1.48u l=130.00n ng=2
MN0 Sb S VSS VSS sg13_lv_nmos m=1 w=550.00n l=130.00n ng=1
MN3 net6 A1 net3 VSS sg13_lv_nmos m=1 w=740.00n l=130.00n ng=1
MN1 net6 A0 net1 VSS sg13_lv_nmos m=1 w=740.00n l=130.00n ng=1
.ENDS

************************************************************************
* Library Name: sg13g2_stdcell
* Cell Name:    sg13g2_mux4_1
* View Name:    schematic
************************************************************************

.SUBCKT sg13g2_mux4_1 X A0 A1 A2 A3 S0 S1 VDD VSS
*.PININFO A0:I A1:I A2:I A3:I S0:I S1:I X:O VDD:B VSS:B
MN12 X Xb VSS VSS sg13_lv_nmos m=1 w=740.00n l=130.00n ng=1
MN2 low S0b net7 VSS sg13_lv_nmos m=1 w=640.00n l=130.00n ng=1
MN3 net7 A0 VSS VSS sg13_lv_nmos m=1 w=640.00n l=130.00n ng=1
MN6 low S1b Xb VSS sg13_lv_nmos m=1 w=640.00n l=130.00n ng=1
MN11 high S1 Xb VSS sg13_lv_nmos m=1 w=640.00n l=130.00n ng=1
MN10 net4 A3 VSS VSS sg13_lv_nmos m=1 w=640.00n l=130.00n ng=1
MN9 high S0 net4 VSS sg13_lv_nmos m=1 w=640.00n l=130.00n ng=1
MN8 net6 A2 VSS VSS sg13_lv_nmos m=1 w=640.00n l=130.00n ng=1
MN7 high S0b net6 VSS sg13_lv_nmos m=1 w=640.00n l=130.00n ng=1
MN5 net2 A1 VSS VSS sg13_lv_nmos m=1 w=640.00n l=130.00n ng=1
MN4 low S0 net2 VSS sg13_lv_nmos m=1 w=640.00n l=130.00n ng=1
MN1 S1b S1 VSS VSS sg13_lv_nmos m=1 w=640.00n l=130.00n ng=1
MN0 S0b S0 VSS VSS sg13_lv_nmos m=1 w=640.00n l=130.00n ng=1
MP6 low S1 Xb VDD sg13_lv_pmos m=1 w=1.000u l=130.00n ng=1
MP11 high S1b Xb VDD sg13_lv_pmos m=1 w=1.000u l=130.00n ng=1
MP12 X Xb VDD VDD sg13_lv_pmos m=1 w=1.12u l=130.00n ng=1
MP10 high S0b net3 VDD sg13_lv_pmos m=1 w=1.000u l=130.00n ng=1
MP9 net3 A3 VDD VDD sg13_lv_pmos m=1 w=1.000u l=130.00n ng=1
MP8 high S0 net5 VDD sg13_lv_pmos m=1 w=1.000u l=130.00n ng=1
MP7 net5 A2 VDD VDD sg13_lv_pmos m=1 w=1.000u l=130.00n ng=1
MP2 net8 A0 VDD VDD sg13_lv_pmos m=1 w=1.000u l=130.00n ng=1
MP3 low S0 net8 VDD sg13_lv_pmos m=1 w=1.000u l=130.00n ng=1
MP1 S1b S1 VDD VDD sg13_lv_pmos m=1 w=1.000u l=130.00n ng=1
MP0 S0b S0 VDD VDD sg13_lv_pmos m=1 w=1.000u l=130.00n ng=1
MP5 low S0b net1 VDD sg13_lv_pmos m=1 w=1.000u l=130.00n ng=1
MP4 net1 A1 VDD VDD sg13_lv_pmos m=1 w=1.000u l=130.00n ng=1
.ENDS

************************************************************************
* Library Name: sg13g2_stdcell
* Cell Name:    sg13g2_nand2_1
* View Name:    schematic
************************************************************************

.SUBCKT sg13g2_nand2_1 Y A B VDD VSS
*.PININFO A:I B:I Y:O VDD:B VSS:B
MP1 Y B VDD VDD sg13_lv_pmos m=1 w=1.12u l=130.00n ng=1
MP0 Y A VDD VDD sg13_lv_pmos m=1 w=1.12u l=130.00n ng=1
MN1 net1 B VSS VSS sg13_lv_nmos m=1 w=740.00n l=130.00n ng=1
MN0 Y A net1 VSS sg13_lv_nmos m=1 w=740.00n l=130.00n ng=1
.ENDS

************************************************************************
* Library Name: sg13g2_stdcell
* Cell Name:    sg13g2_nand2_2
* View Name:    schematic
************************************************************************

.SUBCKT sg13g2_nand2_2 Y A B VDD VSS
*.PININFO A:I B:I Y:O VDD:B VSS:B
MP1 Y B VDD VDD sg13_lv_pmos m=1 w=2.24u l=130.00n ng=2
MP0 Y A VDD VDD sg13_lv_pmos m=1 w=2.24u l=130.00n ng=2
MN1 net1 B VSS VSS sg13_lv_nmos m=1 w=1.44u l=130.00n ng=2
MN0 Y A net1 VSS sg13_lv_nmos m=1 w=1.44u l=130.00n ng=2
.ENDS

************************************************************************
* Library Name: sg13g2_stdcell
* Cell Name:    sg13g2_nand2b_1
* View Name:    schematic
************************************************************************

.SUBCKT sg13g2_nand2b_1 Y A_N B VDD VSS
*.PININFO A_N:I B:I Y:O VDD:B VSS:B
MP2 Y net2 VDD VDD sg13_lv_pmos m=1 w=1.12u l=130.00n ng=1
MP1 net2 A_N VDD VDD sg13_lv_pmos m=1 w=840.00n l=130.00n ng=1
MP0 Y B VDD VDD sg13_lv_pmos m=1 w=1.12u l=130.00n ng=1
MN1 Y net2 net1 VSS sg13_lv_nmos m=1 w=740.00n l=130.00n ng=1
MN0 net2 A_N VSS VSS sg13_lv_nmos m=1 w=550.00n l=130.00n ng=1
MN2 net1 B VSS VSS sg13_lv_nmos m=1 w=740.00n l=130.00n ng=1
.ENDS

************************************************************************
* Library Name: sg13g2_stdcell
* Cell Name:    sg13g2_nand2b_2
* View Name:    schematic
************************************************************************

.SUBCKT sg13g2_nand2b_2 Y A_N B VDD VSS
*.PININFO A_N:I B:I Y:O VDD:B VSS:B
MP2 Y A VDD VDD sg13_lv_pmos m=1 w=2.24u l=130.00n ng=2
MP0 A A_N VDD VDD sg13_lv_pmos m=1 w=840.00n l=130.00n ng=1
MP1 Y B VDD VDD sg13_lv_pmos m=1 w=2.24u l=130.00n ng=2
MN1 Y B net1 VSS sg13_lv_nmos m=1 w=1.44u l=130.00n ng=2
MN0 A A_N VSS VSS sg13_lv_nmos m=1 w=550.00n l=130.00n ng=1
MN2 net1 A VSS VSS sg13_lv_nmos m=1 w=1.44u l=130.00n ng=2
.ENDS

************************************************************************
* Library Name: sg13g2_stdcell
* Cell Name:    sg13g2_nand3_1
* View Name:    schematic
************************************************************************

.SUBCKT sg13g2_nand3_1 Y A B C VDD VSS
*.PININFO A:I B:I C:I Y:O VDD:B VSS:B
MP0 Y A VDD VDD sg13_lv_pmos m=1 w=1.12u l=130.00n ng=1
MP1 Y B VDD VDD sg13_lv_pmos m=1 w=1.12u l=130.00n ng=1
MP2 Y C VDD VDD sg13_lv_pmos m=1 w=1.12u l=130.00n ng=1
MN1 net2 B net3 VSS sg13_lv_nmos m=1 w=740.00n l=130.00n ng=1
MN2 net3 C VSS VSS sg13_lv_nmos m=1 w=740.00n l=130.00n ng=1
MN0 Y A net2 VSS sg13_lv_nmos m=1 w=740.00n l=130.00n ng=1
.ENDS

************************************************************************
* Library Name: sg13g2_stdcell
* Cell Name:    sg13g2_nand3b_1
* View Name:    schematic
************************************************************************

.SUBCKT sg13g2_nand3b_1 Y A_N B C VDD VSS
*.PININFO A_N:I B:I C:I Y:O VDD:B VSS:B
MP0 net1 A_N VDD VDD sg13_lv_pmos m=1 w=840.00n l=130.00n ng=1
MP1 Y net1 VDD VDD sg13_lv_pmos m=1 w=1.12u l=130.00n ng=1
MP2 Y B VDD VDD sg13_lv_pmos m=1 w=1.12u l=130.00n ng=1
MP3 Y C VDD VDD sg13_lv_pmos m=1 w=1.12u l=130.00n ng=1
MN2 net2 B net3 VSS sg13_lv_nmos m=1 w=740.00n l=130.00n ng=1
MN3 net3 C VSS VSS sg13_lv_nmos m=1 w=740.00n l=130.00n ng=1
MN0 net1 A_N VSS VSS sg13_lv_nmos m=1 w=550.00n l=130.00n ng=1
MN1 Y net1 net2 VSS sg13_lv_nmos m=1 w=740.00n l=130.00n ng=1
.ENDS

************************************************************************
* Library Name: sg13g2_stdcell
* Cell Name:    sg13g2_nand4_1
* View Name:    schematic
************************************************************************

.SUBCKT sg13g2_nand4_1 Y A B C D VDD VSS
*.PININFO A:I B:I C:I D:I Y:O VDD:B VSS:B
MP3 Y D VDD VDD sg13_lv_pmos m=1 w=1.12u l=130.00n ng=1
MP0 Y A VDD VDD sg13_lv_pmos m=1 w=1.12u l=130.00n ng=1
MP1 Y B VDD VDD sg13_lv_pmos m=1 w=1.12u l=130.00n ng=1
MP2 Y C VDD VDD sg13_lv_pmos m=1 w=1.12u l=130.00n ng=1
MN1 net2 B net3 VSS sg13_lv_nmos m=1 w=740.00n l=130.00n ng=1
MN2 net3 C net5 VSS sg13_lv_nmos m=1 w=740.00n l=130.00n ng=1
MN0 Y A net2 VSS sg13_lv_nmos m=1 w=740.00n l=130.00n ng=1
MN3 net5 D VSS VSS sg13_lv_nmos m=1 w=740.00n l=130.00n ng=1
.ENDS

************************************************************************
* Library Name: sg13g2_stdcell
* Cell Name:    sg13g2_nor2_1
* View Name:    schematic
************************************************************************

.SUBCKT sg13g2_nor2_1 Y A B VDD VSS
*.PININFO A:I B:I Y:O VDD:B VSS:B
MN0 Y A VSS VSS sg13_lv_nmos m=1 w=740.00n l=130.00n ng=1
MN1 Y B VSS VSS sg13_lv_nmos m=1 w=740.00n l=130.00n ng=1
MP0 net1 A VDD VDD sg13_lv_pmos m=1 w=1.12u l=130.00n ng=1
MP1 Y B net1 VDD sg13_lv_pmos m=1 w=1.12u l=130.00n ng=1
.ENDS

************************************************************************
* Library Name: sg13g2_stdcell
* Cell Name:    sg13g2_nor2_2
* View Name:    schematic
************************************************************************

.SUBCKT sg13g2_nor2_2 Y A B VDD VSS
*.PININFO A:I B:I Y:O VDD:B VSS:B
MN0 Y A VSS VSS sg13_lv_nmos m=1 w=1.48u l=130.00n ng=2
MN1 Y B VSS VSS sg13_lv_nmos m=1 w=1.48u l=130.00n ng=2
MP0 net1 A VDD VDD sg13_lv_pmos m=1 w=2.24u l=130.00n ng=2
MP1 Y B net1 VDD sg13_lv_pmos m=1 w=2.24u l=130.00n ng=2
.ENDS

************************************************************************
* Library Name: sg13g2_stdcell
* Cell Name:    sg13g2_nor2b_1
* View Name:    schematic
************************************************************************

.SUBCKT sg13g2_nor2b_1 Y A B_N VDD VSS
*.PININFO A:I B_N:I Y:O VDD:B VSS:B
MN0 B B_N VSS VSS sg13_lv_nmos m=1 w=550.00n l=130.00n ng=1
MN1 Y A VSS VSS sg13_lv_nmos m=1 w=740.00n l=130.00n ng=1
MN2 Y B VSS VSS sg13_lv_nmos m=1 w=740.00n l=130.00n ng=1
MP0 B B_N VDD VDD sg13_lv_pmos m=1 w=840.00n l=130.00n ng=1
MP1 net1 B VDD VDD sg13_lv_pmos m=1 w=1.12u l=130.00n ng=1
MP2 Y A net1 VDD sg13_lv_pmos m=1 w=1.12u l=130.00n ng=1
.ENDS

************************************************************************
* Library Name: sg13g2_stdcell
* Cell Name:    sg13g2_nor2b_2
* View Name:    schematic
************************************************************************

.SUBCKT sg13g2_nor2b_2 Y A B_N VDD VSS
*.PININFO A:I B_N:I Y:O VDD:B VSS:B
MN0 B B_N VSS VSS sg13_lv_nmos m=1 w=640.00n l=130.00n ng=1
MN1 Y A VSS VSS sg13_lv_nmos m=1 w=1.44u l=130.00n ng=2
MN2 Y B VSS VSS sg13_lv_nmos m=1 w=1.44u l=130.00n ng=2
MP0 B B_N VDD VDD sg13_lv_pmos m=1 w=1.000u l=130.00n ng=1
MP1 net1 B VDD VDD sg13_lv_pmos m=1 w=2.24u l=130.00n ng=2
MP2 Y A net1 VDD sg13_lv_pmos m=1 w=2.24u l=130.00n ng=2
.ENDS

************************************************************************
* Library Name: sg13g2_stdcell
* Cell Name:    sg13g2_nor3_1
* View Name:    schematic
************************************************************************

.SUBCKT sg13g2_nor3_1 Y A B C VDD VSS
*.PININFO A:I B:I C:I Y:O VDD:B VSS:B
MP2 Y C net2 VDD sg13_lv_pmos m=1 w=1.12u l=130.00n ng=1
MP1 net2 B net3 VDD sg13_lv_pmos m=1 w=1.12u l=130.00n ng=1
MP0 net3 A VDD VDD sg13_lv_pmos m=1 w=1.12u l=130.00n ng=1
MN0 Y A VSS VSS sg13_lv_nmos m=1 w=770.00n l=130.00n ng=1
MN1 Y B VSS VSS sg13_lv_nmos m=1 w=770.00n l=130.00n ng=1
MN2 Y C VSS VSS sg13_lv_nmos m=1 w=770.00n l=130.00n ng=1
.ENDS

************************************************************************
* Library Name: sg13g2_stdcell
* Cell Name:    sg13g2_nor3_2
* View Name:    schematic
************************************************************************

.SUBCKT sg13g2_nor3_2 Y A B C VDD VSS
*.PININFO A:I B:I C:I Y:O VDD:B VSS:B
MP2 Y C net2 VDD sg13_lv_pmos m=1 w=2.24u l=130.00n ng=2
MP1 net2 B net3 VDD sg13_lv_pmos m=1 w=2.24u l=130.00n ng=2
MP0 net3 A VDD VDD sg13_lv_pmos m=1 w=2.24u l=130.00n ng=2
MN0 Y A VSS VSS sg13_lv_nmos m=1 w=1.48u l=130.00n ng=2
MN1 Y B VSS VSS sg13_lv_nmos m=1 w=1.48u l=130.00n ng=2
MN2 Y C VSS VSS sg13_lv_nmos m=1 w=1.48u l=130.00n ng=2
.ENDS

************************************************************************
* Library Name: sg13g2_stdcell
* Cell Name:    sg13g2_nor4_1
* View Name:    schematic
************************************************************************

.SUBCKT sg13g2_nor4_1 Y A B C D VDD VSS
*.PININFO A:I B:I C:I D:I Y:O VDD:B VSS:B
MP0 net3 A VDD VDD sg13_lv_pmos m=1 w=1.12u l=130.00n ng=1
MP1 net2 B net3 VDD sg13_lv_pmos m=1 w=1.12u l=130.00n ng=1
MP2 net1 C net2 VDD sg13_lv_pmos m=1 w=1.12u l=130.00n ng=1
MP3 Y D net1 VDD sg13_lv_pmos m=1 w=1.12u l=130.00n ng=1
MN0 Y A VSS VSS sg13_lv_nmos m=1 w=740.00n l=130.00n ng=1
MN3 Y D VSS VSS sg13_lv_nmos m=1 w=740.00n l=130.00n ng=1
MN1 Y B VSS VSS sg13_lv_nmos m=1 w=740.00n l=130.00n ng=1
MN2 Y C VSS VSS sg13_lv_nmos m=1 w=740.00n l=130.00n ng=1
.ENDS

************************************************************************
* Library Name: sg13g2_stdcell
* Cell Name:    sg13g2_nor4_2
* View Name:    schematic
************************************************************************

.SUBCKT sg13g2_nor4_2 Y A B C D VDD VSS
*.PININFO A:I B:I C:I D:I Y:O VDD:B VSS:B
MP0 net3 A VDD VDD sg13_lv_pmos m=1 w=2.24u l=130.00n ng=2
MP1 net2 B net3 VDD sg13_lv_pmos m=1 w=2.24u l=130.00n ng=2
MP2 net1 C net2 VDD sg13_lv_pmos m=1 w=2.24u l=130.00n ng=2
MP3 Y D net1 VDD sg13_lv_pmos m=1 w=2.24u l=130.00n ng=2
MN0 Y A VSS VSS sg13_lv_nmos m=1 w=1.48u l=130.00n ng=2
MN3 Y D VSS VSS sg13_lv_nmos m=1 w=1.48u l=130.00n ng=2
MN1 Y B VSS VSS sg13_lv_nmos m=1 w=1.48u l=130.00n ng=2
MN2 Y C VSS VSS sg13_lv_nmos m=1 w=1.48u l=130.00n ng=2
.ENDS

************************************************************************
* Library Name: sg13g2_stdcell
* Cell Name:    sg13g2_o21ai_1
* View Name:    schematic
************************************************************************

.SUBCKT sg13g2_o21ai_1 Y A1 A2 B1 VDD VSS
*.PININFO A1:I A2:I B1:I Y:O VDD:B VSS:B
MP0 net14 A1 VDD VDD sg13_lv_pmos m=1 w=1.12u l=150.00n ng=1
MP1 Y A2 net14 VDD sg13_lv_pmos m=1 w=1.12u l=150.00n ng=1
MP2 Y B1 VDD VDD sg13_lv_pmos m=1 w=1.12u l=150.00n ng=1
MN0 net1 A2 VSS VSS sg13_lv_nmos m=1 w=740.00n l=150.00n ng=1
MN2 net1 A1 VSS VSS sg13_lv_nmos m=1 w=740.00n l=150.00n ng=1
MN1 Y B1 net1 VSS sg13_lv_nmos m=1 w=740.00n l=150.00n ng=1
.ENDS

************************************************************************
* Library Name: sg13g2_stdcell
* Cell Name:    sg13g2_or2_1
* View Name:    schematic
************************************************************************

.SUBCKT sg13g2_or2_1 X A B VDD VSS
*.PININFO A:I B:I X:O VDD:B VSS:B
MP1 net2 B net3 VDD sg13_lv_pmos m=1 w=840.00n l=130.00n ng=1
MP0 net3 A VDD VDD sg13_lv_pmos m=1 w=840.00n l=130.00n ng=1
MP2 X net2 VDD VDD sg13_lv_pmos m=1 w=1.12u l=130.00n ng=1
MN1 net2 A VSS VSS sg13_lv_nmos m=1 w=550.00n l=130.00n ng=1
MN0 net2 B VSS VSS sg13_lv_nmos m=1 w=550.00n l=130.00n ng=1
MN2 X net2 VSS VSS sg13_lv_nmos m=1 w=740.00n l=130.00n ng=1
.ENDS

************************************************************************
* Library Name: sg13g2_stdcell
* Cell Name:    sg13g2_or2_2
* View Name:    schematic
************************************************************************

.SUBCKT sg13g2_or2_2 X A B VDD VSS
*.PININFO A:I B:I X:O VDD:B VSS:B
MP1 net2 B net3 VDD sg13_lv_pmos m=1 w=840.00n l=130.00n ng=1
MP0 net3 A VDD VDD sg13_lv_pmos m=1 w=840.00n l=130.00n ng=1
MP2 X net2 VDD VDD sg13_lv_pmos m=1 w=2.24u l=130.00n ng=2
MN1 net2 A VSS VSS sg13_lv_nmos m=1 w=550.00n l=130.00n ng=1
MN0 net2 B VSS VSS sg13_lv_nmos m=1 w=550.00n l=130.00n ng=1
MN2 X net2 VSS VSS sg13_lv_nmos m=1 w=1.48u l=130.00n ng=2
.ENDS

************************************************************************
* Library Name: sg13g2_stdcell
* Cell Name:    sg13g2_or3_1
* View Name:    schematic
************************************************************************

.SUBCKT sg13g2_or3_1 X A B C VDD VSS
*.PININFO A:I B:I C:I X:O VDD:B VSS:B
MN2 net1 C VSS VSS sg13_lv_nmos m=1 w=550.00n l=130.00n ng=1
MN3 X net1 VSS VSS sg13_lv_nmos m=1 w=740.00n l=130.00n ng=1
MN1 net1 B VSS VSS sg13_lv_nmos m=1 w=550.00n l=130.00n ng=1
MN0 net1 A VSS VSS sg13_lv_nmos m=1 w=550.00n l=130.00n ng=1
MP3 X net1 VDD VDD sg13_lv_pmos m=1 w=1.12u l=130.00n ng=1
MP1 net9 B net12 VDD sg13_lv_pmos m=1 w=1.000u l=130.00n ng=1
MP0 net12 A VDD VDD sg13_lv_pmos m=1 w=1.000u l=130.00n ng=1
MP2 net1 C net9 VDD sg13_lv_pmos m=1 w=1.000u l=130.00n ng=1
.ENDS

************************************************************************
* Library Name: sg13g2_stdcell
* Cell Name:    sg13g2_or3_2
* View Name:    schematic
************************************************************************

.SUBCKT sg13g2_or3_2 X A B C VDD VSS
*.PININFO A:I B:I C:I X:O VDD:B VSS:B
MN2 net1 C VSS VSS sg13_lv_nmos m=1 w=550.00n l=130.00n ng=1
MN3 X net1 VSS VSS sg13_lv_nmos m=1 w=1.48u l=130.00n ng=2
MN1 net1 B VSS VSS sg13_lv_nmos m=1 w=550.00n l=130.00n ng=1
MN0 net1 A VSS VSS sg13_lv_nmos m=1 w=550.00n l=130.00n ng=1
MP3 X net1 VDD VDD sg13_lv_pmos m=1 w=2.24u l=130.00n ng=2
MP1 net9 B net12 VDD sg13_lv_pmos m=1 w=1.000u l=130.00n ng=1
MP0 net12 A VDD VDD sg13_lv_pmos m=1 w=1.000u l=130.00n ng=1
MP2 net1 C net9 VDD sg13_lv_pmos m=1 w=1.000u l=130.00n ng=1
.ENDS

************************************************************************
* Library Name: sg13g2_stdcell
* Cell Name:    sg13g2_or4_1
* View Name:    schematic
************************************************************************

.SUBCKT sg13g2_or4_1 X A B C D VDD VSS
*.PININFO A:I B:I C:I D:I X:O VDD:B VSS:B
MN4 X net1 VSS VSS sg13_lv_nmos m=1 w=740.00n l=130.00n ng=1
MN3 net1 D VSS VSS sg13_lv_nmos m=1 w=550.00n l=130.00n ng=1
MN2 net1 C VSS VSS sg13_lv_nmos m=1 w=550.00n l=130.00n ng=1
MN1 net1 B VSS VSS sg13_lv_nmos m=1 w=550.00n l=130.00n ng=1
MN0 net1 A VSS VSS sg13_lv_nmos m=1 w=550.00n l=130.00n ng=1
MP0 net4 A VDD VDD sg13_lv_pmos m=1 w=1.000u l=130.00n ng=1
MP1 net3 B net4 VDD sg13_lv_pmos m=1 w=1.000u l=130.00n ng=1
MP2 net2 C net3 VDD sg13_lv_pmos m=1 w=1.000u l=130.00n ng=1
MP3 net1 D net2 VDD sg13_lv_pmos m=1 w=1.000u l=130.00n ng=1
MP4 X net1 VDD VDD sg13_lv_pmos m=1 w=1.12u l=130.00n ng=1
.ENDS

************************************************************************
* Library Name: sg13g2_stdcell
* Cell Name:    sg13g2_or4_2
* View Name:    schematic
************************************************************************

.SUBCKT sg13g2_or4_2 X A B C D VDD VSS
*.PININFO A:I B:I C:I D:I X:O VDD:B VSS:B
MN4 X net1 VSS VSS sg13_lv_nmos m=1 w=1.48u l=130.00n ng=2
MN3 net1 D VSS VSS sg13_lv_nmos m=1 w=550.00n l=130.00n ng=1
MN2 net1 C VSS VSS sg13_lv_nmos m=1 w=550.00n l=130.00n ng=1
MN1 net1 B VSS VSS sg13_lv_nmos m=1 w=550.00n l=130.00n ng=1
MN0 net1 A VSS VSS sg13_lv_nmos m=1 w=550.00n l=130.00n ng=1
MP0 net4 A VDD VDD sg13_lv_pmos m=1 w=1.000u l=130.00n ng=1
MP1 net3 B net4 VDD sg13_lv_pmos m=1 w=1.000u l=130.00n ng=1
MP2 net2 C net3 VDD sg13_lv_pmos m=1 w=1.000u l=130.00n ng=1
MP3 net1 D net2 VDD sg13_lv_pmos m=1 w=1.000u l=130.00n ng=1
MP4 X net1 VDD VDD sg13_lv_pmos m=1 w=2.24u l=130.00n ng=2
.ENDS

************************************************************************
* Library Name: sg13g2_stdcell
* Cell Name:    sg13g2_sdfbbp_1
* View Name:    schematic
************************************************************************

.SUBCKT sg13g2_sdfbbp_1 Q Q_N CLK D RESET_B SCD SCE SET_B VDD VSS
*.PININFO CLK:I D:I RESET_B:I SCD:I SCE:I SET_B:I Q:O Q_N:O VDD:B VSS:B
MP1 resetbb RESET_B VDD VDD sg13_lv_pmos m=1 w=640.00n l=130.00n ng=1
MP19 pre_q DbbLatch2 net8 VDD sg13_lv_pmos m=1 w=1.000u l=130.00n ng=1
MP20 pre_q SET_B VDD VDD sg13_lv_pmos m=1 w=1.000u l=130.00n ng=1
MP3 CLKbb CLKb VDD VDD sg13_lv_pmos m=1 w=1.12u l=130.00n ng=1
MP0 SCEb SCE VDD VDD sg13_lv_pmos m=1 w=640.00n l=130.00n ng=1
MP7 Db D net3 VDD sg13_lv_pmos m=1 w=640.00n l=130.00n ng=1
MP13 DbbTG CLKb net10 VDD sg13_lv_pmos m=1 w=420.00n l=130.00n ng=1
MP12 net10 DbLatchM VDD VDD sg13_lv_pmos m=1 w=420.00n l=130.00n ng=1
MP6 net3 SCE VDD VDD sg13_lv_pmos m=1 w=640.00n l=130.00n ng=1
MP21 Q_N pre_q VDD VDD sg13_lv_pmos m=1 w=1.12u l=130.00n ng=1
MP14 net1 DbLatchM VDD VDD sg13_lv_pmos m=1 w=840.00n l=130.00n ng=1
MP18 net8 resetbb VDD VDD sg13_lv_pmos m=1 w=1.000u l=130.00n ng=1
MP11 DbLatchM SET_B VDD VDD sg13_lv_pmos m=1 w=840.00n l=130.00n ng=1
MP4 net2 SCD VDD VDD sg13_lv_pmos m=1 w=640.00n l=130.00n ng=1
MP2 CLKb CLK VDD VDD sg13_lv_pmos m=1 w=1.12u l=130.00n ng=1
MP10 DbLatchM DbbTG net7 VDD sg13_lv_pmos m=1 w=840.00n l=130.00n ng=1
MP8 Db CLKbb DbbTG VDD sg13_lv_pmos m=1 w=640.00n l=130.00n ng=1
MP5 Db SCEb net2 VDD sg13_lv_pmos m=1 w=640.00n l=130.00n ng=1
MP22 pre_qb pre_q VDD VDD sg13_lv_pmos m=1 w=840.00n l=130.00n ng=1
MP9 net7 resetbb VDD VDD sg13_lv_pmos m=1 w=840.00n l=130.00n ng=1
MP16 net6 pre_q VDD VDD sg13_lv_pmos m=1 w=420.00n l=130.00n ng=1
MP17 DbbLatch2 CLKbb net6 VDD sg13_lv_pmos m=1 w=420.00n l=130.00n ng=1
MP15 DbbLatch2 CLKb net1 VDD sg13_lv_pmos m=1 w=840.00n l=130.00n ng=1
MP23 Q pre_qb VDD VDD sg13_lv_pmos m=1 w=1.12u l=130.00n ng=1
MN4 Db SCE net5 VSS sg13_lv_nmos m=1 w=420.00n l=130.00n ng=1
MN5 net5 SCD VSS VSS sg13_lv_nmos m=1 w=420.00n l=130.00n ng=1
MN18 pre_q DbbLatch2 net11 VSS sg13_lv_nmos m=1 w=740.00n l=130.00n ng=1
MN8 Db CLKb DbbTG VSS sg13_lv_nmos m=1 w=420.00n l=130.00n ng=1
MN7 net4 SCEb VSS VSS sg13_lv_nmos m=1 w=420.00n l=130.00n ng=1
MN3 CLKbb CLKb VSS VSS sg13_lv_nmos m=1 w=740.00n l=130.00n ng=1
MN1 resetbb RESET_B VSS VSS sg13_lv_nmos m=1 w=420.00n l=130.00n ng=1
MN17 net14 pre_q VSS VSS sg13_lv_nmos m=1 w=420.00n l=130.00n ng=1
MN9 DbLatchM DbbTG net12 VSS sg13_lv_nmos m=1 w=550.00n l=130.00n ng=1
MN0 SCEb SCE VSS VSS sg13_lv_nmos m=1 w=420.00n l=130.00n ng=1
MN10 net12 SET_B VSS VSS sg13_lv_nmos m=1 w=550.00n l=130.00n ng=1
MN13 net15 DbLatchM VSS VSS sg13_lv_nmos m=1 w=420.00n l=130.00n ng=1
MN19 net11 SET_B VSS VSS sg13_lv_nmos m=1 w=740.00n l=130.00n ng=1
MN12 DbbTG CLKbb net15 VSS sg13_lv_nmos m=1 w=420.00n l=130.00n ng=1
MN6 Db D net4 VSS sg13_lv_nmos m=1 w=420.00n l=130.00n ng=1
MN22 pre_qb pre_q VSS VSS sg13_lv_nmos m=1 w=550.00n l=130.00n ng=1
MN16 DbbLatch2 CLKb net14 VSS sg13_lv_nmos m=1 w=420.00n l=130.00n ng=1
MN23 Q pre_qb VSS VSS sg13_lv_nmos m=1 w=740.00n l=130.00n ng=1
MN15 net13 DbLatchM VSS VSS sg13_lv_nmos m=1 w=550.00n l=130.00n ng=1
MN2 CLKb CLK VSS VSS sg13_lv_nmos m=1 w=740.00n l=130.00n ng=1
MN14 DbbLatch2 CLKbb net13 VSS sg13_lv_nmos m=1 w=550.00n l=130.00n ng=1
MN11 DbLatchM resetbb net12 VSS sg13_lv_nmos m=1 w=550.00n l=130.00n ng=1
MN21 Q_N pre_q VSS VSS sg13_lv_nmos m=1 w=740.00n l=130.00n ng=1
MN20 pre_q resetbb net11 VSS sg13_lv_nmos m=1 w=740.00n l=130.00n ng=1
.ENDS

************************************************************************
* Library Name: sg13g2_stdcell
* Cell Name:    sg13g2_sighold
* View Name:    schematic
************************************************************************

.SUBCKT sg13g2_sighold SH VDD VSS
*.PININFO SH:B VDD:B VSS:B
MN1 net1 SH VSS VSS sg13_lv_nmos m=1 w=300.0n l=130.00n ng=1
MN0 SH net1 VSS VSS sg13_lv_nmos m=1 w=300.0n l=700.0n ng=1
MP1 net1 SH VDD VDD sg13_lv_pmos m=1 w=450.00n l=130.00n ng=1
MP0 SH net1 VDD VDD sg13_lv_pmos m=1 w=300.0n l=700.0n ng=1
.ENDS

************************************************************************
* Library Name: sg13g2_stdcell
* Cell Name:    sg13g2_slgcp_1
* View Name:    schematic
************************************************************************

.SUBCKT sg13g2_slgcp_1 GCLK CLK GATE SCE VDD VSS
*.PININFO CLK:I GATE:I SCE:I GCLK:O VDD:B VSS:B
MP10 GCLK net5 VDD VDD sg13_lv_pmos m=1 w=1.12u l=130.00n ng=1
MP4 net1 CLKbb net6 VDD sg13_lv_pmos m=1 w=840.00n l=130.00n ng=1
MP1 CLKbb CLKb VDD VDD sg13_lv_pmos m=1 w=840.00n l=130.00n ng=1
MP8 net5 int_GATE VDD VDD sg13_lv_pmos m=1 w=840.00n l=130.00n ng=1
MP2 net3 SCE VDD VDD sg13_lv_pmos m=1 w=840.00n l=130.00n ng=1
MP7 net6 CLKb net4 VDD sg13_lv_pmos m=1 w=420.00n l=130.00n ng=1
MP5 int_GATE net6 VDD VDD sg13_lv_pmos m=1 w=1.12u l=130.00n ng=1
MP0 CLKb CLK VDD VDD sg13_lv_pmos m=1 w=840.00n l=130.00n ng=1
MP9 net5 CLK VDD VDD sg13_lv_pmos m=1 w=840.00n l=130.00n ng=1
MP6 net4 int_GATE VDD VDD sg13_lv_pmos m=1 w=420.00n l=130.00n ng=1
MP3 net1 GATE net3 VDD sg13_lv_pmos m=1 w=840.00n l=130.00n ng=1
MN5 int_GATE net6 VSS VSS sg13_lv_nmos m=1 w=740.00n l=130.00n ng=1
MN9 net2 CLK VSS VSS sg13_lv_nmos m=1 w=640.00n l=130.00n ng=1
MN2 net1 SCE VSS VSS sg13_lv_nmos m=1 w=550.00n l=130.00n ng=1
MN4 net6 CLKb net1 VSS sg13_lv_nmos m=1 w=550.00n l=130.00n ng=1
MN7 net7 int_GATE VSS VSS sg13_lv_nmos m=1 w=420.00n l=130.00n ng=1
MN8 net5 int_GATE net2 VSS sg13_lv_nmos m=1 w=640.00n l=130.00n ng=1
MN10 GCLK net5 VSS VSS sg13_lv_nmos m=1 w=740.00n l=130.00n ng=1
MN1 CLKbb CLKb VSS VSS sg13_lv_nmos m=1 w=740.00n l=130.00n ng=1
MN3 net1 GATE VSS VSS sg13_lv_nmos m=1 w=550.00n l=130.00n ng=1
MN0 CLKb CLK VSS VSS sg13_lv_nmos m=1 w=740.00n l=130.00n ng=1
MN6 net6 CLKbb net7 VSS sg13_lv_nmos m=1 w=420.00n l=130.00n ng=1
.ENDS

************************************************************************
* Library Name: sg13g2_stdcell
* Cell Name:    sg13g2_tiehi
* View Name:    schematic
************************************************************************

.SUBCKT sg13g2_tiehi L_HI VDD VSS
*.PININFO L_HI:O VDD:B VSS:B
MN1 net3 net2 VSS VSS sg13_lv_nmos m=1 w=795.00n l=130.00n ng=1
MN0 net1 net1 VSS VSS sg13_lv_nmos m=1 w=300n l=130.00n ng=1
MP1 L_HI net3 VDD VDD sg13_lv_pmos m=1 w=1.155u l=130.00n ng=1
MP0 net2 net1 VDD VDD sg13_lv_pmos m=1 w=660.0n l=130.00n ng=1
.ENDS

************************************************************************
* Library Name: sg13g2_stdcell
* Cell Name:    sg13g2_tielo
* View Name:    schematic
************************************************************************

.SUBCKT sg13g2_tielo L_LO VDD VSS
*.PININFO L_LO:O VDD:B VSS:B
MN0 net3 net2 VSS VSS sg13_lv_nmos m=1 w=385.00n l=130.00n ng=1
MN1 L_LO net1 VSS VSS sg13_lv_nmos m=1 w=880.0n l=130.00n ng=1
MP0 net2 net2 VDD VDD sg13_lv_pmos m=1 w=300n l=130.00n ng=1
MP1 net1 net3 VDD VDD sg13_lv_pmos m=1 w=1.045u l=130.00n ng=1
.ENDS

************************************************************************
* Library Name: sg13g2_stdcell
* Cell Name:    sg13g2_xnor2_1
* View Name:    schematic
************************************************************************

.SUBCKT sg13g2_xnor2_1 Y A B VDD VSS
*.PININFO A:I B:I Y:O VDD:B VSS:B
MP4 Y net1 VDD VDD sg13_lv_pmos m=1 w=1.12u l=130.00n ng=1
MP3 Y B net4 VDD sg13_lv_pmos m=1 w=1.12u l=130.00n ng=1
MP2 net4 A VDD VDD sg13_lv_pmos m=1 w=1.12u l=130.00n ng=1
MP1 net1 B VDD VDD sg13_lv_pmos m=1 w=840.00n l=130.00n ng=1
MP0 net1 A VDD VDD sg13_lv_pmos m=1 w=840.00n l=130.00n ng=1
MN3 Y net1 net3 VSS sg13_lv_nmos m=1 w=740.00n l=130.00n ng=1
MN1 net2 A VSS VSS sg13_lv_nmos m=1 w=640.00n l=130.00n ng=1
MN0 net1 B net2 VSS sg13_lv_nmos m=1 w=640.00n l=130.00n ng=1
MN4 net3 B VSS VSS sg13_lv_nmos m=1 w=740.00n l=130.00n ng=1
MN2 net3 A VSS VSS sg13_lv_nmos m=1 w=740.00n l=130.00n ng=1
.ENDS

************************************************************************
* Library Name: sg13g2_stdcell
* Cell Name:    sg13g2_xor2_1
* View Name:    schematic
************************************************************************

.SUBCKT sg13g2_xor2_1 X A B VDD VSS
*.PININFO A:I B:I X:O VDD:B VSS:B
MN0 net1 A VSS VSS sg13_lv_nmos m=1 w=550.00n l=130.00n ng=1
MN3 X B net3 VSS sg13_lv_nmos m=1 w=740.00n l=130.00n ng=1
MN2 X net1 VSS VSS sg13_lv_nmos m=1 w=740.00n l=130.00n ng=1
MN4 net3 A VSS VSS sg13_lv_nmos m=1 w=740.00n l=130.00n ng=1
MN1 net1 B VSS VSS sg13_lv_nmos m=1 w=550.00n l=130.00n ng=1
MP0 net6 A VDD VDD sg13_lv_pmos m=1 w=1.000u l=130.00n ng=1
MP1 net1 B net6 VDD sg13_lv_pmos m=1 w=1.000u l=130.00n ng=1
MP2 net5 A VDD VDD sg13_lv_pmos m=1 w=1.12u l=130.00n ng=1
MP4 net5 B VDD VDD sg13_lv_pmos m=1 w=1.12u l=130.00n ng=1
MP3 X net1 net5 VDD sg13_lv_pmos m=1 w=1.12u l=130.00n ng=1
.ENDS

************************************************************************
* Library Name: sg13g2_stdcell
* Cell Name:    sg13g2_a22oi_1
* View Name:    schematic
************************************************************************

.SUBCKT sg13g2_a22oi_1 Y A1 A2 B1 B2 VDD VSS
*.PININFO A1:I A2:I B1:I B2:I Y:O VDD:B VSS:B
MN1 net1 B1 VSS VSS sg13_lv_nmos m=1 w=740.00n l=130.00n ng=1
MN0 Y B2 net1 VSS sg13_lv_nmos m=1 w=740.00n l=130.00n ng=1
MN3 net2 A2 VSS VSS sg13_lv_nmos m=1 w=740.00n l=130.00n ng=1
MN2 Y A1 net2 VSS sg13_lv_nmos m=1 w=740.00n l=130.00n ng=1
MP1 Y B1 net3 VDD sg13_lv_pmos m=1 w=1.12u l=130.00n ng=1
MP3 Y B2 net3 VDD sg13_lv_pmos m=1 w=1.12u l=130.00n ng=1
MP2 net3 A2 VDD VDD sg13_lv_pmos m=1 w=1.12u l=130.00n ng=1
MP0 net3 A1 VDD VDD sg13_lv_pmos m=1 w=1.12u l=130.00n ng=1
.ENDS

************************************************************************
* Library Name: sg13g2_stdcell
* Cell Name:    sg13g2_sdfrbpq_1
* View Name:    schematic
************************************************************************

.SUBCKT sg13g2_sdfrbpq_1 Q CLK D RESET_B SCD SCE VDD VSS
*.PININFO CLK:I D:I RESET_B:I SCD:I SCE:I Q:O VDD:B VSS:B
MN3 Db SCD net63 VSS sg13_lv_nmos m=1 w=740.00n l=130.00n ng=1
MN1 Db D net65 VSS sg13_lv_nmos m=1 w=740.00n l=130.00n ng=1
MN0 SCEb SCE VSS VSS sg13_lv_nmos m=1 w=550.00n l=130.00n ng=1
MN4 net63 SCE VSS VSS sg13_lv_nmos m=1 w=740.00n l=130.00n ng=1
MN2 net65 SCEb VSS VSS sg13_lv_nmos m=1 w=740.00n l=130.00n ng=1
MN17 net12 net2 VSS VSS sg13_lv_nmos m=1 w=420.00n l=130.00n ng=1
MN16 net5 clkneg net12 VSS sg13_lv_nmos m=1 w=420.00n l=130.00n ng=1
MN18 net2 net5 net11 VSS sg13_lv_nmos m=1 w=420.00n l=130.00n ng=1
MN19 net11 RESET_B VSS VSS sg13_lv_nmos m=1 w=420.00n l=130.00n ng=1
MN20 Q net2 VSS VSS sg13_lv_nmos m=1 w=740.00n l=130.00n ng=1
MN6 Dbbb Dbb net10 VSS sg13_lv_nmos m=1 w=420.00n l=130.00n ng=1
MN7 net10 RESET_B VSS VSS sg13_lv_nmos m=1 w=420.00n l=130.00n ng=1
MN10 Dbbb clkneg net6 VSS sg13_lv_nmos m=1 w=420.00n l=130.00n ng=1
MN11 net6 clkpos net9 VSS sg13_lv_nmos m=1 w=420.00n l=130.00n ng=1
MN12 net9 net4 net8 VSS sg13_lv_nmos m=1 w=420.00n l=130.00n ng=1
MN13 net8 RESET_B VSS VSS sg13_lv_nmos m=1 w=420.00n l=130.00n ng=1
MN14 net4 net6 VSS VSS sg13_lv_nmos m=1 w=740.00n l=130.00n ng=1
MN8 clkneg CLK VSS VSS sg13_lv_nmos m=1 w=740.00n l=130.00n ng=1
MN15 net4 clkpos net5 VSS sg13_lv_nmos m=1 w=740.00n l=130.00n ng=1
MN9 clkpos clkneg VSS VSS sg13_lv_nmos m=1 w=740.00n l=130.00n ng=1
MN5 Dbb Db VSS VSS sg13_lv_nmos m=1 w=740.00n l=130.00n ng=1
MP1 net64 SCE VDD VDD sg13_lv_pmos m=1 w=1.000u l=130.00n ng=1
MP3 net62 SCEb VDD VDD sg13_lv_pmos m=1 w=1.000u l=130.00n ng=1
MP0 SCEb SCE VDD VDD sg13_lv_pmos m=1 w=840.00n l=130.00n ng=1
MP4 Db SCD net62 VDD sg13_lv_pmos m=1 w=1.000u l=130.00n ng=1
MP2 Db D net64 VDD sg13_lv_pmos m=1 w=1.000u l=130.00n ng=1
MP17 net5 clkpos net3 VDD sg13_lv_pmos m=1 w=420.00n l=130.00n ng=1
MP18 net2 net5 VDD VDD sg13_lv_pmos m=1 w=420.00n l=130.00n ng=1
MP19 net2 RESET_B VDD VDD sg13_lv_pmos m=1 w=420.00n l=130.00n ng=1
MP20 Q net2 VDD VDD sg13_lv_pmos m=1 w=1.12u l=130.00n ng=1
MP10 Dbbb clkpos net6 VDD sg13_lv_pmos m=1 w=420.00n l=130.00n ng=1
MP6 Dbbb RESET_B VDD VDD sg13_lv_pmos m=1 w=420.00n l=130.00n ng=1
MP7 Dbbb Dbb VDD VDD sg13_lv_pmos m=1 w=420.00n l=130.00n ng=1
MP11 net7 net4 VDD VDD sg13_lv_pmos m=1 w=420.00n l=130.00n ng=1
MP12 net6 clkneg net7 VDD sg13_lv_pmos m=1 w=420.00n l=130.00n ng=1
MP13 net6 RESET_B VDD VDD sg13_lv_pmos m=1 w=420.00n l=130.00n ng=1
MP8 clkneg CLK VDD VDD sg13_lv_pmos m=1 w=1.12u l=130.00n ng=1
MP9 clkpos clkneg VDD VDD sg13_lv_pmos m=1 w=1.12u l=130.00n ng=1
MP14 net4 net6 VDD VDD sg13_lv_pmos m=1 w=1.000u l=130.00n ng=1
MP15 net4 clkneg net5 VDD sg13_lv_pmos m=1 w=1.000u l=130.00n ng=1
MP5 Dbb Db VDD VDD sg13_lv_pmos m=1 w=1.12u l=130.00n ng=1
MP16 net3 net2 VDD VDD sg13_lv_pmos m=1 w=420.00n l=130.00n ng=1
.ENDS

************************************************************************
* Library Name: sg13g2_stdcell
* Cell Name:    sg13g2_sdfrbpq_2
* View Name:    schematic
************************************************************************

.SUBCKT sg13g2_sdfrbpq_2 Q CLK D RESET_B SCD SCE VDD VSS
*.PININFO CLK:I D:I RESET_B:I SCD:I SCE:I Q:O VDD:B VSS:B
MN3 Db SCD net63 VSS sg13_lv_nmos m=1 w=740.00n l=130.00n ng=1
MN1 Db D net65 VSS sg13_lv_nmos m=1 w=740.00n l=130.00n ng=1
MN0 SCEb SCE VSS VSS sg13_lv_nmos m=1 w=550.00n l=130.00n ng=1
MN4 net63 SCE VSS VSS sg13_lv_nmos m=1 w=740.00n l=130.00n ng=1
MN2 net65 SCEb VSS VSS sg13_lv_nmos m=1 w=740.00n l=130.00n ng=1
MN5 Dbb Db VSS VSS sg13_lv_nmos m=1 w=740.00n l=130.00n ng=1
MN17 net12 net2 VSS VSS sg13_lv_nmos m=1 w=420.00n l=130.00n ng=1
MN16 net5 clkneg net12 VSS sg13_lv_nmos m=1 w=420.00n l=130.00n ng=1
MN18 net2 net5 net11 VSS sg13_lv_nmos m=1 w=420.00n l=130.00n ng=1
MN19 net11 RESET_B VSS VSS sg13_lv_nmos m=1 w=420.00n l=130.00n ng=1
MN20 Q net2 VSS VSS sg13_lv_nmos m=1 w=1.48u l=130.00n ng=2
MN6 Dbbb Dbb net10 VSS sg13_lv_nmos m=1 w=420.00n l=130.00n ng=1
MN7 net10 RESET_B VSS VSS sg13_lv_nmos m=1 w=420.00n l=130.00n ng=1
MN10 Dbbb clkneg net6 VSS sg13_lv_nmos m=1 w=420.00n l=130.00n ng=1
MN11 net6 clkpos net9 VSS sg13_lv_nmos m=1 w=420.00n l=130.00n ng=1
MN12 net9 net4 net8 VSS sg13_lv_nmos m=1 w=420.00n l=130.00n ng=1
MN13 net8 RESET_B VSS VSS sg13_lv_nmos m=1 w=420.00n l=130.00n ng=1
MN14 net4 net6 VSS VSS sg13_lv_nmos m=1 w=740.00n l=130.00n ng=1
MN8 clkneg CLK VSS VSS sg13_lv_nmos m=1 w=740.00n l=130.00n ng=1
MN15 net4 clkpos net5 VSS sg13_lv_nmos m=1 w=740.00n l=130.00n ng=1
MN9 clkpos clkneg VSS VSS sg13_lv_nmos m=1 w=740.00n l=130.00n ng=1
MP1 net64 SCE VDD VDD sg13_lv_pmos m=1 w=1.000u l=130.00n ng=1
MP3 net62 SCEb VDD VDD sg13_lv_pmos m=1 w=1.000u l=130.00n ng=1
MP0 SCEb SCE VDD VDD sg13_lv_pmos m=1 w=840.00n l=130.00n ng=1
MP4 Db SCD net62 VDD sg13_lv_pmos m=1 w=1.000u l=130.00n ng=1
MP2 Db D net64 VDD sg13_lv_pmos m=1 w=1.000u l=130.00n ng=1
MP5 Dbb Db VDD VDD sg13_lv_pmos m=1 w=1.12u l=130.00n ng=1
MP17 net5 clkpos net3 VDD sg13_lv_pmos m=1 w=420.00n l=130.00n ng=1
MP18 net2 net5 VDD VDD sg13_lv_pmos m=1 w=420.00n l=130.00n ng=1
MP19 net2 RESET_B VDD VDD sg13_lv_pmos m=1 w=420.00n l=130.00n ng=1
MP20 Q net2 VDD VDD sg13_lv_pmos m=1 w=2.24u l=130.00n ng=2
MP10 Dbbb clkpos net6 VDD sg13_lv_pmos m=1 w=420.00n l=130.00n ng=1
MP6 Dbbb RESET_B VDD VDD sg13_lv_pmos m=1 w=420.00n l=130.00n ng=1
MP7 Dbbb Dbb VDD VDD sg13_lv_pmos m=1 w=420.00n l=130.00n ng=1
MP11 net7 net4 VDD VDD sg13_lv_pmos m=1 w=420.00n l=130.00n ng=1
MP12 net6 clkneg net7 VDD sg13_lv_pmos m=1 w=420.00n l=130.00n ng=1
MP13 net6 RESET_B VDD VDD sg13_lv_pmos m=1 w=420.00n l=130.00n ng=1
MP8 clkneg CLK VDD VDD sg13_lv_pmos m=1 w=1.12u l=130.00n ng=1
MP9 clkpos clkneg VDD VDD sg13_lv_pmos m=1 w=1.12u l=130.00n ng=1
MP14 net4 net6 VDD VDD sg13_lv_pmos m=1 w=1.000u l=130.00n ng=1
MP15 net4 clkneg net5 VDD sg13_lv_pmos m=1 w=1.000u l=130.00n ng=1
MP16 net3 net2 VDD VDD sg13_lv_pmos m=1 w=420.00n l=130.00n ng=1
.ENDS

************************************************************************
* Library Name: sg13g2_stdcell
* Cell Name:    sg13g2_sdfrbp_2
* View Name:    schematic
************************************************************************

.SUBCKT sg13g2_sdfrbp_2 Q Q_N CLK D RESET_B SCD SCE VDD VSS
*.PININFO CLK:I D:I RESET_B:I SCD:I SCE:I Q:O Q_N:O VDD:B VSS:B
MN3 Db SCD net63 VSS sg13_lv_nmos m=1 w=740.00n l=130.00n ng=1
MN1 Db D net65 VSS sg13_lv_nmos m=1 w=740.00n l=130.00n ng=1
MN0 SCEb SCE VSS VSS sg13_lv_nmos m=1 w=550.00n l=130.00n ng=1
MN4 net63 SCE VSS VSS sg13_lv_nmos m=1 w=740.00n l=130.00n ng=1
MN2 net65 SCEb VSS VSS sg13_lv_nmos m=1 w=740.00n l=130.00n ng=1
MN5 Dbb Db VSS VSS sg13_lv_nmos m=1 w=740.00n l=130.00n ng=1
MN17 net12 net2 VSS VSS sg13_lv_nmos m=1 w=420.00n l=130.00n ng=1
MN16 net5 clkneg net12 VSS sg13_lv_nmos m=1 w=420.00n l=130.00n ng=1
MN18 net2 net5 net11 VSS sg13_lv_nmos m=1 w=420.00n l=130.00n ng=1
MN19 net11 RESET_B VSS VSS sg13_lv_nmos m=1 w=420.00n l=130.00n ng=1
MN20 Q_N net5 VSS VSS sg13_lv_nmos m=1 w=1.48u l=130.00n ng=2
MN6 Dbbb Dbb net10 VSS sg13_lv_nmos m=1 w=420.00n l=130.00n ng=1
MN7 net10 RESET_B VSS VSS sg13_lv_nmos m=1 w=420.00n l=130.00n ng=1
MN10 Dbbb clkneg net6 VSS sg13_lv_nmos m=1 w=420.00n l=130.00n ng=1
MN11 net6 clkpos net9 VSS sg13_lv_nmos m=1 w=420.00n l=130.00n ng=1
MN12 net9 net4 net8 VSS sg13_lv_nmos m=1 w=420.00n l=130.00n ng=1
MN13 net8 RESET_B VSS VSS sg13_lv_nmos m=1 w=420.00n l=130.00n ng=1
MN14 net4 net6 VSS VSS sg13_lv_nmos m=1 w=740.00n l=130.00n ng=1
MN8 clkneg CLK VSS VSS sg13_lv_nmos m=1 w=740.00n l=130.00n ng=1
MN15 net4 clkpos net5 VSS sg13_lv_nmos m=1 w=740.00n l=130.00n ng=1
MN9 clkpos clkneg VSS VSS sg13_lv_nmos m=1 w=740.00n l=130.00n ng=1
MN22 Q net1 VSS VSS sg13_lv_nmos m=1 w=1.48u l=130.00n ng=2
MN21 net1 net5 VSS VSS sg13_lv_nmos m=1 w=640.00n l=130.00n ng=1
MP1 net64 SCE VDD VDD sg13_lv_pmos m=1 w=1.000u l=130.00n ng=1
MP3 net62 SCEb VDD VDD sg13_lv_pmos m=1 w=1.000u l=130.00n ng=1
MP0 SCEb SCE VDD VDD sg13_lv_pmos m=1 w=840.00n l=130.00n ng=1
MP4 Db SCD net62 VDD sg13_lv_pmos m=1 w=1.000u l=130.00n ng=1
MP2 Db D net64 VDD sg13_lv_pmos m=1 w=1.000u l=130.00n ng=1
MP5 Dbb Db VDD VDD sg13_lv_pmos m=1 w=1.12u l=130.00n ng=1
MP17 net5 clkpos net3 VDD sg13_lv_pmos m=1 w=420.00n l=130.00n ng=1
MP18 net2 net5 VDD VDD sg13_lv_pmos m=1 w=420.00n l=130.00n ng=1
MP19 net2 RESET_B VDD VDD sg13_lv_pmos m=1 w=420.00n l=130.00n ng=1
MP20 Q_N net5 VDD VDD sg13_lv_pmos m=1 w=2.24u l=130.00n ng=2
MP10 Dbbb clkpos net6 VDD sg13_lv_pmos m=1 w=420.00n l=130.00n ng=1
MP6 Dbbb RESET_B VDD VDD sg13_lv_pmos m=1 w=420.00n l=130.00n ng=1
MP7 Dbbb Dbb VDD VDD sg13_lv_pmos m=1 w=420.00n l=130.00n ng=1
MP11 net7 net4 VDD VDD sg13_lv_pmos m=1 w=420.00n l=130.00n ng=1
MP12 net6 clkneg net7 VDD sg13_lv_pmos m=1 w=420.00n l=130.00n ng=1
MP13 net6 RESET_B VDD VDD sg13_lv_pmos m=1 w=420.00n l=130.00n ng=1
MP8 clkneg CLK VDD VDD sg13_lv_pmos m=1 w=1.12u l=130.00n ng=1
MP9 clkpos clkneg VDD VDD sg13_lv_pmos m=1 w=1.12u l=130.00n ng=1
MP14 net4 net6 VDD VDD sg13_lv_pmos m=1 w=1.000u l=130.00n ng=1
MP15 net4 clkneg net5 VDD sg13_lv_pmos m=1 w=1.000u l=130.00n ng=1
MP22 Q net1 VDD VDD sg13_lv_pmos m=1 w=2.24u l=130.00n ng=2
MP16 net3 net2 VDD VDD sg13_lv_pmos m=1 w=420.00n l=130.00n ng=1
MP21 net1 net5 VDD VDD sg13_lv_pmos m=1 w=1.000u l=130.00n ng=1
.ENDS

************************************************************************
* Library Name: sg13g2_stdcell
* Cell Name:    sg13g2_sdfrbp_1
* View Name:    schematic
************************************************************************

.SUBCKT sg13g2_sdfrbp_1 Q Q_N CLK D RESET_B SCD SCE VDD VSS
*.PININFO CLK:I D:I RESET_B:I SCD:I SCE:I Q:O Q_N:O VDD:B VSS:B
MN3 Db SCD net63 VSS sg13_lv_nmos m=1 w=740.00n l=130.00n ng=1
MN1 Db D net65 VSS sg13_lv_nmos m=1 w=740.00n l=130.00n ng=1
MN0 SCEb SCE VSS VSS sg13_lv_nmos m=1 w=550.00n l=130.00n ng=1
MN4 net63 SCE VSS VSS sg13_lv_nmos m=1 w=740.00n l=130.00n ng=1
MN2 net65 SCEb VSS VSS sg13_lv_nmos m=1 w=740.00n l=130.00n ng=1
MN5 net13 Db VSS VSS sg13_lv_nmos m=1 w=740.00n l=130.00n ng=1
MN17 net12 net2 VSS VSS sg13_lv_nmos m=1 w=420.00n l=130.00n ng=1
MN16 net5 clkneg net12 VSS sg13_lv_nmos m=1 w=420.00n l=130.00n ng=1
MN18 net2 net5 net11 VSS sg13_lv_nmos m=1 w=420.00n l=130.00n ng=1
MN19 net11 RESET_B VSS VSS sg13_lv_nmos m=1 w=420.00n l=130.00n ng=1
MN20 Q_N net5 VSS VSS sg13_lv_nmos m=1 w=740.00n l=130.00n ng=1
MN6 Dbb net13 net10 VSS sg13_lv_nmos m=1 w=420.00n l=130.00n ng=1
MN7 net10 RESET_B VSS VSS sg13_lv_nmos m=1 w=420.00n l=130.00n ng=1
MN10 Dbb clkneg net6 VSS sg13_lv_nmos m=1 w=420.00n l=130.00n ng=1
MN11 net6 clkpos net9 VSS sg13_lv_nmos m=1 w=420.00n l=130.00n ng=1
MN12 net9 net4 net8 VSS sg13_lv_nmos m=1 w=420.00n l=130.00n ng=1
MN13 net8 RESET_B VSS VSS sg13_lv_nmos m=1 w=420.00n l=130.00n ng=1
MN14 net4 net6 VSS VSS sg13_lv_nmos m=1 w=740.00n l=130.00n ng=1
MN8 clkneg CLK VSS VSS sg13_lv_nmos m=1 w=740.00n l=130.00n ng=1
MN15 net4 clkpos net5 VSS sg13_lv_nmos m=1 w=740.00n l=130.00n ng=1
MN9 clkpos clkneg VSS VSS sg13_lv_nmos m=1 w=740.00n l=130.00n ng=1
MN22 Q net1 VSS VSS sg13_lv_nmos m=1 w=740.00n l=130.00n ng=1
MN21 net1 net5 VSS VSS sg13_lv_nmos m=1 w=640.00n l=130.00n ng=1
MP1 net64 SCE VDD VDD sg13_lv_pmos m=1 w=1.000u l=130.00n ng=1
MP3 net62 SCEb VDD VDD sg13_lv_pmos m=1 w=1.000u l=130.00n ng=1
MP0 SCEb SCE VDD VDD sg13_lv_pmos m=1 w=840.00n l=130.00n ng=1
MP4 Db SCD net62 VDD sg13_lv_pmos m=1 w=1.000u l=130.00n ng=1
MP2 Db D net64 VDD sg13_lv_pmos m=1 w=1.000u l=130.00n ng=1
MP5 net13 Db VDD VDD sg13_lv_pmos m=1 w=1.12u l=130.00n ng=1
MP17 net5 clkpos net3 VDD sg13_lv_pmos m=1 w=420.00n l=130.00n ng=1
MP18 net2 net5 VDD VDD sg13_lv_pmos m=1 w=420.00n l=130.00n ng=1
MP19 net2 RESET_B VDD VDD sg13_lv_pmos m=1 w=420.00n l=130.00n ng=1
MP20 Q_N net5 VDD VDD sg13_lv_pmos m=1 w=1.12u l=130.00n ng=1
MP10 Dbb clkpos net6 VDD sg13_lv_pmos m=1 w=420.00n l=130.00n ng=1
MP6 Dbb RESET_B VDD VDD sg13_lv_pmos m=1 w=420.00n l=130.00n ng=1
MP7 Dbb net13 VDD VDD sg13_lv_pmos m=1 w=420.00n l=130.00n ng=1
MP11 net7 net4 VDD VDD sg13_lv_pmos m=1 w=420.00n l=130.00n ng=1
MP12 net6 clkneg net7 VDD sg13_lv_pmos m=1 w=420.00n l=130.00n ng=1
MP13 net6 RESET_B VDD VDD sg13_lv_pmos m=1 w=420.00n l=130.00n ng=1
MP8 clkneg CLK VDD VDD sg13_lv_pmos m=1 w=1.12u l=130.00n ng=1
MP9 clkpos clkneg VDD VDD sg13_lv_pmos m=1 w=1.12u l=130.00n ng=1
MP14 net4 net6 VDD VDD sg13_lv_pmos m=1 w=1.000u l=130.00n ng=1
MP15 net4 clkneg net5 VDD sg13_lv_pmos m=1 w=1.000u l=130.00n ng=1
MP22 Q net1 VDD VDD sg13_lv_pmos m=1 w=1.12u l=130.00n ng=1
MP16 net3 net2 VDD VDD sg13_lv_pmos m=1 w=420.00n l=130.00n ng=1
MP21 net1 net5 VDD VDD sg13_lv_pmos m=1 w=1.000u l=130.00n ng=1
.ENDS

************************************************************************
* Library Name: sg13g2_stdcell
* Cell Name:    sg13g2_dfrbpq_2
* View Name:    schematic
************************************************************************

.SUBCKT sg13g2_dfrbpq_2 Q CLK D RESET_B VDD VSS
*.PININFO CLK:I D:I RESET_B:I Q:O VDD:B VSS:B
MN11 net12 net2 VSS VSS sg13_lv_nmos m=1 w=420.00n l=130.00n ng=1
MN10 net5 clkneg net12 VSS sg13_lv_nmos m=1 w=420.00n l=130.00n ng=1
MN12 net2 net5 net11 VSS sg13_lv_nmos m=1 w=420.00n l=130.00n ng=1
MN13 net11 RESET_B VSS VSS sg13_lv_nmos m=1 w=420.00n l=130.00n ng=1
MN0 Db D net10 VSS sg13_lv_nmos m=1 w=420.00n l=130.00n ng=1
MN1 net10 RESET_B VSS VSS sg13_lv_nmos m=1 w=420.00n l=130.00n ng=1
MN4 Db clkneg net6 VSS sg13_lv_nmos m=1 w=420.00n l=130.00n ng=1
MN5 net6 clkpos net9 VSS sg13_lv_nmos m=1 w=420.00n l=130.00n ng=1
MN6 net9 net4 net8 VSS sg13_lv_nmos m=1 w=420.00n l=130.00n ng=1
MN7 net8 RESET_B VSS VSS sg13_lv_nmos m=1 w=420.00n l=130.00n ng=1
MN8 net4 net6 VSS VSS sg13_lv_nmos m=1 w=740.00n l=130.00n ng=1
MN2 clkneg CLK VSS VSS sg13_lv_nmos m=1 w=740.00n l=130.00n ng=1
MN9 net4 clkpos net5 VSS sg13_lv_nmos m=1 w=740.00n l=130.00n ng=1
MN3 clkpos clkneg VSS VSS sg13_lv_nmos m=1 w=740.00n l=130.00n ng=1
MN15 Q net1 VSS VSS sg13_lv_nmos m=1 w=1.48u l=130.00n ng=2
MN14 net1 net5 VSS VSS sg13_lv_nmos m=1 w=640.00n l=130.00n ng=1
MP11 net5 clkpos net3 VDD sg13_lv_pmos m=1 w=420.00n l=130.00n ng=1
MP12 net2 net5 VDD VDD sg13_lv_pmos m=1 w=420.00n l=130.00n ng=1
MP13 net2 RESET_B VDD VDD sg13_lv_pmos m=1 w=420.00n l=130.00n ng=1
MP4 Db clkpos net6 VDD sg13_lv_pmos m=1 w=420.00n l=130.00n ng=1
MP0 Db RESET_B VDD VDD sg13_lv_pmos m=1 w=420.00n l=130.00n ng=1
MP1 Db D VDD VDD sg13_lv_pmos m=1 w=420.00n l=130.00n ng=1
MP5 net7 net4 VDD VDD sg13_lv_pmos m=1 w=420.00n l=130.00n ng=1
MP6 net6 clkneg net7 VDD sg13_lv_pmos m=1 w=420.00n l=130.00n ng=1
MP7 net6 RESET_B VDD VDD sg13_lv_pmos m=1 w=420.00n l=130.00n ng=1
MP2 clkneg CLK VDD VDD sg13_lv_pmos m=1 w=1.12u l=130.00n ng=1
MP3 clkpos clkneg VDD VDD sg13_lv_pmos m=1 w=1.12u l=130.00n ng=1
MP8 net4 net6 VDD VDD sg13_lv_pmos m=1 w=1.000u l=130.00n ng=1
MP9 net4 clkneg net5 VDD sg13_lv_pmos m=1 w=1.000u l=130.00n ng=1
MP15 Q net1 VDD VDD sg13_lv_pmos m=1 w=2.24u l=130.00n ng=2
MP10 net3 net2 VDD VDD sg13_lv_pmos m=1 w=420.00n l=130.00n ng=1
MP14 net1 net5 VDD VDD sg13_lv_pmos m=1 w=1.000u l=130.00n ng=1
.ENDS

************************************************************************
* Library Name: sg13g2_stdcell
* Cell Name:    sg13g2_dfrbpq_1
* View Name:    schematic
************************************************************************

.SUBCKT sg13g2_dfrbpq_1 Q CLK D RESET_B VDD VSS
*.PININFO CLK:I D:I RESET_B:I Q:O VDD:B VSS:B
MN11 net12 net2 VSS VSS sg13_lv_nmos m=1 w=420.00n l=130.00n ng=1
MN10 net5 clkneg net12 VSS sg13_lv_nmos m=1 w=420.00n l=130.00n ng=1
MN12 net2 net5 net11 VSS sg13_lv_nmos m=1 w=420.00n l=130.00n ng=1
MN13 net11 RESET_B VSS VSS sg13_lv_nmos m=1 w=420.00n l=130.00n ng=1
MN0 Db D net10 VSS sg13_lv_nmos m=1 w=420.00n l=130.00n ng=1
MN1 net10 RESET_B VSS VSS sg13_lv_nmos m=1 w=420.00n l=130.00n ng=1
MN4 Db clkneg net6 VSS sg13_lv_nmos m=1 w=420.00n l=130.00n ng=1
MN5 net6 clkpos net9 VSS sg13_lv_nmos m=1 w=420.00n l=130.00n ng=1
MN6 net9 net4 net8 VSS sg13_lv_nmos m=1 w=420.00n l=130.00n ng=1
MN7 net8 RESET_B VSS VSS sg13_lv_nmos m=1 w=420.00n l=130.00n ng=1
MN8 net4 net6 VSS VSS sg13_lv_nmos m=1 w=740.00n l=130.00n ng=1
MN2 clkneg CLK VSS VSS sg13_lv_nmos m=1 w=740.00n l=130.00n ng=1
MN9 net4 clkpos net5 VSS sg13_lv_nmos m=1 w=740.00n l=130.00n ng=1
MN3 clkpos clkneg VSS VSS sg13_lv_nmos m=1 w=740.00n l=130.00n ng=1
MN15 Q net1 VSS VSS sg13_lv_nmos m=1 w=740.00n l=130.00n ng=1
MN14 net1 net5 VSS VSS sg13_lv_nmos m=1 w=740.00n l=130.00n ng=1
MP11 net5 clkpos net3 VDD sg13_lv_pmos m=1 w=420.00n l=130.00n ng=1
MP12 net2 net5 VDD VDD sg13_lv_pmos m=1 w=420.00n l=130.00n ng=1
MP13 net2 RESET_B VDD VDD sg13_lv_pmos m=1 w=420.00n l=130.00n ng=1
MP4 Db clkpos net6 VDD sg13_lv_pmos m=1 w=420.00n l=130.00n ng=1
MP0 Db RESET_B VDD VDD sg13_lv_pmos m=1 w=420.00n l=130.00n ng=1
MP1 Db D VDD VDD sg13_lv_pmos m=1 w=420.00n l=130.00n ng=1
MP5 net7 net4 VDD VDD sg13_lv_pmos m=1 w=420.00n l=130.00n ng=1
MP6 net6 clkneg net7 VDD sg13_lv_pmos m=1 w=420.00n l=130.00n ng=1
MP7 net6 RESET_B VDD VDD sg13_lv_pmos m=1 w=420.00n l=130.00n ng=1
MP2 clkneg CLK VDD VDD sg13_lv_pmos m=1 w=1.12u l=130.00n ng=1
MP3 clkpos clkneg VDD VDD sg13_lv_pmos m=1 w=1.12u l=130.00n ng=1
MP8 net4 net6 VDD VDD sg13_lv_pmos m=1 w=1.000u l=130.00n ng=1
MP9 net4 clkneg net5 VDD sg13_lv_pmos m=1 w=1.000u l=130.00n ng=1
MP15 Q net1 VDD VDD sg13_lv_pmos m=1 w=1.12u l=130.00n ng=1
MP10 net3 net2 VDD VDD sg13_lv_pmos m=1 w=420.00n l=130.00n ng=1
MP14 net1 net5 VDD VDD sg13_lv_pmos m=1 w=1.12u l=130.00n ng=1
.ENDS

************************************************************************
* Library Name: sg13g2_stdcell
* Cell Name:    sg13g2_fill_1
* View Name:    schematic
************************************************************************

.SUBCKT sg13g2_fill_1 VDD VSS
*.PININFO VDD:B VSS:B
.ENDS

************************************************************************
* Library Name: sg13g2_stdcell
* Cell Name:    sg13g2_fill_2
* View Name:    schematic
************************************************************************

.SUBCKT sg13g2_fill_2 VDD VSS
*.PININFO VDD:B VSS:B
.ENDS

************************************************************************
* Library Name: sg13g2_stdcell
* Cell Name:    sg13g2_fill_4
* View Name:    schematic
************************************************************************

.SUBCKT sg13g2_fill_4 VDD VSS
*.PININFO VDD:B VSS:B
.ENDS

************************************************************************
* Library Name: sg13g2_stdcell
* Cell Name:    sg13g2_fill_8
* View Name:    schematic
************************************************************************

.SUBCKT sg13g2_fill_8 VDD VSS
*.PININFO VDD:B VSS:B
.ENDS
* CDL Netlist generated by OpenROAD

*.BUSDELIMITER [

.SUBCKT PLL_COUNTER_DCO_PHYS COARSE_MUX[0] COARSE_MUX[10]
+ COARSE_MUX[11] COARSE_MUX[12] COARSE_MUX[13] COARSE_MUX[14]
+ COARSE_MUX[1] COARSE_MUX[2] COARSE_MUX[3] COARSE_MUX[4] COARSE_MUX[5]
+ COARSE_MUX[6] COARSE_MUX[7] COARSE_MUX[8] COARSE_MUX[9] DCO_EN
+ FINE_MUX[0] FINE_MUX[10] FINE_MUX[11] FINE_MUX[12] FINE_MUX[13]
+ FINE_MUX[14] FINE_MUX[15] FINE_MUX[16] FINE_MUX[17] FINE_MUX[18]
+ FINE_MUX[19] FINE_MUX[1] FINE_MUX[20] FINE_MUX[21] FINE_MUX[22]
+ FINE_MUX[23] FINE_MUX[24] FINE_MUX[25] FINE_MUX[26] FINE_MUX[27]
+ FINE_MUX[28] FINE_MUX[29] FINE_MUX[2] FINE_MUX[30] FINE_MUX[3]
+ FINE_MUX[4] FINE_MUX[5] FINE_MUX[6] FINE_MUX[7] FINE_MUX[8]
+ FINE_MUX[9] INJ_EN MID_MUX[0] MID_MUX[10] MID_MUX[11] MID_MUX[12]
+ MID_MUX[13] MID_MUX[14] MID_MUX[1] MID_MUX[2] MID_MUX[3] MID_MUX[4]
+ MID_MUX[5] MID_MUX[6] MID_MUX[7] MID_MUX[8] MID_MUX[9] MID_OUT
+ OUT INJ_EDGE REF SS_BBPD[0] SS_BBPD[1] TICK VSS VDD
Xbbpd/buf_nand_x_impl SS_BBPD[1] bbpd/OUT_NANDX VDD VSS sg13g2_buf_1
Xbbpd/buf_nand_y_impl SS_BBPD[0] bbpd/OUT_NANDY VDD VSS sg13g2_buf_1
Xbbpd/nand_x_impl bbpd/OUT_NANDX OUT bbpd/OUT_NANDY VDD VSS
+ sg13g2_nand2_1
Xbbpd/nand_y_impl bbpd/OUT_NANDY REF bbpd/OUT_NANDX VDD VSS
+ sg13g2_nand2_1
Xins_1218_ ins_1174_ FINE_MUX[12] VDD VSS sg13g2_inv_1
Xins_1219_ ins_1185_ FINE_MUX[10] VDD VSS sg13g2_inv_1
Xins_1220_ ins_1196_ FINE_MUX[8] VDD VSS sg13g2_inv_1
Xins_1221_ ins_1207_ MID_MUX[14] VDD VSS sg13g2_inv_1
Xins_1222_ ins_0001_ MID_MUX[11] VDD VSS sg13g2_inv_1
Xins_1223_ ins_0012_ MID_MUX[6] VDD VSS sg13g2_inv_1
Xins_1224_ ins_0023_ MID_MUX[5] VDD VSS sg13g2_inv_1
Xins_1225_ ins_0034_ MID_MUX[3] VDD VSS sg13g2_inv_1
Xins_1226_ ins_0045_ COARSE_MUX[9] VDD VSS sg13g2_inv_1
Xins_1227_ ins_0056_ COARSE_MUX[7] VDD VSS sg13g2_inv_1
Xins_1228_ ins_0067_ COARSE_MUX[3] VDD VSS sg13g2_inv_1
Xins_1229_ ins_0078_ FINE_MUX[30] VDD VSS sg13g2_inv_1
Xins_1230_ ins_0089_ FINE_MUX[28] VDD VSS sg13g2_inv_1
Xins_1231_ ins_0100_ FINE_MUX[27] VDD VSS sg13g2_inv_1
Xins_1232_ ins_0111_ FINE_MUX[26] VDD VSS sg13g2_inv_1
Xins_1233_ ins_0122_ FINE_MUX[25] VDD VSS sg13g2_inv_1
Xins_1234_ ins_0133_ FINE_MUX[24] VDD VSS sg13g2_inv_1
Xins_1235_ ins_0144_ FINE_MUX[23] VDD VSS sg13g2_inv_1
Xins_1236_ ins_0155_ FINE_MUX[22] VDD VSS sg13g2_inv_1
Xins_1237_ ins_0166_ FINE_MUX[18] VDD VSS sg13g2_inv_1
Xins_1238_ ins_0177_ FINE_MUX[17] VDD VSS sg13g2_inv_1
Xins_1239_ ins_0188_ FINE_MUX[16] VDD VSS sg13g2_inv_1
Xins_1240_ ins_0199_ FINE_MUX[14] VDD VSS sg13g2_inv_1
Xins_1241_ ins_0210_ phase_0_ VDD VSS sg13g2_inv_1
Xins_1242_ ins_0221_ phase_12_ VDD VSS sg13g2_inv_1
Xins_1243_ ins_0232_ phase_13_ VDD VSS sg13g2_inv_1
Xins_1244_ ins_0243_ phase_14_ VDD VSS sg13g2_inv_1
Xins_1245_ ins_0254_ phase_15_ VDD VSS sg13g2_inv_1
Xins_1246_ ins_0265_ MID_MUX[0] MID_MUX[1] VDD VSS sg13g2_nor2_1
Xins_1247_ ins_0276_ ins_0265_ VDD VSS sg13g2_inv_1
Xins_1248_ ins_0287_ MID_MUX[0] MID_MUX[1] VDD VSS sg13g2_xnor2_1
Xins_1249_ ins_0298_ MID_MUX[2] ins_0287_ VDD VSS sg13g2_nand2_1
Xins_1250_ ins_0309_ MID_MUX[2] ins_0287_ VDD VSS sg13g2_xor2_1
Xins_1251_ ins_0320_ MID_MUX[3] ins_0309_ VDD VSS sg13g2_nand2_1
Xins_1252_ ins_0331_ ins_0034_ ins_0309_ VDD VSS sg13g2_xnor2_1
Xins_1253_ ins_0342_ MID_MUX[4] ins_0331_ VDD VSS sg13g2_xnor2_1
Xins_1254_ ins_0345_ ins_0023_ ins_0342_ VDD VSS sg13g2_nor2_1
Xins_1255_ ins_0347_ ins_0023_ ins_0342_ VDD VSS sg13g2_xnor2_1
Xins_1256_ ins_0348_ ins_0012_ ins_0347_ VDD VSS sg13g2_or2_1
Xins_1257_ ins_0349_ MID_MUX[6] ins_0347_ VDD VSS sg13g2_xnor2_1
Xins_1258_ ins_0350_ ins_0349_ VDD VSS sg13g2_inv_1
Xins_1259_ ins_0351_ MID_MUX[7] ins_0349_ VDD VSS sg13g2_nand2_1
Xins_1260_ ins_0352_ MID_MUX[7] ins_0349_ VDD VSS sg13g2_xnor2_1
Xins_1261_ ins_0353_ ins_0352_ VDD VSS sg13g2_inv_1
Xins_1262_ ins_0354_ MID_MUX[8] ins_0353_ VDD VSS sg13g2_nand2_1
Xins_1263_ ins_0355_ MID_MUX[8] ins_0352_ VDD VSS sg13g2_xnor2_1
Xins_1264_ ins_0356_ MID_MUX[9] ins_0355_ VDD VSS sg13g2_nand2_1
Xins_1265_ ins_0357_ MID_MUX[9] ins_0355_ VDD VSS sg13g2_xor2_1
Xins_1266_ ins_0358_ MID_MUX[10] ins_0357_ VDD VSS sg13g2_xnor2_1
Xins_1267_ ins_0359_ ins_0001_ ins_0358_ VDD VSS sg13g2_nor2_1
Xins_1268_ ins_0360_ MID_MUX[10] ins_0357_ ins_0359_ VDD VSS
+ sg13g2_a21oi_1
Xins_1269_ ins_0361_ MID_MUX[4] ins_0331_ ins_0345_ VDD VSS
+ sg13g2_a21oi_1
Xins_1270_ ins_0362_ COARSE_MUX[0] COARSE_MUX[1] VDD VSS sg13g2_nand2_1
Xins_1271_ ins_0363_ COARSE_MUX[0] COARSE_MUX[2] COARSE_MUX[1]
+ VDD VSS sg13g2_and3_1
Xins_1272_ ins_0364_ COARSE_MUX[0] COARSE_MUX[2] COARSE_MUX[1]
+ VDD VSS sg13g2_nand3_1
Xins_1273_ ins_0365_ COARSE_MUX[0] COARSE_MUX[2] COARSE_MUX[1]
+ VDD VSS sg13g2_nor3_1
Xins_1274_ ins_0366_ COARSE_MUX[0] COARSE_MUX[1] COARSE_MUX[2]
+ VDD VSS sg13g2_o21ai_1
Xins_1275_ ins_0367_ ins_0362_ ins_0366_ VDD VSS sg13g2_nand2_1
Xins_1276_ ins_0368_ ins_0362_ ins_0366_ ins_0363_ VDD VSS
+ sg13g2_a21oi_1
Xins_1277_ ins_0369_ ins_0067_ ins_0365_ ins_0368_ VDD VSS
+ sg13g2_or3_1
Xins_1278_ ins_0370_ ins_0365_ ins_0368_ ins_0067_ VDD VSS
+ sg13g2_o21ai_1
Xins_1279_ ins_0371_ ins_0369_ ins_0370_ COARSE_MUX[4] VDD
+ VSS sg13g2_a21o_1
Xins_1280_ ins_0372_ COARSE_MUX[4] ins_0369_ ins_0370_ VDD
+ VSS sg13g2_nand3_1
Xins_1281_ ins_0373_ COARSE_MUX[5] ins_0371_ ins_0372_ VDD
+ VSS sg13g2_nand3_1
Xins_1282_ ins_0374_ ins_0371_ ins_0372_ COARSE_MUX[5] VDD
+ VSS sg13g2_a21o_1
Xins_1283_ ins_0375_ COARSE_MUX[6] ins_0373_ ins_0374_ VDD
+ VSS sg13g2_and3_1
Xins_1284_ ins_0376_ ins_0373_ ins_0374_ COARSE_MUX[6] VDD
+ VSS sg13g2_a21oi_1
Xins_1285_ ins_0377_ ins_0056_ ins_0375_ ins_0376_ VDD VSS
+ sg13g2_or3_1
Xins_1286_ ins_0378_ ins_0375_ ins_0376_ ins_0056_ VDD VSS
+ sg13g2_o21ai_1
Xins_1287_ ins_0379_ ins_0377_ ins_0378_ COARSE_MUX[8] VDD
+ VSS sg13g2_a21oi_1
Xins_1288_ ins_0380_ ins_0377_ ins_0378_ COARSE_MUX[8] VDD
+ VSS sg13g2_a21o_1
Xins_1289_ ins_0381_ COARSE_MUX[8] ins_0377_ ins_0378_ VDD
+ VSS sg13g2_nand3_1
Xins_1290_ ins_0382_ ins_0380_ ins_0381_ ins_0045_ VDD VSS
+ sg13g2_a21oi_1
Xins_1291_ ins_0383_ ins_0045_ ins_0380_ ins_0381_ VDD VSS
+ sg13g2_and3_1
Xins_1292_ ins_0384_ ins_0045_ ins_0379_ ins_0381_ VDD VSS
+ sg13g2_o21ai_1
Xins_1293_ ins_0385_ ins_0382_ ins_0383_ COARSE_MUX[10] VDD
+ VSS sg13g2_o21ai_1
Xins_1294_ ins_0386_ COARSE_MUX[10] ins_0382_ ins_0383_ VDD
+ VSS sg13g2_or3_1
Xins_1295_ ins_0387_ COARSE_MUX[11] ins_0385_ ins_0386_ VDD
+ VSS sg13g2_and3_1
Xins_1296_ ins_0388_ COARSE_MUX[11] ins_0385_ ins_0386_ VDD
+ VSS sg13g2_nand3_1
Xins_1297_ ins_0389_ ins_0385_ ins_0386_ COARSE_MUX[11] VDD
+ VSS sg13g2_a21o_1
Xins_1298_ ins_0390_ COARSE_MUX[12] ins_0388_ ins_0389_ VDD
+ VSS sg13g2_nand3_1
Xins_1299_ ins_0391_ ins_0388_ ins_0389_ COARSE_MUX[12] VDD
+ VSS sg13g2_a21o_1
Xins_1300_ ins_0392_ ins_0391_ VDD VSS sg13g2_inv_1
Xins_1301_ ins_0393_ COARSE_MUX[13] ins_0390_ ins_0391_ VDD
+ VSS sg13g2_nand3_1
Xins_1302_ ins_0394_ ins_0390_ ins_0391_ COARSE_MUX[13] VDD
+ VSS sg13g2_a21o_1
Xins_1303_ ins_0395_ COARSE_MUX[14] ins_0393_ ins_0394_ VDD
+ VSS sg13g2_nand3_1
Xins_1304_ ins_0396_ ins_0393_ ins_0394_ COARSE_MUX[14] VDD
+ VSS sg13g2_a21o_1
Xins_1305_ ins_0397_ ins_0276_ ins_0395_ ins_0396_ VDD VSS
+ sg13g2_and3_1
Xins_1306_ ins_0398_ ins_0395_ ins_0396_ ins_0276_ VDD VSS
+ sg13g2_a21oi_1
Xins_1307_ ins_0399_ ins_0397_ ins_0398_ VDD VSS sg13g2_nor2_1
Xins_1308_ ins_0400_ ins_0397_ ins_0398_ VDD VSS sg13g2_or2_1
Xins_1309_ ins_0401_ ins_0298_ ins_0320_ VDD VSS sg13g2_nand2_1
Xins_1310_ ins_0402_ ins_0287_ ins_0399_ VDD VSS sg13g2_nand2_1
Xins_1311_ ins_0403_ ins_0298_ ins_0397_ ins_0398_ VDD VSS
+ sg13g2_nor3_1
Xins_1312_ ins_0404_ ins_0309_ ins_0399_ VDD VSS sg13g2_nand2_1
Xins_1313_ ins_0405_ ins_0320_ ins_0400_ VDD VSS sg13g2_nor2_1
Xins_1314_ ins_0406_ ins_0399_ ins_0401_ VDD VSS sg13g2_xnor2_1
Xins_1315_ ins_0407_ ins_0361_ ins_0406_ VDD VSS sg13g2_xor2_1
Xins_1316_ ins_0408_ ins_0348_ ins_0351_ VDD VSS sg13g2_and2_1
Xins_1317_ ins_0409_ ins_0408_ ins_0407_ VDD VSS sg13g2_nand2b_1
Xins_1318_ ins_0410_ ins_0407_ ins_0408_ VDD VSS sg13g2_xor2_1
Xins_1319_ ins_0411_ ins_0354_ ins_0356_ VDD VSS sg13g2_nand2_1
Xins_1320_ ins_0412_ ins_0410_ ins_0411_ VDD VSS sg13g2_xnor2_1
Xins_1321_ ins_0413_ ins_0367_ ins_0369_ VDD VSS sg13g2_nand2b_1
Xins_1322_ ins_0414_ ins_0067_ ins_0364_ ins_0413_ VDD VSS
+ sg13g2_o21ai_1
Xins_1323_ ins_0415_ ins_0373_ ins_0414_ VDD VSS sg13g2_nor2_1
Xins_1324_ ins_0416_ COARSE_MUX[4] ins_0367_ ins_0369_ ins_0370_
+ VDD VSS sg13g2_nand4_1
Xins_1325_ ins_0417_ ins_0367_ ins_0414_ ins_0372_ VDD VSS
+ sg13g2_mux2_1
Xins_1326_ ins_0418_ ins_0373_ ins_0417_ ins_0415_ VDD VSS
+ sg13g2_a21oi_1
Xins_1327_ ins_0419_ ins_0375_ ins_0418_ VDD VSS sg13g2_nand2_1
Xins_1328_ ins_0420_ ins_0375_ ins_0418_ VDD VSS sg13g2_xor2_1
Xins_1329_ ins_0421_ ins_0377_ ins_0418_ VDD VSS sg13g2_nand2b_1
Xins_1330_ ins_0422_ ins_0377_ ins_0420_ VDD VSS sg13g2_xnor2_1
Xins_1331_ ins_0423_ ins_0384_ ins_0422_ VDD VSS sg13g2_nand2_1
Xins_1332_ ins_0424_ ins_0384_ ins_0422_ VDD VSS sg13g2_xor2_1
Xins_1333_ ins_0425_ ins_0384_ ins_0422_ VDD VSS sg13g2_xnor2_1
Xins_1334_ ins_0426_ COARSE_MUX[11] ins_0385_ ins_0386_ ins_0424_
+ VDD VSS sg13g2_and4_1
Xins_1335_ ins_0427_ ins_0387_ ins_0424_ VDD VSS sg13g2_nand2_1
Xins_1336_ ins_0428_ ins_0385_ ins_0424_ VDD VSS sg13g2_xnor2_1
Xins_1337_ ins_0429_ ins_0387_ ins_0428_ VDD VSS sg13g2_nor2_1
Xins_1338_ ins_0430_ ins_0425_ ins_0428_ ins_0388_ VDD VSS
+ sg13g2_mux2_1
Xins_1339_ ins_0431_ ins_0426_ ins_0429_ VDD VSS sg13g2_or2_1
Xins_1340_ ins_0432_ COARSE_MUX[13] ins_0390_ ins_0391_ ins_0430_
+ VDD VSS sg13g2_nand4_1
Xins_1341_ ins_0433_ COARSE_MUX[12] ins_0388_ ins_0389_ ins_0428_
+ VDD VSS sg13g2_nand4_1
Xins_1342_ ins_0434_ ins_0390_ ins_0430_ VDD VSS sg13g2_xnor2_1
Xins_1343_ ins_0435_ ins_0431_ ins_0434_ ins_0393_ VDD VSS
+ sg13g2_mux2_1
Xins_1344_ ins_0436_ COARSE_MUX[14] ins_0393_ ins_0394_ ins_0434_
+ VDD VSS sg13g2_nand4_1
Xins_1345_ ins_0437_ ins_0395_ ins_0435_ VDD VSS sg13g2_xor2_1
Xins_1346_ ins_0438_ ins_0276_ ins_0395_ ins_0396_ ins_0435_
+ VDD VSS sg13g2_nand4_1
Xins_1347_ ins_0439_ ins_0397_ ins_0437_ VDD VSS sg13g2_xor2_1
Xins_1348_ ins_0440_ ins_0298_ ins_0400_ ins_0439_ VDD VSS
+ sg13g2_nor3_1
Xins_1349_ ins_0441_ ins_0403_ ins_0439_ VDD VSS sg13g2_nand2b_1
Xins_1350_ ins_0442_ ins_0403_ ins_0439_ VDD VSS sg13g2_xor2_1
Xins_1351_ ins_0443_ ins_0405_ ins_0442_ VDD VSS sg13g2_xor2_1
Xins_1352_ ins_0444_ ins_0443_ VDD VSS sg13g2_inv_1
Xins_1353_ ins_0445_ ins_0361_ ins_0406_ ins_0409_ VDD VSS
+ sg13g2_o21ai_1
Xins_1354_ ins_0446_ ins_0406_ ins_0443_ VDD VSS sg13g2_nor2_1
Xins_1355_ ins_0447_ ins_0406_ ins_0443_ VDD VSS sg13g2_or2_1
Xins_1356_ ins_0448_ ins_0361_ ins_0447_ VDD VSS sg13g2_nor2_1
Xins_1357_ ins_0449_ ins_0407_ ins_0444_ VDD VSS sg13g2_nand2_1
Xins_1358_ ins_0450_ ins_0348_ ins_0449_ VDD VSS sg13g2_nor2_1
Xins_1359_ ins_0451_ ins_0351_ ins_0449_ VDD VSS sg13g2_nor2_1
Xins_1360_ ins_0452_ ins_0444_ ins_0445_ VDD VSS sg13g2_xnor2_1
Xins_1361_ ins_0453_ ins_0354_ ins_0410_ VDD VSS sg13g2_nor2_1
Xins_1362_ ins_0454_ ins_0352_ ins_0410_ ins_0452_ VDD VSS
+ sg13g2_nor3_1
Xins_1363_ ins_0455_ ins_0452_ ins_0453_ VDD VSS sg13g2_xnor2_1
Xins_1364_ ins_0456_ ins_0356_ ins_0410_ VDD VSS sg13g2_nor2_1
Xins_1365_ ins_0457_ ins_0455_ ins_0456_ VDD VSS sg13g2_xnor2_1
Xins_1366_ ins_0458_ ins_0412_ ins_0455_ VDD VSS sg13g2_nand2_1
Xins_1367_ ins_0459_ ins_0360_ ins_0412_ VDD VSS sg13g2_nor2b_1
Xins_1368_ ins_0460_ ins_0358_ ins_0458_ VDD VSS sg13g2_nor2_1
Xins_1369_ ins_0461_ ins_0360_ ins_0458_ VDD VSS sg13g2_nor2_1
Xins_1370_ ins_0462_ ins_0457_ ins_0459_ VDD VSS sg13g2_xnor2_1
Xins_1371_ ins_0463_ MID_MUX[11] ins_0358_ VDD VSS sg13g2_xnor2_1
Xins_1372_ ins_0464_ MID_MUX[12] ins_0463_ VDD VSS sg13g2_nand2_1
Xins_1373_ ins_0465_ ins_0360_ ins_0412_ VDD VSS sg13g2_xnor2_1
Xins_1374_ ins_0466_ ins_0360_ ins_0412_ VDD VSS sg13g2_xor2_1
Xins_1375_ ins_0467_ ins_0464_ ins_0466_ VDD VSS sg13g2_nor2_1
Xins_1376_ ins_0468_ ins_0462_ ins_0467_ VDD VSS sg13g2_xor2_1
Xins_1377_ ins_0469_ MID_MUX[12] ins_0463_ VDD VSS sg13g2_xnor2_1
Xins_1378_ ins_0470_ ins_0469_ VDD VSS sg13g2_inv_1
Xins_1379_ ins_0471_ MID_MUX[13] ins_0470_ VDD VSS sg13g2_nand2_1
Xins_1380_ ins_0472_ ins_0466_ ins_0471_ VDD VSS sg13g2_nor2_1
Xins_1381_ ins_0473_ ins_0468_ ins_0472_ VDD VSS sg13g2_xnor2_1
Xins_1382_ ins_0474_ ins_0464_ ins_0466_ VDD VSS sg13g2_xnor2_1
Xins_1383_ ins_0475_ MID_MUX[13] ins_0469_ VDD VSS sg13g2_xor2_1
Xins_1384_ ins_0476_ ins_0473_ ins_0474_ ins_0475_ VDD VSS
+ sg13g2_nor3_1
Xins_1385_ ins_0477_ ins_1207_ ins_0474_ ins_0475_ VDD VSS
+ sg13g2_nor3_1
Xins_1386_ ins_0478_ ins_0468_ ins_0472_ ins_0476_ MID_MUX[14]
+ VDD VSS sg13g2_a22oi_1
Xins_1387_ ins_0479_ COARSE_MUX[3] ins_0363_ ins_0415_ VDD
+ VSS sg13g2_a21oi_1
Xins_1388_ ins_0480_ ins_0416_ ins_0419_ ins_0479_ VDD VSS
+ sg13g2_nand3_1
Xins_1389_ ins_0481_ ins_0416_ ins_0419_ ins_0421_ ins_0479_
+ VDD VSS sg13g2_nand4_1
Xins_1390_ ins_0482_ ins_0421_ ins_0480_ VDD VSS sg13g2_xor2_1
Xins_1391_ ins_0483_ ins_0385_ ins_0425_ ins_0423_ VDD VSS
+ sg13g2_o21ai_1
Xins_1392_ ins_0484_ ins_0482_ ins_0483_ VDD VSS sg13g2_xnor2_1
Xins_1393_ ins_0485_ ins_0427_ ins_0433_ ins_0484_ VDD VSS
+ sg13g2_nand3_1
Xins_1394_ ins_0486_ ins_0427_ ins_0433_ ins_0484_ VDD VSS
+ sg13g2_a21o_1
Xins_1395_ ins_0487_ ins_0485_ ins_0486_ VDD VSS sg13g2_and2_1
Xins_1396_ ins_0488_ ins_0432_ ins_0485_ ins_0486_ VDD VSS
+ sg13g2_nand3b_1
Xins_1397_ ins_0489_ ins_0432_ ins_0487_ VDD VSS sg13g2_xnor2_1
Xins_1398_ ins_0490_ ins_0436_ ins_0487_ VDD VSS sg13g2_nand2b_1
Xins_1399_ ins_0491_ ins_0436_ ins_0489_ VDD VSS sg13g2_xor2_1
Xins_1400_ ins_0492_ ins_0489_ ins_0491_ ins_0438_ VDD VSS
+ sg13g2_mux2_1
Xins_1401_ ins_0493_ ins_0405_ ins_0441_ ins_0440_ VDD VSS
+ sg13g2_a21oi_1
Xins_1402_ ins_0494_ ins_0404_ ins_0442_ ins_0492_ VDD VSS
+ sg13g2_or3_1
Xins_1403_ ins_0495_ ins_0494_ VDD VSS sg13g2_inv_1
Xins_1404_ ins_0496_ ins_0492_ ins_0440_ VDD VSS sg13g2_nand2b_1
Xins_1405_ ins_0497_ ins_0492_ ins_0493_ VDD VSS sg13g2_xor2_1
Xins_1406_ ins_0498_ ins_0492_ ins_0493_ VDD VSS sg13g2_xnor2_1
Xins_1407_ ins_0499_ ins_0447_ ins_0498_ VDD VSS sg13g2_nor2_1
Xins_1408_ ins_0500_ ins_0331_ ins_0446_ ins_0497_ VDD VSS
+ sg13g2_nand3_1
Xins_1409_ ins_0501_ ins_0342_ ins_0447_ ins_0498_ VDD VSS
+ sg13g2_nor3_1
Xins_1410_ ins_0502_ MID_MUX[5] ins_0501_ VDD VSS sg13g2_nand2_1
Xins_1411_ ins_0503_ ins_0448_ ins_0497_ VDD VSS sg13g2_xnor2_1
Xins_1412_ ins_0504_ ins_0450_ ins_0503_ VDD VSS sg13g2_xor2_1
Xins_1413_ ins_0505_ ins_0350_ ins_0449_ ins_0504_ VDD VSS
+ sg13g2_or3_1
Xins_1414_ ins_0506_ ins_0451_ ins_0504_ VDD VSS sg13g2_xnor2_1
Xins_1415_ ins_0507_ MID_MUX[8] ins_0454_ ins_0455_ ins_0456_
+ VDD VSS sg13g2_a22oi_1
Xins_1416_ ins_0508_ ins_0506_ ins_0507_ VDD VSS sg13g2_xnor2_1
Xins_1417_ ins_0509_ ins_0462_ ins_0467_ ins_0461_ VDD VSS
+ sg13g2_a21oi_1
Xins_1418_ ins_0510_ ins_0508_ ins_0509_ VDD VSS sg13g2_xnor2_1
Xins_1419_ ins_0511_ ins_0478_ ins_0510_ VDD VSS sg13g2_xnor2_1
Xins_1420_ ins_0512_ ins_0473_ ins_0477_ VDD VSS sg13g2_xor2_1
Xins_1421_ ins_0513_ FINE_MUX[0] ins_0512_ VDD VSS sg13g2_nand2_1
Xins_1422_ ins_0514_ FINE_MUX[0] ins_0512_ VDD VSS sg13g2_xor2_1
Xins_1423_ ins_0515_ FINE_MUX[1] ins_0514_ VDD VSS sg13g2_nand2_1
Xins_1424_ ins_0516_ ins_0511_ ins_0515_ VDD VSS sg13g2_or2_1
Xins_1425_ ins_0517_ ins_0516_ VDD VSS sg13g2_inv_1
Xins_1426_ ins_0518_ ins_0347_ ins_0449_ ins_0503_ VDD VSS
+ sg13g2_or3_1
Xins_1427_ ins_0519_ ins_0518_ VDD VSS sg13g2_inv_1
Xins_1428_ ins_0520_ MID_MUX[6] ins_0518_ VDD VSS sg13g2_nand2_1
Xins_1429_ ins_0521_ MID_MUX[3] ins_0494_ VDD VSS sg13g2_nand2_1
Xins_1430_ ins_0522_ ins_0437_ ins_0489_ VDD VSS sg13g2_nor2b_1
Xins_1431_ ins_0523_ ins_0384_ ins_0422_ ins_0481_ VDD VSS
+ sg13g2_a21oi_1
Xins_1432_ ins_0524_ ins_0481_ ins_0483_ VDD VSS sg13g2_nor2_1
Xins_1433_ ins_0525_ ins_0385_ ins_0425_ ins_0523_ VDD VSS
+ sg13g2_o21ai_1
Xins_1434_ ins_0526_ ins_0385_ ins_0386_ ins_0424_ ins_0482_
+ VDD VSS sg13g2_nand4_1
Xins_1435_ ins_0527_ ins_0426_ ins_0525_ VDD VSS sg13g2_nor2_1
Xins_1436_ ins_0528_ ins_0426_ ins_0482_ ins_0525_ VDD VSS
+ sg13g2_nand3_1
Xins_1437_ ins_0529_ ins_0527_ ins_0528_ VDD VSS sg13g2_nor2b_1
Xins_1438_ ins_0530_ ins_0433_ ins_0484_ VDD VSS sg13g2_nor2_1
Xins_1439_ ins_0531_ ins_0529_ ins_0530_ VDD VSS sg13g2_xor2_1
Xins_1440_ ins_0532_ ins_0434_ ins_0485_ ins_0486_ ins_0529_
+ VDD VSS sg13g2_nand4_1
Xins_1441_ ins_0533_ COARSE_MUX[12] ins_0426_ ins_0482_ ins_0525_
+ VDD VSS sg13g2_nand4_1
Xins_1442_ ins_0534_ ins_0390_ ins_0533_ VDD VSS sg13g2_nand2_1
Xins_1443_ ins_0535_ ins_0426_ ins_0429_ ins_0484_ ins_0524_
+ VDD VSS sg13g2_or4_1
Xins_1444_ ins_0536_ ins_0534_ ins_0535_ VDD VSS sg13g2_nand2_1
Xins_1445_ ins_0537_ ins_0392_ ins_0528_ ins_0534_ ins_0535_
+ VDD VSS sg13g2_a22oi_1
Xins_1446_ ins_0538_ COARSE_MUX[13] ins_0532_ ins_0537_ VDD
+ VSS sg13g2_nand3_1
Xins_1447_ ins_0539_ COARSE_MUX[13] ins_0537_ VDD VSS sg13g2_or2_1
Xins_1448_ ins_0540_ ins_0435_ ins_0487_ ins_0531_ VDD VSS
+ sg13g2_nand3_1
Xins_1449_ ins_0541_ COARSE_MUX[14] ins_0538_ ins_0539_ ins_0540_
+ VDD VSS sg13g2_and4_1
Xins_1450_ ins_0542_ COARSE_MUX[14] ins_0538_ ins_0539_ ins_0540_
+ VDD VSS sg13g2_nand4_1
Xins_1451_ ins_0543_ ins_0538_ ins_0539_ COARSE_MUX[14] VDD
+ VSS sg13g2_a21o_1
Xins_1452_ ins_0544_ ins_0542_ ins_0543_ VDD VSS sg13g2_and2_1
Xins_1453_ ins_0545_ ins_0395_ ins_0396_ ins_0435_ ins_0489_
+ VDD VSS sg13g2_nand4_1
Xins_1454_ ins_0546_ MID_MUX[0] ins_0545_ VDD VSS sg13g2_or2_1
Xins_1455_ ins_0547_ MID_MUX[0] ins_0545_ MID_MUX[1] VDD VSS
+ sg13g2_o21ai_1
Xins_1456_ ins_0548_ ins_0488_ ins_0531_ VDD VSS sg13g2_xor2_1
Xins_1457_ ins_0549_ ins_0490_ ins_0548_ VDD VSS sg13g2_xnor2_1
Xins_1458_ ins_0550_ MID_MUX[0] ins_0549_ VDD VSS sg13g2_nand2_1
Xins_1459_ ins_0551_ MID_MUX[0] ins_0545_ ins_0549_ VDD VSS
+ sg13g2_and3_1
Xins_1460_ ins_0552_ MID_MUX[0] ins_0545_ ins_0549_ VDD VSS
+ sg13g2_nand3_1
Xins_1461_ ins_0553_ MID_MUX[0] ins_0545_ ins_0549_ VDD VSS
+ sg13g2_a21oi_1
Xins_1462_ ins_0554_ MID_MUX[0] ins_0545_ ins_0549_ VDD VSS
+ sg13g2_a21o_1
Xins_1463_ ins_0555_ ins_0551_ ins_0553_ VDD VSS sg13g2_nor2_1
Xins_1464_ ins_0556_ ins_0551_ ins_0553_ ins_0547_ VDD VSS
+ sg13g2_o21ai_1
Xins_1465_ ins_0557_ MID_MUX[1] ins_0552_ ins_0554_ VDD VSS
+ sg13g2_and3_1
Xins_1466_ ins_0558_ MID_MUX[1] ins_0552_ ins_0554_ VDD VSS
+ sg13g2_nand3_1
Xins_1467_ ins_0559_ MID_MUX[1] ins_0546_ ins_0552_ ins_0554_
+ VDD VSS sg13g2_nand4_1
Xins_1468_ ins_0560_ ins_0556_ ins_0559_ VDD VSS sg13g2_and2_1
Xins_1469_ ins_0561_ MID_MUX[2] ins_0560_ VDD VSS sg13g2_nor2_1
Xins_1470_ ins_0562_ ins_0402_ ins_0437_ ins_0492_ VDD VSS
+ sg13g2_nor3_1
Xins_1471_ ins_0563_ ins_0542_ ins_0543_ ins_0549_ MID_MUX[0]
+ VDD VSS sg13g2_a22oi_1
Xins_1472_ ins_0564_ ins_0547_ ins_0563_ VDD VSS sg13g2_nor2_1
Xins_1473_ ins_0565_ ins_0547_ ins_0551_ ins_0553_ ins_0563_
+ VDD VSS sg13g2_or4_1
Xins_1474_ ins_0566_ ins_0544_ ins_0551_ ins_0563_ VDD VSS
+ sg13g2_a21oi_1
Xins_1475_ ins_0567_ ins_0544_ ins_0551_ ins_0563_ VDD VSS
+ sg13g2_a21o_1
Xins_1476_ ins_0568_ ins_0557_ ins_0566_ ins_0565_ VDD VSS
+ sg13g2_o21ai_1
Xins_1477_ ins_0569_ MID_MUX[2] ins_0556_ ins_0559_ VDD VSS
+ sg13g2_nand3_1
Xins_1478_ ins_0570_ ins_0560_ ins_0562_ ins_0569_ ins_0496_
+ VDD VSS sg13g2_a22oi_1
Xins_1479_ ins_0571_ ins_0561_ ins_0570_ ins_0521_ VDD VSS
+ sg13g2_o21ai_1
Xins_1480_ ins_0572_ ins_0034_ ins_0561_ ins_0570_ VDD VSS
+ sg13g2_or3_1
Xins_1481_ ins_0573_ ins_0034_ ins_0495_ ins_0561_ ins_0570_
+ VDD VSS sg13g2_or4_1
Xins_1482_ ins_0574_ MID_MUX[4] ins_0500_ VDD VSS sg13g2_and2_1
Xins_1483_ ins_0575_ ins_0571_ ins_0573_ ins_0574_ VDD VSS
+ sg13g2_a21o_1
Xins_1484_ ins_0576_ MID_MUX[4] ins_0571_ ins_0573_ VDD VSS
+ sg13g2_and3_1
Xins_1485_ ins_0577_ MID_MUX[4] ins_0500_ ins_0571_ ins_0573_
+ VDD VSS sg13g2_nand4_1
Xins_1486_ ins_0578_ ins_0575_ ins_0577_ VDD VSS sg13g2_and2_1
Xins_1487_ ins_0579_ MID_MUX[5] ins_0578_ VDD VSS sg13g2_nor2_1
Xins_1488_ ins_0580_ MID_MUX[5] ins_0575_ ins_0577_ VDD VSS
+ sg13g2_nand3_1
Xins_1489_ ins_0581_ ins_0555_ ins_0564_ ins_0567_ ins_0558_
+ ins_0562_ VDD VSS sg13g2_a221oi_1
Xins_1490_ ins_0582_ ins_0569_ ins_0581_ VDD VSS sg13g2_nand2b_1
Xins_1491_ ins_0583_ ins_0581_ ins_0568_ ins_0569_ VDD VSS
+ sg13g2_mux2_1
Xins_1492_ ins_0584_ ins_0521_ ins_0561_ ins_0570_ ins_0583_
+ VDD VSS sg13g2_nor4_1
Xins_1493_ ins_0585_ ins_0572_ ins_0583_ ins_0584_ VDD VSS
+ sg13g2_a21o_1
Xins_1494_ ins_0586_ ins_0331_ ins_0499_ ins_0572_ ins_0583_
+ ins_0584_ VDD VSS sg13g2_a221oi_1
Xins_1495_ ins_0587_ ins_0576_ ins_0586_ VDD VSS sg13g2_nand2_1
Xins_1496_ ins_0588_ ins_0585_ ins_0586_ ins_0576_ VDD VSS
+ sg13g2_mux2_1
Xins_1497_ ins_0589_ ins_0501_ ins_0578_ ins_0580_ ins_0502_
+ VDD VSS sg13g2_a22oi_1
Xins_1498_ ins_0590_ ins_0579_ ins_0589_ ins_0520_ VDD VSS
+ sg13g2_o21ai_1
Xins_1499_ ins_0591_ ins_0012_ ins_0579_ ins_0589_ VDD VSS
+ sg13g2_nor3_1
Xins_1500_ ins_0592_ ins_0012_ ins_0519_ ins_0579_ ins_0589_
+ VDD VSS sg13g2_or4_1
Xins_1501_ ins_0593_ MID_MUX[7] ins_0505_ VDD VSS sg13g2_nand2_1
Xins_1502_ ins_0594_ ins_0593_ VDD VSS sg13g2_inv_1
Xins_1503_ ins_0595_ ins_0590_ ins_0592_ ins_0594_ VDD VSS
+ sg13g2_a21oi_1
Xins_1504_ ins_0596_ ins_0590_ ins_0592_ ins_0594_ VDD VSS
+ sg13g2_a21o_1
Xins_1505_ ins_0597_ MID_MUX[7] ins_0590_ ins_0592_ VDD VSS
+ sg13g2_and3_1
Xins_1506_ ins_0598_ MID_MUX[7] ins_0505_ ins_0590_ ins_0592_
+ VDD VSS sg13g2_and4_1
Xins_1507_ ins_0599_ MID_MUX[7] ins_0505_ ins_0590_ ins_0592_
+ VDD VSS sg13g2_nand4_1
Xins_1508_ ins_0600_ ins_0454_ ins_0506_ VDD VSS sg13g2_nand2_1
Xins_1509_ ins_0601_ MID_MUX[8] ins_0600_ VDD VSS sg13g2_nand2_1
Xins_1510_ ins_0602_ ins_0595_ ins_0598_ ins_0601_ VDD VSS
+ sg13g2_nor3_1
Xins_1511_ ins_0603_ MID_MUX[8] ins_0596_ ins_0599_ ins_0600_
+ VDD VSS sg13g2_nand4_1
Xins_1512_ ins_0604_ ins_0596_ ins_0599_ ins_0600_ MID_MUX[8]
+ VDD VSS sg13g2_a22oi_1
Xins_1513_ ins_0605_ ins_0595_ ins_0598_ ins_0601_ VDD VSS
+ sg13g2_o21ai_1
Xins_1514_ ins_0606_ ins_0355_ ins_0455_ ins_0506_ VDD VSS
+ sg13g2_nand3_1
Xins_1515_ ins_0607_ ins_0410_ ins_0606_ MID_MUX[9] VDD VSS
+ sg13g2_o21ai_1
Xins_1516_ ins_0608_ ins_0607_ VDD VSS sg13g2_inv_1
Xins_1517_ ins_0609_ ins_0602_ ins_0604_ ins_0607_ VDD VSS
+ sg13g2_nor3_1
Xins_1518_ ins_0610_ ins_0603_ ins_0605_ ins_0608_ VDD VSS
+ sg13g2_nand3_1
Xins_1519_ ins_0611_ ins_0603_ ins_0605_ ins_0608_ VDD VSS
+ sg13g2_a21oi_1
Xins_1520_ ins_0612_ ins_0602_ ins_0604_ ins_0607_ VDD VSS
+ sg13g2_o21ai_1
Xins_1521_ ins_0613_ ins_0357_ ins_0508_ VDD VSS sg13g2_nand2_1
Xins_1522_ ins_0614_ ins_0458_ ins_0613_ MID_MUX[10] VDD VSS
+ sg13g2_o21ai_1
Xins_1523_ ins_0615_ ins_0614_ VDD VSS sg13g2_inv_1
Xins_1524_ ins_0616_ ins_0609_ ins_0611_ ins_0614_ VDD VSS
+ sg13g2_nor3_1
Xins_1525_ ins_0617_ ins_0610_ ins_0612_ ins_0615_ VDD VSS
+ sg13g2_nand3_1
Xins_1526_ ins_0618_ ins_0610_ ins_0612_ ins_0615_ VDD VSS
+ sg13g2_a21oi_1
Xins_1527_ ins_0619_ ins_0609_ ins_0611_ ins_0614_ VDD VSS
+ sg13g2_o21ai_1
Xins_1528_ ins_0620_ ins_0460_ ins_0508_ ins_0001_ VDD VSS
+ sg13g2_a21o_1
Xins_1529_ ins_0621_ ins_0620_ VDD VSS sg13g2_inv_1
Xins_1530_ ins_0622_ ins_0616_ ins_0618_ ins_0620_ VDD VSS
+ sg13g2_nor3_1
Xins_1531_ ins_0623_ ins_0617_ ins_0619_ ins_0621_ VDD VSS
+ sg13g2_nand3_1
Xins_1532_ ins_0624_ ins_0617_ ins_0619_ ins_0621_ VDD VSS
+ sg13g2_a21oi_1
Xins_1533_ ins_0625_ ins_0616_ ins_0618_ ins_0620_ VDD VSS
+ sg13g2_o21ai_1
Xins_1534_ ins_0626_ ins_0462_ ins_0463_ ins_0465_ ins_0508_
+ VDD VSS sg13g2_nand4_1
Xins_1535_ ins_0627_ MID_MUX[12] ins_0626_ VDD VSS sg13g2_nand2_1
Xins_1536_ ins_0628_ ins_0622_ ins_0624_ ins_0627_ VDD VSS
+ sg13g2_nor3_1
Xins_1537_ ins_0629_ ins_0623_ ins_0625_ ins_0626_ MID_MUX[12]
+ VDD VSS sg13g2_a22oi_1
Xins_1538_ ins_0630_ ins_0622_ ins_0624_ ins_0627_ VDD VSS
+ sg13g2_o21ai_1
Xins_1539_ ins_0631_ ins_0462_ ins_0465_ ins_0470_ ins_0510_
+ VDD VSS sg13g2_nand4_1
Xins_1540_ ins_0632_ MID_MUX[13] ins_0631_ VDD VSS sg13g2_nand2_1
Xins_1541_ ins_0633_ ins_0632_ VDD VSS sg13g2_inv_1
Xins_1542_ ins_0634_ ins_0628_ ins_0630_ ins_0633_ VDD VSS
+ sg13g2_nand3b_1
Xins_1543_ ins_0635_ ins_0628_ ins_0629_ ins_0632_ VDD VSS
+ sg13g2_o21ai_1
Xins_1544_ ins_0636_ ins_0476_ ins_0510_ VDD VSS sg13g2_nand2_1
Xins_1545_ ins_0637_ MID_MUX[14] ins_0634_ ins_0635_ ins_0636_
+ VDD VSS sg13g2_and4_1
Xins_1546_ ins_0638_ ins_0634_ ins_0635_ ins_0636_ MID_MUX[14]
+ VDD VSS sg13g2_a22oi_1
Xins_1547_ ins_0639_ ins_0511_ ins_0513_ VDD VSS sg13g2_nor2_1
Xins_1548_ ins_0640_ ins_0639_ VDD VSS sg13g2_inv_1
Xins_1549_ ins_0641_ ins_0511_ ins_0637_ ins_0638_ VDD VSS
+ sg13g2_nor3_1
Xins_1550_ ins_0642_ ins_0637_ ins_0638_ ins_0640_ VDD VSS
+ sg13g2_or3_1
Xins_1551_ ins_0643_ ins_0637_ ins_0638_ ins_0640_ VDD VSS
+ sg13g2_o21ai_1
Xins_1552_ ins_0644_ ins_0517_ ins_0642_ ins_0643_ VDD VSS
+ sg13g2_nand3_1
Xins_1553_ ins_0645_ ins_0642_ ins_0643_ ins_0517_ VDD VSS
+ sg13g2_a21o_1
Xins_1554_ ins_0646_ FINE_MUX[1] ins_0514_ VDD VSS sg13g2_xnor2_1
Xins_1555_ ins_0647_ ins_0471_ ins_0474_ ins_0472_ VDD VSS
+ sg13g2_a21o_1
Xins_1556_ ins_0648_ ins_1207_ ins_0475_ ins_0647_ VDD VSS
+ sg13g2_o21ai_1
Xins_1557_ ins_0649_ ins_0477_ ins_0648_ VDD VSS sg13g2_nand2b_1
Xins_1558_ ins_0650_ MID_MUX[14] ins_0475_ VDD VSS sg13g2_xnor2_1
Xins_1559_ ins_0651_ ins_1207_ ins_0475_ VDD VSS sg13g2_xnor2_1
Xins_1560_ ins_0652_ FINE_MUX[0] FINE_MUX[1] ins_0650_ VDD
+ VSS sg13g2_nand3_1
Xins_1561_ ins_0653_ ins_0649_ ins_0652_ FINE_MUX[2] VDD VSS
+ sg13g2_o21ai_1
Xins_1562_ ins_0654_ ins_0646_ ins_0653_ VDD VSS sg13g2_nor2_1
Xins_1563_ ins_0655_ FINE_MUX[0] FINE_MUX[1] VDD VSS sg13g2_nor2_1
Xins_1564_ ins_0656_ FINE_MUX[0] FINE_MUX[1] ins_0512_ VDD
+ VSS sg13g2_a21oi_1
Xins_1565_ ins_0657_ ins_0655_ ins_0656_ VDD VSS sg13g2_nor2_1
Xins_1566_ ins_0658_ ins_0511_ ins_0657_ VDD VSS sg13g2_xnor2_1
Xins_1567_ ins_0659_ ins_0654_ ins_0658_ VDD VSS sg13g2_and2_1
Xins_1568_ ins_0660_ ins_0644_ ins_0645_ ins_0659_ VDD VSS
+ sg13g2_and3_1
Xins_1569_ ins_0661_ ins_0644_ ins_0645_ ins_0659_ VDD VSS
+ sg13g2_nand3_1
Xins_1570_ ins_0662_ ins_0644_ ins_0645_ ins_0659_ VDD VSS
+ sg13g2_a21o_1
Xins_1571_ ins_0663_ FINE_MUX[2] FINE_MUX[0] FINE_MUX[1] VDD
+ VSS sg13g2_nand3_1
Xins_1572_ ins_0664_ FINE_MUX[0] FINE_MUX[1] FINE_MUX[2] VDD
+ VSS sg13g2_a21oi_1
Xins_1573_ ins_0665_ ins_0655_ ins_0664_ VDD VSS sg13g2_nor2_1
Xins_1574_ ins_0666_ ins_0663_ ins_0665_ VDD VSS sg13g2_nand2_1
Xins_1575_ ins_0667_ ins_0651_ ins_0666_ VDD VSS sg13g2_or2_1
Xins_1576_ ins_0668_ ins_0649_ ins_0667_ FINE_MUX[3] VDD VSS
+ sg13g2_o21ai_1
Xins_1577_ ins_0669_ ins_0646_ ins_0653_ VDD VSS sg13g2_xor2_1
Xins_1578_ ins_0670_ ins_0668_ ins_0669_ VDD VSS sg13g2_nor2b_1
Xins_1579_ ins_0671_ ins_0658_ ins_0670_ VDD VSS sg13g2_nand2_1
Xins_1580_ ins_0672_ ins_0671_ VDD VSS sg13g2_inv_1
Xins_1581_ ins_0673_ ins_0661_ ins_0662_ ins_0672_ VDD VSS
+ sg13g2_nand3_1
Xins_1582_ ins_0674_ ins_0661_ ins_0662_ ins_0672_ VDD VSS
+ sg13g2_a21o_1
Xins_1583_ ins_0675_ ins_0668_ ins_0669_ VDD VSS sg13g2_xnor2_1
Xins_1584_ ins_0676_ FINE_MUX[2] ins_0655_ VDD VSS sg13g2_nand2b_1
Xins_1585_ ins_0677_ ins_0666_ ins_0676_ VDD VSS sg13g2_nand2_1
Xins_1586_ ins_0678_ FINE_MUX[3] ins_0676_ ins_0677_ VDD VSS
+ sg13g2_nand3_1
Xins_1587_ ins_0679_ ins_0663_ ins_0678_ VDD VSS sg13g2_and2_1
Xins_1588_ ins_0680_ ins_0651_ ins_0679_ VDD VSS sg13g2_nor2_1
Xins_1589_ ins_0681_ ins_0649_ ins_0680_ VDD VSS sg13g2_xnor2_1
Xins_1590_ ins_0682_ FINE_MUX[3] ins_0676_ VDD VSS sg13g2_nor2_1
Xins_1591_ ins_0683_ ins_0682_ ins_0679_ VDD VSS sg13g2_nor2b_1
Xins_1592_ ins_0684_ ins_0651_ ins_0679_ VDD VSS sg13g2_xnor2_1
Xins_1593_ ins_0685_ ins_0650_ ins_0683_ VDD VSS sg13g2_and2_1
Xins_1594_ ins_0686_ FINE_MUX[3] ins_0677_ VDD VSS sg13g2_xor2_1
Xins_1595_ ins_0687_ ins_0681_ ins_0685_ ins_0686_ VDD VSS
+ sg13g2_nand3_1
Xins_1596_ ins_0688_ FINE_MUX[4] ins_0687_ VDD VSS sg13g2_nand2_1
Xins_1597_ ins_0689_ FINE_MUX[4] ins_0675_ ins_0687_ VDD VSS
+ sg13g2_and3_1
Xins_1598_ ins_0690_ ins_0654_ ins_0658_ ins_0670_ VDD VSS
+ sg13g2_nor3_1
Xins_1599_ ins_0691_ ins_0659_ ins_0672_ ins_0690_ VDD VSS
+ sg13g2_nor3_1
Xins_1600_ ins_0692_ ins_0689_ ins_0691_ VDD VSS sg13g2_and2_1
Xins_1601_ ins_0693_ ins_0673_ ins_0674_ ins_0692_ VDD VSS
+ sg13g2_nand3_1
Xins_1602_ ins_0694_ ins_0673_ ins_0674_ ins_0692_ VDD VSS
+ sg13g2_a21o_1
Xins_1603_ ins_0695_ FINE_MUX[4] ins_0686_ VDD VSS sg13g2_and2_1
Xins_1604_ ins_0696_ FINE_MUX[4] ins_0686_ VDD VSS sg13g2_xor2_1
Xins_1605_ ins_0697_ ins_0681_ ins_0685_ ins_0696_ VDD VSS
+ sg13g2_nand3_1
Xins_1606_ ins_0698_ FINE_MUX[5] ins_0697_ VDD VSS sg13g2_nand2_1
Xins_1607_ ins_0699_ ins_0675_ ins_0688_ VDD VSS sg13g2_xnor2_1
Xins_1608_ ins_0700_ ins_0698_ ins_0699_ VDD VSS sg13g2_nor2b_1
Xins_1609_ ins_0701_ ins_0691_ ins_0700_ VDD VSS sg13g2_and2_1
Xins_1610_ ins_0702_ ins_0693_ ins_0694_ ins_0701_ VDD VSS
+ sg13g2_nand3_1
Xins_1611_ ins_0703_ ins_0693_ ins_0694_ ins_0701_ VDD VSS
+ sg13g2_a21o_1
Xins_1612_ ins_0704_ ins_0698_ ins_0699_ VDD VSS sg13g2_xnor2_1
Xins_1613_ ins_0705_ FINE_MUX[5] ins_0696_ ins_0695_ VDD VSS
+ sg13g2_a21oi_1
Xins_1614_ ins_0706_ ins_0705_ ins_0683_ VDD VSS sg13g2_nor2b_1
Xins_1615_ ins_0707_ ins_0684_ ins_0706_ VDD VSS sg13g2_nor2b_1
Xins_1616_ ins_0708_ ins_0681_ ins_0707_ VDD VSS sg13g2_xnor2_1
Xins_1617_ ins_0709_ ins_0683_ ins_0705_ VDD VSS sg13g2_xnor2_1
Xins_1618_ ins_0710_ ins_0684_ ins_0709_ VDD VSS sg13g2_nor2b_1
Xins_1619_ ins_0711_ FINE_MUX[5] ins_0696_ VDD VSS sg13g2_xor2_1
Xins_1620_ ins_0712_ ins_0708_ ins_0710_ ins_0711_ VDD VSS
+ sg13g2_nand3b_1
Xins_1621_ ins_0713_ FINE_MUX[6] ins_0712_ VDD VSS sg13g2_nand2_1
Xins_1622_ ins_0714_ FINE_MUX[6] ins_0704_ ins_0712_ VDD VSS
+ sg13g2_and3_1
Xins_1623_ ins_0715_ ins_0689_ ins_0691_ ins_0700_ VDD VSS
+ sg13g2_nor3_1
Xins_1624_ ins_0716_ ins_0692_ ins_0701_ ins_0715_ VDD VSS
+ sg13g2_nor3_1
Xins_1625_ ins_0717_ ins_0702_ ins_0703_ ins_0714_ ins_0716_
+ VDD VSS sg13g2_and4_1
Xins_1626_ ins_0718_ ins_0702_ ins_0703_ ins_0714_ ins_0716_
+ VDD VSS sg13g2_a22oi_1
Xins_1627_ ins_0719_ ins_0704_ ins_0713_ VDD VSS sg13g2_xor2_1
Xins_1628_ ins_0720_ FINE_MUX[6] ins_0711_ VDD VSS sg13g2_and2_1
Xins_1629_ ins_0721_ ins_0710_ ins_0720_ VDD VSS sg13g2_nand2_1
Xins_1630_ ins_0722_ ins_0708_ ins_0721_ VDD VSS sg13g2_xnor2_1
Xins_1631_ ins_0723_ FINE_MUX[6] ins_0711_ VDD VSS sg13g2_xor2_1
Xins_1632_ ins_0724_ ins_0710_ ins_0723_ VDD VSS sg13g2_nand2_1
Xins_1633_ ins_0725_ ins_0722_ ins_0724_ FINE_MUX[7] VDD VSS
+ sg13g2_o21ai_1
Xins_1634_ ins_0726_ ins_0719_ ins_0725_ VDD VSS sg13g2_nor2_1
Xins_1635_ ins_0727_ ins_0716_ ins_0726_ VDD VSS sg13g2_nand2_1
Xins_1636_ ins_0728_ ins_0717_ ins_0718_ ins_0727_ VDD VSS
+ sg13g2_nor3_1
Xins_1637_ ins_0729_ ins_0717_ ins_0718_ ins_0727_ VDD VSS
+ sg13g2_or3_1
Xins_1638_ ins_0730_ ins_0717_ ins_0718_ ins_0727_ VDD VSS
+ sg13g2_o21ai_1
Xins_1639_ ins_0731_ ins_0719_ ins_0725_ VDD VSS sg13g2_xor2_1
Xins_1640_ ins_0732_ FINE_MUX[7] ins_0723_ VDD VSS sg13g2_and2_1
Xins_1641_ ins_0733_ ins_0709_ ins_0732_ VDD VSS sg13g2_nand2_1
Xins_1642_ ins_0734_ ins_0709_ ins_0720_ ins_0706_ VDD VSS
+ sg13g2_a21oi_1
Xins_1643_ ins_0735_ ins_0684_ ins_0734_ VDD VSS sg13g2_xnor2_1
Xins_1644_ ins_0736_ ins_0733_ ins_0735_ VDD VSS sg13g2_nor2_1
Xins_1645_ ins_0737_ ins_0708_ ins_0736_ VDD VSS sg13g2_nand2_1
Xins_1646_ ins_0738_ ins_0722_ ins_0736_ ins_0737_ VDD VSS
+ sg13g2_o21ai_1
Xins_1647_ ins_0739_ FINE_MUX[7] ins_0723_ VDD VSS sg13g2_xnor2_1
Xins_1648_ ins_0740_ ins_0720_ ins_0732_ VDD VSS sg13g2_nor2_1
Xins_1649_ ins_0741_ ins_0709_ ins_0740_ VDD VSS sg13g2_xor2_1
Xins_1650_ ins_0742_ ins_0739_ ins_0741_ VDD VSS sg13g2_nor2_1
Xins_1651_ ins_0743_ ins_0733_ ins_0735_ VDD VSS sg13g2_xor2_1
Xins_1652_ ins_0744_ ins_0738_ ins_0742_ ins_0743_ VDD VSS
+ sg13g2_nand3_1
Xins_1653_ ins_0745_ FINE_MUX[8] ins_0744_ VDD VSS sg13g2_nand2_1
Xins_1654_ ins_0746_ FINE_MUX[8] ins_0731_ ins_0744_ VDD VSS
+ sg13g2_and3_1
Xins_1655_ ins_0747_ ins_0714_ ins_0726_ VDD VSS sg13g2_nor2_1
Xins_1656_ ins_0748_ ins_0716_ ins_0747_ VDD VSS sg13g2_xnor2_1
Xins_1657_ ins_0749_ ins_0746_ ins_0748_ VDD VSS sg13g2_and2_1
Xins_1658_ ins_0750_ ins_0729_ ins_0730_ ins_0749_ VDD VSS
+ sg13g2_and3_1
Xins_1659_ ins_0751_ ins_0729_ ins_0730_ ins_0749_ VDD VSS
+ sg13g2_nand3_1
Xins_1660_ ins_0752_ ins_0501_ ins_0580_ ins_0588_ VDD VSS
+ sg13g2_nor3_1
Xins_1661_ ins_0753_ ins_0580_ ins_0588_ VDD VSS sg13g2_and2_1
Xins_1662_ ins_0754_ ins_0752_ ins_0753_ VDD VSS sg13g2_or2_1
Xins_1663_ ins_0755_ ins_0519_ ins_0752_ ins_0753_ VDD VSS
+ sg13g2_nor3_1
Xins_1664_ ins_0756_ ins_0591_ ins_0755_ VDD VSS sg13g2_nand2_1
Xins_1665_ ins_0757_ ins_0754_ ins_0755_ ins_0591_ VDD VSS
+ sg13g2_mux2_1
Xins_1666_ ins_0758_ ins_0757_ ins_0505_ ins_0597_ VDD VSS
+ sg13g2_nand3b_1
Xins_1667_ ins_0759_ ins_0597_ ins_0757_ VDD VSS sg13g2_nor2b_1
Xins_1668_ ins_0760_ ins_0597_ ins_0757_ VDD VSS sg13g2_nand2b_1
Xins_1669_ ins_0761_ ins_0758_ ins_0760_ VDD VSS sg13g2_nand2_1
Xins_1670_ ins_0762_ ins_0604_ ins_0607_ ins_0603_ VDD VSS
+ sg13g2_o21ai_1
Xins_1671_ ins_0763_ ins_0610_ ins_0761_ VDD VSS sg13g2_nor2_1
Xins_1672_ ins_0764_ ins_0761_ ins_0762_ VDD VSS sg13g2_xnor2_1
Xins_1673_ ins_0765_ ins_0619_ ins_0621_ ins_0616_ VDD VSS
+ sg13g2_a21oi_1
Xins_1674_ ins_0766_ ins_0622_ ins_0764_ VDD VSS sg13g2_nand2_1
Xins_1675_ ins_0767_ ins_0616_ ins_0764_ VDD VSS sg13g2_nand2_1
Xins_1676_ ins_0768_ ins_0764_ ins_0765_ VDD VSS sg13g2_xnor2_1
Xins_1677_ ins_0769_ ins_0630_ ins_0633_ ins_0628_ VDD VSS
+ sg13g2_a21oi_1
Xins_1678_ ins_0770_ ins_0634_ ins_0768_ VDD VSS sg13g2_nand2b_1
Xins_1679_ ins_0771_ ins_0628_ ins_0768_ VDD VSS sg13g2_nand2_1
Xins_1680_ ins_0772_ ins_0768_ ins_0769_ VDD VSS sg13g2_xnor2_1
Xins_1681_ ins_0773_ ins_0637_ ins_0772_ VDD VSS sg13g2_nand2_1
Xins_1682_ ins_0774_ ins_0637_ ins_0772_ VDD VSS sg13g2_xnor2_1
Xins_1683_ ins_0775_ ins_0512_ ins_0641_ ins_0772_ VDD VSS
+ sg13g2_and3_1
Xins_1684_ ins_0776_ ins_0642_ ins_0774_ ins_0775_ FINE_MUX[0]
+ VDD VSS sg13g2_a22oi_1
Xins_1685_ ins_0777_ ins_0644_ ins_0776_ VDD VSS sg13g2_nor2b_1
Xins_1686_ ins_0778_ ins_0644_ ins_0776_ VDD VSS sg13g2_xnor2_1
Xins_1687_ ins_0779_ ins_0660_ ins_0778_ VDD VSS sg13g2_nand2_1
Xins_1688_ ins_0780_ ins_0660_ ins_0778_ VDD VSS sg13g2_xnor2_1
Xins_1689_ ins_0781_ ins_0673_ ins_0693_ ins_0780_ VDD VSS
+ sg13g2_and3_1
Xins_1690_ ins_0782_ ins_0673_ ins_0780_ VDD VSS sg13g2_nor2_1
Xins_1691_ ins_0783_ ins_0693_ ins_0780_ VDD VSS sg13g2_nor2_1
Xins_1692_ ins_0784_ ins_0783_ VDD VSS sg13g2_inv_1
Xins_1693_ ins_0785_ ins_0781_ ins_0782_ ins_0783_ VDD VSS
+ sg13g2_nor3_1
Xins_1694_ ins_0786_ ins_0702_ ins_0785_ VDD VSS sg13g2_nand2b_1
Xins_1695_ ins_0787_ ins_0702_ ins_0785_ VDD VSS sg13g2_xnor2_1
Xins_1696_ ins_0788_ ins_0717_ ins_0728_ ins_0787_ VDD VSS
+ sg13g2_or3_1
Xins_1697_ ins_0789_ ins_0717_ ins_0787_ VDD VSS sg13g2_nand2_1
Xins_1698_ ins_0790_ ins_0728_ ins_0787_ VDD VSS sg13g2_nand2_1
Xins_1699_ ins_0791_ ins_0788_ ins_0789_ ins_0790_ VDD VSS
+ sg13g2_nand3_1
Xins_1700_ ins_0792_ ins_0751_ ins_0791_ VDD VSS sg13g2_nor2_1
Xins_1701_ ins_0793_ ins_0524_ ins_0526_ ins_0426_ VDD VSS
+ sg13g2_o21ai_1
Xins_1702_ ins_0794_ ins_0429_ ins_0793_ VDD VSS sg13g2_nor2b_1
Xins_1703_ ins_0795_ ins_0536_ ins_0794_ VDD VSS sg13g2_nand2b_1
Xins_1704_ ins_0796_ ins_0536_ ins_0794_ VDD VSS sg13g2_xnor2_1
Xins_1705_ ins_0797_ ins_0538_ ins_0796_ VDD VSS sg13g2_nor2b_1
Xins_1706_ ins_0798_ ins_0538_ ins_0796_ VDD VSS sg13g2_nand2b_1
Xins_1707_ ins_0799_ ins_0538_ ins_0796_ VDD VSS sg13g2_xnor2_1
Xins_1708_ ins_0800_ ins_0541_ ins_0799_ VDD VSS sg13g2_and2_1
Xins_1709_ ins_0801_ ins_0800_ VDD VSS sg13g2_inv_1
Xins_1710_ ins_0802_ ins_0541_ ins_0799_ VDD VSS sg13g2_xnor2_1
Xins_1711_ ins_0803_ ins_0802_ VDD VSS sg13g2_inv_1
Xins_1712_ ins_0804_ ins_0544_ ins_0551_ ins_0803_ VDD VSS
+ sg13g2_a21oi_1
Xins_1713_ ins_0805_ ins_0426_ ins_0524_ ins_0793_ ins_0484_
+ VDD VSS sg13g2_a22oi_1
Xins_1714_ ins_0806_ ins_0795_ ins_0798_ VDD VSS sg13g2_nand2_1
Xins_1715_ ins_0807_ ins_0805_ ins_0806_ VDD VSS sg13g2_xnor2_1
Xins_1716_ ins_0808_ ins_0522_ ins_0802_ ins_0807_ VDD VSS
+ sg13g2_nor3_1
Xins_1717_ ins_0809_ MID_MUX[0] ins_0808_ ins_0804_ VDD VSS
+ sg13g2_a21o_1
Xins_1718_ ins_0810_ ins_0565_ ins_0809_ VDD VSS sg13g2_nor2_1
Xins_1719_ ins_0811_ ins_0565_ ins_0809_ VDD VSS sg13g2_xor2_1
Xins_1720_ ins_0812_ ins_0582_ ins_0811_ VDD VSS sg13g2_nand2b_1
Xins_1721_ ins_0813_ ins_0582_ ins_0811_ VDD VSS sg13g2_xnor2_1
Xins_1722_ ins_0814_ ins_0584_ ins_0813_ VDD VSS sg13g2_nand2_1
Xins_1723_ ins_0815_ ins_0584_ ins_0813_ VDD VSS sg13g2_xnor2_1
Xins_1724_ ins_0816_ ins_0587_ ins_0815_ VDD VSS sg13g2_xor2_1
Xins_1725_ ins_0817_ ins_0752_ ins_0816_ VDD VSS sg13g2_nand2_1
Xins_1726_ ins_0818_ ins_0752_ ins_0816_ VDD VSS sg13g2_xnor2_1
Xins_1727_ ins_0819_ ins_0591_ ins_0755_ ins_0816_ VDD VSS
+ sg13g2_nand3_1
Xins_1728_ ins_0820_ ins_0756_ ins_0818_ VDD VSS sg13g2_xnor2_1
Xins_1729_ ins_0821_ ins_0603_ ins_0759_ ins_0758_ VDD VSS
+ sg13g2_o21ai_1
Xins_1730_ ins_0822_ ins_0820_ ins_0821_ VDD VSS sg13g2_xnor2_1
Xins_1731_ ins_0823_ ins_0763_ ins_0822_ VDD VSS sg13g2_and2_1
Xins_1732_ ins_0824_ ins_0763_ ins_0822_ VDD VSS sg13g2_xnor2_1
Xins_1733_ ins_0825_ ins_0767_ ins_0824_ VDD VSS sg13g2_nor2_1
Xins_1734_ ins_0826_ ins_0767_ ins_0824_ VDD VSS sg13g2_xor2_1
Xins_1735_ ins_0827_ ins_0766_ ins_0826_ VDD VSS sg13g2_nor2b_1
Xins_1736_ ins_0828_ ins_0766_ ins_0826_ VDD VSS sg13g2_xnor2_1
Xins_1737_ ins_0829_ ins_0628_ ins_0768_ ins_0826_ VDD VSS
+ sg13g2_nand3_1
Xins_1738_ ins_0830_ ins_0771_ ins_0828_ VDD VSS sg13g2_xnor2_1
Xins_1739_ ins_0831_ ins_0770_ ins_0830_ VDD VSS sg13g2_nor2b_1
Xins_1740_ ins_0832_ ins_0770_ ins_0830_ VDD VSS sg13g2_xnor2_1
Xins_1741_ ins_0833_ ins_0773_ ins_0832_ VDD VSS sg13g2_nand2b_1
Xins_1742_ ins_0834_ ins_0773_ ins_0832_ VDD VSS sg13g2_xor2_1
Xins_1743_ ins_0835_ ins_0603_ ins_0761_ ins_0820_ VDD VSS
+ sg13g2_nor3_1
Xins_1744_ ins_0836_ ins_0801_ ins_0807_ VDD VSS sg13g2_nor2_1
Xins_1745_ ins_0837_ ins_0800_ ins_0807_ VDD VSS sg13g2_xnor2_1
Xins_1746_ ins_0838_ MID_MUX[0] ins_0491_ VDD VSS sg13g2_nand2_1
Xins_1747_ ins_0839_ MID_MUX[0] ins_0837_ ins_0838_ VDD VSS
+ sg13g2_o21ai_1
Xins_1748_ ins_0840_ ins_0810_ ins_0812_ VDD VSS sg13g2_nor2b_1
Xins_1749_ ins_0841_ ins_0812_ ins_0839_ VDD VSS sg13g2_nor2_1
Xins_1750_ ins_0842_ ins_0839_ ins_0840_ VDD VSS sg13g2_xnor2_1
Xins_1751_ ins_0843_ ins_0814_ ins_0842_ VDD VSS sg13g2_nor2_1
Xins_1752_ ins_0844_ ins_0814_ ins_0842_ VDD VSS sg13g2_xor2_1
Xins_1753_ ins_0845_ ins_0587_ ins_0815_ ins_0817_ VDD VSS
+ sg13g2_o21ai_1
Xins_1754_ ins_0846_ ins_0844_ ins_0845_ VDD VSS sg13g2_nand2_1
Xins_1755_ ins_0847_ ins_0844_ ins_0845_ VDD VSS sg13g2_xor2_1
Xins_1756_ ins_0848_ ins_0758_ ins_0820_ VDD VSS sg13g2_nor2_1
Xins_1757_ ins_0849_ ins_0758_ ins_0820_ ins_0819_ VDD VSS
+ sg13g2_o21ai_1
Xins_1758_ ins_0850_ ins_0819_ ins_0847_ VDD VSS sg13g2_nand2b_1
Xins_1759_ ins_0851_ ins_0847_ ins_0848_ VDD VSS sg13g2_nand2_1
Xins_1760_ ins_0852_ ins_0847_ ins_0849_ VDD VSS sg13g2_xor2_1
Xins_1761_ ins_0853_ ins_0835_ ins_0852_ VDD VSS sg13g2_nand2_1
Xins_1762_ ins_0854_ ins_0835_ ins_0852_ VDD VSS sg13g2_xor2_1
Xins_1763_ ins_0855_ ins_0823_ ins_0854_ VDD VSS sg13g2_xnor2_1
Xins_1764_ ins_0856_ ins_0825_ ins_0855_ VDD VSS sg13g2_xnor2_1
Xins_1765_ ins_0857_ ins_0827_ ins_0856_ VDD VSS sg13g2_and2_1
Xins_1766_ ins_0858_ ins_0827_ ins_0856_ VDD VSS sg13g2_xnor2_1
Xins_1767_ ins_0859_ ins_0829_ ins_0858_ VDD VSS sg13g2_nor2_1
Xins_1768_ ins_0860_ ins_0829_ ins_0858_ VDD VSS sg13g2_xor2_1
Xins_1769_ ins_0861_ ins_0831_ ins_0860_ VDD VSS sg13g2_nand2_1
Xins_1770_ ins_0862_ ins_0831_ ins_0860_ VDD VSS sg13g2_xnor2_1
Xins_1771_ ins_0863_ ins_0833_ ins_0862_ VDD VSS sg13g2_xor2_1
Xins_1772_ ins_0864_ ins_0775_ ins_0834_ ins_0862_ VDD VSS
+ sg13g2_or3_1
Xins_1773_ ins_0865_ FINE_MUX[1] ins_0863_ ins_0864_ VDD VSS
+ sg13g2_nand3_1
Xins_1774_ ins_0866_ FINE_MUX[0] ins_0775_ ins_0834_ VDD VSS
+ sg13g2_a21oi_1
Xins_1775_ ins_0867_ ins_0777_ ins_0865_ ins_0866_ VDD VSS
+ sg13g2_mux2_1
Xins_1776_ ins_0868_ ins_0782_ ins_0867_ VDD VSS sg13g2_nand2_1
Xins_1777_ ins_0869_ ins_0779_ ins_0867_ VDD VSS sg13g2_nor2b_1
Xins_1778_ ins_0870_ ins_0779_ ins_0867_ VDD VSS sg13g2_xor2_1
Xins_1779_ ins_0871_ ins_0870_ ins_0867_ ins_0782_ VDD VSS
+ sg13g2_mux2_1
Xins_1780_ ins_0872_ ins_0784_ ins_0871_ VDD VSS sg13g2_or2_1
Xins_1781_ ins_0873_ ins_0784_ ins_0871_ VDD VSS sg13g2_and2_1
Xins_1782_ ins_0874_ ins_0783_ ins_0871_ VDD VSS sg13g2_xnor2_1
Xins_1783_ ins_0875_ ins_0786_ ins_0874_ VDD VSS sg13g2_nand2b_1
Xins_1784_ ins_0876_ ins_0786_ ins_0874_ VDD VSS sg13g2_xnor2_1
Xins_1785_ ins_0877_ ins_0789_ ins_0876_ VDD VSS sg13g2_nor2b_1
Xins_1786_ ins_0878_ ins_0789_ ins_0876_ VDD VSS sg13g2_xnor2_1
Xins_1787_ ins_0879_ ins_0790_ ins_0878_ VDD VSS sg13g2_nor2b_1
Xins_1788_ ins_0880_ ins_0790_ ins_0878_ VDD VSS sg13g2_xnor2_1
Xins_1789_ ins_0881_ ins_0792_ ins_0880_ VDD VSS sg13g2_nand2_1
Xins_1790_ ins_0882_ ins_0792_ ins_0880_ VDD VSS sg13g2_xnor2_1
Xins_1791_ ins_0883_ ins_0729_ ins_0730_ ins_0749_ VDD VSS
+ sg13g2_a21o_1
Xins_1792_ ins_0884_ ins_1196_ ins_0739_ VDD VSS sg13g2_nor2_1
Xins_1793_ ins_0885_ FINE_MUX[8] ins_0742_ ins_0743_ VDD VSS
+ sg13g2_nand3_1
Xins_1794_ ins_0886_ ins_0738_ ins_0885_ VDD VSS sg13g2_xor2_1
Xins_1795_ ins_0887_ FINE_MUX[8] ins_0739_ VDD VSS sg13g2_xnor2_1
Xins_1796_ ins_0888_ ins_0741_ ins_0887_ VDD VSS sg13g2_nor2b_1
Xins_1797_ ins_0889_ ins_0743_ ins_0888_ VDD VSS sg13g2_nand2_1
Xins_1798_ ins_0890_ ins_0886_ ins_0889_ FINE_MUX[9] VDD VSS
+ sg13g2_o21ai_1
Xins_1799_ ins_0891_ ins_0731_ ins_0745_ VDD VSS sg13g2_xor2_1
Xins_1800_ ins_0892_ ins_0890_ ins_0891_ VDD VSS sg13g2_nor2_1
Xins_1801_ ins_0893_ ins_0748_ ins_0892_ VDD VSS sg13g2_and2_1
Xins_1802_ ins_0894_ ins_0751_ ins_0883_ ins_0893_ VDD VSS
+ sg13g2_and3_1
Xins_1803_ ins_0895_ ins_0791_ ins_0894_ VDD VSS sg13g2_nand2b_1
Xins_1804_ ins_0896_ ins_0882_ ins_0895_ VDD VSS sg13g2_nor2_1
Xins_1805_ ins_0897_ ins_0882_ ins_0895_ VDD VSS sg13g2_xnor2_1
Xins_1806_ ins_0898_ ins_0890_ ins_0891_ VDD VSS sg13g2_xor2_1
Xins_1807_ ins_0899_ FINE_MUX[9] ins_0887_ ins_0884_ VDD VSS
+ sg13g2_a21oi_1
Xins_1808_ ins_0900_ FINE_MUX[9] ins_0888_ VDD VSS sg13g2_nand2_1
Xins_1809_ ins_0901_ ins_0741_ ins_0899_ VDD VSS sg13g2_xor2_1
Xins_1810_ ins_0902_ FINE_MUX[9] ins_0887_ VDD VSS sg13g2_xnor2_1
Xins_1811_ ins_0903_ ins_0886_ ins_0902_ VDD VSS sg13g2_nor2_1
Xins_1812_ ins_0904_ ins_0743_ ins_0901_ ins_0903_ VDD VSS
+ sg13g2_nand3_1
Xins_1813_ ins_0905_ FINE_MUX[10] ins_0904_ VDD VSS sg13g2_nand2_1
Xins_1814_ ins_0906_ FINE_MUX[10] ins_0898_ ins_0904_ VDD
+ VSS sg13g2_and3_1
Xins_1815_ ins_0907_ ins_0746_ ins_0748_ ins_0892_ VDD VSS
+ sg13g2_nor3_1
Xins_1816_ ins_0908_ ins_0749_ ins_0893_ ins_0907_ VDD VSS
+ sg13g2_nor3_1
Xins_1817_ ins_0909_ ins_0906_ ins_0908_ VDD VSS sg13g2_nand2_1
Xins_1818_ ins_0910_ ins_0751_ ins_0883_ ins_0893_ VDD VSS
+ sg13g2_a21oi_1
Xins_1819_ ins_0911_ ins_0751_ ins_0883_ ins_0906_ ins_0908_
+ VDD VSS sg13g2_nand4_1
Xins_1820_ ins_0912_ ins_0883_ ins_0893_ ins_0750_ VDD VSS
+ sg13g2_a21oi_1
Xins_1821_ ins_0913_ ins_0791_ ins_0912_ VDD VSS sg13g2_xor2_1
Xins_1822_ ins_0914_ ins_0911_ ins_0913_ VDD VSS sg13g2_nand2b_1
Xins_1823_ ins_0915_ ins_0911_ ins_0913_ VDD VSS sg13g2_xor2_1
Xins_1824_ ins_0916_ ins_0894_ ins_0910_ ins_0909_ VDD VSS
+ sg13g2_o21ai_1
Xins_1825_ ins_0917_ ins_0898_ ins_0905_ VDD VSS sg13g2_xor2_1
Xins_1826_ ins_0918_ ins_1185_ ins_0902_ VDD VSS sg13g2_nor2_1
Xins_1827_ ins_0919_ ins_0901_ ins_0918_ VDD VSS sg13g2_nand2_1
Xins_1828_ ins_0920_ ins_0900_ ins_0919_ VDD VSS sg13g2_nand2_1
Xins_1829_ ins_0921_ ins_0743_ ins_0920_ VDD VSS sg13g2_nand2_1
Xins_1830_ ins_0922_ ins_0886_ ins_0921_ VDD VSS sg13g2_xnor2_1
Xins_1831_ ins_0923_ FINE_MUX[10] ins_0902_ VDD VSS sg13g2_xnor2_1
Xins_1832_ ins_0924_ ins_0743_ ins_0901_ ins_0923_ VDD VSS
+ sg13g2_nand3_1
Xins_1833_ ins_0925_ ins_0922_ ins_0924_ FINE_MUX[11] VDD
+ VSS sg13g2_o21ai_1
Xins_1834_ ins_0926_ ins_0917_ ins_0925_ VDD VSS sg13g2_nor2_1
Xins_1835_ ins_0927_ ins_0908_ ins_0926_ VDD VSS sg13g2_and2_1
Xins_1836_ ins_0928_ ins_0911_ ins_0916_ ins_0927_ VDD VSS
+ sg13g2_nand3_1
Xins_1837_ ins_0929_ ins_0915_ ins_0928_ VDD VSS sg13g2_or2_1
Xins_1838_ ins_0930_ ins_0897_ ins_0929_ VDD VSS sg13g2_nor2_1
Xins_1839_ ins_0931_ ins_0786_ ins_0873_ ins_0872_ VDD VSS
+ sg13g2_o21ai_1
Xins_1840_ ins_0932_ ins_0655_ ins_0863_ VDD VSS sg13g2_nand2_1
Xins_1841_ ins_0933_ ins_0655_ ins_0834_ VDD VSS sg13g2_nand2_1
Xins_1842_ ins_0934_ ins_0676_ ins_0775_ ins_0933_ VDD VSS
+ sg13g2_nand3_1
Xins_1843_ ins_0935_ ins_0869_ ins_0932_ ins_0934_ ins_0863_
+ VDD VSS sg13g2_a22oi_1
Xins_1844_ ins_0936_ FINE_MUX[3] ins_0864_ VDD VSS sg13g2_nand2_1
Xins_1845_ ins_0937_ ins_0870_ ins_0936_ VDD VSS sg13g2_nor2_1
Xins_1846_ ins_0938_ ins_0937_ ins_0868_ ins_0935_ VDD VSS
+ sg13g2_mux2_1
Xins_1847_ ins_0939_ ins_0931_ ins_0938_ VDD VSS sg13g2_xnor2_1
Xins_1848_ ins_0940_ ins_0877_ ins_0879_ VDD VSS sg13g2_nor2_1
Xins_1849_ ins_0941_ ins_0939_ ins_0940_ VDD VSS sg13g2_xnor2_1
Xins_1850_ ins_0942_ ins_0882_ ins_0895_ ins_0881_ VDD VSS
+ sg13g2_o21ai_1
Xins_1851_ ins_0943_ ins_0941_ ins_0942_ VDD VSS sg13g2_xor2_1
Xins_1852_ ins_0944_ ins_0930_ ins_0943_ VDD VSS sg13g2_nand2_1
Xins_1853_ ins_0945_ ins_0879_ ins_0939_ VDD VSS sg13g2_nand2_1
Xins_1854_ ins_0946_ ins_0682_ ins_0775_ VDD VSS sg13g2_nor2b_1
Xins_1855_ ins_0947_ ins_0484_ ins_0795_ ins_0527_ VDD VSS
+ sg13g2_o21ai_1
Xins_1856_ ins_0948_ ins_0533_ ins_0947_ VDD VSS sg13g2_and2_1
Xins_1857_ ins_0949_ ins_0797_ ins_0805_ ins_0948_ VDD VSS
+ sg13g2_a21oi_1
Xins_1858_ ins_0950_ COARSE_MUX[13] ins_0948_ VDD VSS sg13g2_nand2_1
Xins_1859_ ins_0951_ ins_0531_ ins_0950_ VDD VSS sg13g2_nor2_1
Xins_1860_ ins_0952_ ins_0949_ ins_0951_ VDD VSS sg13g2_nor2_1
Xins_1861_ ins_0953_ COARSE_MUX[14] ins_0548_ VDD VSS sg13g2_nand2_1
Xins_1862_ ins_0954_ COARSE_MUX[14] ins_0548_ ins_0952_ VDD
+ VSS sg13g2_nand3_1
Xins_1863_ ins_0955_ ins_0836_ ins_0953_ ins_0952_ VDD VSS
+ sg13g2_mux2_1
Xins_1864_ ins_0956_ MID_MUX[0] ins_0955_ ins_0550_ VDD VSS
+ sg13g2_o21ai_1
Xins_1865_ ins_0957_ MID_MUX[1] ins_0549_ VDD VSS sg13g2_nand2_1
Xins_1866_ ins_0958_ ins_0957_ ins_0810_ ins_0956_ VDD VSS
+ sg13g2_mux2_1
Xins_1867_ ins_0959_ ins_0841_ ins_0958_ VDD VSS sg13g2_nand2_1
Xins_1868_ ins_0960_ ins_0841_ ins_0958_ VDD VSS sg13g2_xor2_1
Xins_1869_ ins_0961_ ins_0843_ ins_0960_ VDD VSS sg13g2_nand2_1
Xins_1870_ ins_0962_ ins_0843_ ins_0960_ VDD VSS sg13g2_xnor2_1
Xins_1871_ ins_0963_ ins_0846_ ins_0850_ VDD VSS sg13g2_nand2_1
Xins_1872_ ins_0964_ ins_0846_ ins_0962_ VDD VSS sg13g2_nor2_1
Xins_1873_ ins_0965_ ins_0850_ ins_0962_ VDD VSS sg13g2_nor2_1
Xins_1874_ ins_0966_ ins_0962_ ins_0963_ VDD VSS sg13g2_xor2_1
Xins_1875_ ins_0967_ ins_0851_ ins_0966_ VDD VSS sg13g2_nor2_1
Xins_1876_ ins_0968_ ins_0851_ ins_0966_ VDD VSS sg13g2_xnor2_1
Xins_1877_ ins_0969_ ins_0853_ ins_0968_ VDD VSS sg13g2_or2_1
Xins_1878_ ins_0970_ ins_0853_ ins_0968_ VDD VSS sg13g2_xor2_1
Xins_1879_ ins_0971_ ins_0823_ ins_0825_ ins_0854_ VDD VSS
+ sg13g2_o21ai_1
Xins_1880_ ins_0972_ ins_0971_ ins_0970_ VDD VSS sg13g2_nand2b_1
Xins_1881_ ins_0973_ ins_0970_ ins_0971_ VDD VSS sg13g2_xnor2_1
Xins_1882_ ins_0974_ ins_0857_ ins_0859_ ins_0973_ VDD VSS
+ sg13g2_o21ai_1
Xins_1883_ ins_0975_ ins_0857_ ins_0859_ ins_0973_ VDD VSS
+ sg13g2_or3_1
Xins_1884_ ins_0976_ ins_0974_ ins_0975_ VDD VSS sg13g2_and2_1
Xins_1885_ ins_0977_ ins_0833_ ins_0862_ ins_0861_ VDD VSS
+ sg13g2_o21ai_1
Xins_1886_ ins_0978_ ins_0976_ ins_0977_ VDD VSS sg13g2_xor2_1
Xins_1887_ ins_0979_ ins_0946_ ins_0978_ VDD VSS sg13g2_nand2_1
Xins_1888_ ins_0980_ ins_0946_ ins_0978_ VDD VSS sg13g2_xnor2_1
Xins_1889_ ins_0981_ ins_0872_ ins_0938_ ins_0980_ VDD VSS
+ sg13g2_nor3_1
Xins_1890_ ins_0982_ ins_0872_ ins_0938_ ins_0980_ VDD VSS
+ sg13g2_o21ai_1
Xins_1891_ ins_0983_ ins_0981_ ins_0982_ VDD VSS sg13g2_nor2b_1
Xins_1892_ ins_0984_ ins_0875_ ins_0938_ VDD VSS sg13g2_nor2_1
Xins_1893_ ins_0985_ ins_0877_ ins_0939_ VDD VSS sg13g2_and2_1
Xins_1894_ ins_0986_ ins_0984_ ins_0985_ VDD VSS sg13g2_nor2_1
Xins_1895_ ins_0987_ ins_0983_ ins_0986_ VDD VSS sg13g2_xnor2_1
Xins_1896_ ins_0988_ ins_0945_ ins_0987_ VDD VSS sg13g2_nand2b_1
Xins_1897_ ins_0989_ ins_0945_ ins_0987_ VDD VSS sg13g2_xnor2_1
Xins_1898_ ins_0990_ ins_0881_ ins_0941_ VDD VSS sg13g2_nor2b_1
Xins_1899_ ins_0991_ ins_0989_ ins_0990_ VDD VSS sg13g2_nand2_1
Xins_1900_ ins_0992_ ins_0989_ ins_0990_ VDD VSS sg13g2_xor2_1
Xins_1901_ ins_0993_ ins_0896_ ins_0941_ VDD VSS sg13g2_and2_1
Xins_1902_ ins_0994_ ins_0882_ ins_0914_ VDD VSS sg13g2_nor2_1
Xins_1903_ ins_0995_ ins_0943_ ins_0994_ ins_0993_ VDD VSS
+ sg13g2_a21o_1
Xins_1904_ ins_0996_ ins_0992_ ins_0995_ VDD VSS sg13g2_xnor2_1
Xins_1905_ ins_0997_ ins_0944_ ins_0996_ VDD VSS sg13g2_xnor2_1
Xins_1906_ ins_0998_ ins_0915_ ins_0928_ VDD VSS sg13g2_xor2_1
Xins_1907_ ins_0999_ ins_0911_ ins_0916_ ins_0927_ VDD VSS
+ sg13g2_a21o_1
Xins_1908_ ins_1000_ FINE_MUX[11] ins_0923_ VDD VSS sg13g2_and2_1
Xins_1909_ ins_1001_ FINE_MUX[11] ins_0923_ VDD VSS sg13g2_xnor2_1
Xins_1910_ ins_1002_ ins_0918_ ins_1000_ VDD VSS sg13g2_nor2_1
Xins_1911_ ins_1003_ ins_0901_ ins_1000_ VDD VSS sg13g2_nand2_1
Xins_1912_ ins_1004_ ins_0901_ ins_1002_ VDD VSS sg13g2_xnor2_1
Xins_1913_ ins_1005_ ins_0741_ ins_0899_ ins_0919_ VDD VSS
+ sg13g2_o21ai_1
Xins_1914_ ins_1006_ ins_0743_ ins_1005_ VDD VSS sg13g2_xor2_1
Xins_1915_ ins_1007_ ins_1003_ ins_1006_ VDD VSS sg13g2_nor2b_1
Xins_1916_ ins_1008_ ins_1003_ ins_1006_ VDD VSS sg13g2_xnor2_1
Xins_1917_ ins_1009_ ins_1001_ ins_1004_ ins_1008_ VDD VSS
+ sg13g2_nand3b_1
Xins_1918_ ins_1010_ ins_0922_ ins_1009_ FINE_MUX[12] VDD
+ VSS sg13g2_o21ai_1
Xins_1919_ ins_1011_ ins_0917_ ins_0925_ VDD VSS sg13g2_xor2_1
Xins_1920_ ins_1012_ ins_1010_ ins_1011_ VDD VSS sg13g2_nor2b_1
Xins_1921_ ins_1013_ ins_0906_ ins_0926_ VDD VSS sg13g2_nor2_1
Xins_1922_ ins_1014_ ins_0908_ ins_1013_ VDD VSS sg13g2_xnor2_1
Xins_1923_ ins_1015_ ins_1012_ ins_1014_ VDD VSS sg13g2_nand2_1
Xins_1924_ ins_1016_ ins_1015_ VDD VSS sg13g2_inv_1
Xins_1925_ ins_1017_ ins_0928_ ins_0999_ ins_1016_ VDD VSS
+ sg13g2_and3_1
Xins_1926_ ins_1018_ ins_0998_ ins_1017_ VDD VSS sg13g2_and2_1
Xins_1927_ ins_1019_ ins_0897_ ins_0929_ VDD VSS sg13g2_xnor2_1
Xins_1928_ ins_1020_ ins_0914_ ins_1019_ ins_0994_ VDD VSS
+ sg13g2_a21oi_1
Xins_1929_ ins_1021_ ins_1018_ ins_1020_ VDD VSS sg13g2_nand2_1
Xins_1930_ ins_1022_ ins_0914_ ins_0929_ ins_0897_ VDD VSS
+ sg13g2_a21oi_1
Xins_1931_ ins_1023_ ins_0943_ ins_1022_ VDD VSS sg13g2_xor2_1
Xins_1932_ ins_1024_ ins_1021_ ins_1023_ VDD VSS sg13g2_nand2b_1
Xins_1933_ ins_1025_ ins_0997_ ins_1024_ VDD VSS sg13g2_nor2_1
Xins_1934_ ins_1026_ ins_0997_ ins_1024_ VDD VSS sg13g2_xor2_1
Xins_1935_ ins_1027_ ins_1021_ ins_1023_ VDD VSS sg13g2_xnor2_1
Xins_1936_ ins_1028_ ins_0998_ ins_1017_ VDD VSS sg13g2_xor2_1
Xins_1937_ ins_1029_ ins_0928_ ins_0999_ ins_1016_ VDD VSS
+ sg13g2_a21oi_1
Xins_1938_ ins_1030_ ins_1017_ ins_1029_ VDD VSS sg13g2_nor2_1
Xins_1939_ ins_1031_ ins_1010_ ins_1011_ VDD VSS sg13g2_xnor2_1
Xins_1940_ ins_1032_ ins_1174_ ins_1001_ VDD VSS sg13g2_nor2_1
Xins_1941_ ins_1033_ ins_1004_ ins_1032_ VDD VSS sg13g2_and2_1
Xins_1942_ ins_1034_ ins_1008_ ins_1033_ ins_1007_ VDD VSS
+ sg13g2_a21oi_1
Xins_1943_ ins_1035_ ins_0922_ ins_1034_ VDD VSS sg13g2_xor2_1
Xins_1944_ ins_1036_ FINE_MUX[12] ins_1001_ VDD VSS sg13g2_xnor2_1
Xins_1945_ ins_1037_ ins_1004_ ins_1036_ VDD VSS sg13g2_and2_1
Xins_1946_ ins_1038_ ins_1008_ ins_1033_ VDD VSS sg13g2_xor2_1
Xins_1947_ ins_1039_ ins_1008_ ins_1035_ ins_1037_ VDD VSS
+ sg13g2_nand3_1
Xins_1948_ ins_1040_ FINE_MUX[13] ins_1039_ VDD VSS sg13g2_nand2_1
Xins_1949_ ins_1041_ FINE_MUX[13] ins_1031_ ins_1039_ VDD
+ VSS sg13g2_and3_1
Xins_1950_ ins_1042_ ins_1014_ ins_1041_ VDD VSS sg13g2_nand2_1
Xins_1951_ ins_1043_ ins_1017_ ins_1029_ ins_1042_ VDD VSS
+ sg13g2_nor3_1
Xins_1952_ ins_1044_ ins_1028_ ins_1043_ VDD VSS sg13g2_and2_1
Xins_1953_ ins_1045_ ins_1018_ ins_1020_ VDD VSS sg13g2_xor2_1
Xins_1954_ ins_1046_ ins_1027_ ins_1044_ ins_1045_ VDD VSS
+ sg13g2_nand3_1
Xins_1955_ ins_1047_ ins_1026_ ins_1027_ ins_1044_ ins_1045_
+ VDD VSS sg13g2_and4_1
Xins_1956_ ins_1048_ ins_1026_ ins_1046_ VDD VSS sg13g2_xnor2_1
Xins_1957_ ins_1049_ ins_1028_ ins_1043_ VDD VSS sg13g2_xnor2_1
Xins_1958_ ins_1050_ ins_1031_ ins_1040_ VDD VSS sg13g2_xor2_1
Xins_1959_ ins_1051_ FINE_MUX[13] ins_1037_ ins_1038_ VDD
+ VSS sg13g2_nand3_1
Xins_1960_ ins_1052_ ins_1035_ ins_1051_ VDD VSS sg13g2_xor2_1
Xins_1961_ ins_1053_ FINE_MUX[13] ins_1036_ ins_1032_ VDD
+ VSS sg13g2_a21oi_1
Xins_1962_ ins_1054_ ins_1004_ ins_1053_ VDD VSS sg13g2_xnor2_1
Xins_1963_ ins_1055_ FINE_MUX[13] ins_1037_ ins_1038_ VDD
+ VSS sg13g2_a21o_1
Xins_1964_ ins_1056_ ins_1038_ ins_1054_ VDD VSS sg13g2_nand2_1
Xins_1965_ ins_1057_ FINE_MUX[13] ins_1036_ VDD VSS sg13g2_xnor2_1
Xins_1966_ ins_1058_ ins_1052_ ins_1056_ ins_1057_ VDD VSS
+ sg13g2_nor3_1
Xins_1967_ ins_1059_ ins_0199_ ins_1058_ VDD VSS sg13g2_nor2_1
Xins_1968_ ins_1060_ ins_1050_ ins_1059_ VDD VSS sg13g2_nor2b_1
Xins_1969_ ins_1061_ ins_1012_ ins_1041_ VDD VSS sg13g2_nor2_1
Xins_1970_ ins_1062_ ins_1014_ ins_1061_ VDD VSS sg13g2_xnor2_1
Xins_1971_ ins_1063_ ins_1060_ ins_1062_ VDD VSS sg13g2_and2_1
Xins_1972_ ins_1064_ ins_1030_ ins_1063_ VDD VSS sg13g2_nand2_1
Xins_1973_ ins_1065_ ins_1049_ ins_1064_ VDD VSS sg13g2_nor2_1
Xins_1974_ ins_1066_ ins_1023_ ins_1045_ ins_1065_ VDD VSS
+ sg13g2_and3_1
Xins_1975_ ins_1067_ ins_1048_ ins_1066_ VDD VSS sg13g2_nand2_1
Xins_1976_ ins_1068_ ins_1048_ ins_1066_ VDD VSS sg13g2_xor2_1
Xins_1977_ ins_1069_ ins_1044_ ins_1065_ VDD VSS sg13g2_or2_1
Xins_1978_ ins_1070_ ins_1045_ ins_1069_ VDD VSS sg13g2_nand2_1
Xins_1979_ ins_1071_ ins_1045_ ins_1069_ VDD VSS sg13g2_xor2_1
Xins_1980_ ins_1072_ ins_1027_ ins_1070_ VDD VSS sg13g2_xnor2_1
Xins_1981_ ins_1073_ ins_1071_ ins_1072_ VDD VSS sg13g2_nand2_1
Xins_1982_ ins_1074_ ins_1049_ ins_1064_ VDD VSS sg13g2_xnor2_1
Xins_1983_ ins_1075_ ins_1014_ ins_1041_ ins_1063_ VDD VSS
+ sg13g2_a21oi_1
Xins_1984_ ins_1076_ ins_1075_ VDD VSS sg13g2_inv_1
Xins_1985_ ins_1077_ ins_1017_ ins_1029_ ins_1076_ VDD VSS
+ sg13g2_or3_1
Xins_1986_ ins_1078_ ins_1017_ ins_1029_ ins_1076_ VDD VSS
+ sg13g2_o21ai_1
Xins_1987_ ins_1079_ ins_1050_ ins_1059_ VDD VSS sg13g2_xnor2_1
Xins_1988_ ins_1080_ ins_0199_ ins_1057_ VDD VSS sg13g2_nor2_1
Xins_1989_ ins_1081_ ins_1054_ ins_1080_ VDD VSS sg13g2_and2_1
Xins_1990_ ins_1082_ ins_1038_ ins_1054_ ins_1080_ VDD VSS
+ sg13g2_nand3_1
Xins_1991_ ins_1083_ ins_1052_ ins_1082_ VDD VSS sg13g2_xnor2_1
Xins_1992_ ins_1084_ FINE_MUX[14] ins_1057_ VDD VSS sg13g2_xnor2_1
Xins_1993_ ins_1085_ ins_1056_ ins_1084_ VDD VSS sg13g2_nor2b_1
Xins_1994_ ins_1086_ ins_1083_ ins_1085_ VDD VSS sg13g2_nand2b_1
Xins_1995_ ins_1087_ FINE_MUX[15] ins_1086_ VDD VSS sg13g2_nand2_1
Xins_1996_ ins_1088_ FINE_MUX[15] ins_1079_ ins_1086_ VDD
+ VSS sg13g2_and3_1
Xins_1997_ ins_1089_ ins_1062_ ins_1088_ VDD VSS sg13g2_nand2_1
Xins_1998_ ins_1090_ ins_1089_ VDD VSS sg13g2_inv_1
Xins_1999_ ins_1091_ ins_1077_ ins_1078_ ins_1089_ VDD VSS
+ sg13g2_a21oi_1
Xins_2000_ ins_1092_ ins_1077_ ins_1078_ ins_1089_ VDD VSS
+ sg13g2_a21o_1
Xins_2001_ ins_1093_ ins_1074_ ins_1092_ VDD VSS sg13g2_nor2_1
Xins_2002_ ins_1094_ ins_1071_ ins_1072_ ins_1093_ VDD VSS
+ sg13g2_and3_1
Xins_2003_ ins_1095_ ins_1068_ ins_1094_ VDD VSS sg13g2_nand2_1
Xins_2004_ ins_1096_ ins_1068_ ins_1094_ VDD VSS sg13g2_xor2_1
Xins_2005_ ins_1097_ ins_1077_ ins_1078_ ins_1089_ VDD VSS
+ sg13g2_nand3_1
Xins_2006_ ins_1098_ ins_1079_ ins_1087_ VDD VSS sg13g2_xor2_1
Xins_2007_ ins_1099_ ins_1051_ ins_1055_ ins_1081_ VDD VSS
+ sg13g2_a21o_1
Xins_2008_ ins_1100_ ins_1082_ ins_1099_ VDD VSS sg13g2_and2_1
Xins_2009_ ins_1101_ FINE_MUX[15] ins_1084_ VDD VSS sg13g2_and2_1
Xins_2010_ ins_1102_ ins_1054_ ins_1101_ VDD VSS sg13g2_nand2_1
Xins_2011_ ins_1103_ ins_1054_ ins_1100_ ins_1101_ VDD VSS
+ sg13g2_and3_1
Xins_2012_ ins_1104_ ins_1083_ ins_1103_ VDD VSS sg13g2_nor2_1
Xins_2013_ ins_1105_ ins_1052_ ins_1103_ ins_1104_ VDD VSS
+ sg13g2_a21oi_1
Xins_2014_ ins_1106_ FINE_MUX[15] ins_1084_ VDD VSS sg13g2_xnor2_1
Xins_2015_ ins_1107_ ins_1080_ ins_1101_ VDD VSS sg13g2_nor2_1
Xins_2016_ ins_1108_ ins_1054_ ins_1107_ VDD VSS sg13g2_xor2_1
Xins_2017_ ins_1109_ ins_1100_ ins_1102_ VDD VSS sg13g2_xor2_1
Xins_2018_ ins_1110_ ins_1108_ ins_1100_ VDD VSS sg13g2_nand2b_1
Xins_2019_ ins_1111_ ins_1106_ ins_1110_ VDD VSS sg13g2_or2_1
Xins_2020_ ins_1112_ ins_1105_ ins_1111_ FINE_MUX[16] VDD
+ VSS sg13g2_o21ai_1
Xins_2021_ ins_1113_ ins_1098_ ins_1112_ VDD VSS sg13g2_nor2_1
Xins_2022_ ins_1114_ ins_1060_ ins_1062_ ins_1088_ VDD VSS
+ sg13g2_nor3_1
Xins_2023_ ins_1115_ ins_1063_ ins_1090_ ins_1114_ VDD VSS
+ sg13g2_nor3_1
Xins_2024_ ins_1116_ ins_1113_ ins_1115_ VDD VSS sg13g2_and2_1
Xins_2025_ ins_1117_ ins_1092_ ins_1097_ ins_1116_ VDD VSS
+ sg13g2_nand3_1
Xins_2026_ ins_1118_ ins_1073_ ins_1074_ ins_1117_ VDD VSS
+ sg13g2_nor3_1
Xins_2027_ ins_1119_ ins_1096_ ins_1118_ VDD VSS sg13g2_nand2_1
Xins_2028_ ins_1120_ ins_1096_ ins_1118_ VDD VSS sg13g2_xor2_1
Xins_2029_ ins_1121_ ins_1092_ ins_1097_ ins_1116_ VDD VSS
+ sg13g2_a21o_1
Xins_2030_ ins_1122_ ins_1098_ ins_1112_ VDD VSS sg13g2_xor2_1
Xins_2031_ ins_1123_ ins_1122_ VDD VSS sg13g2_inv_1
Xins_2032_ ins_1124_ ins_0188_ ins_1106_ VDD VSS sg13g2_nor2_1
Xins_2033_ ins_1125_ ins_1110_ ins_1124_ VDD VSS sg13g2_nor2b_1
Xins_2034_ ins_1126_ ins_1105_ ins_1125_ VDD VSS sg13g2_xor2_1
Xins_2035_ ins_1127_ ins_0188_ ins_1106_ VDD VSS sg13g2_xnor2_1
Xins_2036_ ins_1128_ ins_1127_ VDD VSS sg13g2_inv_1
Xins_2037_ ins_1129_ ins_1110_ ins_1128_ VDD VSS sg13g2_nand2b_1
Xins_2038_ ins_1130_ ins_1126_ ins_1129_ FINE_MUX[17] VDD
+ VSS sg13g2_o21ai_1
Xins_2039_ ins_1131_ ins_1123_ ins_1130_ VDD VSS sg13g2_nor2_1
Xins_2040_ ins_1132_ ins_1115_ ins_1131_ VDD VSS sg13g2_nand2_1
Xins_2041_ ins_1133_ ins_1132_ VDD VSS sg13g2_inv_1
Xins_2042_ ins_1134_ ins_1117_ ins_1121_ ins_1133_ VDD VSS
+ sg13g2_and3_1
Xins_2043_ ins_1135_ ins_1097_ ins_1116_ ins_1091_ VDD VSS
+ sg13g2_a21oi_1
Xins_2044_ ins_1136_ ins_1074_ ins_1135_ VDD VSS sg13g2_nor2_1
Xins_2045_ ins_1137_ ins_1074_ ins_1135_ VDD VSS sg13g2_xor2_1
Xins_2046_ ins_1138_ ins_1134_ ins_1137_ VDD VSS sg13g2_nand2_1
Xins_2047_ ins_1139_ ins_1071_ ins_1136_ VDD VSS sg13g2_xor2_1
Xins_2048_ ins_1140_ ins_1072_ ins_1139_ VDD VSS sg13g2_nand2_1
Xins_2049_ ins_1141_ ins_1138_ ins_1140_ VDD VSS sg13g2_nor2_1
Xins_2050_ ins_1142_ ins_1120_ ins_1141_ VDD VSS sg13g2_xor2_1
Xins_2051_ ins_1143_ ins_1134_ ins_1137_ VDD VSS sg13g2_xnor2_1
Xins_2052_ ins_1144_ ins_1117_ ins_1121_ ins_1133_ VDD VSS
+ sg13g2_a21oi_1
Xins_2053_ ins_1145_ ins_0177_ ins_1110_ ins_1127_ VDD VSS
+ sg13g2_nor3_1
Xins_2054_ ins_1146_ ins_1126_ ins_1145_ VDD VSS sg13g2_xor2_1
Xins_2055_ ins_1147_ ins_0177_ ins_1127_ VDD VSS sg13g2_xnor2_1
Xins_2056_ ins_1148_ ins_1147_ VDD VSS sg13g2_inv_1
Xins_2057_ ins_1149_ FINE_MUX[17] ins_1128_ ins_1124_ VDD
+ VSS sg13g2_a21oi_1
Xins_2058_ ins_1150_ ins_1108_ ins_1149_ VDD VSS sg13g2_nor2_1
Xins_2059_ ins_1151_ ins_1108_ ins_1149_ VDD VSS sg13g2_xnor2_1
Xins_2060_ ins_1152_ ins_1109_ ins_1150_ VDD VSS sg13g2_xnor2_1
Xins_2061_ ins_1153_ ins_1109_ ins_1151_ VDD VSS sg13g2_nor2_1
Xins_2062_ ins_1154_ ins_1148_ ins_1153_ VDD VSS sg13g2_nand2_1
Xins_2063_ ins_1155_ ins_1146_ ins_1154_ FINE_MUX[18] VDD
+ VSS sg13g2_o21ai_1
Xins_2064_ ins_1156_ ins_1122_ ins_1130_ VDD VSS sg13g2_xor2_1
Xins_2065_ ins_1157_ ins_1155_ ins_1156_ VDD VSS sg13g2_or2_1
Xins_2066_ ins_1158_ ins_1113_ ins_1131_ VDD VSS sg13g2_nor2_1
Xins_2067_ ins_1159_ ins_1115_ ins_1158_ VDD VSS sg13g2_xor2_1
Xins_2068_ ins_1160_ ins_1157_ ins_1159_ VDD VSS sg13g2_or2_1
Xins_2069_ ins_1161_ ins_1134_ ins_1144_ ins_1160_ VDD VSS
+ sg13g2_nor3_1
Xins_2070_ ins_1162_ ins_1134_ ins_1144_ ins_1160_ VDD VSS
+ sg13g2_or3_1
Xins_2071_ ins_1163_ ins_1143_ ins_1161_ VDD VSS sg13g2_nand2b_1
Xins_2072_ ins_1164_ ins_1140_ ins_1163_ VDD VSS sg13g2_nor2_1
Xins_2073_ ins_1165_ ins_1142_ ins_1164_ VDD VSS sg13g2_nand2_1
Xins_2074_ ins_1166_ ins_1142_ ins_1164_ VDD VSS sg13g2_xnor2_1
Xins_2075_ ins_1167_ ins_1143_ ins_1161_ VDD VSS sg13g2_xnor2_1
Xins_2076_ ins_1168_ ins_1167_ VDD VSS sg13g2_inv_1
Xins_2077_ ins_1169_ ins_1134_ ins_1144_ ins_1160_ VDD VSS
+ sg13g2_o21ai_1
Xins_2078_ ins_1170_ ins_1155_ ins_1156_ VDD VSS sg13g2_xor2_1
Xins_2079_ ins_1171_ FINE_MUX[18] ins_1147_ VDD VSS sg13g2_xnor2_1
Xins_2080_ ins_1172_ ins_1146_ ins_1153_ ins_1171_ VDD VSS
+ sg13g2_nand3b_1
Xins_2081_ ins_1173_ FINE_MUX[19] ins_1170_ ins_1172_ VDD
+ VSS sg13g2_nand3_1
Xins_2082_ ins_1175_ ins_1159_ ins_1173_ VDD VSS sg13g2_nor2_1
Xins_2083_ ins_1176_ ins_1162_ ins_1169_ ins_1175_ VDD VSS
+ sg13g2_and3_1
Xins_2084_ ins_1177_ ins_1162_ ins_1169_ ins_1175_ VDD VSS
+ sg13g2_nand3_1
Xins_2085_ ins_1178_ ins_1167_ ins_1176_ VDD VSS sg13g2_nand2_1
Xins_2086_ ins_1179_ ins_1138_ ins_1163_ VDD VSS sg13g2_and2_1
Xins_2087_ ins_1180_ ins_1179_ ins_1139_ VDD VSS sg13g2_nor2b_1
Xins_2088_ ins_1181_ ins_1139_ ins_1179_ VDD VSS sg13g2_xnor2_1
Xins_2089_ ins_1182_ ins_1178_ ins_1181_ VDD VSS sg13g2_nand2b_1
Xins_2090_ ins_1183_ ins_1071_ ins_1136_ ins_1180_ VDD VSS
+ sg13g2_a21oi_1
Xins_2091_ ins_1184_ ins_1072_ ins_1183_ VDD VSS sg13g2_xor2_1
Xins_2092_ ins_1186_ ins_1182_ ins_1184_ VDD VSS sg13g2_nor2_1
Xins_2093_ ins_1187_ ins_1166_ ins_1186_ VDD VSS sg13g2_nand2b_1
Xins_2094_ ins_1188_ ins_1166_ ins_1186_ VDD VSS sg13g2_xnor2_1
Xins_2095_ ins_1189_ ins_1162_ ins_1169_ ins_1175_ VDD VSS
+ sg13g2_a21o_1
Xins_2096_ ins_1190_ ins_0166_ ins_1147_ ins_1151_ VDD VSS
+ sg13g2_nor3_1
Xins_2097_ ins_1191_ FINE_MUX[19] ins_1171_ VDD VSS sg13g2_and2_1
Xins_2098_ ins_1192_ ins_1151_ ins_1191_ VDD VSS sg13g2_nand2b_1
Xins_2099_ ins_1193_ ins_1152_ ins_1190_ VDD VSS sg13g2_xnor2_1
Xins_2100_ ins_1194_ ins_1192_ ins_1193_ VDD VSS sg13g2_nor2_1
Xins_2101_ ins_1195_ ins_1152_ ins_1190_ ins_1194_ VDD VSS
+ sg13g2_a21oi_1
Xins_2102_ ins_1197_ ins_1146_ ins_1195_ VDD VSS sg13g2_xor2_1
Xins_2103_ ins_1198_ FINE_MUX[18] ins_1148_ ins_1191_ VDD
+ VSS sg13g2_a21oi_1
Xins_2104_ ins_1199_ ins_1151_ ins_1198_ VDD VSS sg13g2_xor2_1
Xins_2105_ ins_1200_ ins_1152_ ins_1199_ VDD VSS sg13g2_and2_1
Xins_2106_ ins_1201_ FINE_MUX[19] ins_1171_ VDD VSS sg13g2_xor2_1
Xins_2107_ ins_1202_ ins_1197_ ins_1200_ ins_1201_ VDD VSS
+ sg13g2_nand3_1
Xins_2108_ ins_1203_ FINE_MUX[20] ins_1202_ VDD VSS sg13g2_nand2_1
Xins_2109_ ins_1204_ FINE_MUX[19] ins_1172_ ins_1170_ VDD
+ VSS sg13g2_a21o_1
Xins_2110_ ins_1205_ ins_1173_ ins_1204_ VDD VSS sg13g2_and2_1
Xins_2111_ ins_1206_ ins_1203_ ins_1205_ VDD VSS sg13g2_nor2b_1
Xins_2112_ ins_1208_ ins_1157_ ins_1173_ VDD VSS sg13g2_nand2_1
Xins_2113_ ins_1209_ ins_1159_ ins_1208_ VDD VSS sg13g2_xnor2_1
Xins_2114_ ins_1210_ ins_1206_ ins_1209_ VDD VSS sg13g2_and2_1
Xins_2115_ ins_1211_ ins_1177_ ins_1189_ ins_1210_ VDD VSS
+ sg13g2_nand3_1
Xins_2116_ ins_1212_ ins_1168_ ins_1211_ VDD VSS sg13g2_nor2_1
Xins_2117_ ins_1213_ ins_1178_ ins_1181_ VDD VSS sg13g2_xnor2_1
Xins_2118_ ins_1214_ ins_1212_ ins_1213_ VDD VSS sg13g2_nand2_1
Xins_2119_ ins_1215_ ins_1184_ ins_1214_ VDD VSS sg13g2_nor2_1
Xins_2120_ ins_1216_ ins_1188_ ins_1215_ VDD VSS sg13g2_nand2_1
Xins_2121_ ins_1217_ ins_1188_ ins_1215_ VDD VSS sg13g2_xor2_1
Xins_2122_ ins_0002_ ins_1182_ ins_1214_ VDD VSS sg13g2_nand2_1
Xins_2123_ ins_0003_ ins_1184_ ins_0002_ VDD VSS sg13g2_xor2_1
Xins_2124_ ins_0004_ ins_1212_ ins_1213_ VDD VSS sg13g2_xnor2_1
Xins_2125_ ins_0005_ ins_1189_ ins_1210_ ins_1176_ VDD VSS
+ sg13g2_a21oi_1
Xins_2126_ ins_0006_ ins_1167_ ins_0005_ VDD VSS sg13g2_xnor2_1
Xins_2127_ ins_0007_ ins_1177_ ins_1189_ ins_1210_ VDD VSS
+ sg13g2_a21o_1
Xins_2128_ ins_0008_ ins_1203_ ins_1205_ VDD VSS sg13g2_xnor2_1
Xins_2129_ ins_0009_ FINE_MUX[20] ins_1201_ VDD VSS sg13g2_and2_1
Xins_2130_ ins_0010_ FINE_MUX[20] ins_1201_ VDD VSS sg13g2_xor2_1
Xins_2131_ ins_0011_ ins_1197_ ins_1200_ ins_0010_ VDD VSS
+ sg13g2_nand3_1
Xins_2132_ ins_0013_ FINE_MUX[21] ins_0011_ VDD VSS sg13g2_nand2_1
Xins_2133_ ins_0014_ FINE_MUX[21] ins_0008_ ins_0011_ VDD
+ VSS sg13g2_and3_1
Xins_2134_ ins_0015_ ins_1209_ ins_0014_ VDD VSS sg13g2_and2_1
Xins_2135_ ins_0016_ ins_1211_ ins_0007_ ins_0015_ VDD VSS
+ sg13g2_nand3_1
Xins_2136_ ins_0017_ ins_1211_ ins_0006_ ins_0007_ ins_0015_
+ VDD VSS sg13g2_and4_1
Xins_2137_ ins_0018_ ins_0004_ ins_0017_ VDD VSS sg13g2_nand2b_1
Xins_2138_ ins_0019_ ins_0003_ ins_0018_ VDD VSS sg13g2_nor2_1
Xins_2139_ ins_0020_ ins_1217_ ins_0019_ VDD VSS sg13g2_xor2_1
Xins_2140_ ins_0021_ ins_0006_ ins_0016_ VDD VSS sg13g2_xnor2_1
Xins_2141_ ins_0022_ ins_1211_ ins_0007_ ins_0015_ VDD VSS
+ sg13g2_a21o_1
Xins_2142_ ins_0024_ ins_0008_ ins_0013_ VDD VSS sg13g2_xor2_1
Xins_2143_ ins_0025_ ins_1199_ ins_0009_ VDD VSS sg13g2_nand2_1
Xins_2144_ ins_0026_ ins_1192_ ins_0025_ VDD VSS sg13g2_nand2_1
Xins_2145_ ins_0027_ ins_1193_ ins_0026_ VDD VSS sg13g2_xnor2_1
Xins_2146_ ins_0028_ FINE_MUX[21] ins_0010_ VDD VSS sg13g2_and2_1
Xins_2147_ ins_0029_ ins_1199_ ins_0028_ VDD VSS sg13g2_and2_1
Xins_2148_ ins_0030_ ins_1200_ ins_0009_ ins_0027_ ins_0029_
+ VDD VSS sg13g2_a22oi_1
Xins_2149_ ins_0031_ ins_1197_ ins_0030_ VDD VSS sg13g2_xor2_1
Xins_2150_ ins_0032_ ins_0009_ ins_0028_ VDD VSS sg13g2_nor2_1
Xins_2151_ ins_0033_ ins_1199_ ins_0032_ VDD VSS sg13g2_xnor2_1
Xins_2152_ ins_0035_ ins_0027_ ins_0033_ VDD VSS sg13g2_nand2_1
Xins_2153_ ins_0036_ FINE_MUX[21] ins_0010_ VDD VSS sg13g2_xnor2_1
Xins_2154_ ins_0037_ ins_0031_ ins_0035_ ins_0036_ VDD VSS
+ sg13g2_nor3_1
Xins_2155_ ins_0038_ ins_0155_ ins_0037_ VDD VSS sg13g2_nor2_1
Xins_2156_ ins_0039_ ins_0024_ ins_0038_ VDD VSS sg13g2_nor2b_1
Xins_2157_ ins_0040_ ins_1206_ ins_0014_ VDD VSS sg13g2_nor2_1
Xins_2158_ ins_0041_ ins_1209_ ins_0040_ VDD VSS sg13g2_xnor2_1
Xins_2159_ ins_0042_ ins_0039_ ins_0041_ VDD VSS sg13g2_and2_1
Xins_2160_ ins_0043_ ins_0016_ ins_0022_ ins_0042_ VDD VSS
+ sg13g2_and3_1
Xins_2161_ ins_0044_ ins_0004_ ins_0021_ ins_0043_ VDD VSS
+ sg13g2_nand3b_1
Xins_2162_ ins_0046_ ins_0003_ ins_0044_ VDD VSS sg13g2_nor2_1
Xins_2163_ ins_0047_ ins_0020_ ins_0046_ VDD VSS sg13g2_nand2_1
Xins_2164_ ins_0048_ ins_0020_ ins_0046_ VDD VSS sg13g2_xor2_1
Xins_2165_ ins_0049_ ins_0021_ ins_0043_ VDD VSS sg13g2_xnor2_1
Xins_2166_ ins_0050_ ins_0016_ ins_0022_ ins_0042_ VDD VSS
+ sg13g2_a21oi_1
Xins_2167_ ins_0051_ ins_0155_ ins_0036_ VDD VSS sg13g2_nor2_1
Xins_2168_ ins_0052_ ins_0155_ ins_0036_ VDD VSS sg13g2_xnor2_1
Xins_2169_ ins_0053_ ins_0035_ ins_0052_ VDD VSS sg13g2_or2_1
Xins_2170_ ins_0054_ ins_0031_ ins_0053_ FINE_MUX[23] VDD
+ VSS sg13g2_o21ai_1
Xins_2171_ ins_0055_ ins_0024_ ins_0038_ VDD VSS sg13g2_xor2_1
Xins_2172_ ins_0057_ ins_0054_ ins_0055_ VDD VSS sg13g2_nor2_1
Xins_2173_ ins_0058_ ins_0041_ ins_0057_ VDD VSS sg13g2_nand2_1
Xins_2174_ ins_0059_ ins_0043_ ins_0050_ ins_0058_ VDD VSS
+ sg13g2_or3_1
Xins_2175_ ins_0060_ ins_0049_ ins_0059_ VDD VSS sg13g2_nor2_1
Xins_2176_ ins_0061_ ins_0021_ ins_0043_ ins_0017_ VDD VSS
+ sg13g2_a21oi_1
Xins_2177_ ins_0062_ ins_0018_ ins_0044_ VDD VSS sg13g2_nand2_1
Xins_2178_ ins_0063_ ins_0004_ ins_0061_ VDD VSS sg13g2_xnor2_1
Xins_2179_ ins_0064_ ins_0049_ ins_0059_ ins_0063_ VDD VSS
+ sg13g2_nor3_1
Xins_2180_ ins_0065_ ins_0003_ ins_0062_ VDD VSS sg13g2_xnor2_1
Xins_2181_ ins_0066_ ins_0064_ ins_0065_ VDD VSS sg13g2_and2_1
Xins_2182_ ins_0068_ ins_0048_ ins_0066_ VDD VSS sg13g2_nand2_1
Xins_2183_ ins_0069_ ins_0048_ ins_0066_ VDD VSS sg13g2_xor2_1
Xins_2184_ ins_0070_ ins_0064_ ins_0065_ VDD VSS sg13g2_xnor2_1
Xins_2185_ ins_0071_ ins_0049_ ins_0059_ VDD VSS sg13g2_xor2_1
Xins_2186_ ins_0072_ ins_0043_ ins_0050_ ins_0058_ VDD VSS
+ sg13g2_o21ai_1
Xins_2187_ ins_0073_ ins_0039_ ins_0057_ VDD VSS sg13g2_nor2_1
Xins_2188_ ins_0074_ ins_0041_ ins_0073_ VDD VSS sg13g2_xnor2_1
Xins_2189_ ins_0075_ ins_0054_ ins_0055_ VDD VSS sg13g2_xor2_1
Xins_2190_ ins_0076_ ins_0027_ ins_0033_ ins_0051_ VDD VSS
+ sg13g2_nand3_1
Xins_2191_ ins_0077_ ins_0033_ ins_0051_ ins_0029_ VDD VSS
+ sg13g2_a21oi_1
Xins_2192_ ins_0079_ ins_0027_ ins_0077_ VDD VSS sg13g2_xor2_1
Xins_2193_ ins_0080_ ins_0144_ ins_0052_ VDD VSS sg13g2_nor2_1
Xins_2194_ ins_0081_ ins_0033_ ins_0080_ VDD VSS sg13g2_nand2_1
Xins_2195_ ins_0082_ ins_0079_ ins_0081_ ins_0076_ VDD VSS
+ sg13g2_o21ai_1
Xins_2196_ ins_0083_ ins_0031_ ins_0082_ VDD VSS sg13g2_xnor2_1
Xins_2197_ ins_0084_ ins_0144_ ins_0052_ VDD VSS sg13g2_xnor2_1
Xins_2198_ ins_0085_ ins_0051_ ins_0080_ VDD VSS sg13g2_nor2_1
Xins_2199_ ins_0086_ ins_0033_ ins_0085_ VDD VSS sg13g2_xnor2_1
Xins_2200_ ins_0087_ ins_0079_ ins_0081_ VDD VSS sg13g2_xor2_1
Xins_2201_ ins_0088_ ins_0086_ ins_0087_ VDD VSS sg13g2_nand2_1
Xins_2202_ ins_0090_ ins_0084_ ins_0088_ VDD VSS sg13g2_nor2_1
Xins_2203_ ins_0091_ ins_0083_ ins_0090_ ins_0133_ VDD VSS
+ sg13g2_a21oi_1
Xins_2204_ ins_0092_ ins_0075_ ins_0091_ VDD VSS sg13g2_and2_1
Xins_2205_ ins_0093_ ins_0059_ ins_0072_ ins_0074_ ins_0092_
+ VDD VSS sg13g2_and4_1
Xins_2206_ ins_0094_ ins_0071_ ins_0093_ VDD VSS sg13g2_nand2_1
Xins_2207_ ins_0095_ ins_0063_ ins_0094_ VDD VSS sg13g2_nor2_1
Xins_2208_ ins_0096_ ins_0070_ ins_0095_ VDD VSS sg13g2_nor2b_1
Xins_2209_ ins_0097_ ins_0069_ ins_0096_ VDD VSS sg13g2_nand2_1
Xins_2210_ ins_0098_ ins_0069_ ins_0096_ VDD VSS sg13g2_xor2_1
Xins_2211_ ins_0099_ ins_0071_ ins_0093_ VDD VSS sg13g2_xnor2_1
Xins_2212_ ins_0101_ ins_0059_ ins_0072_ ins_0074_ ins_0092_
+ VDD VSS sg13g2_a22oi_1
Xins_2213_ ins_0102_ ins_0133_ ins_0084_ VDD VSS sg13g2_nor2_1
Xins_2214_ ins_0103_ FINE_MUX[24] ins_0084_ VDD VSS sg13g2_xnor2_1
Xins_2215_ ins_0104_ ins_0087_ ins_0103_ VDD VSS sg13g2_and2_1
Xins_2216_ ins_0105_ ins_0083_ ins_0086_ VDD VSS sg13g2_and2_1
Xins_2217_ ins_0106_ ins_0104_ ins_0105_ ins_0122_ VDD VSS
+ sg13g2_a21oi_1
Xins_2218_ ins_0107_ ins_0075_ ins_0091_ VDD VSS sg13g2_xor2_1
Xins_2219_ ins_0108_ ins_0106_ ins_0107_ VDD VSS sg13g2_and2_1
Xins_2220_ ins_0109_ ins_0074_ ins_0108_ VDD VSS sg13g2_nand2_1
Xins_2221_ ins_0110_ ins_0093_ ins_0101_ ins_0109_ VDD VSS
+ sg13g2_nor3_1
Xins_2222_ ins_0112_ ins_0093_ ins_0101_ ins_0109_ VDD VSS
+ sg13g2_or3_1
Xins_2223_ ins_0113_ ins_0099_ ins_0112_ VDD VSS sg13g2_nor2_1
Xins_2224_ ins_0114_ ins_0071_ ins_0093_ ins_0060_ VDD VSS
+ sg13g2_a21oi_1
Xins_2225_ ins_0115_ ins_0063_ ins_0114_ VDD VSS sg13g2_xor2_1
Xins_2226_ ins_0116_ ins_0113_ ins_0115_ VDD VSS sg13g2_and2_1
Xins_2227_ ins_0117_ ins_0070_ ins_0116_ VDD VSS sg13g2_nor2b_1
Xins_2228_ ins_0118_ ins_0098_ ins_0117_ VDD VSS sg13g2_xor2_1
Xins_2229_ ins_0119_ ins_0093_ ins_0101_ ins_0109_ VDD VSS
+ sg13g2_o21ai_1
Xins_2230_ ins_0120_ ins_0106_ ins_0107_ VDD VSS sg13g2_xor2_1
Xins_2231_ ins_0121_ ins_0086_ ins_0102_ VDD VSS sg13g2_nand2_1
Xins_2232_ ins_0123_ FINE_MUX[25] ins_0086_ ins_0103_ VDD
+ VSS sg13g2_and3_1
Xins_2233_ ins_0124_ ins_0087_ ins_0121_ VDD VSS sg13g2_xnor2_1
Xins_2234_ ins_0125_ FINE_MUX[24] ins_0090_ ins_0123_ ins_0124_
+ VDD VSS sg13g2_a22oi_1
Xins_2235_ ins_0126_ ins_0083_ ins_0125_ VDD VSS sg13g2_xor2_1
Xins_2236_ ins_0127_ FINE_MUX[25] ins_0103_ ins_0102_ VDD
+ VSS sg13g2_a21oi_1
Xins_2237_ ins_0128_ ins_0086_ ins_0127_ VDD VSS sg13g2_xnor2_1
Xins_2238_ ins_0129_ ins_0123_ ins_0124_ VDD VSS sg13g2_xnor2_1
Xins_2239_ ins_0130_ ins_0087_ ins_0128_ VDD VSS sg13g2_nand2_1
Xins_2240_ ins_0131_ FINE_MUX[25] ins_0103_ VDD VSS sg13g2_xnor2_1
Xins_2241_ ins_0132_ ins_0126_ ins_0130_ ins_0131_ VDD VSS
+ sg13g2_nor3_1
Xins_2242_ ins_0134_ ins_0111_ ins_0132_ VDD VSS sg13g2_nor2_1
Xins_2243_ ins_0135_ ins_0120_ ins_0134_ VDD VSS sg13g2_and2_1
Xins_2244_ ins_0136_ ins_0092_ ins_0108_ VDD VSS sg13g2_nor2_1
Xins_2245_ ins_0137_ ins_0074_ ins_0136_ VDD VSS sg13g2_xnor2_1
Xins_2246_ ins_0138_ ins_0135_ ins_0137_ VDD VSS sg13g2_and2_1
Xins_2247_ ins_0139_ ins_0112_ ins_0119_ ins_0138_ VDD VSS
+ sg13g2_nand3_1
Xins_2248_ ins_0140_ ins_0099_ ins_0139_ VDD VSS sg13g2_nor2_1
Xins_2249_ ins_0141_ ins_0113_ ins_0115_ VDD VSS sg13g2_xor2_1
Xins_2250_ ins_0142_ ins_0140_ ins_0141_ VDD VSS sg13g2_nand2_1
Xins_2251_ ins_0143_ ins_0095_ ins_0116_ VDD VSS sg13g2_nor2_1
Xins_2252_ ins_0145_ ins_0070_ ins_0143_ VDD VSS sg13g2_xnor2_1
Xins_2253_ ins_0146_ ins_0142_ ins_0145_ VDD VSS sg13g2_nor2_1
Xins_2254_ ins_0147_ ins_0118_ ins_0146_ VDD VSS sg13g2_nand2_1
Xins_2255_ ins_0148_ ins_0118_ ins_0146_ VDD VSS sg13g2_xor2_1
Xins_2256_ ins_0149_ ins_0112_ ins_0119_ ins_0138_ VDD VSS
+ sg13g2_a21o_1
Xins_2257_ ins_0150_ ins_0139_ ins_0149_ VDD VSS sg13g2_nand2_1
Xins_2258_ ins_0151_ ins_0111_ ins_0131_ VDD VSS sg13g2_nor2_1
Xins_2259_ ins_0152_ ins_0111_ ins_0131_ VDD VSS sg13g2_xnor2_1
Xins_2260_ ins_0153_ ins_0126_ ins_0130_ ins_0152_ VDD VSS
+ sg13g2_nor3_1
Xins_2261_ ins_0154_ ins_0100_ ins_0153_ VDD VSS sg13g2_nor2_1
Xins_2262_ ins_0156_ ins_0120_ ins_0134_ VDD VSS sg13g2_xor2_1
Xins_2263_ ins_0157_ ins_0154_ ins_0156_ VDD VSS sg13g2_and2_1
Xins_2264_ ins_0158_ ins_0137_ ins_0157_ VDD VSS sg13g2_and2_1
Xins_2265_ ins_0159_ ins_0139_ ins_0149_ ins_0158_ VDD VSS
+ sg13g2_nand3_1
Xins_2266_ ins_0160_ ins_0119_ ins_0138_ ins_0110_ VDD VSS
+ sg13g2_a21oi_1
Xins_2267_ ins_0161_ ins_0099_ ins_0160_ VDD VSS sg13g2_xor2_1
Xins_2268_ ins_0162_ ins_0159_ ins_0161_ VDD VSS sg13g2_nor2b_1
Xins_2269_ ins_0163_ ins_0140_ ins_0141_ VDD VSS sg13g2_xor2_1
Xins_2270_ ins_0164_ ins_0163_ VDD VSS sg13g2_inv_1
Xins_2271_ ins_0165_ ins_0162_ ins_0163_ VDD VSS sg13g2_nand2_1
Xins_2272_ ins_0167_ ins_0145_ ins_0165_ VDD VSS sg13g2_nor2_1
Xins_2273_ ins_0168_ ins_0148_ ins_0167_ VDD VSS sg13g2_xor2_1
Xins_2274_ ins_0169_ ins_0159_ ins_0161_ VDD VSS sg13g2_xnor2_1
Xins_2275_ ins_0170_ ins_0154_ ins_0156_ VDD VSS sg13g2_xnor2_1
Xins_2276_ ins_0171_ ins_0128_ ins_0151_ VDD VSS sg13g2_nand2_1
Xins_2277_ ins_0172_ ins_0130_ ins_0151_ VDD VSS sg13g2_nor2b_1
Xins_2278_ ins_0173_ ins_0126_ ins_0172_ VDD VSS sg13g2_nor2_1
Xins_2279_ ins_0174_ ins_0129_ ins_0171_ ins_0172_ VDD VSS
+ sg13g2_a21oi_1
Xins_2280_ ins_0175_ ins_0100_ ins_0152_ VDD VSS sg13g2_nor2_1
Xins_2281_ ins_0176_ ins_0128_ ins_0175_ VDD VSS sg13g2_nand2_1
Xins_2282_ ins_0178_ ins_0176_ VDD VSS sg13g2_inv_1
Xins_2283_ ins_0179_ ins_0126_ ins_0172_ ins_0174_ ins_0178_
+ ins_0173_ VDD VSS sg13g2_a221oi_1
Xins_2284_ ins_0180_ FINE_MUX[27] ins_0153_ ins_0179_ VDD
+ VSS sg13g2_a21o_1
Xins_2285_ ins_0181_ ins_0100_ ins_0152_ VDD VSS sg13g2_xnor2_1
Xins_2286_ ins_0182_ ins_0151_ ins_0175_ VDD VSS sg13g2_nor2_1
Xins_2287_ ins_0183_ ins_0128_ ins_0182_ VDD VSS sg13g2_xnor2_1
Xins_2288_ ins_0184_ ins_0181_ ins_0183_ VDD VSS sg13g2_nor2b_1
Xins_2289_ ins_0185_ ins_0174_ ins_0176_ VDD VSS sg13g2_xnor2_1
Xins_2290_ ins_0186_ ins_0184_ ins_0185_ VDD VSS sg13g2_nand2_1
Xins_2291_ ins_0187_ ins_0180_ ins_0186_ FINE_MUX[28] VDD
+ VSS sg13g2_o21ai_1
Xins_2292_ ins_0189_ ins_0170_ ins_0187_ VDD VSS sg13g2_nor2_1
Xins_2293_ ins_0190_ ins_0135_ ins_0137_ ins_0157_ VDD VSS
+ sg13g2_nor3_1
Xins_2294_ ins_0191_ ins_0138_ ins_0158_ ins_0190_ VDD VSS
+ sg13g2_nor3_1
Xins_2295_ ins_0192_ ins_0189_ ins_0191_ VDD VSS sg13g2_nand2_1
Xins_2296_ ins_0193_ ins_0150_ ins_0192_ VDD VSS sg13g2_nor2_1
Xins_2297_ ins_0194_ ins_0169_ ins_0193_ VDD VSS sg13g2_nand2_1
Xins_2298_ ins_0195_ ins_0164_ ins_0194_ VDD VSS sg13g2_nor2_1
Xins_2299_ ins_0196_ ins_0142_ ins_0165_ VDD VSS sg13g2_nand2_1
Xins_2300_ ins_0197_ ins_0145_ ins_0196_ VDD VSS sg13g2_xor2_1
Xins_2301_ ins_0198_ ins_0164_ ins_0194_ ins_0197_ VDD VSS
+ sg13g2_nor3_1
Xins_2302_ ins_0200_ ins_0168_ ins_0198_ VDD VSS sg13g2_nand2_1
Xins_2303_ ins_0201_ ins_0168_ ins_0198_ VDD VSS sg13g2_xor2_1
Xins_2304_ ins_0202_ ins_0169_ ins_0193_ VDD VSS sg13g2_xnor2_1
Xins_2305_ ins_0203_ ins_0150_ ins_0192_ VDD VSS sg13g2_xor2_1
Xins_2306_ ins_0204_ ins_0158_ ins_0203_ ins_0159_ VDD VSS
+ sg13g2_o21ai_1
Xins_2307_ ins_0205_ ins_0170_ ins_0187_ VDD VSS sg13g2_xor2_1
Xins_2308_ ins_0206_ ins_0089_ ins_0181_ VDD VSS sg13g2_nor2_1
Xins_2309_ ins_0207_ FINE_MUX[28] ins_0184_ ins_0185_ VDD
+ VSS sg13g2_nand3_1
Xins_2310_ ins_0208_ ins_0180_ ins_0207_ VDD VSS sg13g2_xor2_1
Xins_2311_ ins_0209_ FINE_MUX[28] ins_0181_ VDD VSS sg13g2_xnor2_1
Xins_2312_ ins_0211_ ins_0183_ ins_0209_ VDD VSS sg13g2_and2_1
Xins_2313_ ins_0212_ ins_0185_ ins_0208_ ins_0211_ VDD VSS
+ sg13g2_nand3_1
Xins_2314_ ins_0213_ FINE_MUX[29] ins_0212_ VDD VSS sg13g2_and2_1
Xins_2315_ ins_0214_ ins_0205_ ins_0213_ VDD VSS sg13g2_and2_1
Xins_2316_ ins_0215_ ins_0191_ ins_0214_ VDD VSS sg13g2_nand2_1
Xins_2317_ ins_0216_ ins_0202_ ins_0204_ ins_0215_ VDD VSS
+ sg13g2_nor3_1
Xins_2318_ ins_0217_ ins_0169_ ins_0193_ ins_0162_ VDD VSS
+ sg13g2_a21oi_1
Xins_2319_ ins_0218_ ins_0163_ ins_0217_ VDD VSS sg13g2_xnor2_1
Xins_2320_ ins_0219_ ins_0216_ ins_0218_ VDD VSS sg13g2_nand2_1
Xins_2321_ ins_0220_ ins_0197_ ins_0219_ VDD VSS sg13g2_nor2_1
Xins_2322_ ins_0222_ FINE_MUX[28] ins_0184_ ins_0185_ VDD
+ VSS sg13g2_a21o_1
Xins_2323_ ins_0223_ ins_0207_ ins_0222_ VDD VSS sg13g2_and2_1
Xins_2324_ ins_0224_ FINE_MUX[29] ins_0211_ ins_0223_ VDD
+ VSS sg13g2_nand3_1
Xins_2325_ ins_0225_ ins_0180_ ins_0208_ ins_0224_ VDD VSS
+ sg13g2_mux2_1
Xins_2326_ ins_0226_ FINE_MUX[29] ins_0209_ VDD VSS sg13g2_xnor2_1
Xins_2327_ ins_0227_ FINE_MUX[29] ins_0209_ ins_0206_ VDD
+ VSS sg13g2_a21oi_1
Xins_2328_ ins_0228_ ins_0183_ ins_0227_ VDD VSS sg13g2_xnor2_1
Xins_2329_ ins_0229_ ins_0226_ ins_0228_ VDD VSS sg13g2_nor2b_1
Xins_2330_ ins_0230_ FINE_MUX[29] ins_0211_ ins_0223_ VDD
+ VSS sg13g2_a21o_1
Xins_2331_ ins_0231_ ins_0224_ ins_0230_ VDD VSS sg13g2_nand2_1
Xins_2332_ ins_0233_ ins_0231_ ins_0225_ ins_0229_ VDD VSS
+ sg13g2_nand3b_1
Xins_2333_ ins_0234_ FINE_MUX[30] ins_0233_ VDD VSS sg13g2_nand2_1
Xins_2334_ ins_0235_ ins_0205_ ins_0213_ VDD VSS sg13g2_xnor2_1
Xins_2335_ ins_0236_ ins_0234_ ins_0235_ VDD VSS sg13g2_nor2_1
Xins_2336_ ins_0237_ ins_0189_ ins_0214_ VDD VSS sg13g2_nor2_1
Xins_2337_ ins_0238_ ins_0191_ ins_0237_ VDD VSS sg13g2_xnor2_1
Xins_2338_ ins_0239_ ins_0236_ ins_0238_ VDD VSS sg13g2_nand2_1
Xins_2339_ ins_0240_ ins_0204_ ins_0215_ VDD VSS sg13g2_xor2_1
Xins_2340_ ins_0241_ ins_0202_ ins_0204_ ins_0239_ VDD VSS
+ sg13g2_or3_1
Xins_2341_ ins_0242_ ins_0216_ ins_0218_ VDD VSS sg13g2_xor2_1
Xins_2342_ ins_0244_ ins_0241_ ins_0242_ VDD VSS sg13g2_nand2b_1
Xins_2343_ ins_0245_ ins_0216_ ins_0218_ ins_0195_ VDD VSS
+ sg13g2_a21oi_1
Xins_2344_ ins_0246_ ins_0197_ ins_0245_ VDD VSS sg13g2_xnor2_1
Xins_2345_ ins_0247_ ins_0244_ ins_0246_ VDD VSS sg13g2_nor2_1
Xins_2346_ ins_0248_ ins_0220_ ins_0247_ VDD VSS sg13g2_nor2_1
Xins_2347_ ins_0249_ ins_0248_ ins_0201_ VDD VSS sg13g2_nand2b_1
Xins_2348_ ins_0250_ ins_0981_ ins_0984_ ins_0982_ VDD VSS
+ sg13g2_o21ai_1
Xins_2349_ ins_0251_ ins_0276_ ins_0808_ VDD VSS sg13g2_nand2_1
Xins_2350_ ins_0252_ ins_0533_ ins_0954_ VDD VSS sg13g2_nand2_1
Xins_2351_ ins_0253_ ins_0951_ ins_0252_ VDD VSS sg13g2_nor2_1
Xins_2352_ ins_0255_ ins_0959_ ins_0961_ ins_0251_ ins_0253_
+ VDD VSS sg13g2_nand4_1
Xins_2353_ ins_0256_ ins_0964_ ins_0965_ ins_0967_ ins_0255_
+ VDD VSS sg13g2_nor4_1
Xins_2354_ ins_0257_ ins_0969_ ins_0972_ ins_0974_ ins_0256_
+ VDD VSS sg13g2_nand4_1
Xins_2355_ ins_0258_ ins_0976_ ins_0977_ ins_0257_ VDD VSS
+ sg13g2_a21oi_1
Xins_2356_ ins_0259_ ins_0979_ ins_0250_ ins_0258_ VDD VSS
+ sg13g2_nand3_1
Xins_2357_ ins_0260_ ins_0983_ ins_0985_ ins_0259_ VDD VSS
+ sg13g2_a21oi_1
Xins_2358_ ins_0261_ ins_0988_ ins_0991_ ins_0260_ VDD VSS
+ sg13g2_nand3_1
Xins_2359_ ins_0262_ ins_0992_ ins_0995_ ins_0261_ VDD VSS
+ sg13g2_a21oi_1
Xins_2360_ ins_0263_ ins_0944_ ins_0996_ ins_0262_ VDD VSS
+ sg13g2_o21ai_1
Xins_2361_ ins_0264_ ins_1025_ ins_1047_ ins_0263_ VDD VSS
+ sg13g2_nor3_1
Xins_2362_ ins_0266_ ins_1067_ ins_1095_ ins_1119_ ins_0264_
+ VDD VSS sg13g2_nand4_1
Xins_2363_ ins_0267_ ins_1120_ ins_1141_ ins_0266_ VDD VSS
+ sg13g2_a21oi_1
Xins_2364_ ins_0268_ ins_1165_ ins_1187_ ins_1216_ ins_0267_
+ VDD VSS sg13g2_nand4_1
Xins_2365_ ins_0269_ ins_1217_ ins_0019_ ins_0268_ VDD VSS
+ sg13g2_a21oi_1
Xins_2366_ ins_0270_ ins_0047_ ins_0068_ ins_0097_ ins_0269_
+ VDD VSS sg13g2_nand4_1
Xins_2367_ ins_0271_ ins_0098_ ins_0117_ ins_0270_ VDD VSS
+ sg13g2_a21oi_1
Xins_2368_ ins_0272_ ins_0147_ ins_0271_ VDD VSS sg13g2_nand2_1
Xins_2369_ ins_0273_ ins_0148_ ins_0167_ ins_0272_ VDD VSS
+ sg13g2_a21oi_1
Xins_2370_ ins_0274_ ins_0200_ ins_0249_ ins_0273_ VDD VSS
+ sg13g2_nand3_1
Xins_2371_ ins_0275_ phase_11_ ins_0200_ ins_0249_ ins_0273_
+ VDD VSS sg13g2_nand4_1
Xins_2372_ ins_0277_ phase_11_ ins_0274_ VDD VSS sg13g2_xnor2_1
Xins_2373_ ins_0278_ ins_0201_ ins_0248_ VDD VSS sg13g2_xnor2_1
Xins_2374_ ins_0279_ ins_0278_ phase_10_ VDD VSS sg13g2_nor2b_1
Xins_2375_ ins_0280_ phase_10_ ins_0278_ VDD VSS sg13g2_nand2b_1
Xins_2376_ ins_0281_ ins_0279_ ins_0280_ VDD VSS sg13g2_nand2b_1
Xins_2377_ ins_0282_ ins_0244_ ins_0246_ VDD VSS sg13g2_xor2_1
Xins_2378_ ins_0283_ ins_0282_ phase_9_ VDD VSS sg13g2_nand2b_1
Xins_2379_ ins_0284_ phase_9_ ins_0282_ VDD VSS sg13g2_nor2b_1
Xins_2380_ ins_0285_ phase_9_ ins_0282_ VDD VSS sg13g2_xnor2_1
Xins_2381_ ins_0286_ ins_0241_ ins_0242_ VDD VSS sg13g2_xnor2_1
Xins_2382_ ins_0288_ ins_0286_ phase_8_ VDD VSS sg13g2_nor2b_1
Xins_2383_ ins_0289_ ins_0215_ ins_0239_ ins_0204_ VDD VSS
+ sg13g2_a21oi_1
Xins_2384_ ins_0290_ ins_0202_ ins_0289_ VDD VSS sg13g2_xnor2_1
Xins_2385_ ins_0291_ ins_0290_ phase_7_ VDD VSS sg13g2_nor2b_1
Xins_2386_ ins_0292_ ins_0291_ VDD VSS sg13g2_inv_1
Xins_2387_ ins_0293_ phase_7_ ins_0290_ VDD VSS sg13g2_nor2b_1
Xins_2388_ ins_0294_ ins_0291_ ins_0293_ VDD VSS sg13g2_nor2_1
Xins_2389_ ins_0295_ ins_0239_ ins_0240_ VDD VSS sg13g2_xnor2_1
Xins_2390_ ins_0296_ ins_0295_ phase_6_ VDD VSS sg13g2_nor2b_1
Xins_2391_ ins_0297_ phase_6_ ins_0295_ VDD VSS sg13g2_xnor2_1
Xins_2392_ ins_0299_ ins_0236_ ins_0238_ VDD VSS sg13g2_xnor2_1
Xins_2393_ ins_0300_ phase_5_ ins_0299_ VDD VSS sg13g2_and2_1
Xins_2394_ ins_0301_ phase_5_ ins_0299_ VDD VSS sg13g2_nor2_1
Xins_2395_ ins_0302_ ins_0234_ ins_0235_ VDD VSS sg13g2_xor2_1
Xins_2396_ ins_0303_ ins_0302_ phase_4_ VDD VSS sg13g2_nor2b_1
Xins_2397_ ins_0304_ phase_4_ ins_0302_ VDD VSS sg13g2_nand2b_1
Xins_2398_ ins_0305_ ins_0303_ ins_0304_ VDD VSS sg13g2_nand2b_1
Xins_2399_ ins_0306_ ins_0078_ ins_0226_ VDD VSS sg13g2_nor2_1
Xins_2400_ ins_0307_ ins_0228_ ins_0306_ VDD VSS sg13g2_nand2_1
Xins_2401_ ins_0308_ ins_0231_ ins_0307_ VDD VSS sg13g2_nor2_1
Xins_2402_ ins_0310_ ins_0231_ ins_0307_ VDD VSS sg13g2_xor2_1
Xins_2403_ ins_0311_ phase_2_ ins_0310_ VDD VSS sg13g2_and2_1
Xins_2404_ ins_0312_ ins_0228_ ins_0306_ VDD VSS sg13g2_xor2_1
Xins_2405_ ins_0313_ phase_1_ ins_0312_ VDD VSS sg13g2_nand2_1
Xins_2406_ ins_0314_ ins_0078_ ins_0226_ VDD VSS sg13g2_xnor2_1
Xins_2407_ ins_0315_ ins_0210_ ins_0314_ VDD VSS sg13g2_or2_1
Xins_2408_ ins_0316_ phase_1_ ins_0312_ VDD VSS sg13g2_xnor2_1
Xins_2409_ ins_0317_ ins_0315_ ins_0316_ ins_0313_ VDD VSS
+ sg13g2_o21ai_1
Xins_2410_ ins_0318_ phase_2_ ins_0310_ VDD VSS sg13g2_xnor2_1
Xins_2411_ ins_0319_ ins_0318_ ins_0317_ VDD VSS sg13g2_nor2b_1
Xins_2412_ ins_0321_ ins_0311_ ins_0319_ phase_3_ VDD VSS
+ sg13g2_o21ai_1
Xins_2413_ ins_0322_ ins_0321_ VDD VSS sg13g2_inv_1
Xins_2414_ ins_0323_ phase_3_ ins_0311_ ins_0319_ VDD VSS
+ sg13g2_nor3_1
Xins_2415_ ins_0324_ ins_0225_ ins_0308_ VDD VSS sg13g2_xnor2_1
Xins_2416_ ins_0325_ ins_0321_ ins_0324_ ins_0323_ VDD VSS
+ sg13g2_a21oi_1
Xins_2417_ ins_0326_ ins_0304_ ins_0325_ ins_0303_ VDD VSS
+ sg13g2_a21oi_1
Xins_2418_ ins_0327_ ins_0301_ ins_0326_ VDD VSS sg13g2_nor2_1
Xins_2419_ ins_0328_ ins_0300_ ins_0327_ VDD VSS sg13g2_nor2_1
Xins_2420_ ins_0329_ ins_0328_ VDD VSS sg13g2_inv_1
Xins_2421_ ins_0330_ ins_0297_ ins_0329_ ins_0296_ VDD VSS
+ sg13g2_a21oi_1
Xins_2422_ ins_0332_ ins_0293_ ins_0330_ ins_0292_ VDD VSS
+ sg13g2_o21ai_1
Xins_2423_ ins_0333_ phase_8_ ins_0286_ VDD VSS sg13g2_xnor2_1
Xins_2424_ ins_0334_ ins_0332_ ins_0333_ ins_0288_ VDD VSS
+ sg13g2_a21oi_1
Xins_2425_ ins_0335_ ins_0284_ ins_0334_ ins_0283_ VDD VSS
+ sg13g2_o21ai_1
Xins_2426_ ins_0336_ ins_0280_ ins_0335_ ins_0279_ VDD VSS
+ sg13g2_a21oi_1
Xins_2427_ ins_0337_ ins_0336_ ins_0277_ VDD VSS sg13g2_nand2b_1
Xins_2428_ ins_0338_ ins_0275_ ins_0337_ VDD VSS sg13g2_nand2_1
Xins_2429_ ins_0339_ ins_0275_ ins_0337_ ins_0221_ VDD VSS
+ sg13g2_a21o_1
Xins_2430_ ins_0340_ ins_0232_ ins_0243_ ins_0339_ VDD VSS
+ sg13g2_nor3_1
Xins_2431_ ins_0341_ ins_0232_ ins_0243_ ins_0254_ ins_0339_
+ VDD VSS sg13g2_nor4_1
Xins_2432_ ins_0000_ OUT ins_0341_ VDD VSS sg13g2_xor2_1
Xins_2433_ phase_sum_1_ ins_0315_ ins_0316_ VDD VSS sg13g2_xor2_1
Xins_2434_ phase_sum_2_ ins_0317_ ins_0318_ VDD VSS sg13g2_xnor2_1
Xins_2435_ ins_0343_ ins_0322_ ins_0323_ VDD VSS sg13g2_nor2_1
Xins_2436_ phase_sum_3_ ins_0324_ ins_0343_ VDD VSS sg13g2_xnor2_1
Xins_2437_ phase_sum_4_ ins_0305_ ins_0325_ VDD VSS sg13g2_xnor2_1
Xins_2438_ ins_0344_ ins_0300_ ins_0301_ VDD VSS sg13g2_nor2_1
Xins_2439_ phase_sum_5_ ins_0326_ ins_0344_ VDD VSS sg13g2_xnor2_1
Xins_2440_ phase_sum_6_ ins_0297_ ins_0328_ VDD VSS sg13g2_xnor2_1
Xins_2441_ phase_sum_7_ ins_0294_ ins_0330_ VDD VSS sg13g2_xnor2_1
Xins_2442_ phase_sum_8_ ins_0332_ ins_0333_ VDD VSS sg13g2_xor2_1
Xins_2443_ phase_sum_9_ ins_0285_ ins_0334_ VDD VSS sg13g2_xnor2_1
Xins_2444_ phase_sum_10_ ins_0281_ ins_0335_ VDD VSS sg13g2_xnor2_1
Xins_2445_ phase_sum_11_ ins_0277_ ins_0336_ VDD VSS sg13g2_xnor2_1
Xins_2446_ phase_sum_12_ ins_0221_ ins_0338_ VDD VSS sg13g2_xnor2_1
Xins_2447_ phase_sum_13_ phase_13_ ins_0339_ VDD VSS sg13g2_xnor2_1
Xins_2448_ ins_0346_ ins_0232_ ins_0339_ ins_0243_ VDD VSS
+ sg13g2_o21ai_1
Xins_2449_ phase_sum_14_ ins_0340_ ins_0346_ VDD VSS sg13g2_nor2b_1
Xins_2450_ phase_sum_15_ ins_0254_ ins_0340_ VDD VSS sg13g2_xnor2_1
Xins_2451_ phase_sum_0_ phase_0_ ins_0314_ VDD VSS sg13g2_xnor2_1
Xins_2452_ OUT TICK ins_0000_ DCO_EN VDD VSS sg13g2_dfrbpq_1
Xins_2453_ phase_0_ TICK phase_sum_0_ DCO_EN VDD VSS sg13g2_dfrbpq_1
Xins_2454_ phase_1_ TICK phase_sum_1_ DCO_EN VDD VSS sg13g2_dfrbpq_1
Xins_2455_ phase_2_ TICK phase_sum_2_ DCO_EN VDD VSS sg13g2_dfrbpq_1
Xins_2456_ phase_3_ TICK phase_sum_3_ DCO_EN VDD VSS sg13g2_dfrbpq_1
Xins_2457_ phase_4_ TICK phase_sum_4_ DCO_EN VDD VSS sg13g2_dfrbpq_1
Xins_2458_ phase_5_ TICK phase_sum_5_ DCO_EN VDD VSS sg13g2_dfrbpq_1
Xins_2459_ phase_6_ TICK phase_sum_6_ DCO_EN VDD VSS sg13g2_dfrbpq_1
Xins_2460_ phase_7_ TICK phase_sum_7_ DCO_EN VDD VSS sg13g2_dfrbpq_1
Xins_2461_ phase_8_ TICK phase_sum_8_ DCO_EN VDD VSS sg13g2_dfrbpq_1
Xins_2462_ phase_9_ TICK phase_sum_9_ DCO_EN VDD VSS sg13g2_dfrbpq_1
Xins_2463_ phase_10_ TICK phase_sum_10_ DCO_EN VDD VSS sg13g2_dfrbpq_1
Xins_2464_ phase_11_ TICK phase_sum_11_ DCO_EN VDD VSS sg13g2_dfrbpq_1
Xins_2465_ phase_12_ TICK phase_sum_12_ DCO_EN VDD VSS sg13g2_dfrbpq_1
Xins_2466_ phase_13_ TICK phase_sum_13_ DCO_EN VDD VSS sg13g2_dfrbpq_1
Xins_2467_ phase_14_ TICK phase_sum_14_ DCO_EN VDD VSS sg13g2_dfrbpq_1
Xins_2468_ phase_15_ TICK phase_sum_15_ DCO_EN VDD VSS sg13g2_dfrbpq_1
XANTENNA_1 REF VDD VSS sg13g2_antennanp
XFILLER_0_0 VDD VSS sg13g2_decap_8
XFILLER_0_7 VDD VSS sg13g2_decap_8
XFILLER_0_14 VDD VSS sg13g2_decap_8
XFILLER_0_21 VDD VSS sg13g2_decap_8
XFILLER_0_28 VDD VSS sg13g2_decap_8
XFILLER_0_35 VDD VSS sg13g2_decap_8
XFILLER_0_42 VDD VSS sg13g2_decap_8
XFILLER_0_49 VDD VSS sg13g2_decap_8
XFILLER_0_56 VDD VSS sg13g2_decap_8
XFILLER_0_63 VDD VSS sg13g2_decap_8
XFILLER_0_70 VDD VSS sg13g2_decap_8
XFILLER_0_77 VDD VSS sg13g2_fill_2
XFILLER_0_79 VDD VSS sg13g2_fill_1
XFILLER_0_85 VDD VSS sg13g2_decap_8
XFILLER_0_92 VDD VSS sg13g2_decap_8
XFILLER_0_99 VDD VSS sg13g2_decap_8
XFILLER_0_106 VDD VSS sg13g2_fill_1
XFILLER_0_112 VDD VSS sg13g2_decap_8
XFILLER_0_119 VDD VSS sg13g2_decap_8
XFILLER_0_126 VDD VSS sg13g2_decap_8
XFILLER_0_133 VDD VSS sg13g2_decap_8
XFILLER_0_140 VDD VSS sg13g2_decap_8
XFILLER_0_147 VDD VSS sg13g2_decap_8
XFILLER_0_154 VDD VSS sg13g2_decap_8
XFILLER_0_161 VDD VSS sg13g2_decap_8
XFILLER_0_168 VDD VSS sg13g2_decap_8
XFILLER_0_175 VDD VSS sg13g2_decap_8
XFILLER_0_182 VDD VSS sg13g2_decap_8
XFILLER_0_189 VDD VSS sg13g2_decap_8
XFILLER_0_196 VDD VSS sg13g2_decap_8
XFILLER_0_203 VDD VSS sg13g2_decap_8
XFILLER_0_210 VDD VSS sg13g2_decap_8
XFILLER_0_217 VDD VSS sg13g2_decap_8
XFILLER_0_224 VDD VSS sg13g2_decap_8
XFILLER_0_231 VDD VSS sg13g2_decap_8
XFILLER_0_238 VDD VSS sg13g2_decap_8
XFILLER_0_245 VDD VSS sg13g2_decap_8
XFILLER_0_252 VDD VSS sg13g2_decap_8
XFILLER_0_259 VDD VSS sg13g2_decap_4
XFILLER_0_266 VDD VSS sg13g2_decap_8
XFILLER_0_273 VDD VSS sg13g2_decap_8
XFILLER_0_280 VDD VSS sg13g2_decap_8
XFILLER_0_287 VDD VSS sg13g2_decap_8
XFILLER_0_294 VDD VSS sg13g2_decap_8
XFILLER_0_301 VDD VSS sg13g2_fill_2
XFILLER_0_311 VDD VSS sg13g2_decap_8
XFILLER_0_318 VDD VSS sg13g2_decap_4
XFILLER_0_330 VDD VSS sg13g2_decap_8
XFILLER_0_337 VDD VSS sg13g2_decap_8
XFILLER_0_344 VDD VSS sg13g2_decap_4
XFILLER_0_348 VDD VSS sg13g2_fill_1
XFILLER_0_361 VDD VSS sg13g2_decap_8
XFILLER_0_368 VDD VSS sg13g2_decap_8
XFILLER_0_375 VDD VSS sg13g2_decap_8
XFILLER_0_393 VDD VSS sg13g2_decap_8
XFILLER_0_400 VDD VSS sg13g2_decap_8
XFILLER_0_407 VDD VSS sg13g2_decap_4
XFILLER_0_415 VDD VSS sg13g2_decap_8
XFILLER_0_422 VDD VSS sg13g2_decap_8
XFILLER_0_429 VDD VSS sg13g2_decap_8
XFILLER_0_436 VDD VSS sg13g2_decap_8
XFILLER_0_443 VDD VSS sg13g2_decap_8
XFILLER_0_450 VDD VSS sg13g2_decap_8
XFILLER_0_457 VDD VSS sg13g2_decap_8
XFILLER_0_464 VDD VSS sg13g2_fill_1
XFILLER_0_470 VDD VSS sg13g2_decap_8
XFILLER_0_477 VDD VSS sg13g2_fill_2
XFILLER_0_479 VDD VSS sg13g2_fill_1
XFILLER_0_488 VDD VSS sg13g2_decap_8
XFILLER_0_495 VDD VSS sg13g2_decap_8
XFILLER_0_502 VDD VSS sg13g2_decap_8
XFILLER_0_509 VDD VSS sg13g2_decap_4
XFILLER_0_513 VDD VSS sg13g2_fill_1
XFILLER_0_522 VDD VSS sg13g2_decap_8
XFILLER_0_529 VDD VSS sg13g2_decap_8
XFILLER_0_536 VDD VSS sg13g2_decap_8
XFILLER_1_0 VDD VSS sg13g2_decap_8
XFILLER_1_7 VDD VSS sg13g2_decap_4
XFILLER_1_23 VDD VSS sg13g2_decap_4
XFILLER_1_32 VDD VSS sg13g2_decap_8
XFILLER_1_39 VDD VSS sg13g2_fill_1
XFILLER_1_56 VDD VSS sg13g2_fill_1
XFILLER_1_61 VDD VSS sg13g2_decap_8
XFILLER_1_68 VDD VSS sg13g2_decap_4
XFILLER_1_89 VDD VSS sg13g2_decap_8
XFILLER_1_96 VDD VSS sg13g2_decap_4
XFILLER_1_122 VDD VSS sg13g2_decap_8
XFILLER_1_129 VDD VSS sg13g2_decap_8
XFILLER_1_136 VDD VSS sg13g2_decap_8
XFILLER_1_143 VDD VSS sg13g2_decap_8
XFILLER_1_150 VDD VSS sg13g2_decap_8
XFILLER_1_157 VDD VSS sg13g2_decap_8
XFILLER_1_164 VDD VSS sg13g2_decap_8
XFILLER_1_171 VDD VSS sg13g2_decap_8
XFILLER_1_178 VDD VSS sg13g2_decap_8
XFILLER_1_185 VDD VSS sg13g2_decap_8
XFILLER_1_192 VDD VSS sg13g2_decap_8
XFILLER_1_199 VDD VSS sg13g2_decap_8
XFILLER_1_206 VDD VSS sg13g2_decap_8
XFILLER_1_213 VDD VSS sg13g2_decap_8
XFILLER_1_220 VDD VSS sg13g2_decap_8
XFILLER_1_227 VDD VSS sg13g2_decap_8
XFILLER_1_234 VDD VSS sg13g2_decap_8
XFILLER_1_241 VDD VSS sg13g2_decap_8
XFILLER_1_275 VDD VSS sg13g2_fill_2
XFILLER_1_304 VDD VSS sg13g2_fill_1
XFILLER_1_337 VDD VSS sg13g2_decap_4
XFILLER_1_341 VDD VSS sg13g2_fill_1
XFILLER_1_369 VDD VSS sg13g2_decap_4
XFILLER_1_400 VDD VSS sg13g2_decap_8
XFILLER_1_438 VDD VSS sg13g2_decap_4
XFILLER_1_442 VDD VSS sg13g2_fill_1
XFILLER_1_470 VDD VSS sg13g2_fill_1
XFILLER_1_506 VDD VSS sg13g2_fill_2
XFILLER_2_0 VDD VSS sg13g2_decap_4
XFILLER_2_25 VDD VSS sg13g2_fill_1
XFILLER_2_32 VDD VSS sg13g2_decap_4
XFILLER_2_36 VDD VSS sg13g2_fill_2
XFILLER_2_51 VDD VSS sg13g2_fill_2
XFILLER_2_59 VDD VSS sg13g2_decap_4
XFILLER_2_63 VDD VSS sg13g2_fill_1
XFILLER_2_74 VDD VSS sg13g2_fill_2
XFILLER_2_84 VDD VSS sg13g2_decap_8
XFILLER_2_91 VDD VSS sg13g2_fill_2
XFILLER_2_93 VDD VSS sg13g2_fill_1
XFILLER_2_99 VDD VSS sg13g2_fill_2
XFILLER_2_101 VDD VSS sg13g2_fill_1
XFILLER_2_110 VDD VSS sg13g2_fill_1
XFILLER_2_119 VDD VSS sg13g2_fill_2
XFILLER_2_125 VDD VSS sg13g2_decap_8
XFILLER_2_132 VDD VSS sg13g2_decap_8
XFILLER_2_139 VDD VSS sg13g2_decap_8
XFILLER_2_146 VDD VSS sg13g2_decap_8
XFILLER_2_153 VDD VSS sg13g2_decap_8
XFILLER_2_160 VDD VSS sg13g2_decap_8
XFILLER_2_167 VDD VSS sg13g2_decap_8
XFILLER_2_174 VDD VSS sg13g2_decap_8
XFILLER_2_181 VDD VSS sg13g2_decap_8
XFILLER_2_188 VDD VSS sg13g2_decap_8
XFILLER_2_195 VDD VSS sg13g2_decap_8
XFILLER_2_202 VDD VSS sg13g2_decap_8
XFILLER_2_209 VDD VSS sg13g2_decap_8
XFILLER_2_216 VDD VSS sg13g2_decap_8
XFILLER_2_223 VDD VSS sg13g2_decap_8
XFILLER_2_230 VDD VSS sg13g2_decap_8
XFILLER_2_237 VDD VSS sg13g2_fill_2
XFILLER_2_271 VDD VSS sg13g2_decap_8
XFILLER_2_278 VDD VSS sg13g2_decap_8
XFILLER_2_285 VDD VSS sg13g2_decap_8
XFILLER_2_292 VDD VSS sg13g2_decap_4
XFILLER_2_296 VDD VSS sg13g2_fill_2
XFILLER_2_316 VDD VSS sg13g2_decap_4
XFILLER_2_320 VDD VSS sg13g2_fill_2
XFILLER_2_340 VDD VSS sg13g2_decap_8
XFILLER_2_347 VDD VSS sg13g2_fill_2
XFILLER_2_349 VDD VSS sg13g2_fill_1
XFILLER_2_358 VDD VSS sg13g2_fill_1
XFILLER_2_369 VDD VSS sg13g2_decap_8
XFILLER_2_376 VDD VSS sg13g2_decap_4
XFILLER_2_380 VDD VSS sg13g2_fill_1
XFILLER_2_399 VDD VSS sg13g2_decap_4
XFILLER_2_403 VDD VSS sg13g2_fill_2
XFILLER_2_422 VDD VSS sg13g2_decap_8
XFILLER_2_429 VDD VSS sg13g2_decap_8
XFILLER_2_436 VDD VSS sg13g2_decap_8
XFILLER_2_443 VDD VSS sg13g2_decap_8
XFILLER_2_450 VDD VSS sg13g2_fill_1
XFILLER_2_469 VDD VSS sg13g2_decap_8
XFILLER_2_476 VDD VSS sg13g2_fill_1
XFILLER_2_487 VDD VSS sg13g2_decap_8
XFILLER_2_494 VDD VSS sg13g2_decap_8
XFILLER_2_501 VDD VSS sg13g2_decap_8
XFILLER_2_508 VDD VSS sg13g2_fill_2
XFILLER_2_524 VDD VSS sg13g2_decap_8
XFILLER_2_531 VDD VSS sg13g2_decap_8
XFILLER_2_538 VDD VSS sg13g2_decap_4
XFILLER_2_542 VDD VSS sg13g2_fill_1
XFILLER_3_0 VDD VSS sg13g2_decap_8
XFILLER_3_7 VDD VSS sg13g2_fill_2
XFILLER_3_26 VDD VSS sg13g2_decap_8
XFILLER_3_33 VDD VSS sg13g2_decap_8
XFILLER_3_40 VDD VSS sg13g2_decap_4
XFILLER_3_55 VDD VSS sg13g2_decap_8
XFILLER_3_62 VDD VSS sg13g2_decap_4
XFILLER_3_66 VDD VSS sg13g2_fill_2
XFILLER_3_81 VDD VSS sg13g2_decap_8
XFILLER_3_88 VDD VSS sg13g2_decap_4
XFILLER_3_102 VDD VSS sg13g2_decap_8
XFILLER_3_109 VDD VSS sg13g2_decap_8
XFILLER_3_116 VDD VSS sg13g2_decap_8
XFILLER_3_123 VDD VSS sg13g2_decap_4
XFILLER_3_135 VDD VSS sg13g2_decap_8
XFILLER_3_142 VDD VSS sg13g2_decap_8
XFILLER_3_149 VDD VSS sg13g2_decap_8
XFILLER_3_156 VDD VSS sg13g2_decap_8
XFILLER_3_163 VDD VSS sg13g2_decap_8
XFILLER_3_170 VDD VSS sg13g2_decap_8
XFILLER_3_177 VDD VSS sg13g2_decap_8
XFILLER_3_184 VDD VSS sg13g2_decap_8
XFILLER_3_191 VDD VSS sg13g2_decap_8
XFILLER_3_198 VDD VSS sg13g2_decap_8
XFILLER_3_205 VDD VSS sg13g2_decap_8
XFILLER_3_212 VDD VSS sg13g2_decap_8
XFILLER_3_219 VDD VSS sg13g2_decap_8
XFILLER_3_226 VDD VSS sg13g2_decap_8
XFILLER_3_233 VDD VSS sg13g2_fill_1
XFILLER_3_258 VDD VSS sg13g2_fill_1
XFILLER_3_262 VDD VSS sg13g2_decap_8
XFILLER_3_304 VDD VSS sg13g2_decap_8
XFILLER_3_311 VDD VSS sg13g2_decap_8
XFILLER_3_318 VDD VSS sg13g2_decap_8
XFILLER_3_325 VDD VSS sg13g2_decap_8
XFILLER_3_332 VDD VSS sg13g2_decap_8
XFILLER_3_339 VDD VSS sg13g2_decap_4
XFILLER_3_348 VDD VSS sg13g2_decap_8
XFILLER_3_355 VDD VSS sg13g2_decap_8
XFILLER_3_362 VDD VSS sg13g2_decap_8
XFILLER_3_369 VDD VSS sg13g2_decap_8
XFILLER_3_376 VDD VSS sg13g2_decap_4
XFILLER_3_387 VDD VSS sg13g2_decap_8
XFILLER_3_394 VDD VSS sg13g2_decap_8
XFILLER_3_401 VDD VSS sg13g2_decap_8
XFILLER_3_408 VDD VSS sg13g2_decap_4
XFILLER_3_412 VDD VSS sg13g2_fill_2
XFILLER_3_418 VDD VSS sg13g2_decap_8
XFILLER_3_425 VDD VSS sg13g2_decap_4
XFILLER_3_447 VDD VSS sg13g2_decap_8
XFILLER_3_454 VDD VSS sg13g2_fill_1
XFILLER_3_462 VDD VSS sg13g2_decap_8
XFILLER_3_469 VDD VSS sg13g2_decap_8
XFILLER_3_476 VDD VSS sg13g2_decap_4
XFILLER_3_488 VDD VSS sg13g2_decap_8
XFILLER_3_495 VDD VSS sg13g2_decap_8
XFILLER_3_502 VDD VSS sg13g2_decap_4
XFILLER_3_506 VDD VSS sg13g2_fill_1
XFILLER_3_526 VDD VSS sg13g2_decap_8
XFILLER_3_533 VDD VSS sg13g2_decap_8
XFILLER_3_540 VDD VSS sg13g2_fill_2
XFILLER_3_542 VDD VSS sg13g2_fill_1
XFILLER_4_0 VDD VSS sg13g2_decap_8
XFILLER_4_7 VDD VSS sg13g2_fill_2
XFILLER_4_26 VDD VSS sg13g2_decap_8
XFILLER_4_33 VDD VSS sg13g2_decap_8
XFILLER_4_40 VDD VSS sg13g2_decap_4
XFILLER_4_44 VDD VSS sg13g2_fill_2
XFILLER_4_52 VDD VSS sg13g2_decap_8
XFILLER_4_59 VDD VSS sg13g2_decap_8
XFILLER_4_66 VDD VSS sg13g2_fill_2
XFILLER_4_68 VDD VSS sg13g2_fill_1
XFILLER_4_81 VDD VSS sg13g2_decap_4
XFILLER_4_93 VDD VSS sg13g2_decap_8
XFILLER_4_100 VDD VSS sg13g2_decap_4
XFILLER_4_110 VDD VSS sg13g2_decap_8
XFILLER_4_117 VDD VSS sg13g2_decap_8
XFILLER_4_124 VDD VSS sg13g2_fill_2
XFILLER_4_135 VDD VSS sg13g2_fill_1
XFILLER_4_140 VDD VSS sg13g2_decap_8
XFILLER_4_147 VDD VSS sg13g2_decap_8
XFILLER_4_154 VDD VSS sg13g2_decap_8
XFILLER_4_161 VDD VSS sg13g2_decap_8
XFILLER_4_168 VDD VSS sg13g2_decap_8
XFILLER_4_175 VDD VSS sg13g2_decap_8
XFILLER_4_182 VDD VSS sg13g2_decap_8
XFILLER_4_189 VDD VSS sg13g2_decap_8
XFILLER_4_196 VDD VSS sg13g2_decap_8
XFILLER_4_203 VDD VSS sg13g2_decap_8
XFILLER_4_210 VDD VSS sg13g2_decap_8
XFILLER_4_217 VDD VSS sg13g2_decap_8
XFILLER_4_224 VDD VSS sg13g2_decap_8
XFILLER_4_231 VDD VSS sg13g2_decap_8
XFILLER_4_238 VDD VSS sg13g2_fill_2
XFILLER_4_251 VDD VSS sg13g2_decap_8
XFILLER_4_258 VDD VSS sg13g2_decap_8
XFILLER_4_265 VDD VSS sg13g2_decap_8
XFILLER_4_272 VDD VSS sg13g2_decap_8
XFILLER_4_279 VDD VSS sg13g2_decap_8
XFILLER_4_286 VDD VSS sg13g2_decap_4
XFILLER_4_290 VDD VSS sg13g2_fill_1
XFILLER_4_306 VDD VSS sg13g2_decap_8
XFILLER_4_313 VDD VSS sg13g2_decap_8
XFILLER_4_320 VDD VSS sg13g2_decap_8
XFILLER_4_327 VDD VSS sg13g2_decap_8
XFILLER_4_334 VDD VSS sg13g2_fill_2
XFILLER_4_336 VDD VSS sg13g2_fill_1
XFILLER_4_357 VDD VSS sg13g2_decap_8
XFILLER_4_364 VDD VSS sg13g2_decap_8
XFILLER_4_371 VDD VSS sg13g2_decap_4
XFILLER_4_396 VDD VSS sg13g2_decap_8
XFILLER_4_403 VDD VSS sg13g2_decap_8
XFILLER_4_410 VDD VSS sg13g2_fill_2
XFILLER_4_412 VDD VSS sg13g2_fill_1
XFILLER_4_450 VDD VSS sg13g2_decap_8
XFILLER_4_457 VDD VSS sg13g2_decap_8
XFILLER_4_464 VDD VSS sg13g2_decap_8
XFILLER_4_471 VDD VSS sg13g2_fill_2
XFILLER_4_473 VDD VSS sg13g2_fill_1
XFILLER_4_486 VDD VSS sg13g2_decap_8
XFILLER_4_493 VDD VSS sg13g2_decap_8
XFILLER_4_500 VDD VSS sg13g2_fill_1
XFILLER_4_505 VDD VSS sg13g2_fill_2
XFILLER_4_515 VDD VSS sg13g2_fill_1
XFILLER_5_0 VDD VSS sg13g2_decap_8
XFILLER_5_7 VDD VSS sg13g2_decap_8
XFILLER_5_14 VDD VSS sg13g2_fill_2
XFILLER_5_16 VDD VSS sg13g2_fill_1
XFILLER_5_27 VDD VSS sg13g2_decap_8
XFILLER_5_34 VDD VSS sg13g2_fill_2
XFILLER_5_36 VDD VSS sg13g2_fill_1
XFILLER_5_60 VDD VSS sg13g2_decap_8
XFILLER_5_67 VDD VSS sg13g2_decap_8
XFILLER_5_74 VDD VSS sg13g2_decap_8
XFILLER_5_81 VDD VSS sg13g2_fill_2
XFILLER_5_88 VDD VSS sg13g2_decap_8
XFILLER_5_95 VDD VSS sg13g2_fill_2
XFILLER_5_97 VDD VSS sg13g2_fill_1
XFILLER_5_113 VDD VSS sg13g2_decap_4
XFILLER_5_143 VDD VSS sg13g2_decap_8
XFILLER_5_150 VDD VSS sg13g2_decap_8
XFILLER_5_157 VDD VSS sg13g2_decap_8
XFILLER_5_164 VDD VSS sg13g2_decap_8
XFILLER_5_171 VDD VSS sg13g2_decap_8
XFILLER_5_178 VDD VSS sg13g2_decap_8
XFILLER_5_185 VDD VSS sg13g2_decap_8
XFILLER_5_192 VDD VSS sg13g2_decap_8
XFILLER_5_199 VDD VSS sg13g2_decap_8
XFILLER_5_206 VDD VSS sg13g2_decap_8
XFILLER_5_213 VDD VSS sg13g2_decap_8
XFILLER_5_220 VDD VSS sg13g2_decap_8
XFILLER_5_227 VDD VSS sg13g2_decap_8
XFILLER_5_234 VDD VSS sg13g2_decap_4
XFILLER_5_265 VDD VSS sg13g2_decap_8
XFILLER_5_272 VDD VSS sg13g2_decap_8
XFILLER_5_279 VDD VSS sg13g2_decap_8
XFILLER_5_286 VDD VSS sg13g2_decap_8
XFILLER_5_293 VDD VSS sg13g2_fill_1
XFILLER_5_299 VDD VSS sg13g2_decap_8
XFILLER_5_306 VDD VSS sg13g2_decap_8
XFILLER_5_313 VDD VSS sg13g2_decap_8
XFILLER_5_328 VDD VSS sg13g2_decap_8
XFILLER_5_335 VDD VSS sg13g2_fill_1
XFILLER_5_344 VDD VSS sg13g2_fill_1
XFILLER_5_361 VDD VSS sg13g2_decap_8
XFILLER_5_368 VDD VSS sg13g2_decap_8
XFILLER_5_375 VDD VSS sg13g2_decap_4
XFILLER_5_379 VDD VSS sg13g2_fill_1
XFILLER_5_385 VDD VSS sg13g2_fill_2
XFILLER_5_395 VDD VSS sg13g2_decap_8
XFILLER_5_402 VDD VSS sg13g2_decap_8
XFILLER_5_409 VDD VSS sg13g2_fill_1
XFILLER_5_422 VDD VSS sg13g2_decap_8
XFILLER_5_429 VDD VSS sg13g2_decap_8
XFILLER_5_436 VDD VSS sg13g2_decap_4
XFILLER_5_452 VDD VSS sg13g2_decap_8
XFILLER_5_459 VDD VSS sg13g2_decap_8
XFILLER_5_466 VDD VSS sg13g2_decap_8
XFILLER_5_473 VDD VSS sg13g2_decap_8
XFILLER_5_480 VDD VSS sg13g2_fill_1
XFILLER_5_492 VDD VSS sg13g2_decap_8
XFILLER_5_499 VDD VSS sg13g2_fill_2
XFILLER_5_501 VDD VSS sg13g2_fill_1
XFILLER_5_514 VDD VSS sg13g2_decap_8
XFILLER_5_521 VDD VSS sg13g2_decap_8
XFILLER_5_528 VDD VSS sg13g2_decap_8
XFILLER_5_535 VDD VSS sg13g2_decap_8
XFILLER_5_542 VDD VSS sg13g2_fill_1
XFILLER_6_0 VDD VSS sg13g2_decap_8
XFILLER_6_7 VDD VSS sg13g2_decap_4
XFILLER_6_11 VDD VSS sg13g2_fill_2
XFILLER_6_27 VDD VSS sg13g2_fill_1
XFILLER_6_36 VDD VSS sg13g2_decap_8
XFILLER_6_43 VDD VSS sg13g2_fill_2
XFILLER_6_52 VDD VSS sg13g2_fill_1
XFILLER_6_59 VDD VSS sg13g2_decap_8
XFILLER_6_66 VDD VSS sg13g2_decap_8
XFILLER_6_86 VDD VSS sg13g2_fill_1
XFILLER_6_95 VDD VSS sg13g2_decap_8
XFILLER_6_102 VDD VSS sg13g2_decap_8
XFILLER_6_109 VDD VSS sg13g2_decap_8
XFILLER_6_116 VDD VSS sg13g2_decap_8
XFILLER_6_123 VDD VSS sg13g2_decap_8
XFILLER_6_130 VDD VSS sg13g2_decap_4
XFILLER_6_142 VDD VSS sg13g2_decap_8
XFILLER_6_149 VDD VSS sg13g2_decap_8
XFILLER_6_156 VDD VSS sg13g2_decap_8
XFILLER_6_163 VDD VSS sg13g2_decap_8
XFILLER_6_170 VDD VSS sg13g2_decap_8
XFILLER_6_177 VDD VSS sg13g2_decap_8
XFILLER_6_184 VDD VSS sg13g2_decap_8
XFILLER_6_191 VDD VSS sg13g2_decap_8
XFILLER_6_198 VDD VSS sg13g2_decap_8
XFILLER_6_205 VDD VSS sg13g2_decap_8
XFILLER_6_212 VDD VSS sg13g2_decap_8
XFILLER_6_219 VDD VSS sg13g2_decap_8
XFILLER_6_226 VDD VSS sg13g2_decap_8
XFILLER_6_233 VDD VSS sg13g2_decap_8
XFILLER_6_240 VDD VSS sg13g2_decap_4
XFILLER_6_252 VDD VSS sg13g2_decap_8
XFILLER_6_259 VDD VSS sg13g2_decap_8
XFILLER_6_266 VDD VSS sg13g2_decap_8
XFILLER_6_273 VDD VSS sg13g2_fill_2
XFILLER_6_300 VDD VSS sg13g2_decap_8
XFILLER_6_307 VDD VSS sg13g2_decap_8
XFILLER_6_322 VDD VSS sg13g2_fill_2
XFILLER_6_329 VDD VSS sg13g2_decap_8
XFILLER_6_336 VDD VSS sg13g2_decap_8
XFILLER_6_343 VDD VSS sg13g2_decap_4
XFILLER_6_351 VDD VSS sg13g2_fill_2
XFILLER_6_362 VDD VSS sg13g2_decap_8
XFILLER_6_369 VDD VSS sg13g2_decap_8
XFILLER_6_376 VDD VSS sg13g2_fill_2
XFILLER_6_386 VDD VSS sg13g2_decap_8
XFILLER_6_393 VDD VSS sg13g2_fill_2
XFILLER_6_395 VDD VSS sg13g2_fill_1
XFILLER_6_400 VDD VSS sg13g2_decap_8
XFILLER_6_407 VDD VSS sg13g2_decap_8
XFILLER_6_430 VDD VSS sg13g2_decap_8
XFILLER_6_437 VDD VSS sg13g2_decap_8
XFILLER_6_444 VDD VSS sg13g2_fill_1
XFILLER_6_453 VDD VSS sg13g2_decap_8
XFILLER_6_460 VDD VSS sg13g2_decap_8
XFILLER_6_467 VDD VSS sg13g2_fill_2
XFILLER_6_485 VDD VSS sg13g2_decap_8
XFILLER_6_492 VDD VSS sg13g2_decap_8
XFILLER_6_499 VDD VSS sg13g2_decap_8
XFILLER_6_506 VDD VSS sg13g2_fill_2
XFILLER_6_524 VDD VSS sg13g2_fill_1
XFILLER_6_530 VDD VSS sg13g2_decap_8
XFILLER_6_537 VDD VSS sg13g2_decap_4
XFILLER_6_541 VDD VSS sg13g2_fill_2
XFILLER_7_0 VDD VSS sg13g2_decap_4
XFILLER_7_4 VDD VSS sg13g2_fill_2
XFILLER_7_27 VDD VSS sg13g2_decap_8
XFILLER_7_34 VDD VSS sg13g2_decap_8
XFILLER_7_41 VDD VSS sg13g2_decap_8
XFILLER_7_60 VDD VSS sg13g2_decap_8
XFILLER_7_67 VDD VSS sg13g2_fill_2
XFILLER_7_83 VDD VSS sg13g2_decap_8
XFILLER_7_90 VDD VSS sg13g2_decap_8
XFILLER_7_97 VDD VSS sg13g2_decap_8
XFILLER_7_115 VDD VSS sg13g2_fill_2
XFILLER_7_125 VDD VSS sg13g2_decap_8
XFILLER_7_146 VDD VSS sg13g2_decap_8
XFILLER_7_153 VDD VSS sg13g2_decap_8
XFILLER_7_160 VDD VSS sg13g2_decap_8
XFILLER_7_167 VDD VSS sg13g2_decap_8
XFILLER_7_174 VDD VSS sg13g2_decap_8
XFILLER_7_181 VDD VSS sg13g2_decap_8
XFILLER_7_188 VDD VSS sg13g2_decap_8
XFILLER_7_195 VDD VSS sg13g2_decap_8
XFILLER_7_202 VDD VSS sg13g2_decap_8
XFILLER_7_209 VDD VSS sg13g2_decap_8
XFILLER_7_216 VDD VSS sg13g2_decap_8
XFILLER_7_223 VDD VSS sg13g2_decap_8
XFILLER_7_230 VDD VSS sg13g2_decap_8
XFILLER_7_237 VDD VSS sg13g2_fill_1
XFILLER_7_292 VDD VSS sg13g2_decap_4
XFILLER_7_340 VDD VSS sg13g2_decap_8
XFILLER_7_347 VDD VSS sg13g2_decap_4
XFILLER_7_356 VDD VSS sg13g2_decap_4
XFILLER_7_371 VDD VSS sg13g2_fill_2
XFILLER_7_373 VDD VSS sg13g2_fill_1
XFILLER_7_383 VDD VSS sg13g2_decap_8
XFILLER_7_390 VDD VSS sg13g2_fill_2
XFILLER_7_405 VDD VSS sg13g2_decap_8
XFILLER_7_412 VDD VSS sg13g2_decap_8
XFILLER_7_419 VDD VSS sg13g2_fill_2
XFILLER_7_425 VDD VSS sg13g2_decap_8
XFILLER_7_432 VDD VSS sg13g2_decap_4
XFILLER_7_436 VDD VSS sg13g2_fill_1
XFILLER_7_454 VDD VSS sg13g2_decap_8
XFILLER_7_489 VDD VSS sg13g2_decap_8
XFILLER_7_496 VDD VSS sg13g2_decap_8
XFILLER_7_503 VDD VSS sg13g2_decap_8
XFILLER_7_520 VDD VSS sg13g2_fill_2
XFILLER_7_522 VDD VSS sg13g2_fill_1
XFILLER_7_538 VDD VSS sg13g2_decap_4
XFILLER_7_542 VDD VSS sg13g2_fill_1
XFILLER_8_0 VDD VSS sg13g2_decap_8
XFILLER_8_7 VDD VSS sg13g2_decap_8
XFILLER_8_14 VDD VSS sg13g2_fill_2
XFILLER_8_16 VDD VSS sg13g2_fill_1
XFILLER_8_21 VDD VSS sg13g2_decap_8
XFILLER_8_28 VDD VSS sg13g2_decap_8
XFILLER_8_35 VDD VSS sg13g2_decap_8
XFILLER_8_42 VDD VSS sg13g2_decap_8
XFILLER_8_49 VDD VSS sg13g2_decap_8
XFILLER_8_56 VDD VSS sg13g2_decap_4
XFILLER_8_60 VDD VSS sg13g2_fill_1
XFILLER_8_69 VDD VSS sg13g2_fill_1
XFILLER_8_85 VDD VSS sg13g2_decap_8
XFILLER_8_92 VDD VSS sg13g2_decap_8
XFILLER_8_99 VDD VSS sg13g2_fill_1
XFILLER_8_107 VDD VSS sg13g2_decap_8
XFILLER_8_114 VDD VSS sg13g2_fill_2
XFILLER_8_128 VDD VSS sg13g2_decap_8
XFILLER_8_135 VDD VSS sg13g2_fill_2
XFILLER_8_137 VDD VSS sg13g2_fill_1
XFILLER_8_142 VDD VSS sg13g2_decap_8
XFILLER_8_149 VDD VSS sg13g2_decap_8
XFILLER_8_156 VDD VSS sg13g2_decap_8
XFILLER_8_163 VDD VSS sg13g2_decap_8
XFILLER_8_170 VDD VSS sg13g2_decap_8
XFILLER_8_177 VDD VSS sg13g2_decap_8
XFILLER_8_184 VDD VSS sg13g2_decap_8
XFILLER_8_191 VDD VSS sg13g2_decap_8
XFILLER_8_198 VDD VSS sg13g2_decap_8
XFILLER_8_205 VDD VSS sg13g2_decap_8
XFILLER_8_212 VDD VSS sg13g2_decap_8
XFILLER_8_219 VDD VSS sg13g2_decap_8
XFILLER_8_226 VDD VSS sg13g2_decap_8
XFILLER_8_233 VDD VSS sg13g2_decap_8
XFILLER_8_240 VDD VSS sg13g2_decap_8
XFILLER_8_247 VDD VSS sg13g2_decap_8
XFILLER_8_254 VDD VSS sg13g2_decap_8
XFILLER_8_261 VDD VSS sg13g2_decap_8
XFILLER_8_268 VDD VSS sg13g2_decap_8
XFILLER_8_275 VDD VSS sg13g2_fill_2
XFILLER_8_287 VDD VSS sg13g2_decap_8
XFILLER_8_294 VDD VSS sg13g2_decap_8
XFILLER_8_301 VDD VSS sg13g2_decap_8
XFILLER_8_308 VDD VSS sg13g2_decap_8
XFILLER_8_315 VDD VSS sg13g2_decap_4
XFILLER_8_325 VDD VSS sg13g2_decap_8
XFILLER_8_332 VDD VSS sg13g2_decap_8
XFILLER_8_339 VDD VSS sg13g2_decap_8
XFILLER_8_346 VDD VSS sg13g2_decap_4
XFILLER_8_350 VDD VSS sg13g2_fill_2
XFILLER_8_356 VDD VSS sg13g2_decap_8
XFILLER_8_363 VDD VSS sg13g2_fill_2
XFILLER_8_365 VDD VSS sg13g2_fill_1
XFILLER_8_370 VDD VSS sg13g2_decap_8
XFILLER_8_377 VDD VSS sg13g2_fill_2
XFILLER_8_392 VDD VSS sg13g2_decap_8
XFILLER_8_408 VDD VSS sg13g2_decap_8
XFILLER_8_415 VDD VSS sg13g2_decap_8
XFILLER_8_422 VDD VSS sg13g2_decap_4
XFILLER_8_426 VDD VSS sg13g2_fill_2
XFILLER_8_433 VDD VSS sg13g2_decap_8
XFILLER_8_440 VDD VSS sg13g2_decap_4
XFILLER_8_444 VDD VSS sg13g2_fill_2
XFILLER_8_454 VDD VSS sg13g2_decap_8
XFILLER_8_461 VDD VSS sg13g2_decap_8
XFILLER_8_468 VDD VSS sg13g2_decap_4
XFILLER_8_489 VDD VSS sg13g2_decap_8
XFILLER_8_496 VDD VSS sg13g2_decap_8
XFILLER_8_503 VDD VSS sg13g2_decap_8
XFILLER_8_510 VDD VSS sg13g2_fill_1
XFILLER_8_519 VDD VSS sg13g2_decap_8
XFILLER_8_526 VDD VSS sg13g2_fill_1
XFILLER_8_535 VDD VSS sg13g2_decap_8
XFILLER_8_542 VDD VSS sg13g2_fill_1
XFILLER_9_0 VDD VSS sg13g2_decap_4
XFILLER_9_4 VDD VSS sg13g2_fill_2
XFILLER_9_18 VDD VSS sg13g2_decap_8
XFILLER_9_25 VDD VSS sg13g2_decap_8
XFILLER_9_32 VDD VSS sg13g2_decap_8
XFILLER_9_39 VDD VSS sg13g2_fill_2
XFILLER_9_41 VDD VSS sg13g2_fill_1
XFILLER_9_57 VDD VSS sg13g2_decap_8
XFILLER_9_70 VDD VSS sg13g2_decap_8
XFILLER_9_77 VDD VSS sg13g2_decap_8
XFILLER_9_84 VDD VSS sg13g2_decap_8
XFILLER_9_91 VDD VSS sg13g2_decap_8
XFILLER_9_98 VDD VSS sg13g2_decap_8
XFILLER_9_105 VDD VSS sg13g2_decap_8
XFILLER_9_112 VDD VSS sg13g2_decap_8
XFILLER_9_119 VDD VSS sg13g2_decap_8
XFILLER_9_126 VDD VSS sg13g2_decap_4
XFILLER_9_134 VDD VSS sg13g2_decap_8
XFILLER_9_141 VDD VSS sg13g2_decap_4
XFILLER_9_149 VDD VSS sg13g2_decap_8
XFILLER_9_156 VDD VSS sg13g2_decap_8
XFILLER_9_163 VDD VSS sg13g2_decap_8
XFILLER_9_170 VDD VSS sg13g2_decap_8
XFILLER_9_177 VDD VSS sg13g2_decap_8
XFILLER_9_184 VDD VSS sg13g2_decap_8
XFILLER_9_191 VDD VSS sg13g2_decap_8
XFILLER_9_198 VDD VSS sg13g2_fill_2
XFILLER_9_200 VDD VSS sg13g2_fill_1
XFILLER_9_204 VDD VSS sg13g2_decap_8
XFILLER_9_211 VDD VSS sg13g2_decap_8
XFILLER_9_218 VDD VSS sg13g2_decap_8
XFILLER_9_225 VDD VSS sg13g2_decap_8
XFILLER_9_232 VDD VSS sg13g2_decap_4
XFILLER_9_240 VDD VSS sg13g2_fill_1
XFILLER_9_245 VDD VSS sg13g2_decap_8
XFILLER_9_252 VDD VSS sg13g2_fill_1
XFILLER_9_257 VDD VSS sg13g2_decap_8
XFILLER_9_264 VDD VSS sg13g2_decap_8
XFILLER_9_271 VDD VSS sg13g2_decap_8
XFILLER_9_278 VDD VSS sg13g2_decap_8
XFILLER_9_285 VDD VSS sg13g2_decap_8
XFILLER_9_292 VDD VSS sg13g2_decap_8
XFILLER_9_299 VDD VSS sg13g2_decap_8
XFILLER_9_306 VDD VSS sg13g2_decap_8
XFILLER_9_313 VDD VSS sg13g2_decap_8
XFILLER_9_320 VDD VSS sg13g2_decap_8
XFILLER_9_327 VDD VSS sg13g2_decap_8
XFILLER_9_334 VDD VSS sg13g2_fill_2
XFILLER_9_336 VDD VSS sg13g2_fill_1
XFILLER_9_350 VDD VSS sg13g2_fill_2
XFILLER_9_364 VDD VSS sg13g2_fill_2
XFILLER_9_366 VDD VSS sg13g2_fill_1
XFILLER_9_379 VDD VSS sg13g2_decap_8
XFILLER_9_386 VDD VSS sg13g2_decap_8
XFILLER_9_405 VDD VSS sg13g2_fill_2
XFILLER_9_407 VDD VSS sg13g2_fill_1
XFILLER_9_425 VDD VSS sg13g2_decap_4
XFILLER_9_444 VDD VSS sg13g2_fill_2
XFILLER_9_446 VDD VSS sg13g2_fill_1
XFILLER_9_452 VDD VSS sg13g2_decap_8
XFILLER_9_459 VDD VSS sg13g2_decap_8
XFILLER_9_466 VDD VSS sg13g2_decap_8
XFILLER_9_473 VDD VSS sg13g2_fill_2
XFILLER_9_484 VDD VSS sg13g2_decap_8
XFILLER_9_491 VDD VSS sg13g2_decap_4
XFILLER_9_495 VDD VSS sg13g2_fill_2
XFILLER_9_534 VDD VSS sg13g2_decap_8
XFILLER_9_541 VDD VSS sg13g2_fill_2
XFILLER_10_0 VDD VSS sg13g2_decap_4
XFILLER_10_4 VDD VSS sg13g2_fill_2
XFILLER_10_23 VDD VSS sg13g2_decap_8
XFILLER_10_30 VDD VSS sg13g2_decap_8
XFILLER_10_37 VDD VSS sg13g2_decap_4
XFILLER_10_41 VDD VSS sg13g2_fill_2
XFILLER_10_47 VDD VSS sg13g2_decap_8
XFILLER_10_54 VDD VSS sg13g2_decap_8
XFILLER_10_61 VDD VSS sg13g2_decap_8
XFILLER_10_68 VDD VSS sg13g2_decap_8
XFILLER_10_75 VDD VSS sg13g2_fill_2
XFILLER_10_77 VDD VSS sg13g2_fill_1
XFILLER_10_90 VDD VSS sg13g2_decap_8
XFILLER_10_97 VDD VSS sg13g2_fill_2
XFILLER_10_116 VDD VSS sg13g2_decap_8
XFILLER_10_123 VDD VSS sg13g2_decap_4
XFILLER_10_127 VDD VSS sg13g2_fill_1
XFILLER_10_156 VDD VSS sg13g2_decap_8
XFILLER_10_163 VDD VSS sg13g2_decap_8
XFILLER_10_170 VDD VSS sg13g2_decap_4
XFILLER_10_181 VDD VSS sg13g2_fill_1
XFILLER_10_186 VDD VSS sg13g2_decap_8
XFILLER_10_193 VDD VSS sg13g2_fill_1
XFILLER_10_220 VDD VSS sg13g2_fill_2
XFILLER_10_222 VDD VSS sg13g2_fill_1
XFILLER_10_263 VDD VSS sg13g2_decap_8
XFILLER_10_270 VDD VSS sg13g2_decap_8
XFILLER_10_277 VDD VSS sg13g2_fill_2
XFILLER_10_310 VDD VSS sg13g2_decap_4
XFILLER_10_314 VDD VSS sg13g2_fill_1
XFILLER_10_327 VDD VSS sg13g2_decap_8
XFILLER_10_334 VDD VSS sg13g2_decap_8
XFILLER_10_341 VDD VSS sg13g2_decap_4
XFILLER_10_353 VDD VSS sg13g2_fill_1
XFILLER_10_358 VDD VSS sg13g2_decap_8
XFILLER_10_365 VDD VSS sg13g2_decap_8
XFILLER_10_372 VDD VSS sg13g2_decap_8
XFILLER_10_379 VDD VSS sg13g2_fill_1
XFILLER_10_388 VDD VSS sg13g2_decap_8
XFILLER_10_395 VDD VSS sg13g2_fill_1
XFILLER_10_400 VDD VSS sg13g2_decap_8
XFILLER_10_407 VDD VSS sg13g2_decap_8
XFILLER_10_414 VDD VSS sg13g2_decap_8
XFILLER_10_421 VDD VSS sg13g2_decap_8
XFILLER_10_428 VDD VSS sg13g2_decap_8
XFILLER_10_435 VDD VSS sg13g2_decap_8
XFILLER_10_442 VDD VSS sg13g2_fill_1
XFILLER_10_456 VDD VSS sg13g2_decap_8
XFILLER_10_463 VDD VSS sg13g2_decap_8
XFILLER_10_470 VDD VSS sg13g2_decap_8
XFILLER_10_477 VDD VSS sg13g2_decap_8
XFILLER_10_484 VDD VSS sg13g2_decap_8
XFILLER_10_491 VDD VSS sg13g2_decap_8
XFILLER_10_498 VDD VSS sg13g2_fill_1
XFILLER_10_512 VDD VSS sg13g2_decap_8
XFILLER_10_519 VDD VSS sg13g2_fill_2
XFILLER_10_521 VDD VSS sg13g2_fill_1
XFILLER_10_527 VDD VSS sg13g2_decap_8
XFILLER_10_534 VDD VSS sg13g2_decap_8
XFILLER_10_541 VDD VSS sg13g2_fill_2
XFILLER_11_0 VDD VSS sg13g2_fill_2
XFILLER_11_2 VDD VSS sg13g2_fill_1
XFILLER_11_23 VDD VSS sg13g2_decap_8
XFILLER_11_30 VDD VSS sg13g2_decap_8
XFILLER_11_37 VDD VSS sg13g2_decap_8
XFILLER_11_44 VDD VSS sg13g2_decap_4
XFILLER_11_48 VDD VSS sg13g2_fill_1
XFILLER_11_53 VDD VSS sg13g2_fill_2
XFILLER_11_68 VDD VSS sg13g2_decap_8
XFILLER_11_75 VDD VSS sg13g2_decap_4
XFILLER_11_79 VDD VSS sg13g2_fill_1
XFILLER_11_85 VDD VSS sg13g2_fill_1
XFILLER_11_91 VDD VSS sg13g2_fill_2
XFILLER_11_119 VDD VSS sg13g2_decap_8
XFILLER_11_130 VDD VSS sg13g2_decap_4
XFILLER_11_134 VDD VSS sg13g2_fill_2
XFILLER_11_141 VDD VSS sg13g2_fill_1
XFILLER_11_150 VDD VSS sg13g2_decap_8
XFILLER_11_157 VDD VSS sg13g2_decap_8
XFILLER_11_164 VDD VSS sg13g2_fill_1
XFILLER_11_201 VDD VSS sg13g2_decap_4
XFILLER_11_205 VDD VSS sg13g2_fill_2
XFILLER_11_212 VDD VSS sg13g2_decap_4
XFILLER_11_216 VDD VSS sg13g2_fill_2
XFILLER_11_237 VDD VSS sg13g2_decap_4
XFILLER_11_241 VDD VSS sg13g2_fill_2
XFILLER_11_271 VDD VSS sg13g2_fill_1
XFILLER_11_277 VDD VSS sg13g2_decap_4
XFILLER_11_281 VDD VSS sg13g2_fill_1
XFILLER_11_295 VDD VSS sg13g2_decap_4
XFILLER_11_299 VDD VSS sg13g2_fill_2
XFILLER_11_306 VDD VSS sg13g2_decap_4
XFILLER_11_310 VDD VSS sg13g2_fill_1
XFILLER_11_315 VDD VSS sg13g2_fill_2
XFILLER_11_333 VDD VSS sg13g2_decap_8
XFILLER_11_340 VDD VSS sg13g2_decap_8
XFILLER_11_355 VDD VSS sg13g2_decap_8
XFILLER_11_362 VDD VSS sg13g2_fill_1
XFILLER_11_371 VDD VSS sg13g2_decap_8
XFILLER_11_378 VDD VSS sg13g2_fill_2
XFILLER_11_380 VDD VSS sg13g2_fill_1
XFILLER_11_386 VDD VSS sg13g2_decap_8
XFILLER_11_393 VDD VSS sg13g2_decap_4
XFILLER_11_397 VDD VSS sg13g2_fill_2
XFILLER_11_407 VDD VSS sg13g2_decap_8
XFILLER_11_431 VDD VSS sg13g2_decap_8
XFILLER_11_438 VDD VSS sg13g2_decap_8
XFILLER_11_445 VDD VSS sg13g2_fill_2
XFILLER_11_455 VDD VSS sg13g2_decap_8
XFILLER_11_462 VDD VSS sg13g2_decap_8
XFILLER_11_469 VDD VSS sg13g2_fill_1
XFILLER_11_479 VDD VSS sg13g2_fill_2
XFILLER_11_481 VDD VSS sg13g2_fill_1
XFILLER_11_490 VDD VSS sg13g2_decap_8
XFILLER_11_497 VDD VSS sg13g2_decap_8
XFILLER_11_508 VDD VSS sg13g2_fill_2
XFILLER_11_514 VDD VSS sg13g2_fill_1
XFILLER_11_520 VDD VSS sg13g2_fill_2
XFILLER_11_531 VDD VSS sg13g2_decap_8
XFILLER_11_538 VDD VSS sg13g2_decap_4
XFILLER_11_542 VDD VSS sg13g2_fill_1
XFILLER_12_0 VDD VSS sg13g2_decap_8
XFILLER_12_7 VDD VSS sg13g2_fill_2
XFILLER_12_9 VDD VSS sg13g2_fill_1
XFILLER_12_18 VDD VSS sg13g2_decap_8
XFILLER_12_25 VDD VSS sg13g2_decap_8
XFILLER_12_32 VDD VSS sg13g2_decap_4
XFILLER_12_44 VDD VSS sg13g2_fill_2
XFILLER_12_60 VDD VSS sg13g2_decap_8
XFILLER_12_67 VDD VSS sg13g2_decap_8
XFILLER_12_74 VDD VSS sg13g2_decap_4
XFILLER_12_78 VDD VSS sg13g2_fill_1
XFILLER_12_92 VDD VSS sg13g2_fill_2
XFILLER_12_94 VDD VSS sg13g2_fill_1
XFILLER_12_108 VDD VSS sg13g2_decap_8
XFILLER_12_115 VDD VSS sg13g2_decap_4
XFILLER_12_119 VDD VSS sg13g2_fill_1
XFILLER_12_128 VDD VSS sg13g2_fill_2
XFILLER_12_130 VDD VSS sg13g2_fill_1
XFILLER_12_147 VDD VSS sg13g2_decap_8
XFILLER_12_154 VDD VSS sg13g2_decap_8
XFILLER_12_161 VDD VSS sg13g2_decap_8
XFILLER_12_176 VDD VSS sg13g2_decap_8
XFILLER_12_183 VDD VSS sg13g2_decap_4
XFILLER_12_187 VDD VSS sg13g2_fill_2
XFILLER_12_197 VDD VSS sg13g2_decap_4
XFILLER_12_201 VDD VSS sg13g2_fill_1
XFILLER_12_210 VDD VSS sg13g2_decap_8
XFILLER_12_217 VDD VSS sg13g2_decap_8
XFILLER_12_224 VDD VSS sg13g2_decap_8
XFILLER_12_231 VDD VSS sg13g2_decap_8
XFILLER_12_238 VDD VSS sg13g2_fill_2
XFILLER_12_240 VDD VSS sg13g2_fill_1
XFILLER_12_245 VDD VSS sg13g2_decap_8
XFILLER_12_252 VDD VSS sg13g2_decap_8
XFILLER_12_259 VDD VSS sg13g2_decap_8
XFILLER_12_266 VDD VSS sg13g2_fill_2
XFILLER_12_268 VDD VSS sg13g2_fill_1
XFILLER_12_287 VDD VSS sg13g2_fill_1
XFILLER_12_296 VDD VSS sg13g2_decap_8
XFILLER_12_303 VDD VSS sg13g2_fill_1
XFILLER_12_309 VDD VSS sg13g2_fill_2
XFILLER_12_319 VDD VSS sg13g2_fill_1
XFILLER_12_329 VDD VSS sg13g2_decap_8
XFILLER_12_336 VDD VSS sg13g2_decap_8
XFILLER_12_343 VDD VSS sg13g2_decap_8
XFILLER_12_350 VDD VSS sg13g2_decap_4
XFILLER_12_354 VDD VSS sg13g2_fill_2
XFILLER_12_378 VDD VSS sg13g2_decap_8
XFILLER_12_385 VDD VSS sg13g2_decap_8
XFILLER_12_404 VDD VSS sg13g2_fill_1
XFILLER_12_413 VDD VSS sg13g2_decap_8
XFILLER_12_420 VDD VSS sg13g2_decap_8
XFILLER_12_427 VDD VSS sg13g2_decap_4
XFILLER_12_452 VDD VSS sg13g2_decap_8
XFILLER_12_459 VDD VSS sg13g2_decap_4
XFILLER_12_463 VDD VSS sg13g2_fill_1
XFILLER_12_496 VDD VSS sg13g2_decap_8
XFILLER_12_503 VDD VSS sg13g2_decap_8
XFILLER_12_510 VDD VSS sg13g2_decap_4
XFILLER_12_534 VDD VSS sg13g2_decap_8
XFILLER_12_541 VDD VSS sg13g2_fill_2
XFILLER_13_0 VDD VSS sg13g2_decap_8
XFILLER_13_7 VDD VSS sg13g2_decap_4
XFILLER_13_22 VDD VSS sg13g2_decap_8
XFILLER_13_29 VDD VSS sg13g2_decap_8
XFILLER_13_36 VDD VSS sg13g2_decap_8
XFILLER_13_43 VDD VSS sg13g2_decap_4
XFILLER_13_47 VDD VSS sg13g2_fill_2
XFILLER_13_67 VDD VSS sg13g2_decap_8
XFILLER_13_74 VDD VSS sg13g2_decap_8
XFILLER_13_81 VDD VSS sg13g2_decap_8
XFILLER_13_88 VDD VSS sg13g2_decap_8
XFILLER_13_95 VDD VSS sg13g2_decap_8
XFILLER_13_102 VDD VSS sg13g2_decap_8
XFILLER_13_109 VDD VSS sg13g2_decap_8
XFILLER_13_116 VDD VSS sg13g2_decap_8
XFILLER_13_128 VDD VSS sg13g2_decap_4
XFILLER_13_132 VDD VSS sg13g2_fill_1
XFILLER_13_137 VDD VSS sg13g2_decap_8
XFILLER_13_144 VDD VSS sg13g2_decap_8
XFILLER_13_151 VDD VSS sg13g2_decap_8
XFILLER_13_158 VDD VSS sg13g2_decap_8
XFILLER_13_165 VDD VSS sg13g2_fill_2
XFILLER_13_167 VDD VSS sg13g2_fill_1
XFILLER_13_173 VDD VSS sg13g2_fill_2
XFILLER_13_175 VDD VSS sg13g2_fill_1
XFILLER_13_184 VDD VSS sg13g2_decap_4
XFILLER_13_188 VDD VSS sg13g2_fill_2
XFILLER_13_196 VDD VSS sg13g2_decap_8
XFILLER_13_203 VDD VSS sg13g2_decap_8
XFILLER_13_210 VDD VSS sg13g2_decap_8
XFILLER_13_217 VDD VSS sg13g2_decap_4
XFILLER_13_221 VDD VSS sg13g2_fill_1
XFILLER_13_226 VDD VSS sg13g2_decap_8
XFILLER_13_233 VDD VSS sg13g2_decap_8
XFILLER_13_240 VDD VSS sg13g2_decap_8
XFILLER_13_247 VDD VSS sg13g2_decap_4
XFILLER_13_256 VDD VSS sg13g2_decap_8
XFILLER_13_263 VDD VSS sg13g2_decap_8
XFILLER_13_270 VDD VSS sg13g2_decap_8
XFILLER_13_277 VDD VSS sg13g2_decap_8
XFILLER_13_284 VDD VSS sg13g2_decap_8
XFILLER_13_291 VDD VSS sg13g2_decap_8
XFILLER_13_313 VDD VSS sg13g2_fill_2
XFILLER_13_315 VDD VSS sg13g2_fill_1
XFILLER_13_321 VDD VSS sg13g2_fill_1
XFILLER_13_327 VDD VSS sg13g2_decap_8
XFILLER_13_334 VDD VSS sg13g2_decap_8
XFILLER_13_341 VDD VSS sg13g2_decap_8
XFILLER_13_348 VDD VSS sg13g2_decap_8
XFILLER_13_355 VDD VSS sg13g2_decap_8
XFILLER_13_362 VDD VSS sg13g2_fill_2
XFILLER_13_377 VDD VSS sg13g2_decap_4
XFILLER_13_386 VDD VSS sg13g2_decap_8
XFILLER_13_393 VDD VSS sg13g2_decap_8
XFILLER_13_413 VDD VSS sg13g2_decap_8
XFILLER_13_420 VDD VSS sg13g2_fill_1
XFILLER_13_435 VDD VSS sg13g2_decap_8
XFILLER_13_442 VDD VSS sg13g2_fill_1
XFILLER_13_456 VDD VSS sg13g2_decap_8
XFILLER_13_463 VDD VSS sg13g2_decap_8
XFILLER_13_485 VDD VSS sg13g2_decap_8
XFILLER_13_492 VDD VSS sg13g2_decap_4
XFILLER_13_496 VDD VSS sg13g2_fill_2
XFILLER_13_511 VDD VSS sg13g2_decap_8
XFILLER_13_518 VDD VSS sg13g2_decap_4
XFILLER_13_522 VDD VSS sg13g2_fill_1
XFILLER_13_527 VDD VSS sg13g2_fill_2
XFILLER_13_529 VDD VSS sg13g2_fill_1
XFILLER_13_533 VDD VSS sg13g2_decap_8
XFILLER_13_540 VDD VSS sg13g2_fill_2
XFILLER_13_542 VDD VSS sg13g2_fill_1
XFILLER_14_0 VDD VSS sg13g2_fill_2
XFILLER_14_2 VDD VSS sg13g2_fill_1
XFILLER_14_31 VDD VSS sg13g2_decap_8
XFILLER_14_38 VDD VSS sg13g2_fill_2
XFILLER_14_56 VDD VSS sg13g2_fill_1
XFILLER_14_62 VDD VSS sg13g2_decap_8
XFILLER_14_69 VDD VSS sg13g2_decap_4
XFILLER_14_73 VDD VSS sg13g2_fill_1
XFILLER_14_79 VDD VSS sg13g2_fill_1
XFILLER_14_90 VDD VSS sg13g2_decap_8
XFILLER_14_97 VDD VSS sg13g2_fill_2
XFILLER_14_104 VDD VSS sg13g2_decap_8
XFILLER_14_111 VDD VSS sg13g2_decap_4
XFILLER_14_123 VDD VSS sg13g2_decap_4
XFILLER_14_135 VDD VSS sg13g2_decap_8
XFILLER_14_142 VDD VSS sg13g2_decap_8
XFILLER_14_154 VDD VSS sg13g2_decap_4
XFILLER_14_158 VDD VSS sg13g2_fill_1
XFILLER_14_173 VDD VSS sg13g2_fill_1
XFILLER_14_180 VDD VSS sg13g2_decap_8
XFILLER_14_187 VDD VSS sg13g2_decap_4
XFILLER_14_191 VDD VSS sg13g2_fill_1
XFILLER_14_200 VDD VSS sg13g2_decap_8
XFILLER_14_207 VDD VSS sg13g2_decap_4
XFILLER_14_211 VDD VSS sg13g2_fill_2
XFILLER_14_217 VDD VSS sg13g2_fill_1
XFILLER_14_251 VDD VSS sg13g2_fill_2
XFILLER_14_253 VDD VSS sg13g2_fill_1
XFILLER_14_262 VDD VSS sg13g2_decap_8
XFILLER_14_269 VDD VSS sg13g2_decap_4
XFILLER_14_273 VDD VSS sg13g2_fill_1
XFILLER_14_278 VDD VSS sg13g2_fill_2
XFILLER_14_280 VDD VSS sg13g2_fill_1
XFILLER_14_290 VDD VSS sg13g2_decap_8
XFILLER_14_297 VDD VSS sg13g2_decap_8
XFILLER_14_304 VDD VSS sg13g2_decap_8
XFILLER_14_311 VDD VSS sg13g2_fill_2
XFILLER_14_317 VDD VSS sg13g2_decap_8
XFILLER_14_324 VDD VSS sg13g2_fill_1
XFILLER_14_333 VDD VSS sg13g2_decap_8
XFILLER_14_340 VDD VSS sg13g2_fill_2
XFILLER_14_345 VDD VSS sg13g2_decap_8
XFILLER_14_352 VDD VSS sg13g2_decap_8
XFILLER_14_359 VDD VSS sg13g2_decap_8
XFILLER_14_390 VDD VSS sg13g2_decap_8
XFILLER_14_397 VDD VSS sg13g2_decap_4
XFILLER_14_406 VDD VSS sg13g2_decap_8
XFILLER_14_413 VDD VSS sg13g2_decap_8
XFILLER_14_420 VDD VSS sg13g2_decap_8
XFILLER_14_427 VDD VSS sg13g2_decap_8
XFILLER_14_434 VDD VSS sg13g2_decap_8
XFILLER_14_441 VDD VSS sg13g2_decap_8
XFILLER_14_448 VDD VSS sg13g2_decap_8
XFILLER_14_455 VDD VSS sg13g2_decap_8
XFILLER_14_462 VDD VSS sg13g2_decap_8
XFILLER_14_488 VDD VSS sg13g2_decap_8
XFILLER_14_495 VDD VSS sg13g2_decap_8
XFILLER_14_502 VDD VSS sg13g2_decap_8
XFILLER_14_509 VDD VSS sg13g2_decap_8
XFILLER_14_516 VDD VSS sg13g2_decap_8
XFILLER_14_528 VDD VSS sg13g2_decap_8
XFILLER_14_535 VDD VSS sg13g2_decap_8
XFILLER_14_542 VDD VSS sg13g2_fill_1
XFILLER_15_0 VDD VSS sg13g2_decap_8
XFILLER_15_7 VDD VSS sg13g2_fill_2
XFILLER_15_9 VDD VSS sg13g2_fill_1
XFILLER_15_22 VDD VSS sg13g2_decap_8
XFILLER_15_29 VDD VSS sg13g2_decap_8
XFILLER_15_36 VDD VSS sg13g2_fill_2
XFILLER_15_38 VDD VSS sg13g2_fill_1
XFILLER_15_47 VDD VSS sg13g2_fill_2
XFILLER_15_57 VDD VSS sg13g2_fill_2
XFILLER_15_67 VDD VSS sg13g2_decap_8
XFILLER_15_74 VDD VSS sg13g2_decap_4
XFILLER_15_78 VDD VSS sg13g2_fill_2
XFILLER_15_86 VDD VSS sg13g2_decap_8
XFILLER_15_103 VDD VSS sg13g2_fill_2
XFILLER_15_113 VDD VSS sg13g2_fill_2
XFILLER_15_115 VDD VSS sg13g2_fill_1
XFILLER_15_120 VDD VSS sg13g2_decap_8
XFILLER_15_127 VDD VSS sg13g2_decap_8
XFILLER_15_134 VDD VSS sg13g2_decap_8
XFILLER_15_165 VDD VSS sg13g2_fill_2
XFILLER_15_167 VDD VSS sg13g2_fill_1
XFILLER_15_176 VDD VSS sg13g2_decap_4
XFILLER_15_184 VDD VSS sg13g2_decap_8
XFILLER_15_195 VDD VSS sg13g2_decap_8
XFILLER_15_202 VDD VSS sg13g2_decap_8
XFILLER_15_213 VDD VSS sg13g2_decap_4
XFILLER_15_217 VDD VSS sg13g2_fill_2
XFILLER_15_236 VDD VSS sg13g2_decap_8
XFILLER_15_243 VDD VSS sg13g2_fill_1
XFILLER_15_258 VDD VSS sg13g2_decap_8
XFILLER_15_265 VDD VSS sg13g2_fill_1
XFILLER_15_281 VDD VSS sg13g2_fill_2
XFILLER_15_283 VDD VSS sg13g2_fill_1
XFILLER_15_292 VDD VSS sg13g2_decap_4
XFILLER_15_307 VDD VSS sg13g2_decap_8
XFILLER_15_314 VDD VSS sg13g2_decap_8
XFILLER_15_321 VDD VSS sg13g2_decap_4
XFILLER_15_325 VDD VSS sg13g2_fill_1
XFILLER_15_335 VDD VSS sg13g2_fill_2
XFILLER_15_354 VDD VSS sg13g2_decap_8
XFILLER_15_361 VDD VSS sg13g2_decap_8
XFILLER_15_368 VDD VSS sg13g2_decap_4
XFILLER_15_372 VDD VSS sg13g2_fill_2
XFILLER_15_380 VDD VSS sg13g2_decap_8
XFILLER_15_387 VDD VSS sg13g2_decap_8
XFILLER_15_394 VDD VSS sg13g2_decap_8
XFILLER_15_401 VDD VSS sg13g2_decap_8
XFILLER_15_416 VDD VSS sg13g2_decap_8
XFILLER_15_435 VDD VSS sg13g2_decap_8
XFILLER_15_442 VDD VSS sg13g2_fill_2
XFILLER_15_452 VDD VSS sg13g2_decap_8
XFILLER_15_459 VDD VSS sg13g2_decap_8
XFILLER_15_466 VDD VSS sg13g2_decap_8
XFILLER_15_473 VDD VSS sg13g2_fill_2
XFILLER_15_475 VDD VSS sg13g2_fill_1
XFILLER_15_480 VDD VSS sg13g2_decap_8
XFILLER_15_487 VDD VSS sg13g2_decap_8
XFILLER_15_502 VDD VSS sg13g2_decap_8
XFILLER_15_509 VDD VSS sg13g2_fill_2
XFILLER_15_535 VDD VSS sg13g2_decap_8
XFILLER_15_542 VDD VSS sg13g2_fill_1
XFILLER_16_0 VDD VSS sg13g2_fill_2
XFILLER_16_2 VDD VSS sg13g2_fill_1
XFILLER_16_15 VDD VSS sg13g2_decap_8
XFILLER_16_22 VDD VSS sg13g2_decap_8
XFILLER_16_29 VDD VSS sg13g2_decap_8
XFILLER_16_36 VDD VSS sg13g2_decap_8
XFILLER_16_43 VDD VSS sg13g2_fill_2
XFILLER_16_45 VDD VSS sg13g2_fill_1
XFILLER_16_50 VDD VSS sg13g2_fill_2
XFILLER_16_59 VDD VSS sg13g2_decap_8
XFILLER_16_66 VDD VSS sg13g2_decap_8
XFILLER_16_73 VDD VSS sg13g2_decap_4
XFILLER_16_77 VDD VSS sg13g2_fill_2
XFILLER_16_83 VDD VSS sg13g2_decap_8
XFILLER_16_90 VDD VSS sg13g2_decap_8
XFILLER_16_97 VDD VSS sg13g2_decap_8
XFILLER_16_104 VDD VSS sg13g2_decap_8
XFILLER_16_111 VDD VSS sg13g2_decap_8
XFILLER_16_118 VDD VSS sg13g2_fill_2
XFILLER_16_120 VDD VSS sg13g2_fill_1
XFILLER_16_137 VDD VSS sg13g2_fill_2
XFILLER_16_143 VDD VSS sg13g2_decap_8
XFILLER_16_150 VDD VSS sg13g2_fill_2
XFILLER_16_155 VDD VSS sg13g2_fill_2
XFILLER_16_157 VDD VSS sg13g2_fill_1
XFILLER_16_162 VDD VSS sg13g2_decap_8
XFILLER_16_169 VDD VSS sg13g2_decap_8
XFILLER_16_176 VDD VSS sg13g2_decap_8
XFILLER_16_183 VDD VSS sg13g2_decap_8
XFILLER_16_190 VDD VSS sg13g2_decap_8
XFILLER_16_197 VDD VSS sg13g2_decap_8
XFILLER_16_204 VDD VSS sg13g2_decap_4
XFILLER_16_208 VDD VSS sg13g2_fill_2
XFILLER_16_213 VDD VSS sg13g2_decap_8
XFILLER_16_220 VDD VSS sg13g2_decap_8
XFILLER_16_230 VDD VSS sg13g2_decap_8
XFILLER_16_237 VDD VSS sg13g2_decap_8
XFILLER_16_244 VDD VSS sg13g2_decap_8
XFILLER_16_251 VDD VSS sg13g2_fill_1
XFILLER_16_260 VDD VSS sg13g2_decap_8
XFILLER_16_267 VDD VSS sg13g2_decap_8
XFILLER_16_274 VDD VSS sg13g2_decap_8
XFILLER_16_281 VDD VSS sg13g2_decap_8
XFILLER_16_288 VDD VSS sg13g2_decap_8
XFILLER_16_295 VDD VSS sg13g2_fill_2
XFILLER_16_297 VDD VSS sg13g2_fill_1
XFILLER_16_306 VDD VSS sg13g2_decap_8
XFILLER_16_313 VDD VSS sg13g2_decap_8
XFILLER_16_320 VDD VSS sg13g2_fill_2
XFILLER_16_335 VDD VSS sg13g2_decap_4
XFILLER_16_339 VDD VSS sg13g2_fill_2
XFILLER_16_362 VDD VSS sg13g2_decap_8
XFILLER_16_369 VDD VSS sg13g2_decap_8
XFILLER_16_388 VDD VSS sg13g2_decap_8
XFILLER_16_399 VDD VSS sg13g2_decap_4
XFILLER_16_416 VDD VSS sg13g2_decap_8
XFILLER_16_423 VDD VSS sg13g2_decap_8
XFILLER_16_435 VDD VSS sg13g2_decap_8
XFILLER_16_442 VDD VSS sg13g2_decap_4
XFILLER_16_466 VDD VSS sg13g2_decap_8
XFILLER_16_473 VDD VSS sg13g2_decap_8
XFILLER_16_480 VDD VSS sg13g2_decap_4
XFILLER_16_484 VDD VSS sg13g2_fill_1
XFILLER_16_502 VDD VSS sg13g2_decap_8
XFILLER_16_509 VDD VSS sg13g2_fill_2
XFILLER_16_515 VDD VSS sg13g2_fill_2
XFILLER_16_517 VDD VSS sg13g2_fill_1
XFILLER_16_539 VDD VSS sg13g2_decap_4
XFILLER_17_0 VDD VSS sg13g2_decap_8
XFILLER_17_7 VDD VSS sg13g2_decap_8
XFILLER_17_14 VDD VSS sg13g2_fill_2
XFILLER_17_20 VDD VSS sg13g2_decap_8
XFILLER_17_27 VDD VSS sg13g2_decap_8
XFILLER_17_34 VDD VSS sg13g2_decap_8
XFILLER_17_41 VDD VSS sg13g2_fill_2
XFILLER_17_58 VDD VSS sg13g2_decap_8
XFILLER_17_65 VDD VSS sg13g2_decap_4
XFILLER_17_75 VDD VSS sg13g2_decap_8
XFILLER_17_82 VDD VSS sg13g2_decap_8
XFILLER_17_89 VDD VSS sg13g2_decap_8
XFILLER_17_96 VDD VSS sg13g2_decap_8
XFILLER_17_103 VDD VSS sg13g2_decap_8
XFILLER_17_110 VDD VSS sg13g2_fill_2
XFILLER_17_116 VDD VSS sg13g2_fill_2
XFILLER_17_126 VDD VSS sg13g2_decap_8
XFILLER_17_133 VDD VSS sg13g2_decap_8
XFILLER_17_140 VDD VSS sg13g2_decap_8
XFILLER_17_160 VDD VSS sg13g2_decap_8
XFILLER_17_167 VDD VSS sg13g2_decap_8
XFILLER_17_174 VDD VSS sg13g2_decap_8
XFILLER_17_181 VDD VSS sg13g2_fill_2
XFILLER_17_183 VDD VSS sg13g2_fill_1
XFILLER_17_198 VDD VSS sg13g2_fill_1
XFILLER_17_216 VDD VSS sg13g2_decap_8
XFILLER_17_228 VDD VSS sg13g2_decap_8
XFILLER_17_235 VDD VSS sg13g2_decap_8
XFILLER_17_242 VDD VSS sg13g2_decap_8
XFILLER_17_249 VDD VSS sg13g2_decap_8
XFILLER_17_256 VDD VSS sg13g2_decap_8
XFILLER_17_263 VDD VSS sg13g2_decap_8
XFILLER_17_270 VDD VSS sg13g2_fill_2
XFILLER_17_272 VDD VSS sg13g2_fill_1
XFILLER_17_288 VDD VSS sg13g2_decap_8
XFILLER_17_295 VDD VSS sg13g2_decap_8
XFILLER_17_302 VDD VSS sg13g2_fill_2
XFILLER_17_316 VDD VSS sg13g2_decap_8
XFILLER_17_323 VDD VSS sg13g2_decap_8
XFILLER_17_330 VDD VSS sg13g2_decap_8
XFILLER_17_337 VDD VSS sg13g2_decap_4
XFILLER_17_346 VDD VSS sg13g2_decap_4
XFILLER_17_363 VDD VSS sg13g2_decap_8
XFILLER_17_370 VDD VSS sg13g2_decap_8
XFILLER_17_377 VDD VSS sg13g2_decap_8
XFILLER_17_384 VDD VSS sg13g2_decap_4
XFILLER_17_400 VDD VSS sg13g2_fill_1
XFILLER_17_413 VDD VSS sg13g2_decap_8
XFILLER_17_420 VDD VSS sg13g2_fill_2
XFILLER_17_437 VDD VSS sg13g2_decap_8
XFILLER_17_444 VDD VSS sg13g2_fill_2
XFILLER_17_446 VDD VSS sg13g2_fill_1
XFILLER_17_452 VDD VSS sg13g2_fill_2
XFILLER_17_454 VDD VSS sg13g2_fill_1
XFILLER_17_468 VDD VSS sg13g2_decap_8
XFILLER_17_475 VDD VSS sg13g2_decap_8
XFILLER_17_482 VDD VSS sg13g2_fill_2
XFILLER_17_506 VDD VSS sg13g2_decap_8
XFILLER_17_513 VDD VSS sg13g2_decap_8
XFILLER_17_524 VDD VSS sg13g2_decap_8
XFILLER_17_531 VDD VSS sg13g2_decap_8
XFILLER_17_538 VDD VSS sg13g2_decap_4
XFILLER_17_542 VDD VSS sg13g2_fill_1
XFILLER_18_0 VDD VSS sg13g2_decap_4
XFILLER_18_4 VDD VSS sg13g2_fill_1
XFILLER_18_17 VDD VSS sg13g2_fill_1
XFILLER_18_29 VDD VSS sg13g2_decap_8
XFILLER_18_36 VDD VSS sg13g2_decap_4
XFILLER_18_40 VDD VSS sg13g2_fill_2
XFILLER_18_65 VDD VSS sg13g2_decap_8
XFILLER_18_72 VDD VSS sg13g2_decap_8
XFILLER_18_79 VDD VSS sg13g2_fill_1
XFILLER_18_83 VDD VSS sg13g2_decap_4
XFILLER_18_87 VDD VSS sg13g2_fill_1
XFILLER_18_96 VDD VSS sg13g2_decap_8
XFILLER_18_103 VDD VSS sg13g2_fill_1
XFILLER_18_133 VDD VSS sg13g2_decap_8
XFILLER_18_140 VDD VSS sg13g2_fill_2
XFILLER_18_142 VDD VSS sg13g2_fill_1
XFILLER_18_163 VDD VSS sg13g2_decap_8
XFILLER_18_170 VDD VSS sg13g2_decap_8
XFILLER_18_177 VDD VSS sg13g2_decap_4
XFILLER_18_181 VDD VSS sg13g2_fill_2
XFILLER_18_188 VDD VSS sg13g2_decap_8
XFILLER_18_195 VDD VSS sg13g2_decap_8
XFILLER_18_202 VDD VSS sg13g2_decap_4
XFILLER_18_206 VDD VSS sg13g2_fill_1
XFILLER_18_214 VDD VSS sg13g2_decap_8
XFILLER_18_228 VDD VSS sg13g2_fill_1
XFILLER_18_234 VDD VSS sg13g2_decap_8
XFILLER_18_241 VDD VSS sg13g2_fill_2
XFILLER_18_267 VDD VSS sg13g2_decap_8
XFILLER_18_274 VDD VSS sg13g2_decap_4
XFILLER_18_278 VDD VSS sg13g2_fill_1
XFILLER_18_284 VDD VSS sg13g2_decap_8
XFILLER_18_291 VDD VSS sg13g2_decap_8
XFILLER_18_302 VDD VSS sg13g2_decap_8
XFILLER_18_309 VDD VSS sg13g2_fill_2
XFILLER_18_311 VDD VSS sg13g2_fill_1
XFILLER_18_331 VDD VSS sg13g2_decap_8
XFILLER_18_338 VDD VSS sg13g2_decap_8
XFILLER_18_345 VDD VSS sg13g2_decap_8
XFILLER_18_352 VDD VSS sg13g2_fill_1
XFILLER_18_365 VDD VSS sg13g2_decap_8
XFILLER_18_372 VDD VSS sg13g2_decap_8
XFILLER_18_379 VDD VSS sg13g2_fill_1
XFILLER_18_397 VDD VSS sg13g2_decap_8
XFILLER_18_404 VDD VSS sg13g2_decap_8
XFILLER_18_411 VDD VSS sg13g2_decap_8
XFILLER_18_418 VDD VSS sg13g2_fill_2
XFILLER_18_420 VDD VSS sg13g2_fill_1
XFILLER_18_441 VDD VSS sg13g2_decap_8
XFILLER_18_448 VDD VSS sg13g2_decap_8
XFILLER_18_455 VDD VSS sg13g2_fill_1
XFILLER_18_464 VDD VSS sg13g2_decap_8
XFILLER_18_471 VDD VSS sg13g2_decap_4
XFILLER_18_475 VDD VSS sg13g2_fill_2
XFILLER_18_481 VDD VSS sg13g2_decap_8
XFILLER_18_488 VDD VSS sg13g2_decap_4
XFILLER_18_492 VDD VSS sg13g2_fill_1
XFILLER_18_496 VDD VSS sg13g2_fill_1
XFILLER_18_505 VDD VSS sg13g2_decap_8
XFILLER_18_512 VDD VSS sg13g2_decap_8
XFILLER_18_519 VDD VSS sg13g2_decap_4
XFILLER_18_523 VDD VSS sg13g2_fill_1
XFILLER_18_532 VDD VSS sg13g2_decap_8
XFILLER_18_539 VDD VSS sg13g2_decap_4
XFILLER_19_0 VDD VSS sg13g2_decap_8
XFILLER_19_7 VDD VSS sg13g2_fill_2
XFILLER_19_26 VDD VSS sg13g2_decap_8
XFILLER_19_33 VDD VSS sg13g2_decap_8
XFILLER_19_40 VDD VSS sg13g2_decap_8
XFILLER_19_47 VDD VSS sg13g2_decap_8
XFILLER_19_54 VDD VSS sg13g2_fill_2
XFILLER_19_56 VDD VSS sg13g2_fill_1
XFILLER_19_76 VDD VSS sg13g2_fill_1
XFILLER_19_90 VDD VSS sg13g2_fill_2
XFILLER_19_100 VDD VSS sg13g2_decap_8
XFILLER_19_129 VDD VSS sg13g2_fill_2
XFILLER_19_139 VDD VSS sg13g2_decap_8
XFILLER_19_146 VDD VSS sg13g2_fill_2
XFILLER_19_152 VDD VSS sg13g2_decap_8
XFILLER_19_159 VDD VSS sg13g2_decap_8
XFILLER_19_166 VDD VSS sg13g2_decap_4
XFILLER_19_180 VDD VSS sg13g2_decap_4
XFILLER_19_184 VDD VSS sg13g2_fill_2
XFILLER_19_194 VDD VSS sg13g2_decap_8
XFILLER_19_201 VDD VSS sg13g2_decap_4
XFILLER_19_205 VDD VSS sg13g2_fill_2
XFILLER_19_215 VDD VSS sg13g2_fill_2
XFILLER_19_217 VDD VSS sg13g2_fill_1
XFILLER_19_224 VDD VSS sg13g2_fill_2
XFILLER_19_231 VDD VSS sg13g2_fill_2
XFILLER_19_241 VDD VSS sg13g2_decap_4
XFILLER_19_245 VDD VSS sg13g2_fill_1
XFILLER_19_253 VDD VSS sg13g2_decap_8
XFILLER_19_260 VDD VSS sg13g2_decap_4
XFILLER_19_288 VDD VSS sg13g2_decap_8
XFILLER_19_307 VDD VSS sg13g2_decap_8
XFILLER_19_314 VDD VSS sg13g2_decap_8
XFILLER_19_321 VDD VSS sg13g2_fill_2
XFILLER_19_323 VDD VSS sg13g2_fill_1
XFILLER_19_328 VDD VSS sg13g2_fill_1
XFILLER_19_337 VDD VSS sg13g2_decap_8
XFILLER_19_344 VDD VSS sg13g2_fill_2
XFILLER_19_358 VDD VSS sg13g2_fill_2
XFILLER_19_375 VDD VSS sg13g2_decap_8
XFILLER_19_382 VDD VSS sg13g2_decap_8
XFILLER_19_389 VDD VSS sg13g2_decap_8
XFILLER_19_396 VDD VSS sg13g2_decap_8
XFILLER_19_411 VDD VSS sg13g2_decap_8
XFILLER_19_418 VDD VSS sg13g2_decap_8
XFILLER_19_425 VDD VSS sg13g2_decap_8
XFILLER_19_432 VDD VSS sg13g2_fill_1
XFILLER_19_438 VDD VSS sg13g2_decap_8
XFILLER_19_445 VDD VSS sg13g2_decap_8
XFILLER_19_452 VDD VSS sg13g2_decap_8
XFILLER_19_468 VDD VSS sg13g2_fill_2
XFILLER_19_470 VDD VSS sg13g2_fill_1
XFILLER_19_486 VDD VSS sg13g2_decap_8
XFILLER_19_493 VDD VSS sg13g2_decap_4
XFILLER_19_502 VDD VSS sg13g2_fill_2
XFILLER_19_512 VDD VSS sg13g2_fill_2
XFILLER_19_534 VDD VSS sg13g2_decap_8
XFILLER_19_541 VDD VSS sg13g2_fill_2
XFILLER_20_0 VDD VSS sg13g2_decap_8
XFILLER_20_7 VDD VSS sg13g2_fill_2
XFILLER_20_22 VDD VSS sg13g2_decap_8
XFILLER_20_29 VDD VSS sg13g2_decap_8
XFILLER_20_36 VDD VSS sg13g2_decap_8
XFILLER_20_43 VDD VSS sg13g2_decap_8
XFILLER_20_50 VDD VSS sg13g2_fill_2
XFILLER_20_73 VDD VSS sg13g2_decap_8
XFILLER_20_80 VDD VSS sg13g2_decap_4
XFILLER_20_84 VDD VSS sg13g2_fill_1
XFILLER_20_94 VDD VSS sg13g2_decap_8
XFILLER_20_101 VDD VSS sg13g2_decap_8
XFILLER_20_108 VDD VSS sg13g2_decap_8
XFILLER_20_115 VDD VSS sg13g2_decap_8
XFILLER_20_122 VDD VSS sg13g2_decap_4
XFILLER_20_126 VDD VSS sg13g2_fill_1
XFILLER_20_132 VDD VSS sg13g2_decap_8
XFILLER_20_139 VDD VSS sg13g2_decap_8
XFILLER_20_146 VDD VSS sg13g2_decap_8
XFILLER_20_156 VDD VSS sg13g2_decap_8
XFILLER_20_163 VDD VSS sg13g2_fill_1
XFILLER_20_169 VDD VSS sg13g2_decap_4
XFILLER_20_173 VDD VSS sg13g2_fill_2
XFILLER_20_200 VDD VSS sg13g2_decap_4
XFILLER_20_208 VDD VSS sg13g2_decap_8
XFILLER_20_215 VDD VSS sg13g2_decap_8
XFILLER_20_222 VDD VSS sg13g2_decap_8
XFILLER_20_229 VDD VSS sg13g2_decap_8
XFILLER_20_236 VDD VSS sg13g2_decap_8
XFILLER_20_243 VDD VSS sg13g2_fill_1
XFILLER_20_256 VDD VSS sg13g2_decap_8
XFILLER_20_263 VDD VSS sg13g2_decap_8
XFILLER_20_270 VDD VSS sg13g2_decap_8
XFILLER_20_277 VDD VSS sg13g2_fill_2
XFILLER_20_293 VDD VSS sg13g2_decap_8
XFILLER_20_300 VDD VSS sg13g2_decap_8
XFILLER_20_307 VDD VSS sg13g2_fill_2
XFILLER_20_324 VDD VSS sg13g2_decap_8
XFILLER_20_331 VDD VSS sg13g2_decap_8
XFILLER_20_338 VDD VSS sg13g2_decap_8
XFILLER_20_345 VDD VSS sg13g2_fill_2
XFILLER_20_352 VDD VSS sg13g2_decap_8
XFILLER_20_359 VDD VSS sg13g2_fill_1
XFILLER_20_368 VDD VSS sg13g2_decap_8
XFILLER_20_375 VDD VSS sg13g2_decap_8
XFILLER_20_382 VDD VSS sg13g2_decap_8
XFILLER_20_389 VDD VSS sg13g2_decap_4
XFILLER_20_401 VDD VSS sg13g2_fill_2
XFILLER_20_407 VDD VSS sg13g2_decap_8
XFILLER_20_414 VDD VSS sg13g2_fill_2
XFILLER_20_423 VDD VSS sg13g2_fill_1
XFILLER_20_432 VDD VSS sg13g2_fill_2
XFILLER_20_434 VDD VSS sg13g2_fill_1
XFILLER_20_447 VDD VSS sg13g2_decap_8
XFILLER_20_454 VDD VSS sg13g2_decap_4
XFILLER_20_463 VDD VSS sg13g2_decap_8
XFILLER_20_470 VDD VSS sg13g2_fill_2
XFILLER_20_485 VDD VSS sg13g2_decap_4
XFILLER_20_489 VDD VSS sg13g2_fill_1
XFILLER_20_507 VDD VSS sg13g2_decap_4
XFILLER_20_516 VDD VSS sg13g2_decap_4
XFILLER_20_520 VDD VSS sg13g2_fill_1
XFILLER_20_533 VDD VSS sg13g2_decap_8
XFILLER_20_540 VDD VSS sg13g2_fill_2
XFILLER_20_542 VDD VSS sg13g2_fill_1
XFILLER_21_0 VDD VSS sg13g2_decap_8
XFILLER_21_7 VDD VSS sg13g2_fill_2
XFILLER_21_14 VDD VSS sg13g2_decap_4
XFILLER_21_23 VDD VSS sg13g2_decap_8
XFILLER_21_30 VDD VSS sg13g2_decap_8
XFILLER_21_37 VDD VSS sg13g2_decap_8
XFILLER_21_44 VDD VSS sg13g2_decap_8
XFILLER_21_65 VDD VSS sg13g2_decap_8
XFILLER_21_72 VDD VSS sg13g2_decap_8
XFILLER_21_79 VDD VSS sg13g2_decap_8
XFILLER_21_86 VDD VSS sg13g2_fill_1
XFILLER_21_95 VDD VSS sg13g2_fill_2
XFILLER_21_97 VDD VSS sg13g2_fill_1
XFILLER_21_106 VDD VSS sg13g2_decap_8
XFILLER_21_113 VDD VSS sg13g2_decap_4
XFILLER_21_121 VDD VSS sg13g2_decap_8
XFILLER_21_128 VDD VSS sg13g2_decap_8
XFILLER_21_135 VDD VSS sg13g2_decap_8
XFILLER_21_142 VDD VSS sg13g2_decap_4
XFILLER_21_146 VDD VSS sg13g2_fill_2
XFILLER_21_158 VDD VSS sg13g2_fill_2
XFILLER_21_178 VDD VSS sg13g2_decap_8
XFILLER_21_185 VDD VSS sg13g2_decap_8
XFILLER_21_192 VDD VSS sg13g2_decap_8
XFILLER_21_199 VDD VSS sg13g2_decap_8
XFILLER_21_206 VDD VSS sg13g2_decap_8
XFILLER_21_233 VDD VSS sg13g2_decap_8
XFILLER_21_240 VDD VSS sg13g2_decap_8
XFILLER_21_247 VDD VSS sg13g2_decap_8
XFILLER_21_254 VDD VSS sg13g2_decap_4
XFILLER_21_258 VDD VSS sg13g2_fill_2
XFILLER_21_264 VDD VSS sg13g2_decap_8
XFILLER_21_271 VDD VSS sg13g2_decap_8
XFILLER_21_278 VDD VSS sg13g2_decap_8
XFILLER_21_285 VDD VSS sg13g2_decap_8
XFILLER_21_292 VDD VSS sg13g2_decap_8
XFILLER_21_299 VDD VSS sg13g2_decap_8
XFILLER_21_306 VDD VSS sg13g2_decap_8
XFILLER_21_313 VDD VSS sg13g2_decap_4
XFILLER_21_322 VDD VSS sg13g2_decap_8
XFILLER_21_329 VDD VSS sg13g2_decap_8
XFILLER_21_336 VDD VSS sg13g2_fill_2
XFILLER_21_338 VDD VSS sg13g2_fill_1
XFILLER_21_350 VDD VSS sg13g2_decap_8
XFILLER_21_357 VDD VSS sg13g2_decap_4
XFILLER_21_361 VDD VSS sg13g2_fill_1
XFILLER_21_367 VDD VSS sg13g2_fill_2
XFILLER_21_369 VDD VSS sg13g2_fill_1
XFILLER_21_379 VDD VSS sg13g2_decap_8
XFILLER_21_386 VDD VSS sg13g2_decap_4
XFILLER_21_411 VDD VSS sg13g2_decap_8
XFILLER_21_418 VDD VSS sg13g2_fill_2
XFILLER_21_420 VDD VSS sg13g2_fill_1
XFILLER_21_425 VDD VSS sg13g2_decap_4
XFILLER_21_429 VDD VSS sg13g2_fill_2
XFILLER_21_443 VDD VSS sg13g2_decap_8
XFILLER_21_450 VDD VSS sg13g2_decap_8
XFILLER_21_457 VDD VSS sg13g2_decap_8
XFILLER_21_464 VDD VSS sg13g2_decap_8
XFILLER_21_471 VDD VSS sg13g2_decap_8
XFILLER_21_478 VDD VSS sg13g2_decap_8
XFILLER_21_485 VDD VSS sg13g2_decap_8
XFILLER_21_492 VDD VSS sg13g2_decap_8
XFILLER_21_499 VDD VSS sg13g2_decap_8
XFILLER_21_506 VDD VSS sg13g2_decap_8
XFILLER_21_513 VDD VSS sg13g2_decap_8
XFILLER_21_520 VDD VSS sg13g2_fill_2
XFILLER_21_522 VDD VSS sg13g2_fill_1
XFILLER_21_532 VDD VSS sg13g2_decap_8
XFILLER_21_539 VDD VSS sg13g2_decap_4
XFILLER_22_0 VDD VSS sg13g2_decap_4
XFILLER_22_4 VDD VSS sg13g2_fill_1
XFILLER_22_27 VDD VSS sg13g2_decap_8
XFILLER_22_34 VDD VSS sg13g2_decap_8
XFILLER_22_41 VDD VSS sg13g2_decap_4
XFILLER_22_45 VDD VSS sg13g2_fill_1
XFILLER_22_54 VDD VSS sg13g2_fill_1
XFILLER_22_68 VDD VSS sg13g2_decap_8
XFILLER_22_75 VDD VSS sg13g2_decap_4
XFILLER_22_86 VDD VSS sg13g2_fill_2
XFILLER_22_93 VDD VSS sg13g2_fill_1
XFILLER_22_102 VDD VSS sg13g2_decap_8
XFILLER_22_109 VDD VSS sg13g2_decap_8
XFILLER_22_116 VDD VSS sg13g2_decap_8
XFILLER_22_123 VDD VSS sg13g2_decap_8
XFILLER_22_130 VDD VSS sg13g2_decap_4
XFILLER_22_144 VDD VSS sg13g2_fill_2
XFILLER_22_146 VDD VSS sg13g2_fill_1
XFILLER_22_157 VDD VSS sg13g2_decap_8
XFILLER_22_164 VDD VSS sg13g2_decap_4
XFILLER_22_168 VDD VSS sg13g2_fill_1
XFILLER_22_174 VDD VSS sg13g2_decap_8
XFILLER_22_181 VDD VSS sg13g2_decap_8
XFILLER_22_188 VDD VSS sg13g2_decap_8
XFILLER_22_195 VDD VSS sg13g2_decap_8
XFILLER_22_202 VDD VSS sg13g2_decap_8
XFILLER_22_209 VDD VSS sg13g2_fill_2
XFILLER_22_211 VDD VSS sg13g2_fill_1
XFILLER_22_223 VDD VSS sg13g2_fill_1
XFILLER_22_229 VDD VSS sg13g2_decap_4
XFILLER_22_233 VDD VSS sg13g2_fill_1
XFILLER_22_247 VDD VSS sg13g2_decap_8
XFILLER_22_254 VDD VSS sg13g2_fill_2
XFILLER_22_272 VDD VSS sg13g2_decap_8
XFILLER_22_279 VDD VSS sg13g2_fill_2
XFILLER_22_317 VDD VSS sg13g2_decap_8
XFILLER_22_324 VDD VSS sg13g2_decap_8
XFILLER_22_331 VDD VSS sg13g2_decap_8
XFILLER_22_338 VDD VSS sg13g2_decap_4
XFILLER_22_350 VDD VSS sg13g2_decap_8
XFILLER_22_357 VDD VSS sg13g2_decap_4
XFILLER_22_361 VDD VSS sg13g2_fill_2
XFILLER_22_400 VDD VSS sg13g2_decap_8
XFILLER_22_407 VDD VSS sg13g2_decap_8
XFILLER_22_414 VDD VSS sg13g2_decap_8
XFILLER_22_421 VDD VSS sg13g2_decap_8
XFILLER_22_428 VDD VSS sg13g2_decap_8
XFILLER_22_442 VDD VSS sg13g2_decap_8
XFILLER_22_449 VDD VSS sg13g2_decap_4
XFILLER_22_472 VDD VSS sg13g2_decap_8
XFILLER_22_479 VDD VSS sg13g2_decap_4
XFILLER_22_488 VDD VSS sg13g2_decap_8
XFILLER_22_495 VDD VSS sg13g2_decap_4
XFILLER_22_499 VDD VSS sg13g2_fill_2
XFILLER_22_509 VDD VSS sg13g2_fill_1
XFILLER_22_518 VDD VSS sg13g2_fill_1
XFILLER_22_536 VDD VSS sg13g2_decap_8
XFILLER_23_0 VDD VSS sg13g2_fill_2
XFILLER_23_2 VDD VSS sg13g2_fill_1
XFILLER_23_24 VDD VSS sg13g2_decap_8
XFILLER_23_31 VDD VSS sg13g2_decap_8
XFILLER_23_38 VDD VSS sg13g2_decap_4
XFILLER_23_42 VDD VSS sg13g2_fill_2
XFILLER_23_59 VDD VSS sg13g2_fill_1
XFILLER_23_64 VDD VSS sg13g2_decap_8
XFILLER_23_71 VDD VSS sg13g2_decap_4
XFILLER_23_91 VDD VSS sg13g2_fill_2
XFILLER_23_103 VDD VSS sg13g2_decap_8
XFILLER_23_110 VDD VSS sg13g2_decap_4
XFILLER_23_135 VDD VSS sg13g2_decap_8
XFILLER_23_142 VDD VSS sg13g2_decap_8
XFILLER_23_149 VDD VSS sg13g2_decap_8
XFILLER_23_156 VDD VSS sg13g2_decap_8
XFILLER_23_163 VDD VSS sg13g2_decap_8
XFILLER_23_170 VDD VSS sg13g2_decap_4
XFILLER_23_182 VDD VSS sg13g2_decap_8
XFILLER_23_189 VDD VSS sg13g2_decap_4
XFILLER_23_193 VDD VSS sg13g2_fill_1
XFILLER_23_199 VDD VSS sg13g2_decap_8
XFILLER_23_214 VDD VSS sg13g2_decap_8
XFILLER_23_221 VDD VSS sg13g2_fill_1
XFILLER_23_232 VDD VSS sg13g2_fill_2
XFILLER_23_234 VDD VSS sg13g2_fill_1
XFILLER_23_257 VDD VSS sg13g2_decap_8
XFILLER_23_264 VDD VSS sg13g2_fill_2
XFILLER_23_279 VDD VSS sg13g2_decap_4
XFILLER_23_290 VDD VSS sg13g2_decap_8
XFILLER_23_297 VDD VSS sg13g2_decap_8
XFILLER_23_304 VDD VSS sg13g2_decap_4
XFILLER_23_308 VDD VSS sg13g2_fill_2
XFILLER_23_315 VDD VSS sg13g2_decap_4
XFILLER_23_324 VDD VSS sg13g2_decap_4
XFILLER_23_332 VDD VSS sg13g2_decap_8
XFILLER_23_339 VDD VSS sg13g2_decap_4
XFILLER_23_347 VDD VSS sg13g2_decap_4
XFILLER_23_355 VDD VSS sg13g2_fill_2
XFILLER_23_365 VDD VSS sg13g2_decap_8
XFILLER_23_372 VDD VSS sg13g2_decap_8
XFILLER_23_379 VDD VSS sg13g2_decap_8
XFILLER_23_386 VDD VSS sg13g2_fill_2
XFILLER_23_388 VDD VSS sg13g2_fill_1
XFILLER_23_401 VDD VSS sg13g2_decap_4
XFILLER_23_430 VDD VSS sg13g2_decap_4
XFILLER_23_439 VDD VSS sg13g2_decap_8
XFILLER_23_446 VDD VSS sg13g2_decap_4
XFILLER_23_450 VDD VSS sg13g2_fill_1
XFILLER_23_473 VDD VSS sg13g2_decap_8
XFILLER_23_480 VDD VSS sg13g2_decap_4
XFILLER_23_496 VDD VSS sg13g2_decap_8
XFILLER_23_503 VDD VSS sg13g2_decap_8
XFILLER_23_510 VDD VSS sg13g2_decap_8
XFILLER_23_517 VDD VSS sg13g2_fill_2
XFILLER_23_519 VDD VSS sg13g2_fill_1
XFILLER_23_533 VDD VSS sg13g2_decap_8
XFILLER_23_540 VDD VSS sg13g2_fill_2
XFILLER_23_542 VDD VSS sg13g2_fill_1
XFILLER_24_0 VDD VSS sg13g2_decap_8
XFILLER_24_7 VDD VSS sg13g2_decap_4
XFILLER_24_11 VDD VSS sg13g2_fill_1
XFILLER_24_16 VDD VSS sg13g2_decap_8
XFILLER_24_23 VDD VSS sg13g2_decap_8
XFILLER_24_30 VDD VSS sg13g2_decap_8
XFILLER_24_37 VDD VSS sg13g2_decap_8
XFILLER_24_44 VDD VSS sg13g2_decap_4
XFILLER_24_54 VDD VSS sg13g2_decap_8
XFILLER_24_61 VDD VSS sg13g2_decap_8
XFILLER_24_68 VDD VSS sg13g2_decap_8
XFILLER_24_75 VDD VSS sg13g2_fill_2
XFILLER_24_77 VDD VSS sg13g2_fill_1
XFILLER_24_90 VDD VSS sg13g2_decap_8
XFILLER_24_97 VDD VSS sg13g2_decap_8
XFILLER_24_104 VDD VSS sg13g2_decap_8
XFILLER_24_117 VDD VSS sg13g2_decap_8
XFILLER_24_129 VDD VSS sg13g2_decap_8
XFILLER_24_136 VDD VSS sg13g2_fill_1
XFILLER_24_155 VDD VSS sg13g2_decap_8
XFILLER_24_162 VDD VSS sg13g2_fill_2
XFILLER_24_164 VDD VSS sg13g2_fill_1
XFILLER_24_169 VDD VSS sg13g2_decap_8
XFILLER_24_176 VDD VSS sg13g2_fill_1
XFILLER_24_181 VDD VSS sg13g2_decap_4
XFILLER_24_197 VDD VSS sg13g2_fill_2
XFILLER_24_212 VDD VSS sg13g2_fill_2
XFILLER_24_222 VDD VSS sg13g2_decap_8
XFILLER_24_229 VDD VSS sg13g2_decap_8
XFILLER_24_246 VDD VSS sg13g2_decap_8
XFILLER_24_253 VDD VSS sg13g2_decap_8
XFILLER_24_260 VDD VSS sg13g2_decap_8
XFILLER_24_267 VDD VSS sg13g2_decap_8
XFILLER_24_274 VDD VSS sg13g2_fill_2
XFILLER_24_289 VDD VSS sg13g2_decap_8
XFILLER_24_296 VDD VSS sg13g2_decap_8
XFILLER_24_303 VDD VSS sg13g2_decap_8
XFILLER_24_310 VDD VSS sg13g2_fill_2
XFILLER_24_312 VDD VSS sg13g2_fill_1
XFILLER_24_320 VDD VSS sg13g2_fill_2
XFILLER_24_333 VDD VSS sg13g2_decap_4
XFILLER_24_337 VDD VSS sg13g2_fill_2
XFILLER_24_352 VDD VSS sg13g2_decap_8
XFILLER_24_359 VDD VSS sg13g2_decap_8
XFILLER_24_366 VDD VSS sg13g2_decap_8
XFILLER_24_373 VDD VSS sg13g2_decap_8
XFILLER_24_380 VDD VSS sg13g2_decap_4
XFILLER_24_384 VDD VSS sg13g2_fill_2
XFILLER_24_392 VDD VSS sg13g2_fill_2
XFILLER_24_399 VDD VSS sg13g2_decap_8
XFILLER_24_406 VDD VSS sg13g2_decap_8
XFILLER_24_413 VDD VSS sg13g2_decap_8
XFILLER_24_420 VDD VSS sg13g2_decap_8
XFILLER_24_427 VDD VSS sg13g2_decap_4
XFILLER_24_439 VDD VSS sg13g2_decap_8
XFILLER_24_446 VDD VSS sg13g2_decap_8
XFILLER_24_453 VDD VSS sg13g2_decap_4
XFILLER_24_457 VDD VSS sg13g2_fill_2
XFILLER_24_472 VDD VSS sg13g2_decap_8
XFILLER_24_479 VDD VSS sg13g2_decap_4
XFILLER_24_496 VDD VSS sg13g2_decap_8
XFILLER_24_503 VDD VSS sg13g2_decap_4
XFILLER_24_507 VDD VSS sg13g2_fill_2
XFILLER_24_542 VDD VSS sg13g2_fill_1
XFILLER_25_0 VDD VSS sg13g2_decap_8
XFILLER_25_7 VDD VSS sg13g2_decap_8
XFILLER_25_14 VDD VSS sg13g2_decap_8
XFILLER_25_21 VDD VSS sg13g2_decap_8
XFILLER_25_28 VDD VSS sg13g2_decap_8
XFILLER_25_35 VDD VSS sg13g2_decap_8
XFILLER_25_42 VDD VSS sg13g2_fill_1
XFILLER_25_57 VDD VSS sg13g2_decap_8
XFILLER_25_64 VDD VSS sg13g2_decap_8
XFILLER_25_71 VDD VSS sg13g2_decap_8
XFILLER_25_78 VDD VSS sg13g2_decap_4
XFILLER_25_86 VDD VSS sg13g2_decap_8
XFILLER_25_93 VDD VSS sg13g2_decap_8
XFILLER_25_100 VDD VSS sg13g2_fill_2
XFILLER_25_126 VDD VSS sg13g2_decap_8
XFILLER_25_133 VDD VSS sg13g2_decap_8
XFILLER_25_140 VDD VSS sg13g2_decap_8
XFILLER_25_147 VDD VSS sg13g2_fill_2
XFILLER_25_149 VDD VSS sg13g2_fill_1
XFILLER_25_158 VDD VSS sg13g2_decap_8
XFILLER_25_165 VDD VSS sg13g2_decap_8
XFILLER_25_172 VDD VSS sg13g2_decap_8
XFILLER_25_179 VDD VSS sg13g2_fill_2
XFILLER_25_181 VDD VSS sg13g2_fill_1
XFILLER_25_195 VDD VSS sg13g2_decap_4
XFILLER_25_199 VDD VSS sg13g2_fill_2
XFILLER_25_206 VDD VSS sg13g2_decap_8
XFILLER_25_213 VDD VSS sg13g2_decap_8
XFILLER_25_220 VDD VSS sg13g2_decap_8
XFILLER_25_227 VDD VSS sg13g2_decap_8
XFILLER_25_234 VDD VSS sg13g2_decap_8
XFILLER_25_241 VDD VSS sg13g2_decap_4
XFILLER_25_245 VDD VSS sg13g2_fill_2
XFILLER_25_263 VDD VSS sg13g2_decap_4
XFILLER_25_267 VDD VSS sg13g2_fill_2
XFILLER_25_274 VDD VSS sg13g2_decap_8
XFILLER_25_281 VDD VSS sg13g2_decap_8
XFILLER_25_288 VDD VSS sg13g2_decap_8
XFILLER_25_295 VDD VSS sg13g2_fill_2
XFILLER_25_314 VDD VSS sg13g2_decap_8
XFILLER_25_321 VDD VSS sg13g2_decap_8
XFILLER_25_340 VDD VSS sg13g2_decap_8
XFILLER_25_347 VDD VSS sg13g2_decap_8
XFILLER_25_354 VDD VSS sg13g2_decap_4
XFILLER_25_358 VDD VSS sg13g2_fill_1
XFILLER_25_363 VDD VSS sg13g2_fill_2
XFILLER_25_365 VDD VSS sg13g2_fill_1
XFILLER_25_379 VDD VSS sg13g2_decap_8
XFILLER_25_386 VDD VSS sg13g2_decap_4
XFILLER_25_390 VDD VSS sg13g2_fill_1
XFILLER_25_403 VDD VSS sg13g2_decap_8
XFILLER_25_410 VDD VSS sg13g2_decap_8
XFILLER_25_417 VDD VSS sg13g2_decap_8
XFILLER_25_424 VDD VSS sg13g2_fill_1
XFILLER_25_437 VDD VSS sg13g2_decap_8
XFILLER_25_444 VDD VSS sg13g2_decap_4
XFILLER_25_448 VDD VSS sg13g2_fill_1
XFILLER_25_457 VDD VSS sg13g2_decap_4
XFILLER_25_461 VDD VSS sg13g2_fill_1
XFILLER_25_467 VDD VSS sg13g2_decap_8
XFILLER_25_474 VDD VSS sg13g2_decap_4
XFILLER_25_486 VDD VSS sg13g2_decap_8
XFILLER_25_493 VDD VSS sg13g2_decap_8
XFILLER_25_500 VDD VSS sg13g2_decap_8
XFILLER_25_507 VDD VSS sg13g2_decap_8
XFILLER_25_514 VDD VSS sg13g2_decap_8
XFILLER_25_533 VDD VSS sg13g2_decap_8
XFILLER_25_540 VDD VSS sg13g2_fill_2
XFILLER_25_542 VDD VSS sg13g2_fill_1
XFILLER_26_0 VDD VSS sg13g2_decap_8
XFILLER_26_7 VDD VSS sg13g2_decap_8
XFILLER_26_14 VDD VSS sg13g2_decap_8
XFILLER_26_21 VDD VSS sg13g2_decap_8
XFILLER_26_28 VDD VSS sg13g2_decap_8
XFILLER_26_35 VDD VSS sg13g2_decap_8
XFILLER_26_42 VDD VSS sg13g2_decap_4
XFILLER_26_46 VDD VSS sg13g2_fill_1
XFILLER_26_66 VDD VSS sg13g2_decap_8
XFILLER_26_73 VDD VSS sg13g2_decap_4
XFILLER_26_93 VDD VSS sg13g2_decap_8
XFILLER_26_100 VDD VSS sg13g2_decap_8
XFILLER_26_107 VDD VSS sg13g2_fill_2
XFILLER_26_119 VDD VSS sg13g2_fill_2
XFILLER_26_126 VDD VSS sg13g2_decap_8
XFILLER_26_133 VDD VSS sg13g2_decap_8
XFILLER_26_140 VDD VSS sg13g2_decap_8
XFILLER_26_147 VDD VSS sg13g2_decap_4
XFILLER_26_155 VDD VSS sg13g2_decap_8
XFILLER_26_162 VDD VSS sg13g2_fill_2
XFILLER_26_164 VDD VSS sg13g2_fill_1
XFILLER_26_177 VDD VSS sg13g2_decap_4
XFILLER_26_181 VDD VSS sg13g2_fill_1
XFILLER_26_187 VDD VSS sg13g2_decap_4
XFILLER_26_191 VDD VSS sg13g2_fill_1
XFILLER_26_196 VDD VSS sg13g2_decap_8
XFILLER_26_220 VDD VSS sg13g2_decap_8
XFILLER_26_227 VDD VSS sg13g2_decap_8
XFILLER_26_234 VDD VSS sg13g2_decap_8
XFILLER_26_241 VDD VSS sg13g2_fill_1
XFILLER_26_257 VDD VSS sg13g2_fill_2
XFILLER_26_259 VDD VSS sg13g2_fill_1
XFILLER_26_268 VDD VSS sg13g2_fill_2
XFILLER_26_270 VDD VSS sg13g2_fill_1
XFILLER_26_287 VDD VSS sg13g2_decap_8
XFILLER_26_294 VDD VSS sg13g2_decap_8
XFILLER_26_301 VDD VSS sg13g2_decap_8
XFILLER_26_308 VDD VSS sg13g2_decap_4
XFILLER_26_325 VDD VSS sg13g2_decap_8
XFILLER_26_332 VDD VSS sg13g2_decap_8
XFILLER_26_339 VDD VSS sg13g2_decap_8
XFILLER_26_346 VDD VSS sg13g2_decap_4
XFILLER_26_350 VDD VSS sg13g2_fill_1
XFILLER_26_354 VDD VSS sg13g2_decap_8
XFILLER_26_361 VDD VSS sg13g2_decap_4
XFILLER_26_377 VDD VSS sg13g2_decap_8
XFILLER_26_384 VDD VSS sg13g2_fill_2
XFILLER_26_399 VDD VSS sg13g2_fill_2
XFILLER_26_401 VDD VSS sg13g2_fill_1
XFILLER_26_406 VDD VSS sg13g2_decap_8
XFILLER_26_413 VDD VSS sg13g2_fill_2
XFILLER_26_433 VDD VSS sg13g2_decap_8
XFILLER_26_452 VDD VSS sg13g2_fill_2
XFILLER_26_454 VDD VSS sg13g2_fill_1
XFILLER_26_467 VDD VSS sg13g2_decap_8
XFILLER_26_474 VDD VSS sg13g2_decap_8
XFILLER_26_481 VDD VSS sg13g2_fill_1
XFILLER_26_497 VDD VSS sg13g2_decap_8
XFILLER_26_504 VDD VSS sg13g2_fill_2
XFILLER_26_510 VDD VSS sg13g2_decap_8
XFILLER_26_517 VDD VSS sg13g2_fill_2
XFILLER_26_531 VDD VSS sg13g2_decap_8
XFILLER_26_538 VDD VSS sg13g2_decap_4
XFILLER_26_542 VDD VSS sg13g2_fill_1
XFILLER_27_0 VDD VSS sg13g2_decap_8
XFILLER_27_7 VDD VSS sg13g2_decap_8
XFILLER_27_14 VDD VSS sg13g2_decap_8
XFILLER_27_21 VDD VSS sg13g2_decap_8
XFILLER_27_28 VDD VSS sg13g2_decap_8
XFILLER_27_35 VDD VSS sg13g2_decap_8
XFILLER_27_42 VDD VSS sg13g2_decap_8
XFILLER_27_49 VDD VSS sg13g2_decap_4
XFILLER_27_69 VDD VSS sg13g2_decap_8
XFILLER_27_76 VDD VSS sg13g2_decap_4
XFILLER_27_80 VDD VSS sg13g2_fill_2
XFILLER_27_87 VDD VSS sg13g2_decap_8
XFILLER_27_94 VDD VSS sg13g2_decap_8
XFILLER_27_101 VDD VSS sg13g2_decap_8
XFILLER_27_108 VDD VSS sg13g2_decap_8
XFILLER_27_115 VDD VSS sg13g2_fill_2
XFILLER_27_129 VDD VSS sg13g2_fill_1
XFILLER_27_139 VDD VSS sg13g2_decap_8
XFILLER_27_146 VDD VSS sg13g2_decap_4
XFILLER_27_163 VDD VSS sg13g2_decap_4
XFILLER_27_172 VDD VSS sg13g2_decap_8
XFILLER_27_179 VDD VSS sg13g2_decap_8
XFILLER_27_194 VDD VSS sg13g2_fill_2
XFILLER_27_204 VDD VSS sg13g2_decap_8
XFILLER_27_211 VDD VSS sg13g2_decap_8
XFILLER_27_218 VDD VSS sg13g2_decap_8
XFILLER_27_225 VDD VSS sg13g2_decap_8
XFILLER_27_232 VDD VSS sg13g2_fill_2
XFILLER_27_234 VDD VSS sg13g2_fill_1
XFILLER_27_240 VDD VSS sg13g2_decap_4
XFILLER_27_244 VDD VSS sg13g2_fill_1
XFILLER_27_257 VDD VSS sg13g2_decap_8
XFILLER_27_264 VDD VSS sg13g2_fill_2
XFILLER_27_266 VDD VSS sg13g2_fill_1
XFILLER_27_271 VDD VSS sg13g2_decap_4
XFILLER_27_275 VDD VSS sg13g2_fill_1
XFILLER_27_281 VDD VSS sg13g2_decap_4
XFILLER_27_285 VDD VSS sg13g2_fill_1
XFILLER_27_298 VDD VSS sg13g2_decap_8
XFILLER_27_305 VDD VSS sg13g2_decap_8
XFILLER_27_312 VDD VSS sg13g2_decap_8
XFILLER_27_319 VDD VSS sg13g2_decap_4
XFILLER_27_336 VDD VSS sg13g2_fill_2
XFILLER_27_338 VDD VSS sg13g2_fill_1
XFILLER_27_351 VDD VSS sg13g2_fill_2
XFILLER_27_353 VDD VSS sg13g2_fill_1
XFILLER_27_359 VDD VSS sg13g2_fill_2
XFILLER_27_361 VDD VSS sg13g2_fill_1
XFILLER_27_366 VDD VSS sg13g2_fill_2
XFILLER_27_368 VDD VSS sg13g2_fill_1
XFILLER_27_374 VDD VSS sg13g2_decap_8
XFILLER_27_381 VDD VSS sg13g2_decap_8
XFILLER_27_388 VDD VSS sg13g2_decap_8
XFILLER_27_395 VDD VSS sg13g2_fill_2
XFILLER_27_397 VDD VSS sg13g2_fill_1
XFILLER_27_415 VDD VSS sg13g2_fill_1
XFILLER_27_428 VDD VSS sg13g2_decap_8
XFILLER_27_435 VDD VSS sg13g2_decap_4
XFILLER_27_439 VDD VSS sg13g2_fill_1
XFILLER_27_452 VDD VSS sg13g2_decap_8
XFILLER_27_479 VDD VSS sg13g2_fill_1
XFILLER_27_503 VDD VSS sg13g2_fill_2
XFILLER_27_505 VDD VSS sg13g2_fill_1
XFILLER_27_522 VDD VSS sg13g2_fill_1
XFILLER_27_535 VDD VSS sg13g2_decap_8
XFILLER_27_542 VDD VSS sg13g2_fill_1
XFILLER_28_0 VDD VSS sg13g2_decap_8
XFILLER_28_7 VDD VSS sg13g2_decap_8
XFILLER_28_14 VDD VSS sg13g2_decap_8
XFILLER_28_21 VDD VSS sg13g2_decap_8
XFILLER_28_28 VDD VSS sg13g2_decap_8
XFILLER_28_35 VDD VSS sg13g2_decap_8
XFILLER_28_42 VDD VSS sg13g2_decap_8
XFILLER_28_49 VDD VSS sg13g2_decap_8
XFILLER_28_56 VDD VSS sg13g2_fill_2
XFILLER_28_62 VDD VSS sg13g2_fill_1
XFILLER_28_73 VDD VSS sg13g2_decap_8
XFILLER_28_90 VDD VSS sg13g2_fill_1
XFILLER_28_105 VDD VSS sg13g2_decap_8
XFILLER_28_112 VDD VSS sg13g2_decap_8
XFILLER_28_119 VDD VSS sg13g2_decap_8
XFILLER_28_126 VDD VSS sg13g2_decap_8
XFILLER_28_133 VDD VSS sg13g2_decap_4
XFILLER_28_137 VDD VSS sg13g2_fill_2
XFILLER_28_152 VDD VSS sg13g2_decap_8
XFILLER_28_159 VDD VSS sg13g2_fill_2
XFILLER_28_161 VDD VSS sg13g2_fill_1
XFILLER_28_178 VDD VSS sg13g2_decap_8
XFILLER_28_185 VDD VSS sg13g2_fill_2
XFILLER_28_192 VDD VSS sg13g2_decap_8
XFILLER_28_199 VDD VSS sg13g2_decap_8
XFILLER_28_206 VDD VSS sg13g2_decap_4
XFILLER_28_210 VDD VSS sg13g2_fill_2
XFILLER_28_232 VDD VSS sg13g2_decap_4
XFILLER_28_246 VDD VSS sg13g2_decap_8
XFILLER_28_253 VDD VSS sg13g2_decap_8
XFILLER_28_277 VDD VSS sg13g2_decap_8
XFILLER_28_284 VDD VSS sg13g2_decap_4
XFILLER_28_288 VDD VSS sg13g2_fill_1
XFILLER_28_298 VDD VSS sg13g2_fill_2
XFILLER_28_308 VDD VSS sg13g2_fill_1
XFILLER_28_313 VDD VSS sg13g2_decap_8
XFILLER_28_320 VDD VSS sg13g2_decap_8
XFILLER_28_327 VDD VSS sg13g2_decap_8
XFILLER_28_334 VDD VSS sg13g2_decap_4
XFILLER_28_338 VDD VSS sg13g2_fill_1
XFILLER_28_347 VDD VSS sg13g2_decap_8
XFILLER_28_354 VDD VSS sg13g2_decap_8
XFILLER_28_361 VDD VSS sg13g2_fill_2
XFILLER_28_382 VDD VSS sg13g2_decap_8
XFILLER_28_389 VDD VSS sg13g2_decap_8
XFILLER_28_396 VDD VSS sg13g2_fill_2
XFILLER_28_407 VDD VSS sg13g2_decap_8
XFILLER_28_414 VDD VSS sg13g2_decap_8
XFILLER_28_421 VDD VSS sg13g2_decap_8
XFILLER_28_428 VDD VSS sg13g2_decap_8
XFILLER_28_435 VDD VSS sg13g2_decap_8
XFILLER_28_442 VDD VSS sg13g2_decap_8
XFILLER_28_449 VDD VSS sg13g2_decap_8
XFILLER_28_456 VDD VSS sg13g2_decap_8
XFILLER_28_463 VDD VSS sg13g2_decap_8
XFILLER_28_470 VDD VSS sg13g2_decap_8
XFILLER_28_477 VDD VSS sg13g2_fill_2
XFILLER_28_479 VDD VSS sg13g2_fill_1
XFILLER_28_489 VDD VSS sg13g2_decap_8
XFILLER_28_496 VDD VSS sg13g2_fill_1
XFILLER_28_504 VDD VSS sg13g2_decap_8
XFILLER_28_511 VDD VSS sg13g2_decap_4
XFILLER_28_515 VDD VSS sg13g2_fill_1
XFILLER_28_521 VDD VSS sg13g2_decap_8
XFILLER_28_528 VDD VSS sg13g2_decap_8
XFILLER_28_535 VDD VSS sg13g2_decap_8
XFILLER_28_542 VDD VSS sg13g2_fill_1
XFILLER_29_0 VDD VSS sg13g2_decap_8
XFILLER_29_7 VDD VSS sg13g2_decap_8
XFILLER_29_14 VDD VSS sg13g2_decap_8
XFILLER_29_21 VDD VSS sg13g2_decap_8
XFILLER_29_28 VDD VSS sg13g2_decap_8
XFILLER_29_35 VDD VSS sg13g2_decap_8
XFILLER_29_42 VDD VSS sg13g2_decap_8
XFILLER_29_49 VDD VSS sg13g2_decap_8
XFILLER_29_56 VDD VSS sg13g2_decap_8
XFILLER_29_67 VDD VSS sg13g2_decap_8
XFILLER_29_74 VDD VSS sg13g2_decap_8
XFILLER_29_81 VDD VSS sg13g2_decap_4
XFILLER_29_85 VDD VSS sg13g2_fill_1
XFILLER_29_112 VDD VSS sg13g2_decap_8
XFILLER_29_119 VDD VSS sg13g2_decap_8
XFILLER_29_126 VDD VSS sg13g2_fill_1
XFILLER_29_132 VDD VSS sg13g2_decap_8
XFILLER_29_139 VDD VSS sg13g2_decap_8
XFILLER_29_146 VDD VSS sg13g2_fill_2
XFILLER_29_148 VDD VSS sg13g2_fill_1
XFILLER_29_161 VDD VSS sg13g2_decap_8
XFILLER_29_168 VDD VSS sg13g2_decap_8
XFILLER_29_180 VDD VSS sg13g2_decap_4
XFILLER_29_184 VDD VSS sg13g2_fill_2
XFILLER_29_203 VDD VSS sg13g2_decap_4
XFILLER_29_207 VDD VSS sg13g2_fill_2
XFILLER_29_214 VDD VSS sg13g2_decap_8
XFILLER_29_221 VDD VSS sg13g2_decap_4
XFILLER_29_225 VDD VSS sg13g2_fill_2
XFILLER_29_232 VDD VSS sg13g2_decap_8
XFILLER_29_244 VDD VSS sg13g2_decap_4
XFILLER_29_252 VDD VSS sg13g2_decap_8
XFILLER_29_259 VDD VSS sg13g2_decap_8
XFILLER_29_266 VDD VSS sg13g2_decap_8
XFILLER_29_273 VDD VSS sg13g2_decap_8
XFILLER_29_280 VDD VSS sg13g2_fill_2
XFILLER_29_300 VDD VSS sg13g2_fill_2
XFILLER_29_324 VDD VSS sg13g2_decap_8
XFILLER_29_331 VDD VSS sg13g2_decap_4
XFILLER_29_340 VDD VSS sg13g2_decap_4
XFILLER_29_344 VDD VSS sg13g2_fill_1
XFILLER_29_358 VDD VSS sg13g2_decap_8
XFILLER_29_365 VDD VSS sg13g2_fill_2
XFILLER_29_367 VDD VSS sg13g2_fill_1
XFILLER_29_372 VDD VSS sg13g2_decap_8
XFILLER_29_379 VDD VSS sg13g2_decap_8
XFILLER_29_386 VDD VSS sg13g2_decap_8
XFILLER_29_409 VDD VSS sg13g2_decap_8
XFILLER_29_416 VDD VSS sg13g2_decap_8
XFILLER_29_423 VDD VSS sg13g2_decap_8
XFILLER_29_430 VDD VSS sg13g2_decap_8
XFILLER_29_437 VDD VSS sg13g2_decap_8
XFILLER_29_444 VDD VSS sg13g2_fill_2
XFILLER_29_446 VDD VSS sg13g2_fill_1
XFILLER_29_464 VDD VSS sg13g2_decap_8
XFILLER_29_471 VDD VSS sg13g2_decap_8
XFILLER_29_478 VDD VSS sg13g2_decap_4
XFILLER_29_482 VDD VSS sg13g2_fill_2
XFILLER_29_489 VDD VSS sg13g2_fill_2
XFILLER_29_495 VDD VSS sg13g2_decap_8
XFILLER_29_502 VDD VSS sg13g2_decap_8
XFILLER_29_509 VDD VSS sg13g2_decap_8
XFILLER_29_516 VDD VSS sg13g2_decap_4
XFILLER_29_523 VDD VSS sg13g2_decap_8
XFILLER_29_530 VDD VSS sg13g2_decap_8
XFILLER_29_537 VDD VSS sg13g2_decap_4
XFILLER_29_541 VDD VSS sg13g2_fill_2
XFILLER_30_0 VDD VSS sg13g2_decap_8
XFILLER_30_7 VDD VSS sg13g2_decap_8
XFILLER_30_14 VDD VSS sg13g2_decap_8
XFILLER_30_21 VDD VSS sg13g2_decap_8
XFILLER_30_28 VDD VSS sg13g2_decap_8
XFILLER_30_35 VDD VSS sg13g2_decap_8
XFILLER_30_42 VDD VSS sg13g2_decap_8
XFILLER_30_49 VDD VSS sg13g2_decap_8
XFILLER_30_56 VDD VSS sg13g2_decap_8
XFILLER_30_63 VDD VSS sg13g2_decap_8
XFILLER_30_70 VDD VSS sg13g2_decap_8
XFILLER_30_77 VDD VSS sg13g2_decap_8
XFILLER_30_84 VDD VSS sg13g2_decap_4
XFILLER_30_88 VDD VSS sg13g2_fill_2
XFILLER_30_102 VDD VSS sg13g2_decap_8
XFILLER_30_109 VDD VSS sg13g2_decap_8
XFILLER_30_116 VDD VSS sg13g2_decap_8
XFILLER_30_123 VDD VSS sg13g2_fill_2
XFILLER_30_133 VDD VSS sg13g2_fill_1
XFILLER_30_146 VDD VSS sg13g2_decap_8
XFILLER_30_153 VDD VSS sg13g2_decap_8
XFILLER_30_160 VDD VSS sg13g2_decap_4
XFILLER_30_183 VDD VSS sg13g2_decap_8
XFILLER_30_190 VDD VSS sg13g2_decap_8
XFILLER_30_197 VDD VSS sg13g2_decap_8
XFILLER_30_204 VDD VSS sg13g2_decap_8
XFILLER_30_211 VDD VSS sg13g2_decap_8
XFILLER_30_218 VDD VSS sg13g2_decap_8
XFILLER_30_225 VDD VSS sg13g2_decap_8
XFILLER_30_232 VDD VSS sg13g2_decap_8
XFILLER_30_239 VDD VSS sg13g2_decap_4
XFILLER_30_256 VDD VSS sg13g2_decap_8
XFILLER_30_263 VDD VSS sg13g2_decap_8
XFILLER_30_270 VDD VSS sg13g2_fill_2
XFILLER_30_276 VDD VSS sg13g2_decap_8
XFILLER_30_283 VDD VSS sg13g2_decap_8
XFILLER_30_290 VDD VSS sg13g2_decap_4
XFILLER_30_294 VDD VSS sg13g2_fill_2
XFILLER_30_303 VDD VSS sg13g2_decap_8
XFILLER_30_310 VDD VSS sg13g2_decap_8
XFILLER_30_317 VDD VSS sg13g2_decap_8
XFILLER_30_324 VDD VSS sg13g2_fill_2
XFILLER_30_326 VDD VSS sg13g2_fill_1
XFILLER_30_339 VDD VSS sg13g2_decap_8
XFILLER_30_346 VDD VSS sg13g2_decap_8
XFILLER_30_353 VDD VSS sg13g2_fill_2
XFILLER_30_360 VDD VSS sg13g2_fill_2
XFILLER_30_374 VDD VSS sg13g2_decap_8
XFILLER_30_381 VDD VSS sg13g2_decap_8
XFILLER_30_388 VDD VSS sg13g2_decap_8
XFILLER_30_395 VDD VSS sg13g2_fill_1
XFILLER_30_405 VDD VSS sg13g2_decap_4
XFILLER_30_409 VDD VSS sg13g2_fill_2
XFILLER_30_423 VDD VSS sg13g2_fill_1
XFILLER_30_434 VDD VSS sg13g2_decap_8
XFILLER_30_456 VDD VSS sg13g2_decap_8
XFILLER_30_463 VDD VSS sg13g2_decap_8
XFILLER_30_470 VDD VSS sg13g2_decap_8
XFILLER_30_477 VDD VSS sg13g2_decap_4
XFILLER_30_499 VDD VSS sg13g2_decap_8
XFILLER_30_506 VDD VSS sg13g2_decap_8
XFILLER_30_518 VDD VSS sg13g2_fill_1
XFILLER_30_524 VDD VSS sg13g2_fill_1
XFILLER_30_536 VDD VSS sg13g2_decap_8
XFILLER_31_0 VDD VSS sg13g2_decap_8
XFILLER_31_7 VDD VSS sg13g2_decap_8
XFILLER_31_14 VDD VSS sg13g2_decap_8
XFILLER_31_21 VDD VSS sg13g2_decap_8
XFILLER_31_28 VDD VSS sg13g2_decap_8
XFILLER_31_35 VDD VSS sg13g2_decap_8
XFILLER_31_42 VDD VSS sg13g2_decap_8
XFILLER_31_49 VDD VSS sg13g2_decap_8
XFILLER_31_56 VDD VSS sg13g2_decap_8
XFILLER_31_63 VDD VSS sg13g2_decap_8
XFILLER_31_70 VDD VSS sg13g2_decap_8
XFILLER_31_77 VDD VSS sg13g2_decap_8
XFILLER_31_84 VDD VSS sg13g2_decap_8
XFILLER_31_91 VDD VSS sg13g2_decap_8
XFILLER_31_98 VDD VSS sg13g2_decap_8
XFILLER_31_105 VDD VSS sg13g2_decap_8
XFILLER_31_112 VDD VSS sg13g2_decap_8
XFILLER_31_119 VDD VSS sg13g2_fill_1
XFILLER_31_155 VDD VSS sg13g2_decap_8
XFILLER_31_162 VDD VSS sg13g2_fill_2
XFILLER_31_172 VDD VSS sg13g2_decap_8
XFILLER_31_179 VDD VSS sg13g2_decap_8
XFILLER_31_186 VDD VSS sg13g2_decap_8
XFILLER_31_193 VDD VSS sg13g2_decap_8
XFILLER_31_200 VDD VSS sg13g2_decap_8
XFILLER_31_207 VDD VSS sg13g2_decap_8
XFILLER_31_214 VDD VSS sg13g2_decap_8
XFILLER_31_221 VDD VSS sg13g2_decap_8
XFILLER_31_228 VDD VSS sg13g2_decap_8
XFILLER_31_235 VDD VSS sg13g2_decap_8
XFILLER_31_242 VDD VSS sg13g2_decap_8
XFILLER_31_249 VDD VSS sg13g2_decap_8
XFILLER_31_256 VDD VSS sg13g2_fill_2
XFILLER_31_258 VDD VSS sg13g2_fill_1
XFILLER_31_285 VDD VSS sg13g2_decap_8
XFILLER_31_292 VDD VSS sg13g2_decap_8
XFILLER_31_299 VDD VSS sg13g2_fill_2
XFILLER_31_318 VDD VSS sg13g2_fill_2
XFILLER_31_320 VDD VSS sg13g2_fill_1
XFILLER_31_351 VDD VSS sg13g2_fill_2
XFILLER_31_353 VDD VSS sg13g2_fill_1
XFILLER_31_373 VDD VSS sg13g2_decap_8
XFILLER_31_380 VDD VSS sg13g2_fill_1
XFILLER_31_387 VDD VSS sg13g2_fill_2
XFILLER_31_389 VDD VSS sg13g2_fill_1
XFILLER_31_410 VDD VSS sg13g2_fill_1
XFILLER_31_415 VDD VSS sg13g2_fill_2
XFILLER_31_434 VDD VSS sg13g2_decap_8
XFILLER_31_441 VDD VSS sg13g2_decap_4
XFILLER_31_445 VDD VSS sg13g2_fill_2
XFILLER_31_450 VDD VSS sg13g2_decap_8
XFILLER_31_457 VDD VSS sg13g2_decap_4
XFILLER_31_480 VDD VSS sg13g2_fill_2
XFILLER_31_482 VDD VSS sg13g2_fill_1
XFILLER_31_487 VDD VSS sg13g2_decap_8
XFILLER_31_494 VDD VSS sg13g2_decap_4
XFILLER_31_498 VDD VSS sg13g2_fill_2
XFILLER_31_508 VDD VSS sg13g2_fill_1
XFILLER_32_0 VDD VSS sg13g2_decap_8
XFILLER_32_7 VDD VSS sg13g2_decap_8
XFILLER_32_14 VDD VSS sg13g2_decap_8
XFILLER_32_21 VDD VSS sg13g2_decap_8
XFILLER_32_28 VDD VSS sg13g2_decap_8
XFILLER_32_35 VDD VSS sg13g2_decap_8
XFILLER_32_42 VDD VSS sg13g2_decap_8
XFILLER_32_49 VDD VSS sg13g2_decap_8
XFILLER_32_56 VDD VSS sg13g2_decap_8
XFILLER_32_63 VDD VSS sg13g2_decap_8
XFILLER_32_70 VDD VSS sg13g2_decap_8
XFILLER_32_77 VDD VSS sg13g2_decap_8
XFILLER_32_84 VDD VSS sg13g2_decap_8
XFILLER_32_91 VDD VSS sg13g2_decap_8
XFILLER_32_98 VDD VSS sg13g2_decap_8
XFILLER_32_105 VDD VSS sg13g2_decap_8
XFILLER_32_112 VDD VSS sg13g2_decap_8
XFILLER_32_119 VDD VSS sg13g2_decap_8
XFILLER_32_126 VDD VSS sg13g2_fill_2
XFILLER_32_144 VDD VSS sg13g2_decap_8
XFILLER_32_151 VDD VSS sg13g2_decap_8
XFILLER_32_158 VDD VSS sg13g2_decap_8
XFILLER_32_165 VDD VSS sg13g2_decap_8
XFILLER_32_172 VDD VSS sg13g2_decap_8
XFILLER_32_179 VDD VSS sg13g2_decap_8
XFILLER_32_186 VDD VSS sg13g2_decap_8
XFILLER_32_193 VDD VSS sg13g2_decap_8
XFILLER_32_200 VDD VSS sg13g2_decap_8
XFILLER_32_207 VDD VSS sg13g2_decap_8
XFILLER_32_214 VDD VSS sg13g2_decap_8
XFILLER_32_221 VDD VSS sg13g2_decap_8
XFILLER_32_228 VDD VSS sg13g2_decap_8
XFILLER_32_235 VDD VSS sg13g2_decap_8
XFILLER_32_242 VDD VSS sg13g2_decap_8
XFILLER_32_249 VDD VSS sg13g2_decap_8
XFILLER_32_256 VDD VSS sg13g2_fill_2
XFILLER_32_277 VDD VSS sg13g2_decap_8
XFILLER_32_284 VDD VSS sg13g2_fill_2
XFILLER_32_299 VDD VSS sg13g2_fill_2
XFILLER_32_301 VDD VSS sg13g2_fill_1
XFILLER_32_310 VDD VSS sg13g2_decap_8
XFILLER_32_317 VDD VSS sg13g2_decap_8
XFILLER_32_337 VDD VSS sg13g2_decap_8
XFILLER_32_352 VDD VSS sg13g2_decap_4
XFILLER_32_356 VDD VSS sg13g2_fill_1
XFILLER_32_365 VDD VSS sg13g2_fill_2
XFILLER_32_367 VDD VSS sg13g2_fill_1
XFILLER_32_380 VDD VSS sg13g2_fill_2
XFILLER_32_398 VDD VSS sg13g2_decap_8
XFILLER_32_405 VDD VSS sg13g2_decap_8
XFILLER_32_412 VDD VSS sg13g2_decap_8
XFILLER_32_419 VDD VSS sg13g2_decap_4
XFILLER_32_423 VDD VSS sg13g2_fill_2
XFILLER_32_439 VDD VSS sg13g2_decap_4
XFILLER_32_467 VDD VSS sg13g2_decap_4
XFILLER_32_471 VDD VSS sg13g2_fill_2
XFILLER_32_477 VDD VSS sg13g2_fill_1
XFILLER_32_494 VDD VSS sg13g2_decap_8
XFILLER_32_501 VDD VSS sg13g2_decap_8
XFILLER_32_508 VDD VSS sg13g2_decap_8
XFILLER_32_537 VDD VSS sg13g2_decap_4
XFILLER_32_541 VDD VSS sg13g2_fill_2
XFILLER_33_0 VDD VSS sg13g2_decap_8
XFILLER_33_7 VDD VSS sg13g2_decap_8
XFILLER_33_14 VDD VSS sg13g2_decap_8
XFILLER_33_21 VDD VSS sg13g2_decap_8
XFILLER_33_28 VDD VSS sg13g2_decap_8
XFILLER_33_35 VDD VSS sg13g2_decap_8
XFILLER_33_42 VDD VSS sg13g2_decap_8
XFILLER_33_49 VDD VSS sg13g2_decap_8
XFILLER_33_56 VDD VSS sg13g2_decap_8
XFILLER_33_63 VDD VSS sg13g2_decap_8
XFILLER_33_70 VDD VSS sg13g2_decap_8
XFILLER_33_77 VDD VSS sg13g2_decap_8
XFILLER_33_84 VDD VSS sg13g2_decap_8
XFILLER_33_91 VDD VSS sg13g2_decap_8
XFILLER_33_98 VDD VSS sg13g2_decap_8
XFILLER_33_105 VDD VSS sg13g2_decap_8
XFILLER_33_112 VDD VSS sg13g2_decap_8
XFILLER_33_119 VDD VSS sg13g2_decap_8
XFILLER_33_126 VDD VSS sg13g2_decap_8
XFILLER_33_133 VDD VSS sg13g2_decap_8
XFILLER_33_140 VDD VSS sg13g2_decap_8
XFILLER_33_147 VDD VSS sg13g2_decap_8
XFILLER_33_154 VDD VSS sg13g2_decap_8
XFILLER_33_161 VDD VSS sg13g2_decap_8
XFILLER_33_168 VDD VSS sg13g2_decap_8
XFILLER_33_175 VDD VSS sg13g2_decap_8
XFILLER_33_182 VDD VSS sg13g2_decap_8
XFILLER_33_189 VDD VSS sg13g2_decap_8
XFILLER_33_196 VDD VSS sg13g2_decap_8
XFILLER_33_203 VDD VSS sg13g2_decap_8
XFILLER_33_210 VDD VSS sg13g2_decap_8
XFILLER_33_217 VDD VSS sg13g2_decap_8
XFILLER_33_224 VDD VSS sg13g2_decap_8
XFILLER_33_231 VDD VSS sg13g2_decap_8
XFILLER_33_238 VDD VSS sg13g2_decap_8
XFILLER_33_245 VDD VSS sg13g2_decap_8
XFILLER_33_252 VDD VSS sg13g2_decap_8
XFILLER_33_259 VDD VSS sg13g2_decap_8
XFILLER_33_266 VDD VSS sg13g2_decap_8
XFILLER_33_273 VDD VSS sg13g2_decap_8
XFILLER_33_280 VDD VSS sg13g2_decap_8
XFILLER_33_287 VDD VSS sg13g2_decap_8
XFILLER_33_294 VDD VSS sg13g2_decap_8
XFILLER_33_301 VDD VSS sg13g2_decap_8
XFILLER_33_308 VDD VSS sg13g2_decap_8
XFILLER_33_315 VDD VSS sg13g2_decap_8
XFILLER_33_322 VDD VSS sg13g2_decap_8
XFILLER_33_329 VDD VSS sg13g2_decap_8
XFILLER_33_336 VDD VSS sg13g2_decap_8
XFILLER_33_343 VDD VSS sg13g2_decap_8
XFILLER_33_350 VDD VSS sg13g2_decap_8
XFILLER_33_357 VDD VSS sg13g2_decap_8
XFILLER_33_364 VDD VSS sg13g2_decap_8
XFILLER_33_371 VDD VSS sg13g2_decap_8
XFILLER_33_378 VDD VSS sg13g2_decap_8
XFILLER_33_385 VDD VSS sg13g2_decap_8
XFILLER_33_392 VDD VSS sg13g2_decap_8
XFILLER_33_399 VDD VSS sg13g2_decap_8
XFILLER_33_406 VDD VSS sg13g2_decap_8
XFILLER_33_413 VDD VSS sg13g2_decap_8
XFILLER_33_420 VDD VSS sg13g2_decap_8
XFILLER_33_427 VDD VSS sg13g2_fill_1
XFILLER_33_433 VDD VSS sg13g2_decap_8
XFILLER_33_440 VDD VSS sg13g2_decap_8
XFILLER_33_447 VDD VSS sg13g2_decap_8
XFILLER_33_454 VDD VSS sg13g2_decap_8
XFILLER_33_461 VDD VSS sg13g2_decap_8
XFILLER_33_468 VDD VSS sg13g2_decap_8
XFILLER_33_475 VDD VSS sg13g2_decap_8
XFILLER_33_482 VDD VSS sg13g2_fill_2
XFILLER_33_487 VDD VSS sg13g2_decap_8
XFILLER_33_494 VDD VSS sg13g2_decap_8
XFILLER_33_501 VDD VSS sg13g2_decap_8
XFILLER_33_508 VDD VSS sg13g2_decap_8
XFILLER_33_515 VDD VSS sg13g2_decap_8
XFILLER_33_522 VDD VSS sg13g2_decap_8
XFILLER_33_529 VDD VSS sg13g2_decap_8
XFILLER_33_536 VDD VSS sg13g2_decap_8
.ENDS PLL_COUNTER_DCO_PHYS
