* Extracted by KLayout with SG13G2 LVS runset on : 27/11/2026 16:02

.SUBCKT dll8_line_array_top
X$1 \$1 DLL8_LINE_ARRAY
.ENDS dll8_line_array_top

.SUBCKT DLL8_LINE_ARRAY \$1
X$1 \$1 DLL8_FINGER
X$2 \$2 DLL8_FINGER_P
X$3 \$2 DLL8_FINGER_P
X$4 \$2 DLL8_FINGER_P
X$5 \$2 DLL8_FINGER_P
X$6 \$2 DLL8_FINGER_P
X$7 \$2 DLL8_FINGER_P
X$8 \$2 DLL8_FINGER_P
X$9 \$2 DLL8_FINGER_P
X$10 \$2 DLL8_FINGER_P
X$11 \$2 DLL8_FINGER_P
X$12 \$2 DLL8_FINGER_P
X$13 \$2 DLL8_FINGER_P
X$14 \$2 DLL8_FINGER_P
X$15 \$2 DLL8_FINGER_P
X$16 \$2 DLL8_FINGER_P
X$17 \$2 DLL8_FINGER_P
X$18 \$2 DLL8_FINGER_P
X$19 \$2 DLL8_FINGER_P
X$20 \$2 DLL8_FINGER_P
X$21 \$2 DLL8_FINGER_P
X$22 \$2 DLL8_FINGER_P
X$23 \$2 DLL8_FINGER_P
X$24 \$2 DLL8_FINGER_P
X$25 \$2 DLL8_FINGER_P
X$26 \$2 DLL8_FINGER_P
X$27 \$2 DLL8_FINGER_P
X$28 \$2 DLL8_FINGER_P
X$29 \$2 DLL8_FINGER_P
X$30 \$2 DLL8_FINGER_P
X$31 \$2 DLL8_FINGER_P
X$32 \$2 DLL8_FINGER_P
X$33 \$2 DLL8_FINGER_P
X$34 \$2 DLL8_FINGER_P
X$35 \$2 DLL8_FINGER_P
X$36 \$2 DLL8_FINGER_P
X$37 \$2 DLL8_FINGER_P
X$38 \$2 DLL8_FINGER_P
X$39 \$2 DLL8_FINGER_P
X$40 \$2 DLL8_FINGER_P
X$41 \$2 DLL8_FINGER_P
X$42 \$2 DLL8_FINGER_P
X$43 \$2 DLL8_FINGER_P
X$44 \$2 DLL8_FINGER_P
X$45 \$2 DLL8_FINGER_P
X$46 \$2 DLL8_FINGER_P
X$47 \$2 DLL8_FINGER_P
X$48 \$2 DLL8_FINGER_P
X$49 \$2 DLL8_FINGER_P
X$50 \$2 DLL8_FINGER_P
X$51 \$2 DLL8_FINGER_P
X$52 \$2 DLL8_FINGER_P
X$53 \$2 DLL8_FINGER_P
X$54 \$2 DLL8_FINGER_P
X$55 \$2 DLL8_FINGER_P
X$56 \$2 DLL8_FINGER_P
X$57 \$2 DLL8_FINGER_P
X$58 \$2 DLL8_FINGER_P
X$59 \$2 DLL8_FINGER_P
X$60 \$2 DLL8_FINGER_P
X$61 \$2 DLL8_FINGER_P
X$62 \$2 DLL8_FINGER_P
X$63 \$2 DLL8_FINGER_P
X$64 \$2 DLL8_FINGER_P
X$65 \$1 DLL8_FINGER
X$66 \$1 DLL8_FINGER
X$67 \$1 DLL8_FINGER
X$68 \$1 DLL8_FINGER
X$69 \$1 DLL8_FINGER
X$70 \$1 DLL8_FINGER
X$71 \$1 DLL8_FINGER
X$72 \$1 DLL8_FINGER
X$73 \$1 DLL8_FINGER
X$74 \$1 DLL8_FINGER
X$75 \$1 DLL8_FINGER
X$76 \$1 DLL8_FINGER
X$77 \$1 DLL8_FINGER
X$78 \$1 DLL8_FINGER
X$79 \$1 DLL8_FINGER
X$80 \$1 DLL8_FINGER
X$81 \$1 DLL8_FINGER
X$82 \$1 DLL8_FINGER
X$83 \$1 DLL8_FINGER
X$84 \$1 DLL8_FINGER
X$85 \$1 DLL8_FINGER
X$86 \$1 DLL8_FINGER
X$87 \$1 DLL8_FINGER
X$88 \$1 DLL8_FINGER
X$89 \$1 DLL8_FINGER
X$90 \$1 DLL8_FINGER
X$91 \$1 DLL8_FINGER
X$92 \$1 DLL8_FINGER
X$93 \$1 DLL8_FINGER
X$94 \$1 DLL8_FINGER
X$95 \$1 DLL8_FINGER
X$96 \$1 DLL8_FINGER
X$97 \$1 DLL8_FINGER
X$98 \$1 DLL8_FINGER
X$99 \$1 DLL8_FINGER
X$100 \$1 DLL8_FINGER
X$101 \$1 DLL8_FINGER
X$102 \$1 DLL8_FINGER
X$103 \$1 DLL8_FINGER
X$104 \$1 DLL8_FINGER
X$105 \$1 DLL8_FINGER
X$106 \$1 DLL8_FINGER
X$107 \$1 DLL8_FINGER
X$108 \$1 DLL8_FINGER
X$109 \$1 DLL8_FINGER
X$110 \$1 DLL8_FINGER
X$111 \$1 DLL8_FINGER
X$112 \$1 DLL8_FINGER
X$113 \$1 DLL8_FINGER
X$114 \$1 DLL8_FINGER
X$115 \$1 DLL8_FINGER
X$116 \$1 DLL8_FINGER
X$117 \$1 DLL8_FINGER
X$118 \$1 DLL8_FINGER
X$119 \$1 DLL8_FINGER
X$120 \$1 DLL8_FINGER
X$121 \$1 DLL8_FINGER
X$122 \$1 DLL8_FINGER
X$123 \$1 DLL8_FINGER
X$124 \$1 DLL8_FINGER
X$125 \$1 DLL8_FINGER
X$126 \$1 DLL8_FINGER
X$127 \$1 DLL8_FINGER
.ENDS DLL8_LINE_ARRAY

.SUBCKT DLL8_FINGER_P \$I1
X$1 \$1 \$I1 moscap_p
X$2 \$3 \$1 \$3 \$I1 \$2 pmos
C$1 \$1 \$I4 sg13_moscap_p w=1u l=1u
.ENDS DLL8_FINGER_P

.SUBCKT DLL8_FINGER \$4
X$2 \$2 \$1 \$4 \$3 nmos
.ENDS DLL8_FINGER

.SUBCKT pmos \$1 \$2 \$3 \$4 \$5
M$1 \$1 \$5 \$2 \$4 sg13_lv_pmos L=0.13u W=1u AS=0.34p AD=0.34p PS=2.68u
+ PD=2.68u rfmode=0
R$2 \$3 \$4 ntap1 A=3.87p P=25.8u
.ENDS pmos

.SUBCKT moscap_p \$2 \$3
R$1 \$2 \$3 ntap1 A=1.62p P=12u
.ENDS moscap_p

.SUBCKT nmos \$1 \$2 \$4 \$8
M$1 \$1 \$8 \$2 \$4 sg13_lv_nmos L=0.45u W=0.5u AS=0.17p AD=0.17p PS=1.68u
+ PD=1.68u rfmode=0
R$2 \$3 \$4 ptap1 A=3.234p P=21.56u
.ENDS nmos
