* CDL Netlist generated by OpenROAD

*.BUSDELIMITER [

.SUBCKT PLL_RING_DCO_PHYS COARSE_MUX[0] COARSE_MUX[10] COARSE_MUX[11]
+ COARSE_MUX[12] COARSE_MUX[13] COARSE_MUX[14] COARSE_MUX[1]
+ COARSE_MUX[2] COARSE_MUX[3] COARSE_MUX[4] COARSE_MUX[5] COARSE_MUX[6]
+ COARSE_MUX[7] COARSE_MUX[8] COARSE_MUX[9] DCO_EN FINE_MUX[0]
+ FINE_MUX[10] FINE_MUX[11] FINE_MUX[12] FINE_MUX[13] FINE_MUX[14]
+ FINE_MUX[15] FINE_MUX[16] FINE_MUX[17] FINE_MUX[18] FINE_MUX[19]
+ FINE_MUX[1] FINE_MUX[20] FINE_MUX[21] FINE_MUX[22] FINE_MUX[23]
+ FINE_MUX[24] FINE_MUX[25] FINE_MUX[26] FINE_MUX[27] FINE_MUX[28]
+ FINE_MUX[29] FINE_MUX[2] FINE_MUX[30] FINE_MUX[3] FINE_MUX[4]
+ FINE_MUX[5] FINE_MUX[6] FINE_MUX[7] FINE_MUX[8] FINE_MUX[9]
+ INJ_EDGE INJ_EN MID_MUX[0] MID_MUX[10] MID_MUX[11] MID_MUX[12]
+ MID_MUX[13] MID_MUX[14] MID_MUX[1] MID_MUX[2] MID_MUX[3] MID_MUX[4]
+ MID_MUX[5] MID_MUX[6] MID_MUX[7] MID_MUX[8] MID_MUX[9] MID_OUT
+ OUT REF SS_BBPD[0] SS_BBPD[1] VGND VPWR
XFILLER_0_1 VGND VGND VPWR VPWR sky130_fd_sc_hd__decap_12
XFILLER_0_118 VGND VGND VPWR VPWR sky130_fd_sc_hd__decap_8
XFILLER_0_126 VGND VGND VPWR VPWR sky130_fd_sc_hd__decap_3
XFILLER_0_13 VGND VGND VPWR VPWR sky130_fd_sc_hd__decap_12
XFILLER_0_130 VGND VGND VPWR VPWR sky130_fd_sc_hd__decap_12
XFILLER_0_142 VGND VGND VPWR VPWR sky130_fd_sc_hd__decap_12
XFILLER_0_154 VGND VGND VPWR VPWR sky130_fd_sc_hd__decap_12
XFILLER_0_166 VGND VGND VPWR VPWR sky130_fd_sc_hd__decap_6
XFILLER_0_173 VGND VGND VPWR VPWR sky130_fd_sc_hd__decap_12
XFILLER_0_185 VGND VGND VPWR VPWR sky130_fd_sc_hd__decap_12
XFILLER_0_197 VGND VGND VPWR VPWR sky130_fd_sc_hd__decap_12
XFILLER_0_209 VGND VGND VPWR VPWR sky130_fd_sc_hd__decap_3
XFILLER_0_25 VGND VGND VPWR VPWR sky130_fd_sc_hd__decap_12
XFILLER_0_37 VGND VGND VPWR VPWR sky130_fd_sc_hd__decap_6
XFILLER_0_44 VGND VGND VPWR VPWR sky130_fd_sc_hd__decap_12
XFILLER_0_56 VGND VGND VPWR VPWR sky130_fd_sc_hd__decap_12
XFILLER_0_68 VGND VGND VPWR VPWR sky130_fd_sc_hd__decap_8
XFILLER_0_76 VGND VGND VPWR VPWR sky130_fd_sc_hd__fill_2
XFILLER_0_87 VGND VGND VPWR VPWR sky130_fd_sc_hd__fill_1
XFILLER_10_105 VGND VGND VPWR VPWR sky130_fd_sc_hd__decap_12
XFILLER_10_117 VGND VGND VPWR VPWR sky130_fd_sc_hd__decap_12
XFILLER_10_130 VGND VGND VPWR VPWR sky130_fd_sc_hd__decap_12
XFILLER_10_142 VGND VGND VPWR VPWR sky130_fd_sc_hd__decap_6
XFILLER_10_148 VGND VGND VPWR VPWR sky130_fd_sc_hd__fill_1
XFILLER_10_161 VGND VGND VPWR VPWR sky130_fd_sc_hd__decap_8
XFILLER_10_169 VGND VGND VPWR VPWR sky130_fd_sc_hd__fill_1
XFILLER_10_182 VGND VGND VPWR VPWR sky130_fd_sc_hd__decap_12
XFILLER_10_194 VGND VGND VPWR VPWR sky130_fd_sc_hd__decap_12
XFILLER_10_206 VGND VGND VPWR VPWR sky130_fd_sc_hd__decap_6
XFILLER_10_28 VGND VGND VPWR VPWR sky130_fd_sc_hd__decap_12
XFILLER_10_40 VGND VGND VPWR VPWR sky130_fd_sc_hd__decap_3
XFILLER_10_44 VGND VGND VPWR VPWR sky130_fd_sc_hd__decap_8
XFILLER_10_60 VGND VGND VPWR VPWR sky130_fd_sc_hd__decap_12
XFILLER_10_72 VGND VGND VPWR VPWR sky130_fd_sc_hd__decap_8
XFILLER_10_80 VGND VGND VPWR VPWR sky130_fd_sc_hd__fill_1
XFILLER_10_93 VGND VGND VPWR VPWR sky130_fd_sc_hd__decap_12
XFILLER_11_111 VGND VGND VPWR VPWR sky130_fd_sc_hd__decap_12
XFILLER_11_123 VGND VGND VPWR VPWR sky130_fd_sc_hd__decap_12
XFILLER_11_135 VGND VGND VPWR VPWR sky130_fd_sc_hd__decap_12
XFILLER_11_147 VGND VGND VPWR VPWR sky130_fd_sc_hd__decap_4
XFILLER_11_159 VGND VGND VPWR VPWR sky130_fd_sc_hd__decap_12
XFILLER_11_17 VGND VGND VPWR VPWR sky130_fd_sc_hd__fill_2
XFILLER_11_171 VGND VGND VPWR VPWR sky130_fd_sc_hd__fill_1
XFILLER_11_173 VGND VGND VPWR VPWR sky130_fd_sc_hd__fill_1
XFILLER_11_182 VGND VGND VPWR VPWR sky130_fd_sc_hd__decap_12
XFILLER_11_194 VGND VGND VPWR VPWR sky130_fd_sc_hd__decap_12
XFILLER_11_206 VGND VGND VPWR VPWR sky130_fd_sc_hd__decap_6
XFILLER_11_41 VGND VGND VPWR VPWR sky130_fd_sc_hd__decap_6
XFILLER_11_51 VGND VGND VPWR VPWR sky130_fd_sc_hd__decap_3
XFILLER_11_62 VGND VGND VPWR VPWR sky130_fd_sc_hd__decap_12
XFILLER_11_74 VGND VGND VPWR VPWR sky130_fd_sc_hd__decap_12
XFILLER_11_99 VGND VGND VPWR VPWR sky130_fd_sc_hd__decap_12
XFILLER_12_111 VGND VGND VPWR VPWR sky130_fd_sc_hd__decap_12
XFILLER_12_123 VGND VGND VPWR VPWR sky130_fd_sc_hd__decap_6
XFILLER_12_130 VGND VGND VPWR VPWR sky130_fd_sc_hd__decap_12
XFILLER_12_146 VGND VGND VPWR VPWR sky130_fd_sc_hd__fill_1
XFILLER_12_159 VGND VGND VPWR VPWR sky130_fd_sc_hd__decap_8
XFILLER_12_167 VGND VGND VPWR VPWR sky130_fd_sc_hd__fill_2
XFILLER_12_181 VGND VGND VPWR VPWR sky130_fd_sc_hd__decap_12
XFILLER_12_193 VGND VGND VPWR VPWR sky130_fd_sc_hd__decap_12
XFILLER_12_205 VGND VGND VPWR VPWR sky130_fd_sc_hd__decap_6
XFILLER_12_211 VGND VGND VPWR VPWR sky130_fd_sc_hd__fill_1
XFILLER_12_33 VGND VGND VPWR VPWR sky130_fd_sc_hd__fill_2
XFILLER_12_56 VGND VGND VPWR VPWR sky130_fd_sc_hd__decap_12
XFILLER_12_68 VGND VGND VPWR VPWR sky130_fd_sc_hd__decap_12
XFILLER_12_80 VGND VGND VPWR VPWR sky130_fd_sc_hd__decap_6
XFILLER_12_86 VGND VGND VPWR VPWR sky130_fd_sc_hd__fill_1
XFILLER_12_99 VGND VGND VPWR VPWR sky130_fd_sc_hd__decap_12
XFILLER_13_102 VGND VGND VPWR VPWR sky130_fd_sc_hd__decap_12
XFILLER_13_114 VGND VGND VPWR VPWR sky130_fd_sc_hd__decap_12
XFILLER_13_126 VGND VGND VPWR VPWR sky130_fd_sc_hd__decap_12
XFILLER_13_154 VGND VGND VPWR VPWR sky130_fd_sc_hd__decap_12
XFILLER_13_166 VGND VGND VPWR VPWR sky130_fd_sc_hd__fill_2
XFILLER_13_181 VGND VGND VPWR VPWR sky130_fd_sc_hd__decap_12
XFILLER_13_193 VGND VGND VPWR VPWR sky130_fd_sc_hd__decap_12
XFILLER_13_205 VGND VGND VPWR VPWR sky130_fd_sc_hd__decap_6
XFILLER_13_211 VGND VGND VPWR VPWR sky130_fd_sc_hd__fill_1
XFILLER_13_28 VGND VGND VPWR VPWR sky130_fd_sc_hd__decap_4
XFILLER_13_40 VGND VGND VPWR VPWR sky130_fd_sc_hd__decap_12
XFILLER_13_52 VGND VGND VPWR VPWR sky130_fd_sc_hd__decap_12
XFILLER_13_64 VGND VGND VPWR VPWR sky130_fd_sc_hd__decap_12
XFILLER_13_76 VGND VGND VPWR VPWR sky130_fd_sc_hd__decap_8
XFILLER_13_84 VGND VGND VPWR VPWR sky130_fd_sc_hd__fill_2
XFILLER_13_87 VGND VGND VPWR VPWR sky130_fd_sc_hd__decap_3
XFILLER_14_107 VGND VGND VPWR VPWR sky130_fd_sc_hd__decap_12
XFILLER_14_119 VGND VGND VPWR VPWR sky130_fd_sc_hd__decap_8
XFILLER_14_127 VGND VGND VPWR VPWR sky130_fd_sc_hd__fill_2
XFILLER_14_130 VGND VGND VPWR VPWR sky130_fd_sc_hd__decap_6
XFILLER_14_148 VGND VGND VPWR VPWR sky130_fd_sc_hd__decap_12
XFILLER_14_160 VGND VGND VPWR VPWR sky130_fd_sc_hd__decap_6
XFILLER_14_178 VGND VGND VPWR VPWR sky130_fd_sc_hd__decap_12
XFILLER_14_190 VGND VGND VPWR VPWR sky130_fd_sc_hd__decap_12
XFILLER_14_20 VGND VGND VPWR VPWR sky130_fd_sc_hd__decap_3
XFILLER_14_202 VGND VGND VPWR VPWR sky130_fd_sc_hd__decap_8
XFILLER_14_210 VGND VGND VPWR VPWR sky130_fd_sc_hd__fill_2
XFILLER_14_34 VGND VGND VPWR VPWR sky130_fd_sc_hd__decap_8
XFILLER_14_42 VGND VGND VPWR VPWR sky130_fd_sc_hd__fill_1
XFILLER_14_44 VGND VGND VPWR VPWR sky130_fd_sc_hd__decap_12
XFILLER_14_56 VGND VGND VPWR VPWR sky130_fd_sc_hd__decap_12
XFILLER_14_68 VGND VGND VPWR VPWR sky130_fd_sc_hd__decap_12
XFILLER_14_80 VGND VGND VPWR VPWR sky130_fd_sc_hd__decap_8
XFILLER_14_88 VGND VGND VPWR VPWR sky130_fd_sc_hd__decap_3
XFILLER_15_113 VGND VGND VPWR VPWR sky130_fd_sc_hd__decap_12
XFILLER_15_125 VGND VGND VPWR VPWR sky130_fd_sc_hd__decap_6
XFILLER_15_131 VGND VGND VPWR VPWR sky130_fd_sc_hd__fill_1
XFILLER_15_140 VGND VGND VPWR VPWR sky130_fd_sc_hd__decap_12
XFILLER_15_152 VGND VGND VPWR VPWR sky130_fd_sc_hd__decap_12
XFILLER_15_164 VGND VGND VPWR VPWR sky130_fd_sc_hd__decap_4
XFILLER_15_177 VGND VGND VPWR VPWR sky130_fd_sc_hd__decap_12
XFILLER_15_189 VGND VGND VPWR VPWR sky130_fd_sc_hd__decap_12
XFILLER_15_201 VGND VGND VPWR VPWR sky130_fd_sc_hd__decap_8
XFILLER_15_209 VGND VGND VPWR VPWR sky130_fd_sc_hd__decap_3
XFILLER_15_25 VGND VGND VPWR VPWR sky130_fd_sc_hd__fill_1
XFILLER_15_40 VGND VGND VPWR VPWR sky130_fd_sc_hd__decap_12
XFILLER_15_52 VGND VGND VPWR VPWR sky130_fd_sc_hd__fill_1
XFILLER_15_57 VGND VGND VPWR VPWR sky130_fd_sc_hd__decap_12
XFILLER_15_69 VGND VGND VPWR VPWR sky130_fd_sc_hd__decap_12
XFILLER_15_81 VGND VGND VPWR VPWR sky130_fd_sc_hd__decap_4
XFILLER_15_85 VGND VGND VPWR VPWR sky130_fd_sc_hd__fill_1
XFILLER_15_87 VGND VGND VPWR VPWR sky130_fd_sc_hd__decap_12
XFILLER_15_99 VGND VGND VPWR VPWR sky130_fd_sc_hd__fill_2
XFILLER_16_103 VGND VGND VPWR VPWR sky130_fd_sc_hd__fill_2
XFILLER_16_117 VGND VGND VPWR VPWR sky130_fd_sc_hd__decap_12
XFILLER_16_12 VGND VGND VPWR VPWR sky130_fd_sc_hd__fill_1
XFILLER_16_130 VGND VGND VPWR VPWR sky130_fd_sc_hd__decap_3
XFILLER_16_145 VGND VGND VPWR VPWR sky130_fd_sc_hd__decap_12
XFILLER_16_157 VGND VGND VPWR VPWR sky130_fd_sc_hd__decap_8
XFILLER_16_165 VGND VGND VPWR VPWR sky130_fd_sc_hd__fill_1
XFILLER_16_178 VGND VGND VPWR VPWR sky130_fd_sc_hd__decap_12
XFILLER_16_190 VGND VGND VPWR VPWR sky130_fd_sc_hd__decap_12
XFILLER_16_202 VGND VGND VPWR VPWR sky130_fd_sc_hd__decap_8
XFILLER_16_210 VGND VGND VPWR VPWR sky130_fd_sc_hd__fill_2
XFILLER_16_24 VGND VGND VPWR VPWR sky130_fd_sc_hd__fill_1
XFILLER_16_33 VGND VGND VPWR VPWR sky130_fd_sc_hd__fill_1
XFILLER_16_37 VGND VGND VPWR VPWR sky130_fd_sc_hd__decap_6
XFILLER_16_44 VGND VGND VPWR VPWR sky130_fd_sc_hd__decap_6
XFILLER_16_50 VGND VGND VPWR VPWR sky130_fd_sc_hd__fill_1
XFILLER_16_79 VGND VGND VPWR VPWR sky130_fd_sc_hd__decap_12
XFILLER_16_91 VGND VGND VPWR VPWR sky130_fd_sc_hd__decap_12
XFILLER_17_1 VGND VGND VPWR VPWR sky130_fd_sc_hd__fill_1
XFILLER_17_101 VGND VGND VPWR VPWR sky130_fd_sc_hd__fill_1
XFILLER_17_114 VGND VGND VPWR VPWR sky130_fd_sc_hd__decap_12
XFILLER_17_126 VGND VGND VPWR VPWR sky130_fd_sc_hd__decap_4
XFILLER_17_130 VGND VGND VPWR VPWR sky130_fd_sc_hd__fill_1
XFILLER_17_143 VGND VGND VPWR VPWR sky130_fd_sc_hd__decap_12
XFILLER_17_155 VGND VGND VPWR VPWR sky130_fd_sc_hd__decap_8
XFILLER_17_163 VGND VGND VPWR VPWR sky130_fd_sc_hd__fill_1
XFILLER_17_177 VGND VGND VPWR VPWR sky130_fd_sc_hd__decap_12
XFILLER_17_189 VGND VGND VPWR VPWR sky130_fd_sc_hd__decap_12
XFILLER_17_201 VGND VGND VPWR VPWR sky130_fd_sc_hd__decap_3
XFILLER_17_40 VGND VGND VPWR VPWR sky130_fd_sc_hd__decap_8
XFILLER_17_60 VGND VGND VPWR VPWR sky130_fd_sc_hd__decap_8
XFILLER_17_68 VGND VGND VPWR VPWR sky130_fd_sc_hd__fill_1
XFILLER_17_85 VGND VGND VPWR VPWR sky130_fd_sc_hd__fill_1
XFILLER_17_87 VGND VGND VPWR VPWR sky130_fd_sc_hd__decap_4
XFILLER_17_95 VGND VGND VPWR VPWR sky130_fd_sc_hd__decap_6
XFILLER_18_1 VGND VGND VPWR VPWR sky130_fd_sc_hd__fill_1
XFILLER_18_105 VGND VGND VPWR VPWR sky130_fd_sc_hd__decap_12
XFILLER_18_117 VGND VGND VPWR VPWR sky130_fd_sc_hd__decap_12
XFILLER_18_130 VGND VGND VPWR VPWR sky130_fd_sc_hd__decap_6
XFILLER_18_148 VGND VGND VPWR VPWR sky130_fd_sc_hd__decap_12
XFILLER_18_160 VGND VGND VPWR VPWR sky130_fd_sc_hd__decap_6
XFILLER_18_166 VGND VGND VPWR VPWR sky130_fd_sc_hd__fill_1
XFILLER_18_179 VGND VGND VPWR VPWR sky130_fd_sc_hd__decap_12
XFILLER_18_191 VGND VGND VPWR VPWR sky130_fd_sc_hd__decap_6
XFILLER_18_197 VGND VGND VPWR VPWR sky130_fd_sc_hd__fill_1
XFILLER_18_206 VGND VGND VPWR VPWR sky130_fd_sc_hd__decap_6
XFILLER_18_29 VGND VGND VPWR VPWR sky130_fd_sc_hd__decap_12
XFILLER_18_41 VGND VGND VPWR VPWR sky130_fd_sc_hd__fill_2
XFILLER_18_44 VGND VGND VPWR VPWR sky130_fd_sc_hd__decap_6
XFILLER_18_62 VGND VGND VPWR VPWR sky130_fd_sc_hd__decap_8
XFILLER_18_70 VGND VGND VPWR VPWR sky130_fd_sc_hd__decap_3
XFILLER_19_111 VGND VGND VPWR VPWR sky130_fd_sc_hd__decap_12
XFILLER_19_123 VGND VGND VPWR VPWR sky130_fd_sc_hd__decap_12
XFILLER_19_135 VGND VGND VPWR VPWR sky130_fd_sc_hd__decap_3
XFILLER_19_150 VGND VGND VPWR VPWR sky130_fd_sc_hd__decap_12
XFILLER_19_162 VGND VGND VPWR VPWR sky130_fd_sc_hd__decap_6
XFILLER_19_177 VGND VGND VPWR VPWR sky130_fd_sc_hd__decap_12
XFILLER_19_189 VGND VGND VPWR VPWR sky130_fd_sc_hd__decap_6
XFILLER_19_209 VGND VGND VPWR VPWR sky130_fd_sc_hd__decap_3
XFILLER_19_36 VGND VGND VPWR VPWR sky130_fd_sc_hd__decap_12
XFILLER_19_48 VGND VGND VPWR VPWR sky130_fd_sc_hd__fill_2
XFILLER_19_62 VGND VGND VPWR VPWR sky130_fd_sc_hd__decap_12
XFILLER_19_74 VGND VGND VPWR VPWR sky130_fd_sc_hd__fill_1
XFILLER_19_83 VGND VGND VPWR VPWR sky130_fd_sc_hd__decap_3
XFILLER_19_87 VGND VGND VPWR VPWR sky130_fd_sc_hd__decap_12
XFILLER_19_99 VGND VGND VPWR VPWR sky130_fd_sc_hd__decap_12
XFILLER_1_1 VGND VGND VPWR VPWR sky130_fd_sc_hd__decap_12
XFILLER_1_118 VGND VGND VPWR VPWR sky130_fd_sc_hd__decap_12
XFILLER_1_13 VGND VGND VPWR VPWR sky130_fd_sc_hd__decap_12
XFILLER_1_130 VGND VGND VPWR VPWR sky130_fd_sc_hd__decap_12
XFILLER_1_142 VGND VGND VPWR VPWR sky130_fd_sc_hd__decap_12
XFILLER_1_154 VGND VGND VPWR VPWR sky130_fd_sc_hd__decap_12
XFILLER_1_166 VGND VGND VPWR VPWR sky130_fd_sc_hd__decap_6
XFILLER_1_173 VGND VGND VPWR VPWR sky130_fd_sc_hd__decap_12
XFILLER_1_185 VGND VGND VPWR VPWR sky130_fd_sc_hd__decap_12
XFILLER_1_197 VGND VGND VPWR VPWR sky130_fd_sc_hd__decap_12
XFILLER_1_209 VGND VGND VPWR VPWR sky130_fd_sc_hd__decap_3
XFILLER_1_25 VGND VGND VPWR VPWR sky130_fd_sc_hd__decap_12
XFILLER_1_37 VGND VGND VPWR VPWR sky130_fd_sc_hd__decap_12
XFILLER_1_49 VGND VGND VPWR VPWR sky130_fd_sc_hd__decap_12
XFILLER_1_61 VGND VGND VPWR VPWR sky130_fd_sc_hd__decap_12
XFILLER_1_73 VGND VGND VPWR VPWR sky130_fd_sc_hd__decap_4
XFILLER_1_77 VGND VGND VPWR VPWR sky130_fd_sc_hd__fill_1
XFILLER_1_95 VGND VGND VPWR VPWR sky130_fd_sc_hd__fill_1
XFILLER_20_1 VGND VGND VPWR VPWR sky130_fd_sc_hd__decap_6
XFILLER_20_108 VGND VGND VPWR VPWR sky130_fd_sc_hd__decap_12
XFILLER_20_120 VGND VGND VPWR VPWR sky130_fd_sc_hd__decap_8
XFILLER_20_128 VGND VGND VPWR VPWR sky130_fd_sc_hd__fill_1
XFILLER_20_130 VGND VGND VPWR VPWR sky130_fd_sc_hd__decap_12
XFILLER_20_142 VGND VGND VPWR VPWR sky130_fd_sc_hd__fill_2
XFILLER_20_156 VGND VGND VPWR VPWR sky130_fd_sc_hd__decap_12
XFILLER_20_168 VGND VGND VPWR VPWR sky130_fd_sc_hd__decap_3
XFILLER_20_179 VGND VGND VPWR VPWR sky130_fd_sc_hd__decap_8
XFILLER_20_187 VGND VGND VPWR VPWR sky130_fd_sc_hd__decap_3
XFILLER_20_209 VGND VGND VPWR VPWR sky130_fd_sc_hd__decap_3
XFILLER_20_23 VGND VGND VPWR VPWR sky130_fd_sc_hd__fill_1
XFILLER_20_40 VGND VGND VPWR VPWR sky130_fd_sc_hd__decap_3
XFILLER_20_44 VGND VGND VPWR VPWR sky130_fd_sc_hd__decap_8
XFILLER_20_60 VGND VGND VPWR VPWR sky130_fd_sc_hd__decap_12
XFILLER_20_72 VGND VGND VPWR VPWR sky130_fd_sc_hd__decap_12
XFILLER_20_84 VGND VGND VPWR VPWR sky130_fd_sc_hd__decap_12
XFILLER_20_96 VGND VGND VPWR VPWR sky130_fd_sc_hd__decap_12
XFILLER_21_105 VGND VGND VPWR VPWR sky130_fd_sc_hd__decap_12
XFILLER_21_117 VGND VGND VPWR VPWR sky130_fd_sc_hd__decap_12
XFILLER_21_129 VGND VGND VPWR VPWR sky130_fd_sc_hd__decap_12
XFILLER_21_141 VGND VGND VPWR VPWR sky130_fd_sc_hd__decap_4
XFILLER_21_153 VGND VGND VPWR VPWR sky130_fd_sc_hd__decap_12
XFILLER_21_165 VGND VGND VPWR VPWR sky130_fd_sc_hd__decap_6
XFILLER_21_171 VGND VGND VPWR VPWR sky130_fd_sc_hd__fill_1
XFILLER_21_185 VGND VGND VPWR VPWR sky130_fd_sc_hd__decap_4
XFILLER_21_208 VGND VGND VPWR VPWR sky130_fd_sc_hd__decap_4
XFILLER_21_23 VGND VGND VPWR VPWR sky130_fd_sc_hd__decap_3
XFILLER_21_29 VGND VGND VPWR VPWR sky130_fd_sc_hd__fill_1
XFILLER_21_33 VGND VGND VPWR VPWR sky130_fd_sc_hd__decap_12
XFILLER_21_45 VGND VGND VPWR VPWR sky130_fd_sc_hd__decap_4
XFILLER_21_57 VGND VGND VPWR VPWR sky130_fd_sc_hd__decap_12
XFILLER_21_69 VGND VGND VPWR VPWR sky130_fd_sc_hd__fill_1
XFILLER_21_74 VGND VGND VPWR VPWR sky130_fd_sc_hd__decap_3
XFILLER_21_85 VGND VGND VPWR VPWR sky130_fd_sc_hd__fill_1
XFILLER_21_87 VGND VGND VPWR VPWR sky130_fd_sc_hd__fill_2
XFILLER_21_93 VGND VGND VPWR VPWR sky130_fd_sc_hd__fill_1
XFILLER_21_98 VGND VGND VPWR VPWR sky130_fd_sc_hd__decap_3
XFILLER_22_1 VGND VGND VPWR VPWR sky130_fd_sc_hd__decap_3
XFILLER_22_112 VGND VGND VPWR VPWR sky130_fd_sc_hd__decap_12
XFILLER_22_124 VGND VGND VPWR VPWR sky130_fd_sc_hd__decap_4
XFILLER_22_128 VGND VGND VPWR VPWR sky130_fd_sc_hd__fill_1
XFILLER_22_130 VGND VGND VPWR VPWR sky130_fd_sc_hd__decap_12
XFILLER_22_142 VGND VGND VPWR VPWR sky130_fd_sc_hd__decap_4
XFILLER_22_154 VGND VGND VPWR VPWR sky130_fd_sc_hd__decap_12
XFILLER_22_166 VGND VGND VPWR VPWR sky130_fd_sc_hd__fill_2
XFILLER_22_180 VGND VGND VPWR VPWR sky130_fd_sc_hd__decap_12
XFILLER_22_192 VGND VGND VPWR VPWR sky130_fd_sc_hd__fill_1
XFILLER_22_23 VGND VGND VPWR VPWR sky130_fd_sc_hd__decap_12
XFILLER_22_35 VGND VGND VPWR VPWR sky130_fd_sc_hd__decap_8
XFILLER_22_44 VGND VGND VPWR VPWR sky130_fd_sc_hd__decap_3
XFILLER_22_55 VGND VGND VPWR VPWR sky130_fd_sc_hd__decap_8
XFILLER_22_63 VGND VGND VPWR VPWR sky130_fd_sc_hd__fill_1
XFILLER_23_1 VGND VGND VPWR VPWR sky130_fd_sc_hd__decap_4
XFILLER_23_102 VGND VGND VPWR VPWR sky130_fd_sc_hd__decap_6
XFILLER_23_120 VGND VGND VPWR VPWR sky130_fd_sc_hd__decap_12
XFILLER_23_132 VGND VGND VPWR VPWR sky130_fd_sc_hd__decap_12
XFILLER_23_144 VGND VGND VPWR VPWR sky130_fd_sc_hd__fill_2
XFILLER_23_158 VGND VGND VPWR VPWR sky130_fd_sc_hd__decap_8
XFILLER_23_16 VGND VGND VPWR VPWR sky130_fd_sc_hd__decap_12
XFILLER_23_166 VGND VGND VPWR VPWR sky130_fd_sc_hd__fill_1
XFILLER_23_183 VGND VGND VPWR VPWR sky130_fd_sc_hd__decap_4
XFILLER_23_187 VGND VGND VPWR VPWR sky130_fd_sc_hd__fill_1
XFILLER_23_28 VGND VGND VPWR VPWR sky130_fd_sc_hd__decap_12
XFILLER_23_40 VGND VGND VPWR VPWR sky130_fd_sc_hd__fill_1
XFILLER_23_53 VGND VGND VPWR VPWR sky130_fd_sc_hd__fill_1
XFILLER_23_78 VGND VGND VPWR VPWR sky130_fd_sc_hd__decap_8
XFILLER_23_91 VGND VGND VPWR VPWR sky130_fd_sc_hd__decap_6
XFILLER_23_97 VGND VGND VPWR VPWR sky130_fd_sc_hd__fill_1
XFILLER_24_1 VGND VGND VPWR VPWR sky130_fd_sc_hd__decap_4
XFILLER_24_107 VGND VGND VPWR VPWR sky130_fd_sc_hd__decap_4
XFILLER_24_111 VGND VGND VPWR VPWR sky130_fd_sc_hd__fill_1
XFILLER_24_128 VGND VGND VPWR VPWR sky130_fd_sc_hd__fill_1
XFILLER_24_130 VGND VGND VPWR VPWR sky130_fd_sc_hd__fill_2
XFILLER_24_136 VGND VGND VPWR VPWR sky130_fd_sc_hd__fill_1
XFILLER_24_141 VGND VGND VPWR VPWR sky130_fd_sc_hd__decap_3
XFILLER_24_16 VGND VGND VPWR VPWR sky130_fd_sc_hd__decap_12
XFILLER_24_160 VGND VGND VPWR VPWR sky130_fd_sc_hd__decap_12
XFILLER_24_172 VGND VGND VPWR VPWR sky130_fd_sc_hd__fill_1
XFILLER_24_178 VGND VGND VPWR VPWR sky130_fd_sc_hd__decap_4
XFILLER_24_28 VGND VGND VPWR VPWR sky130_fd_sc_hd__decap_12
XFILLER_24_40 VGND VGND VPWR VPWR sky130_fd_sc_hd__decap_3
XFILLER_24_44 VGND VGND VPWR VPWR sky130_fd_sc_hd__decap_3
XFILLER_24_59 VGND VGND VPWR VPWR sky130_fd_sc_hd__decap_12
XFILLER_24_71 VGND VGND VPWR VPWR sky130_fd_sc_hd__decap_12
XFILLER_24_83 VGND VGND VPWR VPWR sky130_fd_sc_hd__decap_12
XFILLER_24_95 VGND VGND VPWR VPWR sky130_fd_sc_hd__decap_12
XFILLER_25_112 VGND VGND VPWR VPWR sky130_fd_sc_hd__decap_8
XFILLER_25_120 VGND VGND VPWR VPWR sky130_fd_sc_hd__decap_3
XFILLER_25_159 VGND VGND VPWR VPWR sky130_fd_sc_hd__decap_12
XFILLER_25_171 VGND VGND VPWR VPWR sky130_fd_sc_hd__fill_1
XFILLER_25_180 VGND VGND VPWR VPWR sky130_fd_sc_hd__decap_8
XFILLER_25_188 VGND VGND VPWR VPWR sky130_fd_sc_hd__fill_2
XFILLER_25_21 VGND VGND VPWR VPWR sky130_fd_sc_hd__decap_12
XFILLER_25_33 VGND VGND VPWR VPWR sky130_fd_sc_hd__decap_12
XFILLER_25_45 VGND VGND VPWR VPWR sky130_fd_sc_hd__decap_12
XFILLER_25_57 VGND VGND VPWR VPWR sky130_fd_sc_hd__decap_12
XFILLER_25_69 VGND VGND VPWR VPWR sky130_fd_sc_hd__decap_12
XFILLER_25_81 VGND VGND VPWR VPWR sky130_fd_sc_hd__decap_4
XFILLER_25_85 VGND VGND VPWR VPWR sky130_fd_sc_hd__fill_1
XFILLER_25_87 VGND VGND VPWR VPWR sky130_fd_sc_hd__decap_12
XFILLER_25_9 VGND VGND VPWR VPWR sky130_fd_sc_hd__decap_12
XFILLER_25_99 VGND VGND VPWR VPWR sky130_fd_sc_hd__decap_6
XFILLER_26_1 VGND VGND VPWR VPWR sky130_fd_sc_hd__decap_12
XFILLER_26_104 VGND VGND VPWR VPWR sky130_fd_sc_hd__decap_12
XFILLER_26_116 VGND VGND VPWR VPWR sky130_fd_sc_hd__decap_8
XFILLER_26_124 VGND VGND VPWR VPWR sky130_fd_sc_hd__fill_1
XFILLER_26_13 VGND VGND VPWR VPWR sky130_fd_sc_hd__decap_12
XFILLER_26_130 VGND VGND VPWR VPWR sky130_fd_sc_hd__decap_12
XFILLER_26_142 VGND VGND VPWR VPWR sky130_fd_sc_hd__decap_12
XFILLER_26_154 VGND VGND VPWR VPWR sky130_fd_sc_hd__decap_12
XFILLER_26_166 VGND VGND VPWR VPWR sky130_fd_sc_hd__decap_4
XFILLER_26_170 VGND VGND VPWR VPWR sky130_fd_sc_hd__fill_1
XFILLER_26_183 VGND VGND VPWR VPWR sky130_fd_sc_hd__decap_8
XFILLER_26_210 VGND VGND VPWR VPWR sky130_fd_sc_hd__fill_2
XFILLER_26_25 VGND VGND VPWR VPWR sky130_fd_sc_hd__decap_12
XFILLER_26_37 VGND VGND VPWR VPWR sky130_fd_sc_hd__decap_6
XFILLER_26_44 VGND VGND VPWR VPWR sky130_fd_sc_hd__decap_12
XFILLER_26_56 VGND VGND VPWR VPWR sky130_fd_sc_hd__decap_12
XFILLER_26_68 VGND VGND VPWR VPWR sky130_fd_sc_hd__decap_12
XFILLER_26_80 VGND VGND VPWR VPWR sky130_fd_sc_hd__decap_12
XFILLER_26_92 VGND VGND VPWR VPWR sky130_fd_sc_hd__decap_12
XFILLER_27_1 VGND VGND VPWR VPWR sky130_fd_sc_hd__decap_12
XFILLER_27_107 VGND VGND VPWR VPWR sky130_fd_sc_hd__decap_3
XFILLER_27_115 VGND VGND VPWR VPWR sky130_fd_sc_hd__decap_12
XFILLER_27_127 VGND VGND VPWR VPWR sky130_fd_sc_hd__decap_12
XFILLER_27_13 VGND VGND VPWR VPWR sky130_fd_sc_hd__decap_12
XFILLER_27_139 VGND VGND VPWR VPWR sky130_fd_sc_hd__decap_12
XFILLER_27_151 VGND VGND VPWR VPWR sky130_fd_sc_hd__decap_12
XFILLER_27_163 VGND VGND VPWR VPWR sky130_fd_sc_hd__decap_8
XFILLER_27_171 VGND VGND VPWR VPWR sky130_fd_sc_hd__fill_1
XFILLER_27_173 VGND VGND VPWR VPWR sky130_fd_sc_hd__fill_2
XFILLER_27_180 VGND VGND VPWR VPWR sky130_fd_sc_hd__decap_3
XFILLER_27_190 VGND VGND VPWR VPWR sky130_fd_sc_hd__fill_1
XFILLER_27_207 VGND VGND VPWR VPWR sky130_fd_sc_hd__decap_4
XFILLER_27_211 VGND VGND VPWR VPWR sky130_fd_sc_hd__fill_1
XFILLER_27_25 VGND VGND VPWR VPWR sky130_fd_sc_hd__decap_12
XFILLER_27_37 VGND VGND VPWR VPWR sky130_fd_sc_hd__decap_12
XFILLER_27_49 VGND VGND VPWR VPWR sky130_fd_sc_hd__decap_12
XFILLER_27_61 VGND VGND VPWR VPWR sky130_fd_sc_hd__decap_12
XFILLER_27_73 VGND VGND VPWR VPWR sky130_fd_sc_hd__decap_12
XFILLER_27_85 VGND VGND VPWR VPWR sky130_fd_sc_hd__fill_1
XFILLER_27_87 VGND VGND VPWR VPWR sky130_fd_sc_hd__decap_12
XFILLER_27_99 VGND VGND VPWR VPWR sky130_fd_sc_hd__decap_8
XFILLER_28_1 VGND VGND VPWR VPWR sky130_fd_sc_hd__decap_12
XFILLER_28_104 VGND VGND VPWR VPWR sky130_fd_sc_hd__decap_12
XFILLER_28_116 VGND VGND VPWR VPWR sky130_fd_sc_hd__decap_12
XFILLER_28_128 VGND VGND VPWR VPWR sky130_fd_sc_hd__fill_1
XFILLER_28_13 VGND VGND VPWR VPWR sky130_fd_sc_hd__decap_12
XFILLER_28_130 VGND VGND VPWR VPWR sky130_fd_sc_hd__decap_12
XFILLER_28_142 VGND VGND VPWR VPWR sky130_fd_sc_hd__decap_12
XFILLER_28_154 VGND VGND VPWR VPWR sky130_fd_sc_hd__decap_12
XFILLER_28_166 VGND VGND VPWR VPWR sky130_fd_sc_hd__decap_8
XFILLER_28_174 VGND VGND VPWR VPWR sky130_fd_sc_hd__fill_2
XFILLER_28_186 VGND VGND VPWR VPWR sky130_fd_sc_hd__decap_3
XFILLER_28_194 VGND VGND VPWR VPWR sky130_fd_sc_hd__fill_2
XFILLER_28_25 VGND VGND VPWR VPWR sky130_fd_sc_hd__decap_12
XFILLER_28_37 VGND VGND VPWR VPWR sky130_fd_sc_hd__decap_6
XFILLER_28_44 VGND VGND VPWR VPWR sky130_fd_sc_hd__decap_12
XFILLER_28_56 VGND VGND VPWR VPWR sky130_fd_sc_hd__decap_12
XFILLER_28_68 VGND VGND VPWR VPWR sky130_fd_sc_hd__decap_12
XFILLER_28_80 VGND VGND VPWR VPWR sky130_fd_sc_hd__decap_12
XFILLER_28_92 VGND VGND VPWR VPWR sky130_fd_sc_hd__decap_12
XFILLER_29_1 VGND VGND VPWR VPWR sky130_fd_sc_hd__decap_12
XFILLER_29_111 VGND VGND VPWR VPWR sky130_fd_sc_hd__decap_12
XFILLER_29_123 VGND VGND VPWR VPWR sky130_fd_sc_hd__decap_12
XFILLER_29_13 VGND VGND VPWR VPWR sky130_fd_sc_hd__decap_12
XFILLER_29_135 VGND VGND VPWR VPWR sky130_fd_sc_hd__decap_12
XFILLER_29_147 VGND VGND VPWR VPWR sky130_fd_sc_hd__decap_12
XFILLER_29_159 VGND VGND VPWR VPWR sky130_fd_sc_hd__decap_12
XFILLER_29_171 VGND VGND VPWR VPWR sky130_fd_sc_hd__fill_1
XFILLER_29_173 VGND VGND VPWR VPWR sky130_fd_sc_hd__decap_8
XFILLER_29_181 VGND VGND VPWR VPWR sky130_fd_sc_hd__decap_3
XFILLER_29_25 VGND VGND VPWR VPWR sky130_fd_sc_hd__decap_12
XFILLER_29_37 VGND VGND VPWR VPWR sky130_fd_sc_hd__decap_12
XFILLER_29_49 VGND VGND VPWR VPWR sky130_fd_sc_hd__decap_12
XFILLER_29_61 VGND VGND VPWR VPWR sky130_fd_sc_hd__decap_12
XFILLER_29_73 VGND VGND VPWR VPWR sky130_fd_sc_hd__decap_12
XFILLER_29_85 VGND VGND VPWR VPWR sky130_fd_sc_hd__fill_1
XFILLER_29_87 VGND VGND VPWR VPWR sky130_fd_sc_hd__decap_12
XFILLER_29_99 VGND VGND VPWR VPWR sky130_fd_sc_hd__decap_12
XFILLER_2_1 VGND VGND VPWR VPWR sky130_fd_sc_hd__decap_12
XFILLER_2_111 VGND VGND VPWR VPWR sky130_fd_sc_hd__decap_12
XFILLER_2_123 VGND VGND VPWR VPWR sky130_fd_sc_hd__decap_6
XFILLER_2_13 VGND VGND VPWR VPWR sky130_fd_sc_hd__decap_12
XFILLER_2_130 VGND VGND VPWR VPWR sky130_fd_sc_hd__decap_12
XFILLER_2_142 VGND VGND VPWR VPWR sky130_fd_sc_hd__decap_12
XFILLER_2_154 VGND VGND VPWR VPWR sky130_fd_sc_hd__decap_12
XFILLER_2_166 VGND VGND VPWR VPWR sky130_fd_sc_hd__decap_12
XFILLER_2_178 VGND VGND VPWR VPWR sky130_fd_sc_hd__decap_12
XFILLER_2_190 VGND VGND VPWR VPWR sky130_fd_sc_hd__decap_12
XFILLER_2_202 VGND VGND VPWR VPWR sky130_fd_sc_hd__decap_8
XFILLER_2_210 VGND VGND VPWR VPWR sky130_fd_sc_hd__fill_2
XFILLER_2_25 VGND VGND VPWR VPWR sky130_fd_sc_hd__decap_12
XFILLER_2_37 VGND VGND VPWR VPWR sky130_fd_sc_hd__decap_6
XFILLER_2_44 VGND VGND VPWR VPWR sky130_fd_sc_hd__decap_12
XFILLER_2_56 VGND VGND VPWR VPWR sky130_fd_sc_hd__decap_12
XFILLER_2_68 VGND VGND VPWR VPWR sky130_fd_sc_hd__decap_12
XFILLER_2_80 VGND VGND VPWR VPWR sky130_fd_sc_hd__decap_4
XFILLER_30_1 VGND VGND VPWR VPWR sky130_fd_sc_hd__decap_12
XFILLER_30_104 VGND VGND VPWR VPWR sky130_fd_sc_hd__decap_12
XFILLER_30_116 VGND VGND VPWR VPWR sky130_fd_sc_hd__decap_12
XFILLER_30_128 VGND VGND VPWR VPWR sky130_fd_sc_hd__fill_1
XFILLER_30_13 VGND VGND VPWR VPWR sky130_fd_sc_hd__decap_12
XFILLER_30_130 VGND VGND VPWR VPWR sky130_fd_sc_hd__decap_12
XFILLER_30_142 VGND VGND VPWR VPWR sky130_fd_sc_hd__decap_12
XFILLER_30_154 VGND VGND VPWR VPWR sky130_fd_sc_hd__decap_12
XFILLER_30_166 VGND VGND VPWR VPWR sky130_fd_sc_hd__decap_12
XFILLER_30_178 VGND VGND VPWR VPWR sky130_fd_sc_hd__decap_8
XFILLER_30_25 VGND VGND VPWR VPWR sky130_fd_sc_hd__decap_12
XFILLER_30_37 VGND VGND VPWR VPWR sky130_fd_sc_hd__decap_6
XFILLER_30_44 VGND VGND VPWR VPWR sky130_fd_sc_hd__decap_12
XFILLER_30_56 VGND VGND VPWR VPWR sky130_fd_sc_hd__decap_12
XFILLER_30_68 VGND VGND VPWR VPWR sky130_fd_sc_hd__decap_12
XFILLER_30_80 VGND VGND VPWR VPWR sky130_fd_sc_hd__decap_12
XFILLER_30_92 VGND VGND VPWR VPWR sky130_fd_sc_hd__decap_12
XFILLER_31_1 VGND VGND VPWR VPWR sky130_fd_sc_hd__decap_12
XFILLER_31_111 VGND VGND VPWR VPWR sky130_fd_sc_hd__decap_12
XFILLER_31_123 VGND VGND VPWR VPWR sky130_fd_sc_hd__decap_12
XFILLER_31_13 VGND VGND VPWR VPWR sky130_fd_sc_hd__decap_12
XFILLER_31_135 VGND VGND VPWR VPWR sky130_fd_sc_hd__fill_2
XFILLER_31_141 VGND VGND VPWR VPWR sky130_fd_sc_hd__decap_12
XFILLER_31_153 VGND VGND VPWR VPWR sky130_fd_sc_hd__decap_12
XFILLER_31_165 VGND VGND VPWR VPWR sky130_fd_sc_hd__decap_6
XFILLER_31_171 VGND VGND VPWR VPWR sky130_fd_sc_hd__fill_1
XFILLER_31_173 VGND VGND VPWR VPWR sky130_fd_sc_hd__decap_12
XFILLER_31_185 VGND VGND VPWR VPWR sky130_fd_sc_hd__fill_1
XFILLER_31_203 VGND VGND VPWR VPWR sky130_fd_sc_hd__fill_1
XFILLER_31_25 VGND VGND VPWR VPWR sky130_fd_sc_hd__decap_12
XFILLER_31_37 VGND VGND VPWR VPWR sky130_fd_sc_hd__decap_12
XFILLER_31_49 VGND VGND VPWR VPWR sky130_fd_sc_hd__decap_12
XFILLER_31_61 VGND VGND VPWR VPWR sky130_fd_sc_hd__decap_12
XFILLER_31_73 VGND VGND VPWR VPWR sky130_fd_sc_hd__decap_12
XFILLER_31_85 VGND VGND VPWR VPWR sky130_fd_sc_hd__fill_1
XFILLER_31_87 VGND VGND VPWR VPWR sky130_fd_sc_hd__decap_12
XFILLER_31_99 VGND VGND VPWR VPWR sky130_fd_sc_hd__decap_12
XFILLER_32_1 VGND VGND VPWR VPWR sky130_fd_sc_hd__decap_12
XFILLER_32_104 VGND VGND VPWR VPWR sky130_fd_sc_hd__decap_6
XFILLER_32_124 VGND VGND VPWR VPWR sky130_fd_sc_hd__decap_4
XFILLER_32_128 VGND VGND VPWR VPWR sky130_fd_sc_hd__fill_1
XFILLER_32_13 VGND VGND VPWR VPWR sky130_fd_sc_hd__decap_12
XFILLER_32_130 VGND VGND VPWR VPWR sky130_fd_sc_hd__decap_3
XFILLER_32_148 VGND VGND VPWR VPWR sky130_fd_sc_hd__decap_12
XFILLER_32_160 VGND VGND VPWR VPWR sky130_fd_sc_hd__decap_4
XFILLER_32_169 VGND VGND VPWR VPWR sky130_fd_sc_hd__decap_12
XFILLER_32_181 VGND VGND VPWR VPWR sky130_fd_sc_hd__decap_8
XFILLER_32_203 VGND VGND VPWR VPWR sky130_fd_sc_hd__fill_1
XFILLER_32_25 VGND VGND VPWR VPWR sky130_fd_sc_hd__decap_12
XFILLER_32_37 VGND VGND VPWR VPWR sky130_fd_sc_hd__decap_6
XFILLER_32_44 VGND VGND VPWR VPWR sky130_fd_sc_hd__decap_12
XFILLER_32_56 VGND VGND VPWR VPWR sky130_fd_sc_hd__decap_12
XFILLER_32_68 VGND VGND VPWR VPWR sky130_fd_sc_hd__decap_12
XFILLER_32_80 VGND VGND VPWR VPWR sky130_fd_sc_hd__decap_12
XFILLER_32_92 VGND VGND VPWR VPWR sky130_fd_sc_hd__decap_12
XFILLER_33_1 VGND VGND VPWR VPWR sky130_fd_sc_hd__decap_12
XFILLER_33_13 VGND VGND VPWR VPWR sky130_fd_sc_hd__decap_12
XFILLER_33_183 VGND VGND VPWR VPWR sky130_fd_sc_hd__decap_4
XFILLER_33_202 VGND VGND VPWR VPWR sky130_fd_sc_hd__decap_8
XFILLER_33_210 VGND VGND VPWR VPWR sky130_fd_sc_hd__fill_2
XFILLER_33_25 VGND VGND VPWR VPWR sky130_fd_sc_hd__decap_12
XFILLER_33_37 VGND VGND VPWR VPWR sky130_fd_sc_hd__decap_12
XFILLER_33_49 VGND VGND VPWR VPWR sky130_fd_sc_hd__decap_12
XFILLER_33_61 VGND VGND VPWR VPWR sky130_fd_sc_hd__decap_12
XFILLER_33_73 VGND VGND VPWR VPWR sky130_fd_sc_hd__decap_12
XFILLER_33_85 VGND VGND VPWR VPWR sky130_fd_sc_hd__fill_1
XFILLER_33_87 VGND VGND VPWR VPWR sky130_fd_sc_hd__decap_12
XFILLER_33_99 VGND VGND VPWR VPWR sky130_fd_sc_hd__decap_8
XFILLER_34_1 VGND VGND VPWR VPWR sky130_fd_sc_hd__decap_12
XFILLER_34_119 VGND VGND VPWR VPWR sky130_fd_sc_hd__fill_2
XFILLER_34_13 VGND VGND VPWR VPWR sky130_fd_sc_hd__decap_12
XFILLER_34_151 VGND VGND VPWR VPWR sky130_fd_sc_hd__fill_1
XFILLER_34_164 VGND VGND VPWR VPWR sky130_fd_sc_hd__decap_3
XFILLER_34_175 VGND VGND VPWR VPWR sky130_fd_sc_hd__fill_1
XFILLER_34_183 VGND VGND VPWR VPWR sky130_fd_sc_hd__decap_12
XFILLER_34_195 VGND VGND VPWR VPWR sky130_fd_sc_hd__decap_12
XFILLER_34_207 VGND VGND VPWR VPWR sky130_fd_sc_hd__decap_4
XFILLER_34_211 VGND VGND VPWR VPWR sky130_fd_sc_hd__fill_1
XFILLER_34_25 VGND VGND VPWR VPWR sky130_fd_sc_hd__decap_12
XFILLER_34_37 VGND VGND VPWR VPWR sky130_fd_sc_hd__decap_6
XFILLER_34_44 VGND VGND VPWR VPWR sky130_fd_sc_hd__decap_12
XFILLER_34_56 VGND VGND VPWR VPWR sky130_fd_sc_hd__decap_12
XFILLER_34_68 VGND VGND VPWR VPWR sky130_fd_sc_hd__decap_12
XFILLER_34_80 VGND VGND VPWR VPWR sky130_fd_sc_hd__decap_12
XFILLER_34_92 VGND VGND VPWR VPWR sky130_fd_sc_hd__decap_8
XFILLER_35_1 VGND VGND VPWR VPWR sky130_fd_sc_hd__decap_12
XFILLER_35_117 VGND VGND VPWR VPWR sky130_fd_sc_hd__fill_2
XFILLER_35_127 VGND VGND VPWR VPWR sky130_fd_sc_hd__fill_2
XFILLER_35_13 VGND VGND VPWR VPWR sky130_fd_sc_hd__decap_12
XFILLER_35_170 VGND VGND VPWR VPWR sky130_fd_sc_hd__fill_2
XFILLER_35_178 VGND VGND VPWR VPWR sky130_fd_sc_hd__decap_12
XFILLER_35_190 VGND VGND VPWR VPWR sky130_fd_sc_hd__decap_12
XFILLER_35_202 VGND VGND VPWR VPWR sky130_fd_sc_hd__decap_8
XFILLER_35_210 VGND VGND VPWR VPWR sky130_fd_sc_hd__fill_2
XFILLER_35_25 VGND VGND VPWR VPWR sky130_fd_sc_hd__decap_12
XFILLER_35_37 VGND VGND VPWR VPWR sky130_fd_sc_hd__decap_6
XFILLER_35_44 VGND VGND VPWR VPWR sky130_fd_sc_hd__decap_12
XFILLER_35_56 VGND VGND VPWR VPWR sky130_fd_sc_hd__decap_12
XFILLER_35_68 VGND VGND VPWR VPWR sky130_fd_sc_hd__decap_12
XFILLER_35_80 VGND VGND VPWR VPWR sky130_fd_sc_hd__decap_6
XFILLER_35_87 VGND VGND VPWR VPWR sky130_fd_sc_hd__decap_12
XFILLER_35_99 VGND VGND VPWR VPWR sky130_fd_sc_hd__fill_2
XFILLER_3_1 VGND VGND VPWR VPWR sky130_fd_sc_hd__decap_12
XFILLER_3_108 VGND VGND VPWR VPWR sky130_fd_sc_hd__decap_12
XFILLER_3_120 VGND VGND VPWR VPWR sky130_fd_sc_hd__decap_12
XFILLER_3_13 VGND VGND VPWR VPWR sky130_fd_sc_hd__decap_12
XFILLER_3_132 VGND VGND VPWR VPWR sky130_fd_sc_hd__decap_12
XFILLER_3_144 VGND VGND VPWR VPWR sky130_fd_sc_hd__decap_12
XFILLER_3_156 VGND VGND VPWR VPWR sky130_fd_sc_hd__decap_12
XFILLER_3_168 VGND VGND VPWR VPWR sky130_fd_sc_hd__decap_4
XFILLER_3_173 VGND VGND VPWR VPWR sky130_fd_sc_hd__decap_12
XFILLER_3_185 VGND VGND VPWR VPWR sky130_fd_sc_hd__decap_12
XFILLER_3_197 VGND VGND VPWR VPWR sky130_fd_sc_hd__decap_12
XFILLER_3_209 VGND VGND VPWR VPWR sky130_fd_sc_hd__decap_3
XFILLER_3_25 VGND VGND VPWR VPWR sky130_fd_sc_hd__fill_1
XFILLER_3_33 VGND VGND VPWR VPWR sky130_fd_sc_hd__decap_12
XFILLER_3_45 VGND VGND VPWR VPWR sky130_fd_sc_hd__decap_12
XFILLER_3_57 VGND VGND VPWR VPWR sky130_fd_sc_hd__decap_12
XFILLER_3_69 VGND VGND VPWR VPWR sky130_fd_sc_hd__decap_12
XFILLER_3_81 VGND VGND VPWR VPWR sky130_fd_sc_hd__decap_4
XFILLER_3_85 VGND VGND VPWR VPWR sky130_fd_sc_hd__fill_1
XFILLER_3_87 VGND VGND VPWR VPWR sky130_fd_sc_hd__decap_8
XFILLER_3_95 VGND VGND VPWR VPWR sky130_fd_sc_hd__fill_2
XFILLER_4_1 VGND VGND VPWR VPWR sky130_fd_sc_hd__decap_6
XFILLER_4_104 VGND VGND VPWR VPWR sky130_fd_sc_hd__decap_12
XFILLER_4_11 VGND VGND VPWR VPWR sky130_fd_sc_hd__fill_1
XFILLER_4_116 VGND VGND VPWR VPWR sky130_fd_sc_hd__decap_12
XFILLER_4_128 VGND VGND VPWR VPWR sky130_fd_sc_hd__fill_1
XFILLER_4_130 VGND VGND VPWR VPWR sky130_fd_sc_hd__decap_12
XFILLER_4_142 VGND VGND VPWR VPWR sky130_fd_sc_hd__decap_8
XFILLER_4_15 VGND VGND VPWR VPWR sky130_fd_sc_hd__decap_8
XFILLER_4_154 VGND VGND VPWR VPWR sky130_fd_sc_hd__decap_12
XFILLER_4_166 VGND VGND VPWR VPWR sky130_fd_sc_hd__decap_12
XFILLER_4_178 VGND VGND VPWR VPWR sky130_fd_sc_hd__decap_12
XFILLER_4_190 VGND VGND VPWR VPWR sky130_fd_sc_hd__decap_12
XFILLER_4_202 VGND VGND VPWR VPWR sky130_fd_sc_hd__decap_8
XFILLER_4_210 VGND VGND VPWR VPWR sky130_fd_sc_hd__fill_2
XFILLER_4_23 VGND VGND VPWR VPWR sky130_fd_sc_hd__decap_3
XFILLER_4_32 VGND VGND VPWR VPWR sky130_fd_sc_hd__decap_8
XFILLER_4_40 VGND VGND VPWR VPWR sky130_fd_sc_hd__decap_3
XFILLER_4_44 VGND VGND VPWR VPWR sky130_fd_sc_hd__decap_12
XFILLER_4_56 VGND VGND VPWR VPWR sky130_fd_sc_hd__decap_12
XFILLER_4_68 VGND VGND VPWR VPWR sky130_fd_sc_hd__decap_12
XFILLER_4_7 VGND VGND VPWR VPWR sky130_fd_sc_hd__fill_1
XFILLER_4_80 VGND VGND VPWR VPWR sky130_fd_sc_hd__decap_12
XFILLER_4_92 VGND VGND VPWR VPWR sky130_fd_sc_hd__decap_12
XFILLER_5_111 VGND VGND VPWR VPWR sky130_fd_sc_hd__decap_12
XFILLER_5_123 VGND VGND VPWR VPWR sky130_fd_sc_hd__decap_12
XFILLER_5_135 VGND VGND VPWR VPWR sky130_fd_sc_hd__fill_1
XFILLER_5_156 VGND VGND VPWR VPWR sky130_fd_sc_hd__decap_3
XFILLER_5_163 VGND VGND VPWR VPWR sky130_fd_sc_hd__decap_4
XFILLER_5_171 VGND VGND VPWR VPWR sky130_fd_sc_hd__fill_1
XFILLER_5_181 VGND VGND VPWR VPWR sky130_fd_sc_hd__decap_12
XFILLER_5_193 VGND VGND VPWR VPWR sky130_fd_sc_hd__decap_12
XFILLER_5_20 VGND VGND VPWR VPWR sky130_fd_sc_hd__fill_1
XFILLER_5_205 VGND VGND VPWR VPWR sky130_fd_sc_hd__decap_6
XFILLER_5_211 VGND VGND VPWR VPWR sky130_fd_sc_hd__fill_1
XFILLER_5_34 VGND VGND VPWR VPWR sky130_fd_sc_hd__decap_12
XFILLER_5_46 VGND VGND VPWR VPWR sky130_fd_sc_hd__decap_12
XFILLER_5_58 VGND VGND VPWR VPWR sky130_fd_sc_hd__decap_12
XFILLER_5_70 VGND VGND VPWR VPWR sky130_fd_sc_hd__decap_12
XFILLER_5_82 VGND VGND VPWR VPWR sky130_fd_sc_hd__decap_4
XFILLER_5_87 VGND VGND VPWR VPWR sky130_fd_sc_hd__decap_12
XFILLER_5_99 VGND VGND VPWR VPWR sky130_fd_sc_hd__decap_12
XFILLER_6_104 VGND VGND VPWR VPWR sky130_fd_sc_hd__decap_12
XFILLER_6_116 VGND VGND VPWR VPWR sky130_fd_sc_hd__decap_12
XFILLER_6_128 VGND VGND VPWR VPWR sky130_fd_sc_hd__fill_1
XFILLER_6_142 VGND VGND VPWR VPWR sky130_fd_sc_hd__decap_8
XFILLER_6_150 VGND VGND VPWR VPWR sky130_fd_sc_hd__decap_3
XFILLER_6_185 VGND VGND VPWR VPWR sky130_fd_sc_hd__decap_12
XFILLER_6_197 VGND VGND VPWR VPWR sky130_fd_sc_hd__decap_12
XFILLER_6_209 VGND VGND VPWR VPWR sky130_fd_sc_hd__decap_3
XFILLER_6_22 VGND VGND VPWR VPWR sky130_fd_sc_hd__fill_1
XFILLER_6_38 VGND VGND VPWR VPWR sky130_fd_sc_hd__decap_4
XFILLER_6_42 VGND VGND VPWR VPWR sky130_fd_sc_hd__fill_1
XFILLER_6_44 VGND VGND VPWR VPWR sky130_fd_sc_hd__decap_12
XFILLER_6_56 VGND VGND VPWR VPWR sky130_fd_sc_hd__decap_12
XFILLER_6_68 VGND VGND VPWR VPWR sky130_fd_sc_hd__decap_12
XFILLER_6_80 VGND VGND VPWR VPWR sky130_fd_sc_hd__decap_12
XFILLER_6_92 VGND VGND VPWR VPWR sky130_fd_sc_hd__decap_12
XFILLER_7_111 VGND VGND VPWR VPWR sky130_fd_sc_hd__decap_12
XFILLER_7_123 VGND VGND VPWR VPWR sky130_fd_sc_hd__decap_3
XFILLER_7_134 VGND VGND VPWR VPWR sky130_fd_sc_hd__decap_12
XFILLER_7_146 VGND VGND VPWR VPWR sky130_fd_sc_hd__decap_12
XFILLER_7_158 VGND VGND VPWR VPWR sky130_fd_sc_hd__decap_12
XFILLER_7_170 VGND VGND VPWR VPWR sky130_fd_sc_hd__fill_2
XFILLER_7_173 VGND VGND VPWR VPWR sky130_fd_sc_hd__fill_1
XFILLER_7_186 VGND VGND VPWR VPWR sky130_fd_sc_hd__decap_12
XFILLER_7_198 VGND VGND VPWR VPWR sky130_fd_sc_hd__decap_12
XFILLER_7_210 VGND VGND VPWR VPWR sky130_fd_sc_hd__fill_2
XFILLER_7_34 VGND VGND VPWR VPWR sky130_fd_sc_hd__fill_2
XFILLER_7_39 VGND VGND VPWR VPWR sky130_fd_sc_hd__decap_12
XFILLER_7_51 VGND VGND VPWR VPWR sky130_fd_sc_hd__decap_12
XFILLER_7_75 VGND VGND VPWR VPWR sky130_fd_sc_hd__decap_8
XFILLER_7_83 VGND VGND VPWR VPWR sky130_fd_sc_hd__decap_3
XFILLER_7_87 VGND VGND VPWR VPWR sky130_fd_sc_hd__decap_12
XFILLER_7_99 VGND VGND VPWR VPWR sky130_fd_sc_hd__decap_12
XFILLER_8_105 VGND VGND VPWR VPWR sky130_fd_sc_hd__decap_12
XFILLER_8_117 VGND VGND VPWR VPWR sky130_fd_sc_hd__decap_8
XFILLER_8_130 VGND VGND VPWR VPWR sky130_fd_sc_hd__fill_1
XFILLER_8_143 VGND VGND VPWR VPWR sky130_fd_sc_hd__decap_8
XFILLER_8_155 VGND VGND VPWR VPWR sky130_fd_sc_hd__decap_12
XFILLER_8_167 VGND VGND VPWR VPWR sky130_fd_sc_hd__decap_6
XFILLER_8_185 VGND VGND VPWR VPWR sky130_fd_sc_hd__decap_12
XFILLER_8_197 VGND VGND VPWR VPWR sky130_fd_sc_hd__decap_12
XFILLER_8_209 VGND VGND VPWR VPWR sky130_fd_sc_hd__decap_3
XFILLER_8_21 VGND VGND VPWR VPWR sky130_fd_sc_hd__fill_2
XFILLER_8_44 VGND VGND VPWR VPWR sky130_fd_sc_hd__decap_12
XFILLER_8_56 VGND VGND VPWR VPWR sky130_fd_sc_hd__decap_4
XFILLER_8_60 VGND VGND VPWR VPWR sky130_fd_sc_hd__fill_1
XFILLER_8_81 VGND VGND VPWR VPWR sky130_fd_sc_hd__decap_12
XFILLER_8_93 VGND VGND VPWR VPWR sky130_fd_sc_hd__decap_12
XFILLER_9_1 VGND VGND VPWR VPWR sky130_fd_sc_hd__fill_1
XFILLER_9_103 VGND VGND VPWR VPWR sky130_fd_sc_hd__decap_12
XFILLER_9_115 VGND VGND VPWR VPWR sky130_fd_sc_hd__decap_12
XFILLER_9_127 VGND VGND VPWR VPWR sky130_fd_sc_hd__decap_12
XFILLER_9_159 VGND VGND VPWR VPWR sky130_fd_sc_hd__decap_12
XFILLER_9_171 VGND VGND VPWR VPWR sky130_fd_sc_hd__fill_1
XFILLER_9_173 VGND VGND VPWR VPWR sky130_fd_sc_hd__decap_3
XFILLER_9_184 VGND VGND VPWR VPWR sky130_fd_sc_hd__decap_12
XFILLER_9_196 VGND VGND VPWR VPWR sky130_fd_sc_hd__decap_12
XFILLER_9_208 VGND VGND VPWR VPWR sky130_fd_sc_hd__decap_4
XFILLER_9_27 VGND VGND VPWR VPWR sky130_fd_sc_hd__decap_12
XFILLER_9_43 VGND VGND VPWR VPWR sky130_fd_sc_hd__decap_8
XFILLER_9_51 VGND VGND VPWR VPWR sky130_fd_sc_hd__fill_2
XFILLER_9_69 VGND VGND VPWR VPWR sky130_fd_sc_hd__decap_4
XFILLER_9_73 VGND VGND VPWR VPWR sky130_fd_sc_hd__fill_1
XFILLER_9_91 VGND VGND VPWR VPWR sky130_fd_sc_hd__decap_12
XPHY_EDGE_ROW_0_Left_36 VGND VPWR sky130_fd_sc_hd__tapvpwrvgnd_1
XPHY_EDGE_ROW_0_Right_0 VGND VPWR sky130_fd_sc_hd__tapvpwrvgnd_1
XPHY_EDGE_ROW_10_Left_46 VGND VPWR sky130_fd_sc_hd__tapvpwrvgnd_1
XPHY_EDGE_ROW_10_Right_10 VGND VPWR sky130_fd_sc_hd__tapvpwrvgnd_1
XPHY_EDGE_ROW_11_Left_47 VGND VPWR sky130_fd_sc_hd__tapvpwrvgnd_1
XPHY_EDGE_ROW_11_Right_11 VGND VPWR sky130_fd_sc_hd__tapvpwrvgnd_1
XPHY_EDGE_ROW_12_Left_48 VGND VPWR sky130_fd_sc_hd__tapvpwrvgnd_1
XPHY_EDGE_ROW_12_Right_12 VGND VPWR sky130_fd_sc_hd__tapvpwrvgnd_1
XPHY_EDGE_ROW_13_Left_49 VGND VPWR sky130_fd_sc_hd__tapvpwrvgnd_1
XPHY_EDGE_ROW_13_Right_13 VGND VPWR sky130_fd_sc_hd__tapvpwrvgnd_1
XPHY_EDGE_ROW_14_Left_50 VGND VPWR sky130_fd_sc_hd__tapvpwrvgnd_1
XPHY_EDGE_ROW_14_Right_14 VGND VPWR sky130_fd_sc_hd__tapvpwrvgnd_1
XPHY_EDGE_ROW_15_Left_51 VGND VPWR sky130_fd_sc_hd__tapvpwrvgnd_1
XPHY_EDGE_ROW_15_Right_15 VGND VPWR sky130_fd_sc_hd__tapvpwrvgnd_1
XPHY_EDGE_ROW_16_Left_52 VGND VPWR sky130_fd_sc_hd__tapvpwrvgnd_1
XPHY_EDGE_ROW_16_Right_16 VGND VPWR sky130_fd_sc_hd__tapvpwrvgnd_1
XPHY_EDGE_ROW_17_Left_53 VGND VPWR sky130_fd_sc_hd__tapvpwrvgnd_1
XPHY_EDGE_ROW_17_Right_17 VGND VPWR sky130_fd_sc_hd__tapvpwrvgnd_1
XPHY_EDGE_ROW_18_Left_54 VGND VPWR sky130_fd_sc_hd__tapvpwrvgnd_1
XPHY_EDGE_ROW_18_Right_18 VGND VPWR sky130_fd_sc_hd__tapvpwrvgnd_1
XPHY_EDGE_ROW_19_Left_55 VGND VPWR sky130_fd_sc_hd__tapvpwrvgnd_1
XPHY_EDGE_ROW_19_Right_19 VGND VPWR sky130_fd_sc_hd__tapvpwrvgnd_1
XPHY_EDGE_ROW_1_Left_37 VGND VPWR sky130_fd_sc_hd__tapvpwrvgnd_1
XPHY_EDGE_ROW_1_Right_1 VGND VPWR sky130_fd_sc_hd__tapvpwrvgnd_1
XPHY_EDGE_ROW_20_Left_56 VGND VPWR sky130_fd_sc_hd__tapvpwrvgnd_1
XPHY_EDGE_ROW_20_Right_20 VGND VPWR sky130_fd_sc_hd__tapvpwrvgnd_1
XPHY_EDGE_ROW_21_Left_57 VGND VPWR sky130_fd_sc_hd__tapvpwrvgnd_1
XPHY_EDGE_ROW_21_Right_21 VGND VPWR sky130_fd_sc_hd__tapvpwrvgnd_1
XPHY_EDGE_ROW_22_Left_58 VGND VPWR sky130_fd_sc_hd__tapvpwrvgnd_1
XPHY_EDGE_ROW_22_Right_22 VGND VPWR sky130_fd_sc_hd__tapvpwrvgnd_1
XPHY_EDGE_ROW_23_Left_59 VGND VPWR sky130_fd_sc_hd__tapvpwrvgnd_1
XPHY_EDGE_ROW_23_Right_23 VGND VPWR sky130_fd_sc_hd__tapvpwrvgnd_1
XPHY_EDGE_ROW_24_Left_60 VGND VPWR sky130_fd_sc_hd__tapvpwrvgnd_1
XPHY_EDGE_ROW_24_Right_24 VGND VPWR sky130_fd_sc_hd__tapvpwrvgnd_1
XPHY_EDGE_ROW_25_Left_61 VGND VPWR sky130_fd_sc_hd__tapvpwrvgnd_1
XPHY_EDGE_ROW_25_Right_25 VGND VPWR sky130_fd_sc_hd__tapvpwrvgnd_1
XPHY_EDGE_ROW_26_Left_62 VGND VPWR sky130_fd_sc_hd__tapvpwrvgnd_1
XPHY_EDGE_ROW_26_Right_26 VGND VPWR sky130_fd_sc_hd__tapvpwrvgnd_1
XPHY_EDGE_ROW_27_Left_63 VGND VPWR sky130_fd_sc_hd__tapvpwrvgnd_1
XPHY_EDGE_ROW_27_Right_27 VGND VPWR sky130_fd_sc_hd__tapvpwrvgnd_1
XPHY_EDGE_ROW_28_Left_64 VGND VPWR sky130_fd_sc_hd__tapvpwrvgnd_1
XPHY_EDGE_ROW_28_Right_28 VGND VPWR sky130_fd_sc_hd__tapvpwrvgnd_1
XPHY_EDGE_ROW_29_Left_65 VGND VPWR sky130_fd_sc_hd__tapvpwrvgnd_1
XPHY_EDGE_ROW_29_Right_29 VGND VPWR sky130_fd_sc_hd__tapvpwrvgnd_1
XPHY_EDGE_ROW_2_Left_38 VGND VPWR sky130_fd_sc_hd__tapvpwrvgnd_1
XPHY_EDGE_ROW_2_Right_2 VGND VPWR sky130_fd_sc_hd__tapvpwrvgnd_1
XPHY_EDGE_ROW_30_Left_66 VGND VPWR sky130_fd_sc_hd__tapvpwrvgnd_1
XPHY_EDGE_ROW_30_Right_30 VGND VPWR sky130_fd_sc_hd__tapvpwrvgnd_1
XPHY_EDGE_ROW_31_Left_67 VGND VPWR sky130_fd_sc_hd__tapvpwrvgnd_1
XPHY_EDGE_ROW_31_Right_31 VGND VPWR sky130_fd_sc_hd__tapvpwrvgnd_1
XPHY_EDGE_ROW_32_Left_68 VGND VPWR sky130_fd_sc_hd__tapvpwrvgnd_1
XPHY_EDGE_ROW_32_Right_32 VGND VPWR sky130_fd_sc_hd__tapvpwrvgnd_1
XPHY_EDGE_ROW_33_Left_69 VGND VPWR sky130_fd_sc_hd__tapvpwrvgnd_1
XPHY_EDGE_ROW_33_Right_33 VGND VPWR sky130_fd_sc_hd__tapvpwrvgnd_1
XPHY_EDGE_ROW_34_Left_70 VGND VPWR sky130_fd_sc_hd__tapvpwrvgnd_1
XPHY_EDGE_ROW_34_Right_34 VGND VPWR sky130_fd_sc_hd__tapvpwrvgnd_1
XPHY_EDGE_ROW_35_Left_71 VGND VPWR sky130_fd_sc_hd__tapvpwrvgnd_1
XPHY_EDGE_ROW_35_Right_35 VGND VPWR sky130_fd_sc_hd__tapvpwrvgnd_1
XPHY_EDGE_ROW_3_Left_39 VGND VPWR sky130_fd_sc_hd__tapvpwrvgnd_1
XPHY_EDGE_ROW_3_Right_3 VGND VPWR sky130_fd_sc_hd__tapvpwrvgnd_1
XPHY_EDGE_ROW_4_Left_40 VGND VPWR sky130_fd_sc_hd__tapvpwrvgnd_1
XPHY_EDGE_ROW_4_Right_4 VGND VPWR sky130_fd_sc_hd__tapvpwrvgnd_1
XPHY_EDGE_ROW_5_Left_41 VGND VPWR sky130_fd_sc_hd__tapvpwrvgnd_1
XPHY_EDGE_ROW_5_Right_5 VGND VPWR sky130_fd_sc_hd__tapvpwrvgnd_1
XPHY_EDGE_ROW_6_Left_42 VGND VPWR sky130_fd_sc_hd__tapvpwrvgnd_1
XPHY_EDGE_ROW_6_Right_6 VGND VPWR sky130_fd_sc_hd__tapvpwrvgnd_1
XPHY_EDGE_ROW_7_Left_43 VGND VPWR sky130_fd_sc_hd__tapvpwrvgnd_1
XPHY_EDGE_ROW_7_Right_7 VGND VPWR sky130_fd_sc_hd__tapvpwrvgnd_1
XPHY_EDGE_ROW_8_Left_44 VGND VPWR sky130_fd_sc_hd__tapvpwrvgnd_1
XPHY_EDGE_ROW_8_Right_8 VGND VPWR sky130_fd_sc_hd__tapvpwrvgnd_1
XPHY_EDGE_ROW_9_Left_45 VGND VPWR sky130_fd_sc_hd__tapvpwrvgnd_1
XPHY_EDGE_ROW_9_Right_9 VGND VPWR sky130_fd_sc_hd__tapvpwrvgnd_1
XTAP_TAPCELL_ROW_0_72 VGND VPWR sky130_fd_sc_hd__tapvpwrvgnd_1
XTAP_TAPCELL_ROW_0_73 VGND VPWR sky130_fd_sc_hd__tapvpwrvgnd_1
XTAP_TAPCELL_ROW_0_74 VGND VPWR sky130_fd_sc_hd__tapvpwrvgnd_1
XTAP_TAPCELL_ROW_0_75 VGND VPWR sky130_fd_sc_hd__tapvpwrvgnd_1
XTAP_TAPCELL_ROW_10_94 VGND VPWR sky130_fd_sc_hd__tapvpwrvgnd_1
XTAP_TAPCELL_ROW_10_95 VGND VPWR sky130_fd_sc_hd__tapvpwrvgnd_1
XTAP_TAPCELL_ROW_11_96 VGND VPWR sky130_fd_sc_hd__tapvpwrvgnd_1
XTAP_TAPCELL_ROW_11_97 VGND VPWR sky130_fd_sc_hd__tapvpwrvgnd_1
XTAP_TAPCELL_ROW_12_98 VGND VPWR sky130_fd_sc_hd__tapvpwrvgnd_1
XTAP_TAPCELL_ROW_12_99 VGND VPWR sky130_fd_sc_hd__tapvpwrvgnd_1
XTAP_TAPCELL_ROW_13_100 VGND VPWR sky130_fd_sc_hd__tapvpwrvgnd_1
XTAP_TAPCELL_ROW_13_101 VGND VPWR sky130_fd_sc_hd__tapvpwrvgnd_1
XTAP_TAPCELL_ROW_14_102 VGND VPWR sky130_fd_sc_hd__tapvpwrvgnd_1
XTAP_TAPCELL_ROW_14_103 VGND VPWR sky130_fd_sc_hd__tapvpwrvgnd_1
XTAP_TAPCELL_ROW_15_104 VGND VPWR sky130_fd_sc_hd__tapvpwrvgnd_1
XTAP_TAPCELL_ROW_15_105 VGND VPWR sky130_fd_sc_hd__tapvpwrvgnd_1
XTAP_TAPCELL_ROW_16_106 VGND VPWR sky130_fd_sc_hd__tapvpwrvgnd_1
XTAP_TAPCELL_ROW_16_107 VGND VPWR sky130_fd_sc_hd__tapvpwrvgnd_1
XTAP_TAPCELL_ROW_17_108 VGND VPWR sky130_fd_sc_hd__tapvpwrvgnd_1
XTAP_TAPCELL_ROW_17_109 VGND VPWR sky130_fd_sc_hd__tapvpwrvgnd_1
XTAP_TAPCELL_ROW_18_110 VGND VPWR sky130_fd_sc_hd__tapvpwrvgnd_1
XTAP_TAPCELL_ROW_18_111 VGND VPWR sky130_fd_sc_hd__tapvpwrvgnd_1
XTAP_TAPCELL_ROW_19_112 VGND VPWR sky130_fd_sc_hd__tapvpwrvgnd_1
XTAP_TAPCELL_ROW_19_113 VGND VPWR sky130_fd_sc_hd__tapvpwrvgnd_1
XTAP_TAPCELL_ROW_1_76 VGND VPWR sky130_fd_sc_hd__tapvpwrvgnd_1
XTAP_TAPCELL_ROW_1_77 VGND VPWR sky130_fd_sc_hd__tapvpwrvgnd_1
XTAP_TAPCELL_ROW_20_114 VGND VPWR sky130_fd_sc_hd__tapvpwrvgnd_1
XTAP_TAPCELL_ROW_20_115 VGND VPWR sky130_fd_sc_hd__tapvpwrvgnd_1
XTAP_TAPCELL_ROW_21_116 VGND VPWR sky130_fd_sc_hd__tapvpwrvgnd_1
XTAP_TAPCELL_ROW_21_117 VGND VPWR sky130_fd_sc_hd__tapvpwrvgnd_1
XTAP_TAPCELL_ROW_22_118 VGND VPWR sky130_fd_sc_hd__tapvpwrvgnd_1
XTAP_TAPCELL_ROW_22_119 VGND VPWR sky130_fd_sc_hd__tapvpwrvgnd_1
XTAP_TAPCELL_ROW_23_120 VGND VPWR sky130_fd_sc_hd__tapvpwrvgnd_1
XTAP_TAPCELL_ROW_23_121 VGND VPWR sky130_fd_sc_hd__tapvpwrvgnd_1
XTAP_TAPCELL_ROW_24_122 VGND VPWR sky130_fd_sc_hd__tapvpwrvgnd_1
XTAP_TAPCELL_ROW_24_123 VGND VPWR sky130_fd_sc_hd__tapvpwrvgnd_1
XTAP_TAPCELL_ROW_25_124 VGND VPWR sky130_fd_sc_hd__tapvpwrvgnd_1
XTAP_TAPCELL_ROW_25_125 VGND VPWR sky130_fd_sc_hd__tapvpwrvgnd_1
XTAP_TAPCELL_ROW_26_126 VGND VPWR sky130_fd_sc_hd__tapvpwrvgnd_1
XTAP_TAPCELL_ROW_26_127 VGND VPWR sky130_fd_sc_hd__tapvpwrvgnd_1
XTAP_TAPCELL_ROW_27_128 VGND VPWR sky130_fd_sc_hd__tapvpwrvgnd_1
XTAP_TAPCELL_ROW_27_129 VGND VPWR sky130_fd_sc_hd__tapvpwrvgnd_1
XTAP_TAPCELL_ROW_28_130 VGND VPWR sky130_fd_sc_hd__tapvpwrvgnd_1
XTAP_TAPCELL_ROW_28_131 VGND VPWR sky130_fd_sc_hd__tapvpwrvgnd_1
XTAP_TAPCELL_ROW_29_132 VGND VPWR sky130_fd_sc_hd__tapvpwrvgnd_1
XTAP_TAPCELL_ROW_29_133 VGND VPWR sky130_fd_sc_hd__tapvpwrvgnd_1
XTAP_TAPCELL_ROW_2_78 VGND VPWR sky130_fd_sc_hd__tapvpwrvgnd_1
XTAP_TAPCELL_ROW_2_79 VGND VPWR sky130_fd_sc_hd__tapvpwrvgnd_1
XTAP_TAPCELL_ROW_30_134 VGND VPWR sky130_fd_sc_hd__tapvpwrvgnd_1
XTAP_TAPCELL_ROW_30_135 VGND VPWR sky130_fd_sc_hd__tapvpwrvgnd_1
XTAP_TAPCELL_ROW_31_136 VGND VPWR sky130_fd_sc_hd__tapvpwrvgnd_1
XTAP_TAPCELL_ROW_31_137 VGND VPWR sky130_fd_sc_hd__tapvpwrvgnd_1
XTAP_TAPCELL_ROW_32_138 VGND VPWR sky130_fd_sc_hd__tapvpwrvgnd_1
XTAP_TAPCELL_ROW_32_139 VGND VPWR sky130_fd_sc_hd__tapvpwrvgnd_1
XTAP_TAPCELL_ROW_33_140 VGND VPWR sky130_fd_sc_hd__tapvpwrvgnd_1
XTAP_TAPCELL_ROW_33_141 VGND VPWR sky130_fd_sc_hd__tapvpwrvgnd_1
XTAP_TAPCELL_ROW_34_142 VGND VPWR sky130_fd_sc_hd__tapvpwrvgnd_1
XTAP_TAPCELL_ROW_34_143 VGND VPWR sky130_fd_sc_hd__tapvpwrvgnd_1
XTAP_TAPCELL_ROW_35_144 VGND VPWR sky130_fd_sc_hd__tapvpwrvgnd_1
XTAP_TAPCELL_ROW_35_145 VGND VPWR sky130_fd_sc_hd__tapvpwrvgnd_1
XTAP_TAPCELL_ROW_35_146 VGND VPWR sky130_fd_sc_hd__tapvpwrvgnd_1
XTAP_TAPCELL_ROW_35_147 VGND VPWR sky130_fd_sc_hd__tapvpwrvgnd_1
XTAP_TAPCELL_ROW_3_80 VGND VPWR sky130_fd_sc_hd__tapvpwrvgnd_1
XTAP_TAPCELL_ROW_3_81 VGND VPWR sky130_fd_sc_hd__tapvpwrvgnd_1
XTAP_TAPCELL_ROW_4_82 VGND VPWR sky130_fd_sc_hd__tapvpwrvgnd_1
XTAP_TAPCELL_ROW_4_83 VGND VPWR sky130_fd_sc_hd__tapvpwrvgnd_1
XTAP_TAPCELL_ROW_5_84 VGND VPWR sky130_fd_sc_hd__tapvpwrvgnd_1
XTAP_TAPCELL_ROW_5_85 VGND VPWR sky130_fd_sc_hd__tapvpwrvgnd_1
XTAP_TAPCELL_ROW_6_86 VGND VPWR sky130_fd_sc_hd__tapvpwrvgnd_1
XTAP_TAPCELL_ROW_6_87 VGND VPWR sky130_fd_sc_hd__tapvpwrvgnd_1
XTAP_TAPCELL_ROW_7_88 VGND VPWR sky130_fd_sc_hd__tapvpwrvgnd_1
XTAP_TAPCELL_ROW_7_89 VGND VPWR sky130_fd_sc_hd__tapvpwrvgnd_1
XTAP_TAPCELL_ROW_8_90 VGND VPWR sky130_fd_sc_hd__tapvpwrvgnd_1
XTAP_TAPCELL_ROW_8_91 VGND VPWR sky130_fd_sc_hd__tapvpwrvgnd_1
XTAP_TAPCELL_ROW_9_92 VGND VPWR sky130_fd_sc_hd__tapvpwrvgnd_1
XTAP_TAPCELL_ROW_9_93 VGND VPWR sky130_fd_sc_hd__tapvpwrvgnd_1
X_4_ REF VGND VGND VPWR VPWR net63 sky130_fd_sc_hd__buf_2
X_5_ ring.dff_y.Q VGND VGND VPWR VPWR net65 sky130_fd_sc_hd__buf_2
X_6_ ring.dff_x.Q VGND VGND VPWR VPWR net66 sky130_fd_sc_hd__buf_2
Xinput1 COARSE_MUX[0] VGND VGND VPWR VPWR net1 sky130_fd_sc_hd__clkdlybuf4s50_1
Xinput10 COARSE_MUX[4] VGND VGND VPWR VPWR net10 sky130_fd_sc_hd__clkdlybuf4s50_1
Xinput11 COARSE_MUX[5] VGND VGND VPWR VPWR net11 sky130_fd_sc_hd__clkdlybuf4s50_1
Xinput12 COARSE_MUX[6] VGND VGND VPWR VPWR net12 sky130_fd_sc_hd__clkdlybuf4s50_1
Xinput13 COARSE_MUX[7] VGND VGND VPWR VPWR net13 sky130_fd_sc_hd__clkdlybuf4s50_1
Xinput14 COARSE_MUX[8] VGND VGND VPWR VPWR net14 sky130_fd_sc_hd__clkdlybuf4s50_1
Xinput15 COARSE_MUX[9] VGND VGND VPWR VPWR net15 sky130_fd_sc_hd__clkdlybuf4s50_1
Xinput16 DCO_EN VGND VGND VPWR VPWR net16 sky130_fd_sc_hd__clkdlybuf4s50_1
Xinput17 FINE_MUX[0] VGND VGND VPWR VPWR net17 sky130_fd_sc_hd__clkdlybuf4s50_1
Xinput18 FINE_MUX[10] VGND VGND VPWR VPWR net18 sky130_fd_sc_hd__clkdlybuf4s50_1
Xinput19 FINE_MUX[11] VGND VGND VPWR VPWR net19 sky130_fd_sc_hd__clkdlybuf4s50_1
Xinput2 COARSE_MUX[10] VGND VGND VPWR VPWR net2 sky130_fd_sc_hd__clkdlybuf4s50_1
Xinput20 FINE_MUX[12] VGND VGND VPWR VPWR net20 sky130_fd_sc_hd__clkdlybuf4s50_1
Xinput21 FINE_MUX[13] VGND VGND VPWR VPWR net21 sky130_fd_sc_hd__clkdlybuf4s50_1
Xinput22 FINE_MUX[14] VGND VGND VPWR VPWR net22 sky130_fd_sc_hd__clkdlybuf4s50_1
Xinput23 FINE_MUX[15] VGND VGND VPWR VPWR net23 sky130_fd_sc_hd__clkdlybuf4s50_1
Xinput24 FINE_MUX[16] VGND VGND VPWR VPWR net24 sky130_fd_sc_hd__clkdlybuf4s50_1
Xinput25 FINE_MUX[17] VGND VGND VPWR VPWR net25 sky130_fd_sc_hd__clkdlybuf4s50_1
Xinput26 FINE_MUX[18] VGND VGND VPWR VPWR net26 sky130_fd_sc_hd__clkdlybuf4s50_1
Xinput27 FINE_MUX[19] VGND VGND VPWR VPWR net27 sky130_fd_sc_hd__clkdlybuf4s50_1
Xinput28 FINE_MUX[1] VGND VGND VPWR VPWR net28 sky130_fd_sc_hd__clkdlybuf4s50_1
Xinput29 FINE_MUX[20] VGND VGND VPWR VPWR net29 sky130_fd_sc_hd__clkdlybuf4s50_1
Xinput3 COARSE_MUX[11] VGND VGND VPWR VPWR net3 sky130_fd_sc_hd__clkdlybuf4s50_1
Xinput30 FINE_MUX[21] VGND VGND VPWR VPWR net30 sky130_fd_sc_hd__clkdlybuf4s50_1
Xinput31 FINE_MUX[22] VGND VGND VPWR VPWR net31 sky130_fd_sc_hd__clkdlybuf4s50_1
Xinput32 FINE_MUX[23] VGND VGND VPWR VPWR net32 sky130_fd_sc_hd__clkdlybuf4s50_1
Xinput33 FINE_MUX[24] VGND VGND VPWR VPWR net33 sky130_fd_sc_hd__clkdlybuf4s50_1
Xinput34 FINE_MUX[25] VGND VGND VPWR VPWR net34 sky130_fd_sc_hd__clkdlybuf4s50_1
Xinput35 FINE_MUX[26] VGND VGND VPWR VPWR net35 sky130_fd_sc_hd__clkdlybuf4s50_1
Xinput36 FINE_MUX[27] VGND VGND VPWR VPWR net36 sky130_fd_sc_hd__clkdlybuf4s50_1
Xinput37 FINE_MUX[28] VGND VGND VPWR VPWR net37 sky130_fd_sc_hd__clkdlybuf4s50_1
Xinput38 FINE_MUX[29] VGND VGND VPWR VPWR net38 sky130_fd_sc_hd__clkdlybuf4s50_1
Xinput39 FINE_MUX[2] VGND VGND VPWR VPWR net39 sky130_fd_sc_hd__clkdlybuf4s50_1
Xinput4 COARSE_MUX[12] VGND VGND VPWR VPWR net4 sky130_fd_sc_hd__clkdlybuf4s50_1
Xinput40 FINE_MUX[30] VGND VGND VPWR VPWR net40 sky130_fd_sc_hd__clkdlybuf4s50_1
Xinput41 FINE_MUX[3] VGND VGND VPWR VPWR net41 sky130_fd_sc_hd__clkdlybuf4s50_1
Xinput42 FINE_MUX[4] VGND VGND VPWR VPWR net42 sky130_fd_sc_hd__clkdlybuf4s50_1
Xinput43 FINE_MUX[5] VGND VGND VPWR VPWR net43 sky130_fd_sc_hd__clkdlybuf4s50_1
Xinput44 FINE_MUX[6] VGND VGND VPWR VPWR net44 sky130_fd_sc_hd__clkdlybuf4s50_1
Xinput45 FINE_MUX[7] VGND VGND VPWR VPWR net45 sky130_fd_sc_hd__clkdlybuf4s50_1
Xinput46 FINE_MUX[8] VGND VGND VPWR VPWR net46 sky130_fd_sc_hd__clkdlybuf4s50_1
Xinput47 FINE_MUX[9] VGND VGND VPWR VPWR net47 sky130_fd_sc_hd__clkdlybuf4s50_1
Xinput48 MID_MUX[0] VGND VGND VPWR VPWR net48 sky130_fd_sc_hd__clkdlybuf4s50_1
Xinput49 MID_MUX[10] VGND VGND VPWR VPWR net49 sky130_fd_sc_hd__clkdlybuf4s50_1
Xinput5 COARSE_MUX[13] VGND VGND VPWR VPWR net5 sky130_fd_sc_hd__clkdlybuf4s50_1
Xinput50 MID_MUX[11] VGND VGND VPWR VPWR net50 sky130_fd_sc_hd__clkdlybuf4s50_1
Xinput51 MID_MUX[12] VGND VGND VPWR VPWR net51 sky130_fd_sc_hd__clkdlybuf4s50_1
Xinput52 MID_MUX[13] VGND VGND VPWR VPWR net52 sky130_fd_sc_hd__clkdlybuf4s50_1
Xinput53 MID_MUX[14] VGND VGND VPWR VPWR net53 sky130_fd_sc_hd__clkdlybuf4s50_1
Xinput54 MID_MUX[1] VGND VGND VPWR VPWR net54 sky130_fd_sc_hd__clkdlybuf4s50_1
Xinput55 MID_MUX[2] VGND VGND VPWR VPWR net55 sky130_fd_sc_hd__clkdlybuf4s50_1
Xinput56 MID_MUX[3] VGND VGND VPWR VPWR net56 sky130_fd_sc_hd__clkdlybuf4s50_1
Xinput57 MID_MUX[4] VGND VGND VPWR VPWR net57 sky130_fd_sc_hd__clkdlybuf4s50_1
Xinput58 MID_MUX[5] VGND VGND VPWR VPWR net58 sky130_fd_sc_hd__clkdlybuf4s50_1
Xinput59 MID_MUX[6] VGND VGND VPWR VPWR net59 sky130_fd_sc_hd__clkdlybuf4s50_1
Xinput6 COARSE_MUX[14] VGND VGND VPWR VPWR net6 sky130_fd_sc_hd__clkdlybuf4s50_1
Xinput60 MID_MUX[7] VGND VGND VPWR VPWR net60 sky130_fd_sc_hd__clkdlybuf4s50_1
Xinput61 MID_MUX[8] VGND VGND VPWR VPWR net61 sky130_fd_sc_hd__clkdlybuf4s50_1
Xinput62 MID_MUX[9] VGND VGND VPWR VPWR net62 sky130_fd_sc_hd__clkdlybuf4s50_1
Xinput7 COARSE_MUX[1] VGND VGND VPWR VPWR net7 sky130_fd_sc_hd__clkdlybuf4s50_1
Xinput8 COARSE_MUX[2] VGND VGND VPWR VPWR net8 sky130_fd_sc_hd__clkdlybuf4s50_1
Xinput9 COARSE_MUX[3] VGND VGND VPWR VPWR net9 sky130_fd_sc_hd__clkdlybuf4s50_1
Xoutput63 net63 VGND VGND VPWR VPWR INJ_EDGE sky130_fd_sc_hd__clkdlybuf4s50_1
Xoutput64 net64 VGND VGND VPWR VPWR MID_OUT sky130_fd_sc_hd__clkdlybuf4s50_1
Xoutput65 net65 VGND VGND VPWR VPWR SS_BBPD[0] sky130_fd_sc_hd__clkdlybuf4s50_1
Xoutput66 net66 VGND VGND VPWR VPWR SS_BBPD[1] sky130_fd_sc_hd__clkdlybuf4s50_1
Xring.base_delay.stage\[0\].delay_cell.impl OUT VGND VGND
+ VPWR VPWR ring.base_delay.stage\[0\].delay_cell.Z sky130_fd_sc_hd__buf_2
Xring.base_delay.stage\[100\].delay_cell.impl ring.base_delay.stage\[100\].delay_cell.I
+ VGND VGND VPWR VPWR ring.base_delay.stage\[100\].delay_cell.Z
+ sky130_fd_sc_hd__buf_2
Xring.base_delay.stage\[101\].delay_cell.impl ring.base_delay.stage\[100\].delay_cell.Z
+ VGND VGND VPWR VPWR ring.base_delay.stage\[101\].delay_cell.Z
+ sky130_fd_sc_hd__buf_2
Xring.base_delay.stage\[102\].delay_cell.impl ring.base_delay.stage\[101\].delay_cell.Z
+ VGND VGND VPWR VPWR ring.base_delay.stage\[102\].delay_cell.Z
+ sky130_fd_sc_hd__buf_2
Xring.base_delay.stage\[103\].delay_cell.impl ring.base_delay.stage\[102\].delay_cell.Z
+ VGND VGND VPWR VPWR ring.base_delay.stage\[103\].delay_cell.Z
+ sky130_fd_sc_hd__buf_2
Xring.base_delay.stage\[104\].delay_cell.impl ring.base_delay.stage\[103\].delay_cell.Z
+ VGND VGND VPWR VPWR ring.base_delay.stage\[104\].delay_cell.Z
+ sky130_fd_sc_hd__buf_2
Xring.base_delay.stage\[105\].delay_cell.impl ring.base_delay.stage\[104\].delay_cell.Z
+ VGND VGND VPWR VPWR ring.base_delay.stage\[105\].delay_cell.Z
+ sky130_fd_sc_hd__buf_2
Xring.base_delay.stage\[106\].delay_cell.impl ring.base_delay.stage\[105\].delay_cell.Z
+ VGND VGND VPWR VPWR ring.base_delay.stage\[106\].delay_cell.Z
+ sky130_fd_sc_hd__buf_2
Xring.base_delay.stage\[107\].delay_cell.impl ring.base_delay.stage\[106\].delay_cell.Z
+ VGND VGND VPWR VPWR ring.base_delay.stage\[107\].delay_cell.Z
+ sky130_fd_sc_hd__buf_2
Xring.base_delay.stage\[108\].delay_cell.impl ring.base_delay.stage\[107\].delay_cell.Z
+ VGND VGND VPWR VPWR ring.base_delay.stage\[108\].delay_cell.Z
+ sky130_fd_sc_hd__buf_2
Xring.base_delay.stage\[109\].delay_cell.impl ring.base_delay.stage\[108\].delay_cell.Z
+ VGND VGND VPWR VPWR ring.base_delay.stage\[109\].delay_cell.Z
+ sky130_fd_sc_hd__buf_2
Xring.base_delay.stage\[10\].delay_cell.impl ring.base_delay.stage\[10\].delay_cell.I
+ VGND VGND VPWR VPWR ring.base_delay.stage\[10\].delay_cell.Z
+ sky130_fd_sc_hd__buf_2
Xring.base_delay.stage\[110\].delay_cell.impl ring.base_delay.stage\[109\].delay_cell.Z
+ VGND VGND VPWR VPWR ring.base_delay.stage\[110\].delay_cell.Z
+ sky130_fd_sc_hd__buf_2
Xring.base_delay.stage\[111\].delay_cell.impl ring.base_delay.stage\[110\].delay_cell.Z
+ VGND VGND VPWR VPWR ring.base_delay.stage\[111\].delay_cell.Z
+ sky130_fd_sc_hd__buf_2
Xring.base_delay.stage\[112\].delay_cell.impl ring.base_delay.stage\[111\].delay_cell.Z
+ VGND VGND VPWR VPWR ring.base_delay.stage\[112\].delay_cell.Z
+ sky130_fd_sc_hd__buf_2
Xring.base_delay.stage\[113\].delay_cell.impl ring.base_delay.stage\[112\].delay_cell.Z
+ VGND VGND VPWR VPWR ring.base_delay.stage\[113\].delay_cell.Z
+ sky130_fd_sc_hd__buf_2
Xring.base_delay.stage\[114\].delay_cell.impl ring.base_delay.stage\[113\].delay_cell.Z
+ VGND VGND VPWR VPWR ring.base_delay.stage\[114\].delay_cell.Z
+ sky130_fd_sc_hd__buf_2
Xring.base_delay.stage\[115\].delay_cell.impl ring.base_delay.stage\[114\].delay_cell.Z
+ VGND VGND VPWR VPWR ring.base_delay.stage\[115\].delay_cell.Z
+ sky130_fd_sc_hd__buf_2
Xring.base_delay.stage\[116\].delay_cell.impl ring.base_delay.stage\[115\].delay_cell.Z
+ VGND VGND VPWR VPWR ring.base_delay.stage\[116\].delay_cell.Z
+ sky130_fd_sc_hd__buf_2
Xring.base_delay.stage\[117\].delay_cell.impl ring.base_delay.stage\[116\].delay_cell.Z
+ VGND VGND VPWR VPWR ring.base_delay.stage\[117\].delay_cell.Z
+ sky130_fd_sc_hd__buf_2
Xring.base_delay.stage\[118\].delay_cell.impl ring.base_delay.stage\[117\].delay_cell.Z
+ VGND VGND VPWR VPWR ring.base_delay.stage\[118\].delay_cell.Z
+ sky130_fd_sc_hd__buf_2
Xring.base_delay.stage\[119\].delay_cell.impl ring.base_delay.stage\[118\].delay_cell.Z
+ VGND VGND VPWR VPWR ring.base_delay.stage\[119\].delay_cell.Z
+ sky130_fd_sc_hd__buf_2
Xring.base_delay.stage\[11\].delay_cell.impl ring.base_delay.stage\[10\].delay_cell.Z
+ VGND VGND VPWR VPWR ring.base_delay.stage\[11\].delay_cell.Z
+ sky130_fd_sc_hd__buf_2
Xring.base_delay.stage\[120\].delay_cell.impl ring.base_delay.stage\[119\].delay_cell.Z
+ VGND VGND VPWR VPWR ring.base_delay.stage\[120\].delay_cell.Z
+ sky130_fd_sc_hd__buf_2
Xring.base_delay.stage\[121\].delay_cell.impl ring.base_delay.stage\[120\].delay_cell.Z
+ VGND VGND VPWR VPWR ring.base_delay.stage\[121\].delay_cell.Z
+ sky130_fd_sc_hd__buf_2
Xring.base_delay.stage\[122\].delay_cell.impl ring.base_delay.stage\[121\].delay_cell.Z
+ VGND VGND VPWR VPWR ring.base_delay.stage\[122\].delay_cell.Z
+ sky130_fd_sc_hd__buf_2
Xring.base_delay.stage\[123\].delay_cell.impl ring.base_delay.stage\[122\].delay_cell.Z
+ VGND VGND VPWR VPWR ring.base_delay.stage\[123\].delay_cell.Z
+ sky130_fd_sc_hd__buf_2
Xring.base_delay.stage\[124\].delay_cell.impl ring.base_delay.stage\[123\].delay_cell.Z
+ VGND VGND VPWR VPWR ring.base_delay.stage\[124\].delay_cell.Z
+ sky130_fd_sc_hd__buf_2
Xring.base_delay.stage\[125\].delay_cell.impl ring.base_delay.stage\[124\].delay_cell.Z
+ VGND VGND VPWR VPWR ring.base_delay.stage\[125\].delay_cell.Z
+ sky130_fd_sc_hd__buf_2
Xring.base_delay.stage\[126\].delay_cell.impl ring.base_delay.stage\[125\].delay_cell.Z
+ VGND VGND VPWR VPWR ring.base_delay.stage\[126\].delay_cell.Z
+ sky130_fd_sc_hd__buf_2
Xring.base_delay.stage\[127\].delay_cell.impl ring.base_delay.stage\[126\].delay_cell.Z
+ VGND VGND VPWR VPWR ring.base_delay.stage\[127\].delay_cell.Z
+ sky130_fd_sc_hd__buf_2
Xring.base_delay.stage\[128\].delay_cell.impl ring.base_delay.stage\[127\].delay_cell.Z
+ VGND VGND VPWR VPWR ring.base_delay.stage\[128\].delay_cell.Z
+ sky130_fd_sc_hd__buf_2
Xring.base_delay.stage\[129\].delay_cell.impl ring.base_delay.stage\[128\].delay_cell.Z
+ VGND VGND VPWR VPWR ring.base_delay.stage\[129\].delay_cell.Z
+ sky130_fd_sc_hd__buf_2
Xring.base_delay.stage\[12\].delay_cell.impl ring.base_delay.stage\[11\].delay_cell.Z
+ VGND VGND VPWR VPWR ring.base_delay.stage\[12\].delay_cell.Z
+ sky130_fd_sc_hd__buf_2
Xring.base_delay.stage\[130\].delay_cell.impl ring.base_delay.stage\[129\].delay_cell.Z
+ VGND VGND VPWR VPWR ring.base_delay.stage\[130\].delay_cell.Z
+ sky130_fd_sc_hd__buf_2
Xring.base_delay.stage\[131\].delay_cell.impl ring.base_delay.stage\[130\].delay_cell.Z
+ VGND VGND VPWR VPWR ring.base_delay.stage\[131\].delay_cell.Z
+ sky130_fd_sc_hd__buf_2
Xring.base_delay.stage\[132\].delay_cell.impl ring.base_delay.stage\[131\].delay_cell.Z
+ VGND VGND VPWR VPWR ring.base_delay.stage\[132\].delay_cell.Z
+ sky130_fd_sc_hd__buf_2
Xring.base_delay.stage\[133\].delay_cell.impl ring.base_delay.stage\[132\].delay_cell.Z
+ VGND VGND VPWR VPWR ring.base_delay.stage\[133\].delay_cell.Z
+ sky130_fd_sc_hd__buf_2
Xring.base_delay.stage\[134\].delay_cell.impl ring.base_delay.stage\[133\].delay_cell.Z
+ VGND VGND VPWR VPWR ring.base_delay.stage\[134\].delay_cell.Z
+ sky130_fd_sc_hd__buf_2
Xring.base_delay.stage\[135\].delay_cell.impl ring.base_delay.stage\[134\].delay_cell.Z
+ VGND VGND VPWR VPWR ring.base_delay.stage\[135\].delay_cell.Z
+ sky130_fd_sc_hd__buf_2
Xring.base_delay.stage\[136\].delay_cell.impl ring.base_delay.stage\[135\].delay_cell.Z
+ VGND VGND VPWR VPWR ring.base_delay.stage\[136\].delay_cell.Z
+ sky130_fd_sc_hd__buf_2
Xring.base_delay.stage\[137\].delay_cell.impl ring.base_delay.stage\[136\].delay_cell.Z
+ VGND VGND VPWR VPWR ring.base_delay.stage\[137\].delay_cell.Z
+ sky130_fd_sc_hd__buf_2
Xring.base_delay.stage\[138\].delay_cell.impl ring.base_delay.stage\[137\].delay_cell.Z
+ VGND VGND VPWR VPWR ring.base_delay.stage\[138\].delay_cell.Z
+ sky130_fd_sc_hd__buf_2
Xring.base_delay.stage\[139\].delay_cell.impl ring.base_delay.stage\[138\].delay_cell.Z
+ VGND VGND VPWR VPWR ring.base_delay.stage\[139\].delay_cell.Z
+ sky130_fd_sc_hd__buf_2
Xring.base_delay.stage\[13\].delay_cell.impl ring.base_delay.stage\[12\].delay_cell.Z
+ VGND VGND VPWR VPWR ring.base_delay.stage\[13\].delay_cell.Z
+ sky130_fd_sc_hd__buf_2
Xring.base_delay.stage\[140\].delay_cell.impl ring.base_delay.stage\[139\].delay_cell.Z
+ VGND VGND VPWR VPWR ring.base_delay.stage\[140\].delay_cell.Z
+ sky130_fd_sc_hd__buf_2
Xring.base_delay.stage\[141\].delay_cell.impl ring.base_delay.stage\[140\].delay_cell.Z
+ VGND VGND VPWR VPWR ring.base_delay.stage\[141\].delay_cell.Z
+ sky130_fd_sc_hd__buf_2
Xring.base_delay.stage\[142\].delay_cell.impl ring.base_delay.stage\[141\].delay_cell.Z
+ VGND VGND VPWR VPWR ring.base_delay.stage\[142\].delay_cell.Z
+ sky130_fd_sc_hd__buf_2
Xring.base_delay.stage\[143\].delay_cell.impl ring.base_delay.stage\[142\].delay_cell.Z
+ VGND VGND VPWR VPWR ring.base_delay.stage\[143\].delay_cell.Z
+ sky130_fd_sc_hd__buf_2
Xring.base_delay.stage\[144\].delay_cell.impl ring.base_delay.stage\[143\].delay_cell.Z
+ VGND VGND VPWR VPWR ring.base_delay.stage\[144\].delay_cell.Z
+ sky130_fd_sc_hd__buf_2
Xring.base_delay.stage\[145\].delay_cell.impl ring.base_delay.stage\[144\].delay_cell.Z
+ VGND VGND VPWR VPWR ring.base_delay.stage\[145\].delay_cell.Z
+ sky130_fd_sc_hd__buf_2
Xring.base_delay.stage\[146\].delay_cell.impl ring.base_delay.stage\[145\].delay_cell.Z
+ VGND VGND VPWR VPWR ring.base_delay.stage\[146\].delay_cell.Z
+ sky130_fd_sc_hd__buf_2
Xring.base_delay.stage\[147\].delay_cell.impl ring.base_delay.stage\[146\].delay_cell.Z
+ VGND VGND VPWR VPWR ring.base_delay.stage\[147\].delay_cell.Z
+ sky130_fd_sc_hd__buf_2
Xring.base_delay.stage\[148\].delay_cell.impl ring.base_delay.stage\[147\].delay_cell.Z
+ VGND VGND VPWR VPWR ring.base_delay.stage\[148\].delay_cell.Z
+ sky130_fd_sc_hd__buf_2
Xring.base_delay.stage\[149\].delay_cell.impl ring.base_delay.stage\[148\].delay_cell.Z
+ VGND VGND VPWR VPWR ring.base_delay.stage\[149\].delay_cell.Z
+ sky130_fd_sc_hd__buf_2
Xring.base_delay.stage\[14\].delay_cell.impl ring.base_delay.stage\[13\].delay_cell.Z
+ VGND VGND VPWR VPWR ring.base_delay.stage\[14\].delay_cell.Z
+ sky130_fd_sc_hd__buf_2
Xring.base_delay.stage\[150\].delay_cell.impl ring.base_delay.stage\[149\].delay_cell.Z
+ VGND VGND VPWR VPWR ring.base_delay.stage\[150\].delay_cell.Z
+ sky130_fd_sc_hd__buf_2
Xring.base_delay.stage\[151\].delay_cell.impl ring.base_delay.stage\[150\].delay_cell.Z
+ VGND VGND VPWR VPWR ring.base_delay.stage\[151\].delay_cell.Z
+ sky130_fd_sc_hd__buf_2
Xring.base_delay.stage\[152\].delay_cell.impl ring.base_delay.stage\[151\].delay_cell.Z
+ VGND VGND VPWR VPWR ring.base_delay.stage\[152\].delay_cell.Z
+ sky130_fd_sc_hd__buf_2
Xring.base_delay.stage\[153\].delay_cell.impl ring.base_delay.stage\[152\].delay_cell.Z
+ VGND VGND VPWR VPWR ring.base_delay.stage\[153\].delay_cell.Z
+ sky130_fd_sc_hd__buf_2
Xring.base_delay.stage\[154\].delay_cell.impl ring.base_delay.stage\[153\].delay_cell.Z
+ VGND VGND VPWR VPWR ring.base_delay.stage\[154\].delay_cell.Z
+ sky130_fd_sc_hd__buf_2
Xring.base_delay.stage\[155\].delay_cell.impl ring.base_delay.stage\[154\].delay_cell.Z
+ VGND VGND VPWR VPWR ring.base_delay.stage\[155\].delay_cell.Z
+ sky130_fd_sc_hd__buf_2
Xring.base_delay.stage\[156\].delay_cell.impl ring.base_delay.stage\[155\].delay_cell.Z
+ VGND VGND VPWR VPWR ring.base_delay.stage\[156\].delay_cell.Z
+ sky130_fd_sc_hd__buf_2
Xring.base_delay.stage\[157\].delay_cell.impl ring.base_delay.stage\[156\].delay_cell.Z
+ VGND VGND VPWR VPWR ring.base_delay.stage\[157\].delay_cell.Z
+ sky130_fd_sc_hd__buf_2
Xring.base_delay.stage\[158\].delay_cell.impl ring.base_delay.stage\[157\].delay_cell.Z
+ VGND VGND VPWR VPWR ring.base_delay.stage\[158\].delay_cell.Z
+ sky130_fd_sc_hd__buf_2
Xring.base_delay.stage\[159\].delay_cell.impl ring.base_delay.stage\[158\].delay_cell.Z
+ VGND VGND VPWR VPWR ring.base_delay.stage\[159\].delay_cell.Z
+ sky130_fd_sc_hd__buf_2
Xring.base_delay.stage\[15\].delay_cell.impl ring.base_delay.stage\[14\].delay_cell.Z
+ VGND VGND VPWR VPWR ring.base_delay.stage\[15\].delay_cell.Z
+ sky130_fd_sc_hd__buf_2
Xring.base_delay.stage\[160\].delay_cell.impl ring.base_delay.stage\[159\].delay_cell.Z
+ VGND VGND VPWR VPWR ring.base_delay.stage\[160\].delay_cell.Z
+ sky130_fd_sc_hd__buf_2
Xring.base_delay.stage\[161\].delay_cell.impl ring.base_delay.stage\[160\].delay_cell.Z
+ VGND VGND VPWR VPWR ring.base_delay.stage\[161\].delay_cell.Z
+ sky130_fd_sc_hd__buf_2
Xring.base_delay.stage\[162\].delay_cell.impl ring.base_delay.stage\[161\].delay_cell.Z
+ VGND VGND VPWR VPWR ring.base_delay.stage\[162\].delay_cell.Z
+ sky130_fd_sc_hd__buf_2
Xring.base_delay.stage\[163\].delay_cell.impl ring.base_delay.stage\[162\].delay_cell.Z
+ VGND VGND VPWR VPWR ring.base_delay.stage\[163\].delay_cell.Z
+ sky130_fd_sc_hd__buf_2
Xring.base_delay.stage\[164\].delay_cell.impl ring.base_delay.stage\[163\].delay_cell.Z
+ VGND VGND VPWR VPWR ring.base_delay.stage\[164\].delay_cell.Z
+ sky130_fd_sc_hd__buf_2
Xring.base_delay.stage\[165\].delay_cell.impl ring.base_delay.stage\[164\].delay_cell.Z
+ VGND VGND VPWR VPWR ring.base_delay.stage\[165\].delay_cell.Z
+ sky130_fd_sc_hd__buf_2
Xring.base_delay.stage\[166\].delay_cell.impl ring.base_delay.stage\[165\].delay_cell.Z
+ VGND VGND VPWR VPWR ring.base_delay.stage\[166\].delay_cell.Z
+ sky130_fd_sc_hd__buf_2
Xring.base_delay.stage\[167\].delay_cell.impl ring.base_delay.stage\[166\].delay_cell.Z
+ VGND VGND VPWR VPWR ring.base_delay.stage\[167\].delay_cell.Z
+ sky130_fd_sc_hd__buf_2
Xring.base_delay.stage\[168\].delay_cell.impl ring.base_delay.stage\[167\].delay_cell.Z
+ VGND VGND VPWR VPWR ring.base_delay.stage\[168\].delay_cell.Z
+ sky130_fd_sc_hd__buf_2
Xring.base_delay.stage\[169\].delay_cell.impl ring.base_delay.stage\[168\].delay_cell.Z
+ VGND VGND VPWR VPWR ring.base_delay.stage\[169\].delay_cell.Z
+ sky130_fd_sc_hd__buf_2
Xring.base_delay.stage\[16\].delay_cell.impl ring.base_delay.stage\[15\].delay_cell.Z
+ VGND VGND VPWR VPWR ring.base_delay.stage\[16\].delay_cell.Z
+ sky130_fd_sc_hd__buf_2
Xring.base_delay.stage\[170\].delay_cell.impl ring.base_delay.stage\[169\].delay_cell.Z
+ VGND VGND VPWR VPWR ring.base_delay.stage\[170\].delay_cell.Z
+ sky130_fd_sc_hd__buf_2
Xring.base_delay.stage\[171\].delay_cell.impl ring.base_delay.stage\[170\].delay_cell.Z
+ VGND VGND VPWR VPWR ring.base_delay.stage\[171\].delay_cell.Z
+ sky130_fd_sc_hd__buf_2
Xring.base_delay.stage\[172\].delay_cell.impl ring.base_delay.stage\[171\].delay_cell.Z
+ VGND VGND VPWR VPWR ring.base_delay.stage\[172\].delay_cell.Z
+ sky130_fd_sc_hd__buf_2
Xring.base_delay.stage\[173\].delay_cell.impl ring.base_delay.stage\[172\].delay_cell.Z
+ VGND VGND VPWR VPWR ring.base_delay.stage\[173\].delay_cell.Z
+ sky130_fd_sc_hd__buf_2
Xring.base_delay.stage\[174\].delay_cell.impl ring.base_delay.stage\[173\].delay_cell.Z
+ VGND VGND VPWR VPWR ring.base_delay.stage\[174\].delay_cell.Z
+ sky130_fd_sc_hd__buf_2
Xring.base_delay.stage\[175\].delay_cell.impl ring.base_delay.stage\[174\].delay_cell.Z
+ VGND VGND VPWR VPWR ring.base_delay.stage\[175\].delay_cell.Z
+ sky130_fd_sc_hd__buf_2
Xring.base_delay.stage\[176\].delay_cell.impl ring.base_delay.stage\[175\].delay_cell.Z
+ VGND VGND VPWR VPWR ring.base_delay.stage\[176\].delay_cell.Z
+ sky130_fd_sc_hd__buf_2
Xring.base_delay.stage\[177\].delay_cell.impl ring.base_delay.stage\[176\].delay_cell.Z
+ VGND VGND VPWR VPWR ring.base_delay.stage\[177\].delay_cell.Z
+ sky130_fd_sc_hd__buf_2
Xring.base_delay.stage\[178\].delay_cell.impl ring.base_delay.stage\[177\].delay_cell.Z
+ VGND VGND VPWR VPWR ring.base_delay.stage\[178\].delay_cell.Z
+ sky130_fd_sc_hd__buf_2
Xring.base_delay.stage\[179\].delay_cell.impl ring.base_delay.stage\[178\].delay_cell.Z
+ VGND VGND VPWR VPWR ring.base_delay.stage\[179\].delay_cell.Z
+ sky130_fd_sc_hd__buf_2
Xring.base_delay.stage\[17\].delay_cell.impl ring.base_delay.stage\[16\].delay_cell.Z
+ VGND VGND VPWR VPWR ring.base_delay.stage\[17\].delay_cell.Z
+ sky130_fd_sc_hd__buf_2
Xring.base_delay.stage\[180\].delay_cell.impl ring.base_delay.stage\[179\].delay_cell.Z
+ VGND VGND VPWR VPWR ring.base_delay.stage\[180\].delay_cell.Z
+ sky130_fd_sc_hd__buf_2
Xring.base_delay.stage\[181\].delay_cell.impl ring.base_delay.stage\[180\].delay_cell.Z
+ VGND VGND VPWR VPWR ring.base_delay.stage\[181\].delay_cell.Z
+ sky130_fd_sc_hd__buf_2
Xring.base_delay.stage\[182\].delay_cell.impl ring.base_delay.stage\[181\].delay_cell.Z
+ VGND VGND VPWR VPWR ring.base_delay.stage\[182\].delay_cell.Z
+ sky130_fd_sc_hd__buf_2
Xring.base_delay.stage\[183\].delay_cell.impl ring.base_delay.stage\[182\].delay_cell.Z
+ VGND VGND VPWR VPWR ring.base_delay.stage\[183\].delay_cell.Z
+ sky130_fd_sc_hd__buf_2
Xring.base_delay.stage\[184\].delay_cell.impl ring.base_delay.stage\[183\].delay_cell.Z
+ VGND VGND VPWR VPWR ring.base_delay.stage\[184\].delay_cell.Z
+ sky130_fd_sc_hd__buf_2
Xring.base_delay.stage\[185\].delay_cell.impl ring.base_delay.stage\[184\].delay_cell.Z
+ VGND VGND VPWR VPWR ring.base_delay.stage\[185\].delay_cell.Z
+ sky130_fd_sc_hd__buf_2
Xring.base_delay.stage\[186\].delay_cell.impl ring.base_delay.stage\[185\].delay_cell.Z
+ VGND VGND VPWR VPWR ring.base_delay.stage\[186\].delay_cell.Z
+ sky130_fd_sc_hd__buf_2
Xring.base_delay.stage\[187\].delay_cell.impl ring.base_delay.stage\[186\].delay_cell.Z
+ VGND VGND VPWR VPWR ring.base_delay.stage\[187\].delay_cell.Z
+ sky130_fd_sc_hd__buf_2
Xring.base_delay.stage\[188\].delay_cell.impl ring.base_delay.stage\[187\].delay_cell.Z
+ VGND VGND VPWR VPWR ring.base_delay.stage\[188\].delay_cell.Z
+ sky130_fd_sc_hd__buf_2
Xring.base_delay.stage\[189\].delay_cell.impl ring.base_delay.stage\[188\].delay_cell.Z
+ VGND VGND VPWR VPWR ring.base_delay.stage\[189\].delay_cell.Z
+ sky130_fd_sc_hd__buf_2
Xring.base_delay.stage\[18\].delay_cell.impl ring.base_delay.stage\[17\].delay_cell.Z
+ VGND VGND VPWR VPWR ring.base_delay.stage\[18\].delay_cell.Z
+ sky130_fd_sc_hd__buf_2
Xring.base_delay.stage\[190\].delay_cell.impl ring.base_delay.stage\[189\].delay_cell.Z
+ VGND VGND VPWR VPWR ring.base_delay.stage\[190\].delay_cell.Z
+ sky130_fd_sc_hd__buf_2
Xring.base_delay.stage\[191\].delay_cell.impl ring.base_delay.stage\[190\].delay_cell.Z
+ VGND VGND VPWR VPWR ring.base_delay.stage\[191\].delay_cell.Z
+ sky130_fd_sc_hd__buf_2
Xring.base_delay.stage\[192\].delay_cell.impl ring.base_delay.stage\[191\].delay_cell.Z
+ VGND VGND VPWR VPWR ring.base_delay.stage\[192\].delay_cell.Z
+ sky130_fd_sc_hd__buf_2
Xring.base_delay.stage\[193\].delay_cell.impl ring.base_delay.stage\[192\].delay_cell.Z
+ VGND VGND VPWR VPWR ring.base_delay.stage\[193\].delay_cell.Z
+ sky130_fd_sc_hd__buf_2
Xring.base_delay.stage\[194\].delay_cell.impl ring.base_delay.stage\[193\].delay_cell.Z
+ VGND VGND VPWR VPWR ring.base_delay.stage\[194\].delay_cell.Z
+ sky130_fd_sc_hd__buf_2
Xring.base_delay.stage\[195\].delay_cell.impl ring.base_delay.stage\[194\].delay_cell.Z
+ VGND VGND VPWR VPWR ring.base_delay.stage\[195\].delay_cell.Z
+ sky130_fd_sc_hd__buf_2
Xring.base_delay.stage\[196\].delay_cell.impl ring.base_delay.stage\[195\].delay_cell.Z
+ VGND VGND VPWR VPWR ring.base_delay.stage\[196\].delay_cell.Z
+ sky130_fd_sc_hd__buf_2
Xring.base_delay.stage\[197\].delay_cell.impl ring.base_delay.stage\[196\].delay_cell.Z
+ VGND VGND VPWR VPWR ring.base_delay.stage\[197\].delay_cell.Z
+ sky130_fd_sc_hd__buf_2
Xring.base_delay.stage\[198\].delay_cell.impl ring.base_delay.stage\[197\].delay_cell.Z
+ VGND VGND VPWR VPWR ring.base_delay.stage\[198\].delay_cell.Z
+ sky130_fd_sc_hd__buf_2
Xring.base_delay.stage\[199\].delay_cell.impl ring.base_delay.stage\[198\].delay_cell.Z
+ VGND VGND VPWR VPWR ring.base_delay.stage\[199\].delay_cell.Z
+ sky130_fd_sc_hd__buf_2
Xring.base_delay.stage\[19\].delay_cell.impl ring.base_delay.stage\[18\].delay_cell.Z
+ VGND VGND VPWR VPWR ring.base_delay.stage\[19\].delay_cell.Z
+ sky130_fd_sc_hd__buf_2
Xring.base_delay.stage\[1\].delay_cell.impl ring.base_delay.stage\[0\].delay_cell.Z
+ VGND VGND VPWR VPWR ring.base_delay.stage\[1\].delay_cell.Z
+ sky130_fd_sc_hd__buf_2
Xring.base_delay.stage\[200\].delay_cell.impl ring.base_delay.stage\[199\].delay_cell.Z
+ VGND VGND VPWR VPWR ring.base_delay.stage\[200\].delay_cell.Z
+ sky130_fd_sc_hd__buf_2
Xring.base_delay.stage\[201\].delay_cell.impl ring.base_delay.stage\[200\].delay_cell.Z
+ VGND VGND VPWR VPWR ring.base_delay.stage\[201\].delay_cell.Z
+ sky130_fd_sc_hd__buf_2
Xring.base_delay.stage\[202\].delay_cell.impl ring.base_delay.stage\[201\].delay_cell.Z
+ VGND VGND VPWR VPWR ring.base_delay.stage\[202\].delay_cell.Z
+ sky130_fd_sc_hd__buf_2
Xring.base_delay.stage\[203\].delay_cell.impl ring.base_delay.stage\[202\].delay_cell.Z
+ VGND VGND VPWR VPWR ring.base_delay.stage\[203\].delay_cell.Z
+ sky130_fd_sc_hd__buf_2
Xring.base_delay.stage\[204\].delay_cell.impl ring.base_delay.stage\[203\].delay_cell.Z
+ VGND VGND VPWR VPWR ring.base_delay.stage\[204\].delay_cell.Z
+ sky130_fd_sc_hd__buf_2
Xring.base_delay.stage\[205\].delay_cell.impl ring.base_delay.stage\[204\].delay_cell.Z
+ VGND VGND VPWR VPWR ring.base_delay.stage\[205\].delay_cell.Z
+ sky130_fd_sc_hd__buf_2
Xring.base_delay.stage\[206\].delay_cell.impl ring.base_delay.stage\[205\].delay_cell.Z
+ VGND VGND VPWR VPWR ring.base_delay.stage\[206\].delay_cell.Z
+ sky130_fd_sc_hd__buf_2
Xring.base_delay.stage\[207\].delay_cell.impl ring.base_delay.stage\[206\].delay_cell.Z
+ VGND VGND VPWR VPWR ring.base_delay.stage\[207\].delay_cell.Z
+ sky130_fd_sc_hd__buf_2
Xring.base_delay.stage\[208\].delay_cell.impl ring.base_delay.stage\[207\].delay_cell.Z
+ VGND VGND VPWR VPWR ring.base_delay.stage\[208\].delay_cell.Z
+ sky130_fd_sc_hd__buf_2
Xring.base_delay.stage\[209\].delay_cell.impl ring.base_delay.stage\[208\].delay_cell.Z
+ VGND VGND VPWR VPWR ring.base_delay.stage\[209\].delay_cell.Z
+ sky130_fd_sc_hd__buf_2
Xring.base_delay.stage\[20\].delay_cell.impl ring.base_delay.stage\[19\].delay_cell.Z
+ VGND VGND VPWR VPWR ring.base_delay.stage\[20\].delay_cell.Z
+ sky130_fd_sc_hd__buf_2
Xring.base_delay.stage\[210\].delay_cell.impl ring.base_delay.stage\[209\].delay_cell.Z
+ VGND VGND VPWR VPWR ring.base_delay.stage\[210\].delay_cell.Z
+ sky130_fd_sc_hd__buf_2
Xring.base_delay.stage\[211\].delay_cell.impl ring.base_delay.stage\[210\].delay_cell.Z
+ VGND VGND VPWR VPWR ring.base_delay.stage\[211\].delay_cell.Z
+ sky130_fd_sc_hd__buf_2
Xring.base_delay.stage\[212\].delay_cell.impl ring.base_delay.stage\[211\].delay_cell.Z
+ VGND VGND VPWR VPWR ring.base_delay.stage\[212\].delay_cell.Z
+ sky130_fd_sc_hd__buf_2
Xring.base_delay.stage\[213\].delay_cell.impl ring.base_delay.stage\[212\].delay_cell.Z
+ VGND VGND VPWR VPWR ring.base_delay.stage\[213\].delay_cell.Z
+ sky130_fd_sc_hd__buf_2
Xring.base_delay.stage\[214\].delay_cell.impl ring.base_delay.stage\[213\].delay_cell.Z
+ VGND VGND VPWR VPWR ring.base_delay.stage\[214\].delay_cell.Z
+ sky130_fd_sc_hd__buf_2
Xring.base_delay.stage\[215\].delay_cell.impl ring.base_delay.stage\[214\].delay_cell.Z
+ VGND VGND VPWR VPWR ring.base_delay.stage\[215\].delay_cell.Z
+ sky130_fd_sc_hd__buf_2
Xring.base_delay.stage\[216\].delay_cell.impl ring.base_delay.stage\[215\].delay_cell.Z
+ VGND VGND VPWR VPWR ring.base_delay.stage\[216\].delay_cell.Z
+ sky130_fd_sc_hd__buf_2
Xring.base_delay.stage\[217\].delay_cell.impl ring.base_delay.stage\[216\].delay_cell.Z
+ VGND VGND VPWR VPWR ring.base_delay.stage\[217\].delay_cell.Z
+ sky130_fd_sc_hd__buf_2
Xring.base_delay.stage\[218\].delay_cell.impl ring.base_delay.stage\[217\].delay_cell.Z
+ VGND VGND VPWR VPWR ring.base_delay.stage\[218\].delay_cell.Z
+ sky130_fd_sc_hd__buf_2
Xring.base_delay.stage\[219\].delay_cell.impl ring.base_delay.stage\[218\].delay_cell.Z
+ VGND VGND VPWR VPWR ring.base_delay.stage\[219\].delay_cell.Z
+ sky130_fd_sc_hd__buf_2
Xring.base_delay.stage\[21\].delay_cell.impl ring.base_delay.stage\[20\].delay_cell.Z
+ VGND VGND VPWR VPWR ring.base_delay.stage\[21\].delay_cell.Z
+ sky130_fd_sc_hd__buf_2
Xring.base_delay.stage\[220\].delay_cell.impl ring.base_delay.stage\[219\].delay_cell.Z
+ VGND VGND VPWR VPWR ring.base_delay.stage\[220\].delay_cell.Z
+ sky130_fd_sc_hd__buf_2
Xring.base_delay.stage\[221\].delay_cell.impl ring.base_delay.stage\[220\].delay_cell.Z
+ VGND VGND VPWR VPWR ring.base_delay.stage\[221\].delay_cell.Z
+ sky130_fd_sc_hd__buf_2
Xring.base_delay.stage\[222\].delay_cell.impl ring.base_delay.stage\[221\].delay_cell.Z
+ VGND VGND VPWR VPWR ring.base_delay.stage\[222\].delay_cell.Z
+ sky130_fd_sc_hd__buf_2
Xring.base_delay.stage\[223\].delay_cell.impl ring.base_delay.stage\[222\].delay_cell.Z
+ VGND VGND VPWR VPWR ring.base_delay.stage\[223\].delay_cell.Z
+ sky130_fd_sc_hd__buf_2
Xring.base_delay.stage\[224\].delay_cell.impl ring.base_delay.stage\[223\].delay_cell.Z
+ VGND VGND VPWR VPWR ring.base_delay.stage\[224\].delay_cell.Z
+ sky130_fd_sc_hd__buf_2
Xring.base_delay.stage\[225\].delay_cell.impl ring.base_delay.stage\[224\].delay_cell.Z
+ VGND VGND VPWR VPWR ring.base_delay.stage\[225\].delay_cell.Z
+ sky130_fd_sc_hd__buf_2
Xring.base_delay.stage\[226\].delay_cell.impl ring.base_delay.stage\[225\].delay_cell.Z
+ VGND VGND VPWR VPWR ring.base_delay.stage\[226\].delay_cell.Z
+ sky130_fd_sc_hd__buf_2
Xring.base_delay.stage\[227\].delay_cell.impl ring.base_delay.stage\[226\].delay_cell.Z
+ VGND VGND VPWR VPWR ring.base_delay.stage\[227\].delay_cell.Z
+ sky130_fd_sc_hd__buf_2
Xring.base_delay.stage\[228\].delay_cell.impl ring.base_delay.stage\[227\].delay_cell.Z
+ VGND VGND VPWR VPWR ring.base_delay.stage\[228\].delay_cell.Z
+ sky130_fd_sc_hd__buf_2
Xring.base_delay.stage\[229\].delay_cell.impl ring.base_delay.stage\[228\].delay_cell.Z
+ VGND VGND VPWR VPWR ring.base_delay.stage\[229\].delay_cell.Z
+ sky130_fd_sc_hd__buf_2
Xring.base_delay.stage\[22\].delay_cell.impl ring.base_delay.stage\[21\].delay_cell.Z
+ VGND VGND VPWR VPWR ring.base_delay.stage\[22\].delay_cell.Z
+ sky130_fd_sc_hd__buf_2
Xring.base_delay.stage\[230\].delay_cell.impl ring.base_delay.stage\[229\].delay_cell.Z
+ VGND VGND VPWR VPWR ring.base_delay.stage\[230\].delay_cell.Z
+ sky130_fd_sc_hd__buf_2
Xring.base_delay.stage\[231\].delay_cell.impl ring.base_delay.stage\[230\].delay_cell.Z
+ VGND VGND VPWR VPWR ring.base_delay.stage\[231\].delay_cell.Z
+ sky130_fd_sc_hd__buf_2
Xring.base_delay.stage\[232\].delay_cell.impl ring.base_delay.stage\[231\].delay_cell.Z
+ VGND VGND VPWR VPWR ring.base_delay.stage\[232\].delay_cell.Z
+ sky130_fd_sc_hd__buf_2
Xring.base_delay.stage\[233\].delay_cell.impl ring.base_delay.stage\[232\].delay_cell.Z
+ VGND VGND VPWR VPWR ring.base_delay.stage\[233\].delay_cell.Z
+ sky130_fd_sc_hd__buf_2
Xring.base_delay.stage\[234\].delay_cell.impl ring.base_delay.stage\[233\].delay_cell.Z
+ VGND VGND VPWR VPWR ring.base_delay.stage\[234\].delay_cell.Z
+ sky130_fd_sc_hd__buf_2
Xring.base_delay.stage\[235\].delay_cell.impl ring.base_delay.stage\[234\].delay_cell.Z
+ VGND VGND VPWR VPWR ring.base_delay.stage\[235\].delay_cell.Z
+ sky130_fd_sc_hd__buf_2
Xring.base_delay.stage\[236\].delay_cell.impl ring.base_delay.stage\[235\].delay_cell.Z
+ VGND VGND VPWR VPWR ring.base_delay.stage\[236\].delay_cell.Z
+ sky130_fd_sc_hd__buf_2
Xring.base_delay.stage\[237\].delay_cell.impl ring.base_delay.stage\[236\].delay_cell.Z
+ VGND VGND VPWR VPWR ring.base_delay.stage\[237\].delay_cell.Z
+ sky130_fd_sc_hd__buf_2
Xring.base_delay.stage\[238\].delay_cell.impl ring.base_delay.stage\[237\].delay_cell.Z
+ VGND VGND VPWR VPWR ring.base_delay.stage\[238\].delay_cell.Z
+ sky130_fd_sc_hd__buf_2
Xring.base_delay.stage\[239\].delay_cell.impl ring.base_delay.stage\[238\].delay_cell.Z
+ VGND VGND VPWR VPWR ring.base_delay.stage\[239\].delay_cell.Z
+ sky130_fd_sc_hd__buf_2
Xring.base_delay.stage\[23\].delay_cell.impl ring.base_delay.stage\[22\].delay_cell.Z
+ VGND VGND VPWR VPWR ring.base_delay.stage\[23\].delay_cell.Z
+ sky130_fd_sc_hd__buf_2
Xring.base_delay.stage\[240\].delay_cell.impl ring.base_delay.stage\[239\].delay_cell.Z
+ VGND VGND VPWR VPWR ring.base_delay.stage\[240\].delay_cell.Z
+ sky130_fd_sc_hd__buf_2
Xring.base_delay.stage\[241\].delay_cell.impl ring.base_delay.stage\[240\].delay_cell.Z
+ VGND VGND VPWR VPWR ring.base_delay.stage\[241\].delay_cell.Z
+ sky130_fd_sc_hd__buf_2
Xring.base_delay.stage\[242\].delay_cell.impl ring.base_delay.stage\[241\].delay_cell.Z
+ VGND VGND VPWR VPWR ring.base_delay.stage\[242\].delay_cell.Z
+ sky130_fd_sc_hd__buf_2
Xring.base_delay.stage\[243\].delay_cell.impl ring.base_delay.stage\[242\].delay_cell.Z
+ VGND VGND VPWR VPWR ring.base_delay.stage\[243\].delay_cell.Z
+ sky130_fd_sc_hd__buf_2
Xring.base_delay.stage\[244\].delay_cell.impl ring.base_delay.stage\[243\].delay_cell.Z
+ VGND VGND VPWR VPWR ring.base_delay.stage\[244\].delay_cell.Z
+ sky130_fd_sc_hd__buf_2
Xring.base_delay.stage\[245\].delay_cell.impl ring.base_delay.stage\[244\].delay_cell.Z
+ VGND VGND VPWR VPWR ring.base_delay.stage\[245\].delay_cell.Z
+ sky130_fd_sc_hd__buf_2
Xring.base_delay.stage\[246\].delay_cell.impl ring.base_delay.stage\[245\].delay_cell.Z
+ VGND VGND VPWR VPWR ring.base_delay.stage\[246\].delay_cell.Z
+ sky130_fd_sc_hd__buf_2
Xring.base_delay.stage\[247\].delay_cell.impl ring.base_delay.stage\[246\].delay_cell.Z
+ VGND VGND VPWR VPWR ring.base_delay.stage\[247\].delay_cell.Z
+ sky130_fd_sc_hd__buf_2
Xring.base_delay.stage\[248\].delay_cell.impl ring.base_delay.stage\[247\].delay_cell.Z
+ VGND VGND VPWR VPWR ring.base_delay.stage\[248\].delay_cell.Z
+ sky130_fd_sc_hd__buf_2
Xring.base_delay.stage\[249\].delay_cell.impl ring.base_delay.stage\[248\].delay_cell.Z
+ VGND VGND VPWR VPWR ring.base_delay.stage\[249\].delay_cell.Z
+ sky130_fd_sc_hd__buf_2
Xring.base_delay.stage\[24\].delay_cell.impl ring.base_delay.stage\[23\].delay_cell.Z
+ VGND VGND VPWR VPWR ring.base_delay.stage\[24\].delay_cell.Z
+ sky130_fd_sc_hd__buf_2
Xring.base_delay.stage\[250\].delay_cell.impl ring.base_delay.stage\[249\].delay_cell.Z
+ VGND VGND VPWR VPWR ring.base_delay.stage\[250\].delay_cell.Z
+ sky130_fd_sc_hd__buf_2
Xring.base_delay.stage\[251\].delay_cell.impl ring.base_delay.stage\[250\].delay_cell.Z
+ VGND VGND VPWR VPWR ring.base_delay.stage\[251\].delay_cell.Z
+ sky130_fd_sc_hd__buf_2
Xring.base_delay.stage\[252\].delay_cell.impl ring.base_delay.stage\[251\].delay_cell.Z
+ VGND VGND VPWR VPWR ring.base_delay.stage\[252\].delay_cell.Z
+ sky130_fd_sc_hd__buf_2
Xring.base_delay.stage\[253\].delay_cell.impl ring.base_delay.stage\[252\].delay_cell.Z
+ VGND VGND VPWR VPWR ring.base_delay.stage\[253\].delay_cell.Z
+ sky130_fd_sc_hd__buf_2
Xring.base_delay.stage\[254\].delay_cell.impl ring.base_delay.stage\[253\].delay_cell.Z
+ VGND VGND VPWR VPWR ring.base_delay.stage\[254\].delay_cell.Z
+ sky130_fd_sc_hd__buf_2
Xring.base_delay.stage\[255\].delay_cell.impl ring.base_delay.stage\[254\].delay_cell.Z
+ VGND VGND VPWR VPWR ring.DCO_IN sky130_fd_sc_hd__buf_2
Xring.base_delay.stage\[25\].delay_cell.impl ring.base_delay.stage\[24\].delay_cell.Z
+ VGND VGND VPWR VPWR ring.base_delay.stage\[25\].delay_cell.Z
+ sky130_fd_sc_hd__buf_2
Xring.base_delay.stage\[26\].delay_cell.impl ring.base_delay.stage\[25\].delay_cell.Z
+ VGND VGND VPWR VPWR ring.base_delay.stage\[26\].delay_cell.Z
+ sky130_fd_sc_hd__buf_2
Xring.base_delay.stage\[27\].delay_cell.impl ring.base_delay.stage\[26\].delay_cell.Z
+ VGND VGND VPWR VPWR ring.base_delay.stage\[27\].delay_cell.Z
+ sky130_fd_sc_hd__buf_2
Xring.base_delay.stage\[28\].delay_cell.impl ring.base_delay.stage\[27\].delay_cell.Z
+ VGND VGND VPWR VPWR ring.base_delay.stage\[28\].delay_cell.Z
+ sky130_fd_sc_hd__buf_2
Xring.base_delay.stage\[29\].delay_cell.impl ring.base_delay.stage\[28\].delay_cell.Z
+ VGND VGND VPWR VPWR ring.base_delay.stage\[29\].delay_cell.Z
+ sky130_fd_sc_hd__buf_2
Xring.base_delay.stage\[2\].delay_cell.impl ring.base_delay.stage\[1\].delay_cell.Z
+ VGND VGND VPWR VPWR ring.base_delay.stage\[2\].delay_cell.Z
+ sky130_fd_sc_hd__buf_2
Xring.base_delay.stage\[30\].delay_cell.impl ring.base_delay.stage\[29\].delay_cell.Z
+ VGND VGND VPWR VPWR ring.base_delay.stage\[30\].delay_cell.Z
+ sky130_fd_sc_hd__buf_2
Xring.base_delay.stage\[31\].delay_cell.impl ring.base_delay.stage\[30\].delay_cell.Z
+ VGND VGND VPWR VPWR ring.base_delay.stage\[31\].delay_cell.Z
+ sky130_fd_sc_hd__buf_2
Xring.base_delay.stage\[32\].delay_cell.impl ring.base_delay.stage\[31\].delay_cell.Z
+ VGND VGND VPWR VPWR ring.base_delay.stage\[32\].delay_cell.Z
+ sky130_fd_sc_hd__buf_2
Xring.base_delay.stage\[33\].delay_cell.impl ring.base_delay.stage\[32\].delay_cell.Z
+ VGND VGND VPWR VPWR ring.base_delay.stage\[33\].delay_cell.Z
+ sky130_fd_sc_hd__buf_2
Xring.base_delay.stage\[34\].delay_cell.impl ring.base_delay.stage\[33\].delay_cell.Z
+ VGND VGND VPWR VPWR ring.base_delay.stage\[34\].delay_cell.Z
+ sky130_fd_sc_hd__buf_2
Xring.base_delay.stage\[35\].delay_cell.impl ring.base_delay.stage\[34\].delay_cell.Z
+ VGND VGND VPWR VPWR ring.base_delay.stage\[35\].delay_cell.Z
+ sky130_fd_sc_hd__buf_2
Xring.base_delay.stage\[36\].delay_cell.impl ring.base_delay.stage\[35\].delay_cell.Z
+ VGND VGND VPWR VPWR ring.base_delay.stage\[36\].delay_cell.Z
+ sky130_fd_sc_hd__buf_2
Xring.base_delay.stage\[37\].delay_cell.impl ring.base_delay.stage\[36\].delay_cell.Z
+ VGND VGND VPWR VPWR ring.base_delay.stage\[37\].delay_cell.Z
+ sky130_fd_sc_hd__buf_2
Xring.base_delay.stage\[38\].delay_cell.impl ring.base_delay.stage\[37\].delay_cell.Z
+ VGND VGND VPWR VPWR ring.base_delay.stage\[38\].delay_cell.Z
+ sky130_fd_sc_hd__buf_2
Xring.base_delay.stage\[39\].delay_cell.impl ring.base_delay.stage\[38\].delay_cell.Z
+ VGND VGND VPWR VPWR ring.base_delay.stage\[39\].delay_cell.Z
+ sky130_fd_sc_hd__buf_2
Xring.base_delay.stage\[3\].delay_cell.impl ring.base_delay.stage\[2\].delay_cell.Z
+ VGND VGND VPWR VPWR ring.base_delay.stage\[3\].delay_cell.Z
+ sky130_fd_sc_hd__buf_2
Xring.base_delay.stage\[40\].delay_cell.impl ring.base_delay.stage\[39\].delay_cell.Z
+ VGND VGND VPWR VPWR ring.base_delay.stage\[40\].delay_cell.Z
+ sky130_fd_sc_hd__buf_2
Xring.base_delay.stage\[41\].delay_cell.impl ring.base_delay.stage\[40\].delay_cell.Z
+ VGND VGND VPWR VPWR ring.base_delay.stage\[41\].delay_cell.Z
+ sky130_fd_sc_hd__buf_2
Xring.base_delay.stage\[42\].delay_cell.impl ring.base_delay.stage\[41\].delay_cell.Z
+ VGND VGND VPWR VPWR ring.base_delay.stage\[42\].delay_cell.Z
+ sky130_fd_sc_hd__buf_2
Xring.base_delay.stage\[43\].delay_cell.impl ring.base_delay.stage\[42\].delay_cell.Z
+ VGND VGND VPWR VPWR ring.base_delay.stage\[43\].delay_cell.Z
+ sky130_fd_sc_hd__buf_2
Xring.base_delay.stage\[44\].delay_cell.impl ring.base_delay.stage\[43\].delay_cell.Z
+ VGND VGND VPWR VPWR ring.base_delay.stage\[44\].delay_cell.Z
+ sky130_fd_sc_hd__buf_2
Xring.base_delay.stage\[45\].delay_cell.impl ring.base_delay.stage\[44\].delay_cell.Z
+ VGND VGND VPWR VPWR ring.base_delay.stage\[45\].delay_cell.Z
+ sky130_fd_sc_hd__buf_2
Xring.base_delay.stage\[46\].delay_cell.impl ring.base_delay.stage\[45\].delay_cell.Z
+ VGND VGND VPWR VPWR ring.base_delay.stage\[46\].delay_cell.Z
+ sky130_fd_sc_hd__buf_2
Xring.base_delay.stage\[47\].delay_cell.impl ring.base_delay.stage\[46\].delay_cell.Z
+ VGND VGND VPWR VPWR ring.base_delay.stage\[47\].delay_cell.Z
+ sky130_fd_sc_hd__buf_2
Xring.base_delay.stage\[48\].delay_cell.impl ring.base_delay.stage\[47\].delay_cell.Z
+ VGND VGND VPWR VPWR ring.base_delay.stage\[48\].delay_cell.Z
+ sky130_fd_sc_hd__buf_2
Xring.base_delay.stage\[49\].delay_cell.impl ring.base_delay.stage\[48\].delay_cell.Z
+ VGND VGND VPWR VPWR ring.base_delay.stage\[49\].delay_cell.Z
+ sky130_fd_sc_hd__buf_2
Xring.base_delay.stage\[4\].delay_cell.impl ring.base_delay.stage\[3\].delay_cell.Z
+ VGND VGND VPWR VPWR ring.base_delay.stage\[4\].delay_cell.Z
+ sky130_fd_sc_hd__buf_2
Xring.base_delay.stage\[50\].delay_cell.impl ring.base_delay.stage\[49\].delay_cell.Z
+ VGND VGND VPWR VPWR ring.base_delay.stage\[50\].delay_cell.Z
+ sky130_fd_sc_hd__buf_2
Xring.base_delay.stage\[51\].delay_cell.impl ring.base_delay.stage\[50\].delay_cell.Z
+ VGND VGND VPWR VPWR ring.base_delay.stage\[51\].delay_cell.Z
+ sky130_fd_sc_hd__buf_2
Xring.base_delay.stage\[52\].delay_cell.impl ring.base_delay.stage\[51\].delay_cell.Z
+ VGND VGND VPWR VPWR ring.base_delay.stage\[52\].delay_cell.Z
+ sky130_fd_sc_hd__buf_2
Xring.base_delay.stage\[53\].delay_cell.impl ring.base_delay.stage\[52\].delay_cell.Z
+ VGND VGND VPWR VPWR ring.base_delay.stage\[53\].delay_cell.Z
+ sky130_fd_sc_hd__buf_2
Xring.base_delay.stage\[54\].delay_cell.impl ring.base_delay.stage\[53\].delay_cell.Z
+ VGND VGND VPWR VPWR ring.base_delay.stage\[54\].delay_cell.Z
+ sky130_fd_sc_hd__buf_2
Xring.base_delay.stage\[55\].delay_cell.impl ring.base_delay.stage\[54\].delay_cell.Z
+ VGND VGND VPWR VPWR ring.base_delay.stage\[55\].delay_cell.Z
+ sky130_fd_sc_hd__buf_2
Xring.base_delay.stage\[56\].delay_cell.impl ring.base_delay.stage\[55\].delay_cell.Z
+ VGND VGND VPWR VPWR ring.base_delay.stage\[56\].delay_cell.Z
+ sky130_fd_sc_hd__buf_2
Xring.base_delay.stage\[57\].delay_cell.impl ring.base_delay.stage\[56\].delay_cell.Z
+ VGND VGND VPWR VPWR ring.base_delay.stage\[57\].delay_cell.Z
+ sky130_fd_sc_hd__buf_2
Xring.base_delay.stage\[58\].delay_cell.impl ring.base_delay.stage\[57\].delay_cell.Z
+ VGND VGND VPWR VPWR ring.base_delay.stage\[58\].delay_cell.Z
+ sky130_fd_sc_hd__buf_2
Xring.base_delay.stage\[59\].delay_cell.impl ring.base_delay.stage\[58\].delay_cell.Z
+ VGND VGND VPWR VPWR ring.base_delay.stage\[59\].delay_cell.Z
+ sky130_fd_sc_hd__buf_2
Xring.base_delay.stage\[5\].delay_cell.impl ring.base_delay.stage\[4\].delay_cell.Z
+ VGND VGND VPWR VPWR ring.base_delay.stage\[5\].delay_cell.Z
+ sky130_fd_sc_hd__buf_2
Xring.base_delay.stage\[60\].delay_cell.impl ring.base_delay.stage\[59\].delay_cell.Z
+ VGND VGND VPWR VPWR ring.base_delay.stage\[60\].delay_cell.Z
+ sky130_fd_sc_hd__buf_2
Xring.base_delay.stage\[61\].delay_cell.impl ring.base_delay.stage\[60\].delay_cell.Z
+ VGND VGND VPWR VPWR ring.base_delay.stage\[61\].delay_cell.Z
+ sky130_fd_sc_hd__buf_2
Xring.base_delay.stage\[62\].delay_cell.impl ring.base_delay.stage\[61\].delay_cell.Z
+ VGND VGND VPWR VPWR ring.base_delay.stage\[62\].delay_cell.Z
+ sky130_fd_sc_hd__buf_2
Xring.base_delay.stage\[63\].delay_cell.impl ring.base_delay.stage\[62\].delay_cell.Z
+ VGND VGND VPWR VPWR ring.base_delay.stage\[63\].delay_cell.Z
+ sky130_fd_sc_hd__buf_2
Xring.base_delay.stage\[64\].delay_cell.impl ring.base_delay.stage\[63\].delay_cell.Z
+ VGND VGND VPWR VPWR ring.base_delay.stage\[64\].delay_cell.Z
+ sky130_fd_sc_hd__buf_2
Xring.base_delay.stage\[65\].delay_cell.impl ring.base_delay.stage\[64\].delay_cell.Z
+ VGND VGND VPWR VPWR ring.base_delay.stage\[65\].delay_cell.Z
+ sky130_fd_sc_hd__buf_2
Xring.base_delay.stage\[66\].delay_cell.impl ring.base_delay.stage\[65\].delay_cell.Z
+ VGND VGND VPWR VPWR ring.base_delay.stage\[66\].delay_cell.Z
+ sky130_fd_sc_hd__buf_2
Xring.base_delay.stage\[67\].delay_cell.impl ring.base_delay.stage\[66\].delay_cell.Z
+ VGND VGND VPWR VPWR ring.base_delay.stage\[67\].delay_cell.Z
+ sky130_fd_sc_hd__buf_2
Xring.base_delay.stage\[68\].delay_cell.impl ring.base_delay.stage\[67\].delay_cell.Z
+ VGND VGND VPWR VPWR ring.base_delay.stage\[68\].delay_cell.Z
+ sky130_fd_sc_hd__buf_2
Xring.base_delay.stage\[69\].delay_cell.impl ring.base_delay.stage\[68\].delay_cell.Z
+ VGND VGND VPWR VPWR ring.base_delay.stage\[69\].delay_cell.Z
+ sky130_fd_sc_hd__buf_2
Xring.base_delay.stage\[6\].delay_cell.impl ring.base_delay.stage\[5\].delay_cell.Z
+ VGND VGND VPWR VPWR ring.base_delay.stage\[6\].delay_cell.Z
+ sky130_fd_sc_hd__buf_2
Xring.base_delay.stage\[70\].delay_cell.impl ring.base_delay.stage\[69\].delay_cell.Z
+ VGND VGND VPWR VPWR ring.base_delay.stage\[70\].delay_cell.Z
+ sky130_fd_sc_hd__buf_2
Xring.base_delay.stage\[71\].delay_cell.impl ring.base_delay.stage\[70\].delay_cell.Z
+ VGND VGND VPWR VPWR ring.base_delay.stage\[71\].delay_cell.Z
+ sky130_fd_sc_hd__buf_2
Xring.base_delay.stage\[72\].delay_cell.impl ring.base_delay.stage\[71\].delay_cell.Z
+ VGND VGND VPWR VPWR ring.base_delay.stage\[72\].delay_cell.Z
+ sky130_fd_sc_hd__buf_2
Xring.base_delay.stage\[73\].delay_cell.impl ring.base_delay.stage\[72\].delay_cell.Z
+ VGND VGND VPWR VPWR ring.base_delay.stage\[73\].delay_cell.Z
+ sky130_fd_sc_hd__buf_2
Xring.base_delay.stage\[74\].delay_cell.impl ring.base_delay.stage\[73\].delay_cell.Z
+ VGND VGND VPWR VPWR ring.base_delay.stage\[74\].delay_cell.Z
+ sky130_fd_sc_hd__buf_2
Xring.base_delay.stage\[75\].delay_cell.impl ring.base_delay.stage\[74\].delay_cell.Z
+ VGND VGND VPWR VPWR ring.base_delay.stage\[75\].delay_cell.Z
+ sky130_fd_sc_hd__buf_2
Xring.base_delay.stage\[76\].delay_cell.impl ring.base_delay.stage\[75\].delay_cell.Z
+ VGND VGND VPWR VPWR ring.base_delay.stage\[76\].delay_cell.Z
+ sky130_fd_sc_hd__buf_2
Xring.base_delay.stage\[77\].delay_cell.impl ring.base_delay.stage\[76\].delay_cell.Z
+ VGND VGND VPWR VPWR ring.base_delay.stage\[77\].delay_cell.Z
+ sky130_fd_sc_hd__buf_2
Xring.base_delay.stage\[78\].delay_cell.impl ring.base_delay.stage\[77\].delay_cell.Z
+ VGND VGND VPWR VPWR ring.base_delay.stage\[78\].delay_cell.Z
+ sky130_fd_sc_hd__buf_2
Xring.base_delay.stage\[79\].delay_cell.impl ring.base_delay.stage\[78\].delay_cell.Z
+ VGND VGND VPWR VPWR ring.base_delay.stage\[79\].delay_cell.Z
+ sky130_fd_sc_hd__buf_2
Xring.base_delay.stage\[7\].delay_cell.impl ring.base_delay.stage\[6\].delay_cell.Z
+ VGND VGND VPWR VPWR ring.base_delay.stage\[7\].delay_cell.Z
+ sky130_fd_sc_hd__buf_2
Xring.base_delay.stage\[80\].delay_cell.impl ring.base_delay.stage\[79\].delay_cell.Z
+ VGND VGND VPWR VPWR ring.base_delay.stage\[80\].delay_cell.Z
+ sky130_fd_sc_hd__buf_2
Xring.base_delay.stage\[81\].delay_cell.impl ring.base_delay.stage\[80\].delay_cell.Z
+ VGND VGND VPWR VPWR ring.base_delay.stage\[81\].delay_cell.Z
+ sky130_fd_sc_hd__buf_2
Xring.base_delay.stage\[82\].delay_cell.impl ring.base_delay.stage\[81\].delay_cell.Z
+ VGND VGND VPWR VPWR ring.base_delay.stage\[82\].delay_cell.Z
+ sky130_fd_sc_hd__buf_2
Xring.base_delay.stage\[83\].delay_cell.impl ring.base_delay.stage\[82\].delay_cell.Z
+ VGND VGND VPWR VPWR ring.base_delay.stage\[83\].delay_cell.Z
+ sky130_fd_sc_hd__buf_2
Xring.base_delay.stage\[84\].delay_cell.impl ring.base_delay.stage\[83\].delay_cell.Z
+ VGND VGND VPWR VPWR ring.base_delay.stage\[84\].delay_cell.Z
+ sky130_fd_sc_hd__buf_2
Xring.base_delay.stage\[85\].delay_cell.impl ring.base_delay.stage\[84\].delay_cell.Z
+ VGND VGND VPWR VPWR ring.base_delay.stage\[85\].delay_cell.Z
+ sky130_fd_sc_hd__buf_2
Xring.base_delay.stage\[86\].delay_cell.impl ring.base_delay.stage\[85\].delay_cell.Z
+ VGND VGND VPWR VPWR ring.base_delay.stage\[86\].delay_cell.Z
+ sky130_fd_sc_hd__buf_2
Xring.base_delay.stage\[87\].delay_cell.impl ring.base_delay.stage\[86\].delay_cell.Z
+ VGND VGND VPWR VPWR ring.base_delay.stage\[87\].delay_cell.Z
+ sky130_fd_sc_hd__buf_2
Xring.base_delay.stage\[88\].delay_cell.impl ring.base_delay.stage\[87\].delay_cell.Z
+ VGND VGND VPWR VPWR ring.base_delay.stage\[88\].delay_cell.Z
+ sky130_fd_sc_hd__buf_2
Xring.base_delay.stage\[89\].delay_cell.impl ring.base_delay.stage\[88\].delay_cell.Z
+ VGND VGND VPWR VPWR ring.base_delay.stage\[89\].delay_cell.Z
+ sky130_fd_sc_hd__buf_2
Xring.base_delay.stage\[8\].delay_cell.impl ring.base_delay.stage\[7\].delay_cell.Z
+ VGND VGND VPWR VPWR ring.base_delay.stage\[8\].delay_cell.Z
+ sky130_fd_sc_hd__buf_2
Xring.base_delay.stage\[90\].delay_cell.impl ring.base_delay.stage\[89\].delay_cell.Z
+ VGND VGND VPWR VPWR ring.base_delay.stage\[90\].delay_cell.Z
+ sky130_fd_sc_hd__buf_2
Xring.base_delay.stage\[91\].delay_cell.impl ring.base_delay.stage\[90\].delay_cell.Z
+ VGND VGND VPWR VPWR ring.base_delay.stage\[91\].delay_cell.Z
+ sky130_fd_sc_hd__buf_2
Xring.base_delay.stage\[92\].delay_cell.impl ring.base_delay.stage\[91\].delay_cell.Z
+ VGND VGND VPWR VPWR ring.base_delay.stage\[92\].delay_cell.Z
+ sky130_fd_sc_hd__buf_2
Xring.base_delay.stage\[93\].delay_cell.impl ring.base_delay.stage\[92\].delay_cell.Z
+ VGND VGND VPWR VPWR ring.base_delay.stage\[93\].delay_cell.Z
+ sky130_fd_sc_hd__buf_2
Xring.base_delay.stage\[94\].delay_cell.impl ring.base_delay.stage\[93\].delay_cell.Z
+ VGND VGND VPWR VPWR ring.base_delay.stage\[94\].delay_cell.Z
+ sky130_fd_sc_hd__buf_2
Xring.base_delay.stage\[95\].delay_cell.impl ring.base_delay.stage\[94\].delay_cell.Z
+ VGND VGND VPWR VPWR ring.base_delay.stage\[95\].delay_cell.Z
+ sky130_fd_sc_hd__buf_2
Xring.base_delay.stage\[96\].delay_cell.impl ring.base_delay.stage\[95\].delay_cell.Z
+ VGND VGND VPWR VPWR ring.base_delay.stage\[96\].delay_cell.Z
+ sky130_fd_sc_hd__buf_2
Xring.base_delay.stage\[97\].delay_cell.impl ring.base_delay.stage\[96\].delay_cell.Z
+ VGND VGND VPWR VPWR ring.base_delay.stage\[97\].delay_cell.Z
+ sky130_fd_sc_hd__buf_2
Xring.base_delay.stage\[98\].delay_cell.impl ring.base_delay.stage\[97\].delay_cell.Z
+ VGND VGND VPWR VPWR ring.base_delay.stage\[98\].delay_cell.Z
+ sky130_fd_sc_hd__buf_2
Xring.base_delay.stage\[99\].delay_cell.impl ring.base_delay.stage\[98\].delay_cell.Z
+ VGND VGND VPWR VPWR ring.base_delay.stage\[100\].delay_cell.I
+ sky130_fd_sc_hd__buf_2
Xring.base_delay.stage\[9\].delay_cell.impl ring.base_delay.stage\[8\].delay_cell.Z
+ VGND VGND VPWR VPWR ring.base_delay.stage\[10\].delay_cell.I
+ sky130_fd_sc_hd__buf_2
Xring.coarse.impl_last.impl ring.coarse.impl_last.I VGND VGND
+ VPWR VPWR ring.coarse.impl_last.Z sky130_fd_sc_hd__buf_2
Xring.coarse.stage\[0\].impl.dwn.impl ring.coarse.stage\[0\].impl.PATH_0
+ ring.coarse.stage\[0\].impl.CHAIN_IN VGND VGND VPWR VPWR ring.COARSE_OUT
+ sky130_fd_sc_hd__nand2_2
Xring.coarse.stage\[0\].impl.mid.impl net1 ring.DCO_IN VGND
+ VGND VPWR VPWR ring.coarse.stage\[0\].impl.PATH_0 sky130_fd_sc_hd__nand2b_2
Xring.coarse.stage\[0\].impl.upp.impl net1 ring.DCO_IN VGND
+ VGND VPWR VPWR ring.coarse.stage\[0\].impl.CHAIN_OUT sky130_fd_sc_hd__nand2_2
Xring.coarse.stage\[10\].impl.dwn.impl ring.coarse.stage\[10\].impl.PATH_0
+ ring.coarse.stage\[10\].impl.CHAIN_IN VGND VGND VPWR VPWR
+ ring.coarse.stage\[10\].impl.OUT sky130_fd_sc_hd__nand2_2
Xring.coarse.stage\[10\].impl.mid.impl net2 ring.coarse.stage\[10\].impl.IN
+ VGND VGND VPWR VPWR ring.coarse.stage\[10\].impl.PATH_0 sky130_fd_sc_hd__nand2b_2
Xring.coarse.stage\[10\].impl.upp.impl net2 ring.coarse.stage\[10\].impl.IN
+ VGND VGND VPWR VPWR ring.coarse.stage\[10\].impl.CHAIN_OUT
+ sky130_fd_sc_hd__nand2_2
Xring.coarse.stage\[11\].impl.dwn.impl ring.coarse.stage\[11\].impl.PATH_0
+ ring.coarse.stage\[11\].impl.CHAIN_IN VGND VGND VPWR VPWR
+ ring.coarse.stage\[10\].impl.CHAIN_IN sky130_fd_sc_hd__nand2_2
Xring.coarse.stage\[11\].impl.mid.impl net3 ring.coarse.stage\[10\].impl.CHAIN_OUT
+ VGND VGND VPWR VPWR ring.coarse.stage\[11\].impl.PATH_0 sky130_fd_sc_hd__nand2b_2
Xring.coarse.stage\[11\].impl.upp.impl net3 ring.coarse.stage\[10\].impl.CHAIN_OUT
+ VGND VGND VPWR VPWR ring.coarse.stage\[11\].impl.CHAIN_OUT
+ sky130_fd_sc_hd__nand2_2
Xring.coarse.stage\[12\].impl.dwn.impl ring.coarse.stage\[12\].impl.PATH_0
+ ring.coarse.stage\[12\].impl.CHAIN_IN VGND VGND VPWR VPWR
+ ring.coarse.stage\[11\].impl.CHAIN_IN sky130_fd_sc_hd__nand2_2
Xring.coarse.stage\[12\].impl.mid.impl net4 ring.coarse.stage\[11\].impl.CHAIN_OUT
+ VGND VGND VPWR VPWR ring.coarse.stage\[12\].impl.PATH_0 sky130_fd_sc_hd__nand2b_2
Xring.coarse.stage\[12\].impl.upp.impl net4 ring.coarse.stage\[11\].impl.CHAIN_OUT
+ VGND VGND VPWR VPWR ring.coarse.stage\[12\].impl.CHAIN_OUT
+ sky130_fd_sc_hd__nand2_2
Xring.coarse.stage\[13\].impl.dwn.impl ring.coarse.stage\[13\].impl.PATH_0
+ ring.coarse.stage\[13\].impl.CHAIN_IN VGND VGND VPWR VPWR
+ ring.coarse.stage\[12\].impl.CHAIN_IN sky130_fd_sc_hd__nand2_2
Xring.coarse.stage\[13\].impl.mid.impl net5 ring.coarse.stage\[12\].impl.CHAIN_OUT
+ VGND VGND VPWR VPWR ring.coarse.stage\[13\].impl.PATH_0 sky130_fd_sc_hd__nand2b_2
Xring.coarse.stage\[13\].impl.upp.impl net5 ring.coarse.stage\[12\].impl.CHAIN_OUT
+ VGND VGND VPWR VPWR ring.coarse.stage\[13\].impl.CHAIN_OUT
+ sky130_fd_sc_hd__nand2_2
Xring.coarse.stage\[14\].impl.dwn.impl ring.coarse.stage\[14\].impl.PATH_0
+ ring.coarse.impl_last.Z VGND VGND VPWR VPWR ring.coarse.stage\[13\].impl.CHAIN_IN
+ sky130_fd_sc_hd__nand2_2
Xring.coarse.stage\[14\].impl.mid.impl net6 ring.coarse.stage\[13\].impl.CHAIN_OUT
+ VGND VGND VPWR VPWR ring.coarse.stage\[14\].impl.PATH_0 sky130_fd_sc_hd__nand2b_2
Xring.coarse.stage\[14\].impl.upp.impl net6 ring.coarse.stage\[13\].impl.CHAIN_OUT
+ VGND VGND VPWR VPWR ring.coarse.impl_last.I sky130_fd_sc_hd__nand2_2
Xring.coarse.stage\[1\].impl.dwn.impl ring.coarse.stage\[1\].impl.PATH_0
+ ring.coarse.stage\[1\].impl.CHAIN_IN VGND VGND VPWR VPWR ring.coarse.stage\[0\].impl.CHAIN_IN
+ sky130_fd_sc_hd__nand2_2
Xring.coarse.stage\[1\].impl.mid.impl net7 ring.coarse.stage\[0\].impl.CHAIN_OUT
+ VGND VGND VPWR VPWR ring.coarse.stage\[1\].impl.PATH_0 sky130_fd_sc_hd__nand2b_2
Xring.coarse.stage\[1\].impl.upp.impl net7 ring.coarse.stage\[0\].impl.CHAIN_OUT
+ VGND VGND VPWR VPWR ring.coarse.stage\[1\].impl.CHAIN_OUT
+ sky130_fd_sc_hd__nand2_2
Xring.coarse.stage\[2\].impl.dwn.impl ring.coarse.stage\[2\].impl.PATH_0
+ ring.coarse.stage\[2\].impl.CHAIN_IN VGND VGND VPWR VPWR ring.coarse.stage\[1\].impl.CHAIN_IN
+ sky130_fd_sc_hd__nand2_2
Xring.coarse.stage\[2\].impl.mid.impl net8 ring.coarse.stage\[1\].impl.CHAIN_OUT
+ VGND VGND VPWR VPWR ring.coarse.stage\[2\].impl.PATH_0 sky130_fd_sc_hd__nand2b_2
Xring.coarse.stage\[2\].impl.upp.impl net8 ring.coarse.stage\[1\].impl.CHAIN_OUT
+ VGND VGND VPWR VPWR ring.coarse.stage\[2\].impl.CHAIN_OUT
+ sky130_fd_sc_hd__nand2_2
Xring.coarse.stage\[3\].impl.dwn.impl ring.coarse.stage\[3\].impl.PATH_0
+ ring.coarse.stage\[3\].impl.CHAIN_IN VGND VGND VPWR VPWR ring.coarse.stage\[2\].impl.CHAIN_IN
+ sky130_fd_sc_hd__nand2_2
Xring.coarse.stage\[3\].impl.mid.impl net9 ring.coarse.stage\[2\].impl.CHAIN_OUT
+ VGND VGND VPWR VPWR ring.coarse.stage\[3\].impl.PATH_0 sky130_fd_sc_hd__nand2b_2
Xring.coarse.stage\[3\].impl.upp.impl net9 ring.coarse.stage\[2\].impl.CHAIN_OUT
+ VGND VGND VPWR VPWR ring.coarse.stage\[3\].impl.CHAIN_OUT
+ sky130_fd_sc_hd__nand2_2
Xring.coarse.stage\[4\].impl.dwn.impl ring.coarse.stage\[4\].impl.PATH_0
+ ring.coarse.stage\[4\].impl.CHAIN_IN VGND VGND VPWR VPWR ring.coarse.stage\[3\].impl.CHAIN_IN
+ sky130_fd_sc_hd__nand2_2
Xring.coarse.stage\[4\].impl.mid.impl net10 ring.coarse.stage\[3\].impl.CHAIN_OUT
+ VGND VGND VPWR VPWR ring.coarse.stage\[4\].impl.PATH_0 sky130_fd_sc_hd__nand2b_2
Xring.coarse.stage\[4\].impl.upp.impl net10 ring.coarse.stage\[3\].impl.CHAIN_OUT
+ VGND VGND VPWR VPWR ring.coarse.stage\[4\].impl.CHAIN_OUT
+ sky130_fd_sc_hd__nand2_2
Xring.coarse.stage\[5\].impl.dwn.impl ring.coarse.stage\[5\].impl.PATH_0
+ ring.coarse.stage\[5\].impl.CHAIN_IN VGND VGND VPWR VPWR ring.coarse.stage\[4\].impl.CHAIN_IN
+ sky130_fd_sc_hd__nand2_2
Xring.coarse.stage\[5\].impl.mid.impl net11 ring.coarse.stage\[4\].impl.CHAIN_OUT
+ VGND VGND VPWR VPWR ring.coarse.stage\[5\].impl.PATH_0 sky130_fd_sc_hd__nand2b_2
Xring.coarse.stage\[5\].impl.upp.impl net11 ring.coarse.stage\[4\].impl.CHAIN_OUT
+ VGND VGND VPWR VPWR ring.coarse.stage\[5\].impl.CHAIN_OUT
+ sky130_fd_sc_hd__nand2_2
Xring.coarse.stage\[6\].impl.dwn.impl ring.coarse.stage\[6\].impl.PATH_0
+ ring.coarse.stage\[6\].impl.CHAIN_IN VGND VGND VPWR VPWR ring.coarse.stage\[5\].impl.CHAIN_IN
+ sky130_fd_sc_hd__nand2_2
Xring.coarse.stage\[6\].impl.mid.impl net12 ring.coarse.stage\[5\].impl.CHAIN_OUT
+ VGND VGND VPWR VPWR ring.coarse.stage\[6\].impl.PATH_0 sky130_fd_sc_hd__nand2b_2
Xring.coarse.stage\[6\].impl.upp.impl net12 ring.coarse.stage\[5\].impl.CHAIN_OUT
+ VGND VGND VPWR VPWR ring.coarse.stage\[6\].impl.CHAIN_OUT
+ sky130_fd_sc_hd__nand2_2
Xring.coarse.stage\[7\].impl.dwn.impl ring.coarse.stage\[7\].impl.PATH_0
+ ring.coarse.stage\[7\].impl.CHAIN_IN VGND VGND VPWR VPWR ring.coarse.stage\[6\].impl.CHAIN_IN
+ sky130_fd_sc_hd__nand2_2
Xring.coarse.stage\[7\].impl.mid.impl net13 ring.coarse.stage\[6\].impl.CHAIN_OUT
+ VGND VGND VPWR VPWR ring.coarse.stage\[7\].impl.PATH_0 sky130_fd_sc_hd__nand2b_2
Xring.coarse.stage\[7\].impl.upp.impl net13 ring.coarse.stage\[6\].impl.CHAIN_OUT
+ VGND VGND VPWR VPWR ring.coarse.stage\[7\].impl.CHAIN_OUT
+ sky130_fd_sc_hd__nand2_2
Xring.coarse.stage\[8\].impl.dwn.impl ring.coarse.stage\[8\].impl.PATH_0
+ ring.coarse.stage\[8\].impl.CHAIN_IN VGND VGND VPWR VPWR ring.coarse.stage\[7\].impl.CHAIN_IN
+ sky130_fd_sc_hd__nand2_2
Xring.coarse.stage\[8\].impl.mid.impl net14 ring.coarse.stage\[7\].impl.CHAIN_OUT
+ VGND VGND VPWR VPWR ring.coarse.stage\[8\].impl.PATH_0 sky130_fd_sc_hd__nand2b_2
Xring.coarse.stage\[8\].impl.upp.impl net14 ring.coarse.stage\[7\].impl.CHAIN_OUT
+ VGND VGND VPWR VPWR ring.coarse.stage\[8\].impl.CHAIN_OUT
+ sky130_fd_sc_hd__nand2_2
Xring.coarse.stage\[9\].impl.dwn.impl ring.coarse.stage\[9\].impl.PATH_0
+ ring.coarse.stage\[10\].impl.OUT VGND VGND VPWR VPWR ring.coarse.stage\[8\].impl.CHAIN_IN
+ sky130_fd_sc_hd__nand2_2
Xring.coarse.stage\[9\].impl.mid.impl net15 ring.coarse.stage\[8\].impl.CHAIN_OUT
+ VGND VGND VPWR VPWR ring.coarse.stage\[9\].impl.PATH_0 sky130_fd_sc_hd__nand2b_2
Xring.coarse.stage\[9\].impl.upp.impl net15 ring.coarse.stage\[8\].impl.CHAIN_OUT
+ VGND VGND VPWR VPWR ring.coarse.stage\[10\].impl.IN sky130_fd_sc_hd__nand2_2
Xring.dff_x.impl ring.dff_x.CKN_B ring.dff_x.D VGND VGND VPWR
+ VPWR ring.dff_x.Q sky130_fd_sc_hd__dfxtp_2
Xring.dff_x.inv_ck.impl REF VGND VGND VPWR VPWR ring.dff_x.CKN_B
+ sky130_fd_sc_hd__inv_2
Xring.dff_y.impl ring.dff_y.CKN_B ring.dff_y.D VGND VGND VPWR
+ VPWR ring.dff_y.Q sky130_fd_sc_hd__dfxtp_2
Xring.dff_y.inv_ck.impl REF VGND VGND VPWR VPWR ring.dff_y.CKN_B
+ sky130_fd_sc_hd__inv_2
Xring.fine.inv_0.impl net64 VGND VGND VPWR VPWR ring.fine.LOAD
+ sky130_fd_sc_hd__inv_6
Xring.fine.inv_1.impl ring.fine.LOAD VGND VGND VPWR VPWR ring.FINE_OUT
+ sky130_fd_sc_hd__inv_6
Xring.fine.stage\[0\].dyn.impl net17 ring.fine.LOAD ring.fine.stage\[0\].dyn.A2
+ VGND VGND VPWR VPWR ring.fine.stage\[0\].dyn.ZN sky130_fd_sc_hd__nand3_2
Xring.fine.stage\[0\].inv_b.impl net17 VGND VGND VPWR VPWR
+ ring.fine.stage\[0\].dyn.A2 sky130_fd_sc_hd__inv_2
Xring.fine.stage\[10\].dyn.impl net18 ring.fine.LOAD ring.fine.stage\[10\].dyn.A2
+ VGND VGND VPWR VPWR ring.fine.stage\[10\].dyn.ZN sky130_fd_sc_hd__nand3_2
Xring.fine.stage\[10\].inv_b.impl net18 VGND VGND VPWR VPWR
+ ring.fine.stage\[10\].dyn.A2 sky130_fd_sc_hd__inv_2
Xring.fine.stage\[11\].dyn.impl net19 ring.fine.LOAD ring.fine.stage\[11\].dyn.A2
+ VGND VGND VPWR VPWR ring.fine.stage\[11\].dyn.ZN sky130_fd_sc_hd__nand3_2
Xring.fine.stage\[11\].inv_b.impl net19 VGND VGND VPWR VPWR
+ ring.fine.stage\[11\].dyn.A2 sky130_fd_sc_hd__inv_2
Xring.fine.stage\[12\].dyn.impl net20 ring.fine.LOAD ring.fine.stage\[12\].dyn.A2
+ VGND VGND VPWR VPWR ring.fine.stage\[12\].dyn.ZN sky130_fd_sc_hd__nand3_2
Xring.fine.stage\[12\].inv_b.impl net20 VGND VGND VPWR VPWR
+ ring.fine.stage\[12\].dyn.A2 sky130_fd_sc_hd__inv_2
Xring.fine.stage\[13\].dyn.impl net21 ring.fine.LOAD ring.fine.stage\[13\].dyn.A2
+ VGND VGND VPWR VPWR ring.fine.stage\[13\].dyn.ZN sky130_fd_sc_hd__nand3_2
Xring.fine.stage\[13\].inv_b.impl net21 VGND VGND VPWR VPWR
+ ring.fine.stage\[13\].dyn.A2 sky130_fd_sc_hd__inv_2
Xring.fine.stage\[14\].dyn.impl net22 ring.fine.LOAD ring.fine.stage\[14\].dyn.A2
+ VGND VGND VPWR VPWR ring.fine.stage\[14\].dyn.ZN sky130_fd_sc_hd__nand3_2
Xring.fine.stage\[14\].inv_b.impl net22 VGND VGND VPWR VPWR
+ ring.fine.stage\[14\].dyn.A2 sky130_fd_sc_hd__inv_2
Xring.fine.stage\[15\].dyn.impl net23 ring.fine.LOAD ring.fine.stage\[15\].dyn.A2
+ VGND VGND VPWR VPWR ring.fine.stage\[15\].dyn.ZN sky130_fd_sc_hd__nand3_2
Xring.fine.stage\[15\].inv_b.impl net23 VGND VGND VPWR VPWR
+ ring.fine.stage\[15\].dyn.A2 sky130_fd_sc_hd__inv_2
Xring.fine.stage\[16\].dyn.impl net24 ring.fine.LOAD ring.fine.stage\[16\].dyn.A2
+ VGND VGND VPWR VPWR ring.fine.stage\[16\].dyn.ZN sky130_fd_sc_hd__nand3_2
Xring.fine.stage\[16\].inv_b.impl net24 VGND VGND VPWR VPWR
+ ring.fine.stage\[16\].dyn.A2 sky130_fd_sc_hd__inv_2
Xring.fine.stage\[17\].dyn.impl net25 ring.fine.LOAD ring.fine.stage\[17\].dyn.A2
+ VGND VGND VPWR VPWR ring.fine.stage\[17\].dyn.ZN sky130_fd_sc_hd__nand3_2
Xring.fine.stage\[17\].inv_b.impl net25 VGND VGND VPWR VPWR
+ ring.fine.stage\[17\].dyn.A2 sky130_fd_sc_hd__inv_2
Xring.fine.stage\[18\].dyn.impl net26 ring.fine.LOAD ring.fine.stage\[18\].dyn.A2
+ VGND VGND VPWR VPWR ring.fine.stage\[18\].dyn.ZN sky130_fd_sc_hd__nand3_2
Xring.fine.stage\[18\].inv_b.impl net26 VGND VGND VPWR VPWR
+ ring.fine.stage\[18\].dyn.A2 sky130_fd_sc_hd__inv_2
Xring.fine.stage\[19\].dyn.impl net27 ring.fine.LOAD ring.fine.stage\[19\].dyn.A2
+ VGND VGND VPWR VPWR ring.fine.stage\[19\].dyn.ZN sky130_fd_sc_hd__nand3_2
Xring.fine.stage\[19\].inv_b.impl net27 VGND VGND VPWR VPWR
+ ring.fine.stage\[19\].dyn.A2 sky130_fd_sc_hd__inv_2
Xring.fine.stage\[1\].dyn.impl net28 ring.fine.LOAD ring.fine.stage\[1\].dyn.A2
+ VGND VGND VPWR VPWR ring.fine.stage\[1\].dyn.ZN sky130_fd_sc_hd__nand3_2
Xring.fine.stage\[1\].inv_b.impl net28 VGND VGND VPWR VPWR
+ ring.fine.stage\[1\].dyn.A2 sky130_fd_sc_hd__inv_2
Xring.fine.stage\[20\].dyn.impl net29 ring.fine.LOAD ring.fine.stage\[20\].dyn.A2
+ VGND VGND VPWR VPWR ring.fine.stage\[20\].dyn.ZN sky130_fd_sc_hd__nand3_2
Xring.fine.stage\[20\].inv_b.impl net29 VGND VGND VPWR VPWR
+ ring.fine.stage\[20\].dyn.A2 sky130_fd_sc_hd__inv_2
Xring.fine.stage\[21\].dyn.impl net30 ring.fine.LOAD ring.fine.stage\[21\].dyn.A2
+ VGND VGND VPWR VPWR ring.fine.stage\[21\].dyn.ZN sky130_fd_sc_hd__nand3_2
Xring.fine.stage\[21\].inv_b.impl net30 VGND VGND VPWR VPWR
+ ring.fine.stage\[21\].dyn.A2 sky130_fd_sc_hd__inv_2
Xring.fine.stage\[22\].dyn.impl net31 ring.fine.LOAD ring.fine.stage\[22\].dyn.A2
+ VGND VGND VPWR VPWR ring.fine.stage\[22\].dyn.ZN sky130_fd_sc_hd__nand3_2
Xring.fine.stage\[22\].inv_b.impl net31 VGND VGND VPWR VPWR
+ ring.fine.stage\[22\].dyn.A2 sky130_fd_sc_hd__inv_2
Xring.fine.stage\[23\].dyn.impl net32 ring.fine.LOAD ring.fine.stage\[23\].dyn.A2
+ VGND VGND VPWR VPWR ring.fine.stage\[23\].dyn.ZN sky130_fd_sc_hd__nand3_2
Xring.fine.stage\[23\].inv_b.impl net32 VGND VGND VPWR VPWR
+ ring.fine.stage\[23\].dyn.A2 sky130_fd_sc_hd__inv_2
Xring.fine.stage\[24\].dyn.impl net33 ring.fine.LOAD ring.fine.stage\[24\].dyn.A2
+ VGND VGND VPWR VPWR ring.fine.stage\[24\].dyn.ZN sky130_fd_sc_hd__nand3_2
Xring.fine.stage\[24\].inv_b.impl net33 VGND VGND VPWR VPWR
+ ring.fine.stage\[24\].dyn.A2 sky130_fd_sc_hd__inv_2
Xring.fine.stage\[25\].dyn.impl net34 ring.fine.LOAD ring.fine.stage\[25\].dyn.A2
+ VGND VGND VPWR VPWR ring.fine.stage\[25\].dyn.ZN sky130_fd_sc_hd__nand3_2
Xring.fine.stage\[25\].inv_b.impl net34 VGND VGND VPWR VPWR
+ ring.fine.stage\[25\].dyn.A2 sky130_fd_sc_hd__inv_2
Xring.fine.stage\[26\].dyn.impl net35 ring.fine.LOAD ring.fine.stage\[26\].dyn.A2
+ VGND VGND VPWR VPWR ring.fine.stage\[26\].dyn.ZN sky130_fd_sc_hd__nand3_2
Xring.fine.stage\[26\].inv_b.impl net35 VGND VGND VPWR VPWR
+ ring.fine.stage\[26\].dyn.A2 sky130_fd_sc_hd__inv_2
Xring.fine.stage\[27\].dyn.impl net36 ring.fine.LOAD ring.fine.stage\[27\].dyn.A2
+ VGND VGND VPWR VPWR ring.fine.stage\[27\].dyn.ZN sky130_fd_sc_hd__nand3_2
Xring.fine.stage\[27\].inv_b.impl net36 VGND VGND VPWR VPWR
+ ring.fine.stage\[27\].dyn.A2 sky130_fd_sc_hd__inv_2
Xring.fine.stage\[28\].dyn.impl net37 ring.fine.LOAD ring.fine.stage\[28\].dyn.A2
+ VGND VGND VPWR VPWR ring.fine.stage\[28\].dyn.ZN sky130_fd_sc_hd__nand3_2
Xring.fine.stage\[28\].inv_b.impl net37 VGND VGND VPWR VPWR
+ ring.fine.stage\[28\].dyn.A2 sky130_fd_sc_hd__inv_2
Xring.fine.stage\[29\].dyn.impl net38 ring.fine.LOAD ring.fine.stage\[29\].dyn.A2
+ VGND VGND VPWR VPWR ring.fine.stage\[29\].dyn.ZN sky130_fd_sc_hd__nand3_2
Xring.fine.stage\[29\].inv_b.impl net38 VGND VGND VPWR VPWR
+ ring.fine.stage\[29\].dyn.A2 sky130_fd_sc_hd__inv_2
Xring.fine.stage\[2\].dyn.impl net39 ring.fine.LOAD ring.fine.stage\[2\].dyn.A2
+ VGND VGND VPWR VPWR ring.fine.stage\[2\].dyn.ZN sky130_fd_sc_hd__nand3_2
Xring.fine.stage\[2\].inv_b.impl net39 VGND VGND VPWR VPWR
+ ring.fine.stage\[2\].dyn.A2 sky130_fd_sc_hd__inv_2
Xring.fine.stage\[30\].dyn.impl net40 ring.fine.LOAD ring.fine.stage\[30\].dyn.A2
+ VGND VGND VPWR VPWR ring.fine.stage\[30\].dyn.ZN sky130_fd_sc_hd__nand3_2
Xring.fine.stage\[30\].inv_b.impl net40 VGND VGND VPWR VPWR
+ ring.fine.stage\[30\].dyn.A2 sky130_fd_sc_hd__inv_2
Xring.fine.stage\[3\].dyn.impl net41 ring.fine.LOAD ring.fine.stage\[3\].dyn.A2
+ VGND VGND VPWR VPWR ring.fine.stage\[3\].dyn.ZN sky130_fd_sc_hd__nand3_2
Xring.fine.stage\[3\].inv_b.impl net41 VGND VGND VPWR VPWR
+ ring.fine.stage\[3\].dyn.A2 sky130_fd_sc_hd__inv_2
Xring.fine.stage\[4\].dyn.impl net42 ring.fine.LOAD ring.fine.stage\[4\].dyn.A2
+ VGND VGND VPWR VPWR ring.fine.stage\[4\].dyn.ZN sky130_fd_sc_hd__nand3_2
Xring.fine.stage\[4\].inv_b.impl net42 VGND VGND VPWR VPWR
+ ring.fine.stage\[4\].dyn.A2 sky130_fd_sc_hd__inv_2
Xring.fine.stage\[5\].dyn.impl net43 ring.fine.LOAD ring.fine.stage\[5\].dyn.A2
+ VGND VGND VPWR VPWR ring.fine.stage\[5\].dyn.ZN sky130_fd_sc_hd__nand3_2
Xring.fine.stage\[5\].inv_b.impl net43 VGND VGND VPWR VPWR
+ ring.fine.stage\[5\].dyn.A2 sky130_fd_sc_hd__inv_2
Xring.fine.stage\[6\].dyn.impl net44 ring.fine.LOAD ring.fine.stage\[6\].dyn.A2
+ VGND VGND VPWR VPWR ring.fine.stage\[6\].dyn.ZN sky130_fd_sc_hd__nand3_2
Xring.fine.stage\[6\].inv_b.impl net44 VGND VGND VPWR VPWR
+ ring.fine.stage\[6\].dyn.A2 sky130_fd_sc_hd__inv_2
Xring.fine.stage\[7\].dyn.impl net45 ring.fine.LOAD ring.fine.stage\[7\].dyn.A2
+ VGND VGND VPWR VPWR ring.fine.stage\[7\].dyn.ZN sky130_fd_sc_hd__nand3_2
Xring.fine.stage\[7\].inv_b.impl net45 VGND VGND VPWR VPWR
+ ring.fine.stage\[7\].dyn.A2 sky130_fd_sc_hd__inv_2
Xring.fine.stage\[8\].dyn.impl net46 ring.fine.LOAD ring.fine.stage\[8\].dyn.A2
+ VGND VGND VPWR VPWR ring.fine.stage\[8\].dyn.ZN sky130_fd_sc_hd__nand3_2
Xring.fine.stage\[8\].inv_b.impl net46 VGND VGND VPWR VPWR
+ ring.fine.stage\[8\].dyn.A2 sky130_fd_sc_hd__inv_2
Xring.fine.stage\[9\].dyn.impl net47 ring.fine.LOAD ring.fine.stage\[9\].dyn.A2
+ VGND VGND VPWR VPWR ring.fine.stage\[9\].dyn.ZN sky130_fd_sc_hd__nand3_2
Xring.fine.stage\[9\].inv_b.impl net47 VGND VGND VPWR VPWR
+ ring.fine.stage\[9\].dyn.A2 sky130_fd_sc_hd__inv_2
Xring.mid.inv_0.impl ring.COARSE_OUT VGND VGND VPWR VPWR ring.mid.LOAD
+ sky130_fd_sc_hd__inv_4
Xring.mid.inv_1.impl ring.mid.LOAD VGND VGND VPWR VPWR net64
+ sky130_fd_sc_hd__inv_4
Xring.mid.stage\[0\].dyn.impl net48 ring.mid.LOAD ring.mid.stage\[0\].dyn.A2
+ VGND VGND VPWR VPWR ring.mid.stage\[0\].dyn.ZN sky130_fd_sc_hd__nand3_2
Xring.mid.stage\[0\].inv_b.impl net48 VGND VGND VPWR VPWR
+ ring.mid.stage\[0\].dyn.A2 sky130_fd_sc_hd__inv_2
Xring.mid.stage\[10\].dyn.impl net49 ring.mid.LOAD ring.mid.stage\[10\].dyn.A2
+ VGND VGND VPWR VPWR ring.mid.stage\[10\].dyn.ZN sky130_fd_sc_hd__nand3_2
Xring.mid.stage\[10\].inv_b.impl net49 VGND VGND VPWR VPWR
+ ring.mid.stage\[10\].dyn.A2 sky130_fd_sc_hd__inv_2
Xring.mid.stage\[11\].dyn.impl net50 ring.mid.LOAD ring.mid.stage\[11\].dyn.A2
+ VGND VGND VPWR VPWR ring.mid.stage\[11\].dyn.ZN sky130_fd_sc_hd__nand3_2
Xring.mid.stage\[11\].inv_b.impl net50 VGND VGND VPWR VPWR
+ ring.mid.stage\[11\].dyn.A2 sky130_fd_sc_hd__inv_2
Xring.mid.stage\[12\].dyn.impl net51 ring.mid.LOAD ring.mid.stage\[12\].dyn.A2
+ VGND VGND VPWR VPWR ring.mid.stage\[12\].dyn.ZN sky130_fd_sc_hd__nand3_2
Xring.mid.stage\[12\].inv_b.impl net51 VGND VGND VPWR VPWR
+ ring.mid.stage\[12\].dyn.A2 sky130_fd_sc_hd__inv_2
Xring.mid.stage\[13\].dyn.impl net52 ring.mid.LOAD ring.mid.stage\[13\].dyn.A2
+ VGND VGND VPWR VPWR ring.mid.stage\[13\].dyn.ZN sky130_fd_sc_hd__nand3_2
Xring.mid.stage\[13\].inv_b.impl net52 VGND VGND VPWR VPWR
+ ring.mid.stage\[13\].dyn.A2 sky130_fd_sc_hd__inv_2
Xring.mid.stage\[14\].dyn.impl net53 ring.mid.LOAD ring.mid.stage\[14\].dyn.A2
+ VGND VGND VPWR VPWR ring.mid.stage\[14\].dyn.ZN sky130_fd_sc_hd__nand3_2
Xring.mid.stage\[14\].inv_b.impl net53 VGND VGND VPWR VPWR
+ ring.mid.stage\[14\].dyn.A2 sky130_fd_sc_hd__inv_2
Xring.mid.stage\[1\].dyn.impl net54 ring.mid.LOAD ring.mid.stage\[1\].dyn.A2
+ VGND VGND VPWR VPWR ring.mid.stage\[1\].dyn.ZN sky130_fd_sc_hd__nand3_2
Xring.mid.stage\[1\].inv_b.impl net54 VGND VGND VPWR VPWR
+ ring.mid.stage\[1\].dyn.A2 sky130_fd_sc_hd__inv_2
Xring.mid.stage\[2\].dyn.impl net55 ring.mid.LOAD ring.mid.stage\[2\].dyn.A2
+ VGND VGND VPWR VPWR ring.mid.stage\[2\].dyn.ZN sky130_fd_sc_hd__nand3_2
Xring.mid.stage\[2\].inv_b.impl net55 VGND VGND VPWR VPWR
+ ring.mid.stage\[2\].dyn.A2 sky130_fd_sc_hd__inv_2
Xring.mid.stage\[3\].dyn.impl net56 ring.mid.LOAD ring.mid.stage\[3\].dyn.A2
+ VGND VGND VPWR VPWR ring.mid.stage\[3\].dyn.ZN sky130_fd_sc_hd__nand3_2
Xring.mid.stage\[3\].inv_b.impl net56 VGND VGND VPWR VPWR
+ ring.mid.stage\[3\].dyn.A2 sky130_fd_sc_hd__inv_2
Xring.mid.stage\[4\].dyn.impl net57 ring.mid.LOAD ring.mid.stage\[4\].dyn.A2
+ VGND VGND VPWR VPWR ring.mid.stage\[4\].dyn.ZN sky130_fd_sc_hd__nand3_2
Xring.mid.stage\[4\].inv_b.impl net57 VGND VGND VPWR VPWR
+ ring.mid.stage\[4\].dyn.A2 sky130_fd_sc_hd__inv_2
Xring.mid.stage\[5\].dyn.impl net58 ring.mid.LOAD ring.mid.stage\[5\].dyn.A2
+ VGND VGND VPWR VPWR ring.mid.stage\[5\].dyn.ZN sky130_fd_sc_hd__nand3_2
Xring.mid.stage\[5\].inv_b.impl net58 VGND VGND VPWR VPWR
+ ring.mid.stage\[5\].dyn.A2 sky130_fd_sc_hd__inv_2
Xring.mid.stage\[6\].dyn.impl net59 ring.mid.LOAD ring.mid.stage\[6\].dyn.A2
+ VGND VGND VPWR VPWR ring.mid.stage\[6\].dyn.ZN sky130_fd_sc_hd__nand3_2
Xring.mid.stage\[6\].inv_b.impl net59 VGND VGND VPWR VPWR
+ ring.mid.stage\[6\].dyn.A2 sky130_fd_sc_hd__inv_2
Xring.mid.stage\[7\].dyn.impl net60 ring.mid.LOAD ring.mid.stage\[7\].dyn.A2
+ VGND VGND VPWR VPWR ring.mid.stage\[7\].dyn.ZN sky130_fd_sc_hd__nand3_2
Xring.mid.stage\[7\].inv_b.impl net60 VGND VGND VPWR VPWR
+ ring.mid.stage\[7\].dyn.A2 sky130_fd_sc_hd__inv_2
Xring.mid.stage\[8\].dyn.impl net61 ring.mid.LOAD ring.mid.stage\[8\].dyn.A2
+ VGND VGND VPWR VPWR ring.mid.stage\[8\].dyn.ZN sky130_fd_sc_hd__nand3_2
Xring.mid.stage\[8\].inv_b.impl net61 VGND VGND VPWR VPWR
+ ring.mid.stage\[8\].dyn.A2 sky130_fd_sc_hd__inv_2
Xring.mid.stage\[9\].dyn.impl net62 ring.mid.LOAD ring.mid.stage\[9\].dyn.A2
+ VGND VGND VPWR VPWR ring.mid.stage\[9\].dyn.ZN sky130_fd_sc_hd__nand3_2
Xring.mid.stage\[9\].inv_b.impl net62 VGND VGND VPWR VPWR
+ ring.mid.stage\[9\].dyn.A2 sky130_fd_sc_hd__inv_2
Xring.sym.inj_dummy_inv.impl ring.sym.INJ_EDGE_BALANCED VGND
+ VGND VPWR VPWR ring.sym.INJ_DUMMY sky130_fd_sc_hd__inv_2
Xring.sym.inj_slope_balancer.impl REF VGND VGND VPWR VPWR
+ ring.sym.INJ_EDGE_BALANCED sky130_fd_sc_hd__inv_2
Xring.sym.osc_dummy_inv.impl ring.sym.OSC_BALANCED VGND VGND
+ VPWR VPWR ring.sym.OSC_DUMMY sky130_fd_sc_hd__inv_2
Xring.sym.osc_slope_balancer.impl ring.FINE_OUT VGND VGND
+ VPWR VPWR ring.sym.OSC_BALANCED sky130_fd_sc_hd__inv_2
Xring.sym.ssbbpd_impl.buf_nand_x.impl ring.sym.ssbbpd_impl.OUT_NANDX
+ VGND VGND VPWR VPWR ring.dff_x.D sky130_fd_sc_hd__buf_2
Xring.sym.ssbbpd_impl.buf_nand_y.impl ring.sym.ssbbpd_impl.OUT_NANDY
+ VGND VGND VPWR VPWR ring.dff_y.D sky130_fd_sc_hd__buf_2
Xring.sym.ssbbpd_impl.nand_x.impl ring.sym.OSC_BALANCED ring.sym.ssbbpd_impl.OUT_NANDY
+ VGND VGND VPWR VPWR ring.sym.ssbbpd_impl.OUT_NANDX sky130_fd_sc_hd__nand2_2
Xring.sym.ssbbpd_impl.nand_y.impl ring.sym.INJ_EDGE_BALANCED
+ ring.sym.ssbbpd_impl.OUT_NANDX VGND VGND VPWR VPWR ring.sym.ssbbpd_impl.OUT_NANDY
+ sky130_fd_sc_hd__nand2_2
Xring.sym.sym_mux.nand_inj.impl ring.sym.OSC_BALANCED ring.sym.sym_mux.DCO_EN_INJ_WIN
+ VGND VGND VPWR VPWR ring.sym.sym_mux.OSC_INJ sky130_fd_sc_hd__nand2_2
Xring.sym.sym_mux.nand_pll.impl ring.sym.sym_mux.REF_INJ ring.sym.sym_mux.OSC_INJ
+ VGND VGND VPWR VPWR OUT sky130_fd_sc_hd__nand2_2
Xring.sym.sym_mux.nand_ref.impl ring.sym.INJ_EDGE_BALANCED
+ net VGND VGND VPWR VPWR ring.sym.sym_mux.REF_INJ sky130_fd_sc_hd__nand2b_2
Xring.sym.sym_mux.nand_ref.impl_67 VGND VGND VPWR VPWR _unconnected_0
+ net sky130_fd_sc_hd__conb_1
Xring.sym.sym_mux.norb_en_inj.impl net16 net67 VGND VGND VPWR
+ VPWR ring.sym.sym_mux.DCO_EN_INJ_WIN sky130_fd_sc_hd__nor2b_2
Xring.sym.sym_mux.norb_en_inj.impl_68 VGND VGND VPWR VPWR
+ _unconnected_1 net67 sky130_fd_sc_hd__conb_1
.ENDS PLL_RING_DCO_PHYS
