* CDL Netlist generated by OpenROAD

*.BUSDELIMITER [

.SUBCKT PLL_COUNTER_DCO_PHYS COARSE_MUX[0] COARSE_MUX[10]
+ COARSE_MUX[11] COARSE_MUX[12] COARSE_MUX[13] COARSE_MUX[14]
+ COARSE_MUX[1] COARSE_MUX[2] COARSE_MUX[3] COARSE_MUX[4] COARSE_MUX[5]
+ COARSE_MUX[6] COARSE_MUX[7] COARSE_MUX[8] COARSE_MUX[9] DCO_EN
+ FINE_MUX[0] FINE_MUX[10] FINE_MUX[11] FINE_MUX[12] FINE_MUX[13]
+ FINE_MUX[14] FINE_MUX[15] FINE_MUX[16] FINE_MUX[17] FINE_MUX[18]
+ FINE_MUX[19] FINE_MUX[1] FINE_MUX[20] FINE_MUX[21] FINE_MUX[22]
+ FINE_MUX[23] FINE_MUX[24] FINE_MUX[25] FINE_MUX[26] FINE_MUX[27]
+ FINE_MUX[28] FINE_MUX[29] FINE_MUX[2] FINE_MUX[30] FINE_MUX[3]
+ FINE_MUX[4] FINE_MUX[5] FINE_MUX[6] FINE_MUX[7] FINE_MUX[8]
+ FINE_MUX[9] INJ_EDGE INJ_EN MID_MUX[0] MID_MUX[10] MID_MUX[11]
+ MID_MUX[12] MID_MUX[13] MID_MUX[14] MID_MUX[1] MID_MUX[2]
+ MID_MUX[3] MID_MUX[4] MID_MUX[5] MID_MUX[6] MID_MUX[7] MID_MUX[8]
+ MID_MUX[9] MID_OUT OUT REF SS_BBPD[0] SS_BBPD[1] TICK VPWR
+ VGND
X_348_ net18 VGND VGND VPWR VPWR _344_ sky130_fd_sc_hd__clkinv_1
X_349_ net29 VGND VGND VPWR VPWR _345_ sky130_fd_sc_hd__clkinv_1
X_350_ net53 VGND VGND VPWR VPWR _346_ sky130_fd_sc_hd__clkinv_1
X_351_ net57 VGND VGND VPWR VPWR _347_ sky130_fd_sc_hd__clkinv_1
X_352_ net55 VGND VGND VPWR VPWR _001_ sky130_fd_sc_hd__clkinv_1
X_353_ add_hi0.A\[1\] VGND VGND VPWR VPWR _002_ sky130_fd_sc_hd__clkinv_1
X_354_ add_hi0.A\[2\] VGND VGND VPWR VPWR _003_ sky130_fd_sc_hd__clkinv_1
X_355_ add_hi0.A\[3\] VGND VGND VPWR VPWR _004_ sky130_fd_sc_hd__clkinv_1
X_356_ net31 net20 VGND VGND VPWR VPWR _005_ sky130_fd_sc_hd__xnor2_1
X_357_ net38 _005_ VGND VGND VPWR VPWR _006_ sky130_fd_sc_hd__xnor2_1
X_358_ _006_ VGND VGND VPWR VPWR _007_ sky130_fd_sc_hd__clkinv_1
X_359_ net34 net32 net36 VGND VGND VPWR VPWR _008_ sky130_fd_sc_hd__xor3_1
X_360_ net27 net25 net30 VGND VGND VPWR VPWR _009_ sky130_fd_sc_hd__xor3_1
X_361_ net33 _008_ _009_ VGND VGND VPWR VPWR _010_ sky130_fd_sc_hd__xor3_1
X_362_ net26 net24 _010_ VGND VGND VPWR VPWR _011_ sky130_fd_sc_hd__xor3_1
X_363_ net21 net19 net23 VGND VGND VPWR VPWR _012_ sky130_fd_sc_hd__xor3_1
X_364_ net37 net35 _012_ VGND VGND VPWR VPWR _013_ sky130_fd_sc_hd__xnor3_1
X_365_ net45 net43 net47 VGND VGND VPWR VPWR _014_ sky130_fd_sc_hd__xor3_1
X_366_ net28 net17 net41 VGND VGND VPWR VPWR _015_ sky130_fd_sc_hd__xor3_1
X_367_ net40 _014_ _015_ VGND VGND VPWR VPWR _016_ sky130_fd_sc_hd__xnor3_1
X_368_ _345_ _013_ _016_ VGND VGND VPWR VPWR _017_ sky130_fd_sc_hd__xnor3_1
X_369_ net22 _011_ _017_ VGND VGND VPWR VPWR _018_ sky130_fd_sc_hd__xnor3_1
X_370_ _344_ _007_ _018_ VGND VGND VPWR VPWR _019_ sky130_fd_sc_hd__xnor3_1
X_371_ net44 net46 _019_ VGND VGND VPWR VPWR _020_ sky130_fd_sc_hd__xor3_1
X_372_ net42 _020_ VGND VGND VPWR VPWR _021_ sky130_fd_sc_hd__xor2_1
X_373_ net39 _021_ VGND VGND VPWR VPWR _022_ sky130_fd_sc_hd__xnor2_1
X_374_ add_lo.A\[0\] _022_ VGND VGND VPWR VPWR _023_ sky130_fd_sc_hd__nand2_1
X_375_ net42 net39 _020_ VGND VGND VPWR VPWR _024_ sky130_fd_sc_hd__maj3_1
X_376_ net44 net46 _019_ VGND VGND VPWR VPWR _025_ sky130_fd_sc_hd__maj3_1
X_377_ net31 net20 net38 VGND VGND VPWR VPWR _026_ sky130_fd_sc_hd__maj3_1
X_378_ _344_ _007_ _018_ VGND VGND VPWR VPWR _027_ sky130_fd_sc_hd__maj3_1
X_379_ _027_ VGND VGND VPWR VPWR _028_ sky130_fd_sc_hd__clkinv_1
X_380_ net34 net32 net36 VGND VGND VPWR VPWR _029_ sky130_fd_sc_hd__maj3_1
X_381_ net26 net24 _010_ VGND VGND VPWR VPWR _030_ sky130_fd_sc_hd__maj3_1
X_382_ _029_ _030_ VGND VGND VPWR VPWR _031_ sky130_fd_sc_hd__nand2_1
X_383_ _029_ _030_ VGND VGND VPWR VPWR _032_ sky130_fd_sc_hd__xor2_1
X_384_ net22 _011_ _017_ VGND VGND VPWR VPWR _033_ sky130_fd_sc_hd__maj3_1
X_385_ net33 _008_ _009_ VGND VGND VPWR VPWR _034_ sky130_fd_sc_hd__maj3_1
X_386_ net27 net25 net30 VGND VGND VPWR VPWR _035_ sky130_fd_sc_hd__maj3_1
X_387_ net37 net35 _012_ VGND VGND VPWR VPWR _036_ sky130_fd_sc_hd__maj3_1
X_388_ _034_ _035_ _036_ VGND VGND VPWR VPWR _037_ sky130_fd_sc_hd__xnor3_1
X_389_ _345_ _013_ _016_ VGND VGND VPWR VPWR _038_ sky130_fd_sc_hd__maj3_1
X_390_ net21 net19 net23 VGND VGND VPWR VPWR _039_ sky130_fd_sc_hd__maj3_1
X_391_ net45 net43 net47 VGND VGND VPWR VPWR _040_ sky130_fd_sc_hd__maj3_1
X_392_ _039_ _040_ VGND VGND VPWR VPWR _041_ sky130_fd_sc_hd__nand2_1
X_393_ _039_ _040_ VGND VGND VPWR VPWR _042_ sky130_fd_sc_hd__xnor2_1
X_394_ net40 _014_ _015_ VGND VGND VPWR VPWR _043_ sky130_fd_sc_hd__maj3_1
X_395_ net28 net17 net41 VGND VGND VPWR VPWR _044_ sky130_fd_sc_hd__maj3_1
X_396_ _043_ _044_ VGND VGND VPWR VPWR _045_ sky130_fd_sc_hd__xnor2_1
X_397_ _042_ _043_ _044_ VGND VGND VPWR VPWR _046_ sky130_fd_sc_hd__xor3_1
X_398_ _037_ _038_ _046_ VGND VGND VPWR VPWR _047_ sky130_fd_sc_hd__xnor3_1
X_399_ _032_ _033_ _047_ VGND VGND VPWR VPWR _048_ sky130_fd_sc_hd__xor3_1
X_400_ _026_ _027_ _048_ VGND VGND VPWR VPWR _049_ sky130_fd_sc_hd__xnor3_1
X_401_ _025_ _049_ VGND VGND VPWR VPWR _050_ sky130_fd_sc_hd__xor2_1
X_402_ _024_ _050_ VGND VGND VPWR VPWR _051_ sky130_fd_sc_hd__xnor2_1
X_403_ _022_ _051_ VGND VGND VPWR VPWR _052_ sky130_fd_sc_hd__nor2_1
X_404_ _022_ _051_ VGND VGND VPWR VPWR _053_ sky130_fd_sc_hd__xor2_1
X_405_ add_lo.A\[1\] _053_ VGND VGND VPWR VPWR _054_ sky130_fd_sc_hd__nand2_1
X_406_ add_lo.A\[1\] _053_ VGND VGND VPWR VPWR _055_ sky130_fd_sc_hd__xnor2_1
X_407_ _023_ _055_ VGND VGND VPWR VPWR add_lo.S\[1\] sky130_fd_sc_hd__xor2_1
X_408_ _023_ _055_ _054_ VGND VGND VPWR VPWR _056_ sky130_fd_sc_hd__o21ai_0
X_409_ _026_ _028_ _048_ VGND VGND VPWR VPWR _057_ sky130_fd_sc_hd__maj3_1
X_410_ _032_ _033_ _047_ VGND VGND VPWR VPWR _058_ sky130_fd_sc_hd__maj3_1
X_411_ _037_ _038_ _046_ VGND VGND VPWR VPWR _059_ sky130_fd_sc_hd__maj3_1
X_412_ _059_ VGND VGND VPWR VPWR _060_ sky130_fd_sc_hd__clkinv_1
X_413_ _041_ _043_ _044_ VGND VGND VPWR VPWR _061_ sky130_fd_sc_hd__and3b_1
X_414_ _043_ _044_ _041_ VGND VGND VPWR VPWR _062_ sky130_fd_sc_hd__a21boi_0
X_415_ _042_ _045_ _061_ _062_ VGND VGND VPWR VPWR _063_ sky130_fd_sc_hd__o22ai_1
X_416_ _059_ _063_ VGND VGND VPWR VPWR _064_ sky130_fd_sc_hd__xor2_1
X_417_ _034_ _035_ _036_ VGND VGND VPWR VPWR _065_ sky130_fd_sc_hd__maj3_1
X_418_ _064_ _065_ VGND VGND VPWR VPWR _066_ sky130_fd_sc_hd__xnor2_1
X_419_ _058_ _066_ VGND VGND VPWR VPWR _067_ sky130_fd_sc_hd__nand2_1
X_420_ _058_ _064_ _065_ VGND VGND VPWR VPWR _068_ sky130_fd_sc_hd__xor3_1
X_421_ _031_ _068_ VGND VGND VPWR VPWR _069_ sky130_fd_sc_hd__xnor2_1
X_422_ _057_ _069_ VGND VGND VPWR VPWR _070_ sky130_fd_sc_hd__lpflow_isobufsrc_1
X_423_ _057_ _069_ VGND VGND VPWR VPWR _071_ sky130_fd_sc_hd__xnor2_1
X_424_ _024_ _025_ _049_ VGND VGND VPWR VPWR _072_ sky130_fd_sc_hd__maj3_1
X_425_ _071_ _072_ VGND VGND VPWR VPWR _073_ sky130_fd_sc_hd__xnor2_1
X_426_ _051_ _073_ VGND VGND VPWR VPWR _074_ sky130_fd_sc_hd__and2_0
X_427_ _051_ _073_ VGND VGND VPWR VPWR _075_ sky130_fd_sc_hd__nand2_1
X_428_ _051_ _073_ VGND VGND VPWR VPWR _076_ sky130_fd_sc_hd__xor2_1
X_429_ net54 net48 net56 VGND VGND VPWR VPWR _077_ sky130_fd_sc_hd__xnor3_1
X_430_ net60 net58 net62 VGND VGND VPWR VPWR _078_ sky130_fd_sc_hd__xnor3_1
X_431_ _346_ _077_ _078_ VGND VGND VPWR VPWR _079_ sky130_fd_sc_hd__xnor3_1
X_432_ net50 net51 VGND VGND VPWR VPWR _080_ sky130_fd_sc_hd__xnor2_1
X_433_ net52 _080_ VGND VGND VPWR VPWR _081_ sky130_fd_sc_hd__xnor2_1
X_434_ net49 _079_ _081_ VGND VGND VPWR VPWR _082_ sky130_fd_sc_hd__xor3_1
X_435_ net59 net61 _082_ VGND VGND VPWR VPWR _083_ sky130_fd_sc_hd__xnor3_1
X_436_ net57 _083_ VGND VGND VPWR VPWR _084_ sky130_fd_sc_hd__xnor2_1
X_437_ net55 _084_ VGND VGND VPWR VPWR _085_ sky130_fd_sc_hd__xnor2_1
X_438_ _085_ VGND VGND VPWR VPWR _086_ sky130_fd_sc_hd__clkinv_1
X_439_ _022_ _085_ VGND VGND VPWR VPWR _087_ sky130_fd_sc_hd__xnor2_1
X_440_ _076_ _087_ VGND VGND VPWR VPWR _088_ sky130_fd_sc_hd__nor2_1
X_441_ _076_ _087_ VGND VGND VPWR VPWR _089_ sky130_fd_sc_hd__xor2_1
X_442_ _052_ _089_ VGND VGND VPWR VPWR _090_ sky130_fd_sc_hd__nand2_1
X_443_ _052_ _089_ VGND VGND VPWR VPWR _091_ sky130_fd_sc_hd__xor2_1
X_444_ _053_ _091_ VGND VGND VPWR VPWR _092_ sky130_fd_sc_hd__lpflow_inputiso1p_1
X_445_ _053_ _089_ _092_ VGND VGND VPWR VPWR _093_ sky130_fd_sc_hd__a21boi_0
X_446_ add_lo.A\[2\] _093_ VGND VGND VPWR VPWR _094_ sky130_fd_sc_hd__xnor2_1
X_447_ _056_ _094_ VGND VGND VPWR VPWR add_lo.S\[2\] sky130_fd_sc_hd__xnor2_1
X_448_ add_lo.A\[2\] _056_ _093_ VGND VGND VPWR VPWR _095_
+ sky130_fd_sc_hd__maj3_1
X_449_ net7 net1 VGND VGND VPWR VPWR _096_ sky130_fd_sc_hd__xor2_1
X_450_ net9 _096_ VGND VGND VPWR VPWR _097_ sky130_fd_sc_hd__xor2_1
X_451_ net6 _097_ VGND VGND VPWR VPWR _098_ sky130_fd_sc_hd__nand2_1
X_452_ net9 net6 _096_ VGND VGND VPWR VPWR _099_ sky130_fd_sc_hd__xnor3_1
X_453_ net13 net11 VGND VGND VPWR VPWR _100_ sky130_fd_sc_hd__xor2_1
X_454_ net15 _100_ VGND VGND VPWR VPWR _101_ sky130_fd_sc_hd__xnor2_1
X_455_ _099_ _101_ VGND VGND VPWR VPWR _102_ sky130_fd_sc_hd__xor2_1
X_456_ net2 _102_ VGND VGND VPWR VPWR _103_ sky130_fd_sc_hd__and2_0
X_457_ net2 _099_ _101_ VGND VGND VPWR VPWR _104_ sky130_fd_sc_hd__xnor3_1
X_458_ net3 net4 VGND VGND VPWR VPWR _105_ sky130_fd_sc_hd__xor2_1
X_459_ net5 _105_ VGND VGND VPWR VPWR _106_ sky130_fd_sc_hd__xnor2_1
X_460_ _104_ _106_ VGND VGND VPWR VPWR _107_ sky130_fd_sc_hd__nor2_1
X_461_ _104_ _106_ VGND VGND VPWR VPWR _108_ sky130_fd_sc_hd__xor2_1
X_462_ net12 _108_ VGND VGND VPWR VPWR _109_ sky130_fd_sc_hd__xnor2_1
X_463_ net14 _109_ VGND VGND VPWR VPWR _110_ sky130_fd_sc_hd__xnor2_1
X_464_ net10 _110_ VGND VGND VPWR VPWR _111_ sky130_fd_sc_hd__xor2_1
X_465_ net8 _111_ VGND VGND VPWR VPWR _112_ sky130_fd_sc_hd__xnor2_1
X_466_ _112_ VGND VGND VPWR VPWR _113_ sky130_fd_sc_hd__clkinv_1
X_467_ _347_ _001_ _083_ VGND VGND VPWR VPWR _114_ sky130_fd_sc_hd__maj3_1
X_468_ net59 net61 _082_ VGND VGND VPWR VPWR _115_ sky130_fd_sc_hd__maj3_1
X_469_ net50 net51 net52 VGND VGND VPWR VPWR _116_ sky130_fd_sc_hd__maj3_1
X_470_ net49 _079_ _081_ VGND VGND VPWR VPWR _117_ sky130_fd_sc_hd__maj3_1
X_471_ _346_ _077_ _078_ VGND VGND VPWR VPWR _118_ sky130_fd_sc_hd__maj3_1
X_472_ net54 net48 net56 VGND VGND VPWR VPWR _119_ sky130_fd_sc_hd__maj3_1
X_473_ _119_ VGND VGND VPWR VPWR _120_ sky130_fd_sc_hd__clkinv_1
X_474_ _118_ _120_ VGND VGND VPWR VPWR _121_ sky130_fd_sc_hd__nor2_1
X_475_ _118_ _120_ VGND VGND VPWR VPWR _122_ sky130_fd_sc_hd__nand2_1
X_476_ net60 net58 net62 VGND VGND VPWR VPWR _123_ sky130_fd_sc_hd__maj3_1
X_477_ _118_ _119_ _123_ VGND VGND VPWR VPWR _124_ sky130_fd_sc_hd__xnor3_1
X_478_ _116_ _117_ _124_ VGND VGND VPWR VPWR _125_ sky130_fd_sc_hd__xor3_1
X_479_ _115_ _125_ VGND VGND VPWR VPWR _126_ sky130_fd_sc_hd__nand2_1
X_480_ _115_ _125_ VGND VGND VPWR VPWR _127_ sky130_fd_sc_hd__xnor2_1
X_481_ _114_ _127_ VGND VGND VPWR VPWR _128_ sky130_fd_sc_hd__xnor2_1
X_482_ _085_ _128_ VGND VGND VPWR VPWR _129_ sky130_fd_sc_hd__and2_0
X_483_ _085_ _128_ VGND VGND VPWR VPWR _130_ sky130_fd_sc_hd__xnor2_1
X_484_ _022_ _130_ VGND VGND VPWR VPWR _131_ sky130_fd_sc_hd__nand2_1
X_485_ _022_ _128_ _131_ VGND VGND VPWR VPWR _132_ sky130_fd_sc_hd__o21a_1
X_486_ _071_ _072_ _070_ VGND VGND VPWR VPWR _133_ sky130_fd_sc_hd__a21o_1
X_487_ _031_ _068_ _067_ VGND VGND VPWR VPWR _134_ sky130_fd_sc_hd__o21ai_0
X_488_ _060_ _063_ _065_ VGND VGND VPWR VPWR _135_ sky130_fd_sc_hd__maj3_1
X_489_ _061_ _135_ VGND VGND VPWR VPWR _136_ sky130_fd_sc_hd__xnor2_1
X_490_ _134_ _136_ VGND VGND VPWR VPWR _137_ sky130_fd_sc_hd__xnor2_1
X_491_ _133_ _137_ VGND VGND VPWR VPWR _138_ sky130_fd_sc_hd__xnor2_1
X_492_ _076_ _138_ VGND VGND VPWR VPWR _139_ sky130_fd_sc_hd__xor2_1
X_493_ _076_ _132_ _138_ VGND VGND VPWR VPWR _140_ sky130_fd_sc_hd__xor3_1
X_494_ _076_ _087_ _140_ VGND VGND VPWR VPWR _141_ sky130_fd_sc_hd__nor3_1
X_495_ _076_ _087_ _140_ VGND VGND VPWR VPWR _142_ sky130_fd_sc_hd__o21ai_0
X_496_ _074_ _088_ _140_ VGND VGND VPWR VPWR _143_ sky130_fd_sc_hd__xnor3_1
X_497_ _090_ _112_ _143_ VGND VGND VPWR VPWR _144_ sky130_fd_sc_hd__xnor3_1
X_498_ _092_ _144_ VGND VGND VPWR VPWR _145_ sky130_fd_sc_hd__nand2b_1
X_499_ _092_ _144_ VGND VGND VPWR VPWR _146_ sky130_fd_sc_hd__xnor2_1
X_500_ add_lo.A\[3\] _146_ VGND VGND VPWR VPWR _147_ sky130_fd_sc_hd__xnor2_1
X_501_ _095_ _147_ VGND VGND VPWR VPWR add_lo.S\[3\] sky130_fd_sc_hd__xnor2_1
X_502_ add_lo.A\[3\] _095_ _146_ VGND VGND VPWR VPWR _148_
+ sky130_fd_sc_hd__maj3_1
X_503_ _090_ _113_ _143_ VGND VGND VPWR VPWR _149_ sky130_fd_sc_hd__maj3_1
X_504_ _149_ VGND VGND VPWR VPWR _150_ sky130_fd_sc_hd__clkinv_1
X_505_ _075_ _141_ _142_ VGND VGND VPWR VPWR _151_ sky130_fd_sc_hd__o21a_1
X_506_ _076_ _138_ _074_ VGND VGND VPWR VPWR _152_ sky130_fd_sc_hd__a21oi_1
X_507_ _086_ _131_ VGND VGND VPWR VPWR _153_ sky130_fd_sc_hd__nand2_1
X_508_ _153_ _139_ _132_ VGND VGND VPWR VPWR _154_ sky130_fd_sc_hd__mux2_1
X_509_ _022_ _130_ VGND VGND VPWR VPWR _155_ sky130_fd_sc_hd__nor2_1
X_510_ _114_ _127_ _126_ VGND VGND VPWR VPWR _156_ sky130_fd_sc_hd__o21ai_0
X_511_ _116_ _117_ _124_ VGND VGND VPWR VPWR _157_ sky130_fd_sc_hd__maj3_1
X_512_ _122_ _123_ _121_ VGND VGND VPWR VPWR _158_ sky130_fd_sc_hd__a21o_1
X_513_ _157_ _158_ VGND VGND VPWR VPWR _159_ sky130_fd_sc_hd__xor2_1
X_514_ _156_ _159_ VGND VGND VPWR VPWR _160_ sky130_fd_sc_hd__xnor2_1
X_515_ _129_ _160_ VGND VGND VPWR VPWR _161_ sky130_fd_sc_hd__xnor2_1
X_516_ _051_ _161_ VGND VGND VPWR VPWR _162_ sky130_fd_sc_hd__xor2_1
X_517_ _073_ _162_ VGND VGND VPWR VPWR _163_ sky130_fd_sc_hd__xnor2_1
X_518_ _155_ _163_ VGND VGND VPWR VPWR _164_ sky130_fd_sc_hd__xnor2_1
X_519_ net10 net8 _110_ VGND VGND VPWR VPWR _165_ sky130_fd_sc_hd__maj3_1
X_520_ _165_ VGND VGND VPWR VPWR _166_ sky130_fd_sc_hd__clkinv_1
X_521_ net12 net14 _108_ VGND VGND VPWR VPWR _167_ sky130_fd_sc_hd__maj3_1
X_522_ _167_ VGND VGND VPWR VPWR _168_ sky130_fd_sc_hd__clkinv_1
X_523_ _103_ _107_ VGND VGND VPWR VPWR _169_ sky130_fd_sc_hd__nor2_1
X_524_ _099_ _101_ _098_ VGND VGND VPWR VPWR _170_ sky130_fd_sc_hd__o21ai_0
X_525_ net7 net1 net9 VGND VGND VPWR VPWR _171_ sky130_fd_sc_hd__maj3_1
X_526_ _170_ _171_ VGND VGND VPWR VPWR _172_ sky130_fd_sc_hd__nand2_1
X_527_ _170_ _171_ VGND VGND VPWR VPWR _173_ sky130_fd_sc_hd__xor2_1
X_528_ net13 net11 net15 VGND VGND VPWR VPWR _174_ sky130_fd_sc_hd__maj3_1
X_529_ _173_ _174_ VGND VGND VPWR VPWR _175_ sky130_fd_sc_hd__nand2_1
X_530_ _173_ _174_ VGND VGND VPWR VPWR _176_ sky130_fd_sc_hd__xor2_1
X_531_ _103_ _107_ _176_ VGND VGND VPWR VPWR _177_ sky130_fd_sc_hd__o21ai_0
X_532_ _169_ _176_ VGND VGND VPWR VPWR _178_ sky130_fd_sc_hd__xnor2_1
X_533_ net3 net4 net5 VGND VGND VPWR VPWR _179_ sky130_fd_sc_hd__maj3_1
X_534_ _178_ _179_ VGND VGND VPWR VPWR _180_ sky130_fd_sc_hd__nand2_1
X_535_ _178_ _179_ VGND VGND VPWR VPWR _181_ sky130_fd_sc_hd__xnor2_1
X_536_ _166_ _167_ _181_ VGND VGND VPWR VPWR _182_ sky130_fd_sc_hd__xnor3_1
X_537_ _182_ VGND VGND VPWR VPWR _183_ sky130_fd_sc_hd__clkinv_1
X_538_ _061_ _134_ _135_ VGND VGND VPWR VPWR _184_ sky130_fd_sc_hd__maj3_1
X_539_ _133_ _137_ _184_ VGND VGND VPWR VPWR _185_ sky130_fd_sc_hd__a21oi_1
X_540_ _184_ _185_ _138_ VGND VGND VPWR VPWR _186_ sky130_fd_sc_hd__mux2i_1
X_541_ _183_ _186_ VGND VGND VPWR VPWR _187_ sky130_fd_sc_hd__and2_0
X_542_ _183_ _186_ VGND VGND VPWR VPWR _188_ sky130_fd_sc_hd__nor2_1
X_543_ _164_ _183_ _186_ VGND VGND VPWR VPWR _189_ sky130_fd_sc_hd__xnor3_1
X_544_ _154_ _189_ VGND VGND VPWR VPWR _190_ sky130_fd_sc_hd__nor2_1
X_545_ _154_ _189_ VGND VGND VPWR VPWR _191_ sky130_fd_sc_hd__nand2_1
X_546_ _152_ _154_ _189_ VGND VGND VPWR VPWR _192_ sky130_fd_sc_hd__xor3_1
X_547_ _151_ _192_ VGND VGND VPWR VPWR _193_ sky130_fd_sc_hd__nor2_1
X_548_ _193_ VGND VGND VPWR VPWR _194_ sky130_fd_sc_hd__clkinv_1
X_549_ _151_ _192_ VGND VGND VPWR VPWR _195_ sky130_fd_sc_hd__xnor2_1
X_550_ _149_ _195_ VGND VGND VPWR VPWR _196_ sky130_fd_sc_hd__xnor2_1
X_551_ _145_ _196_ VGND VGND VPWR VPWR _197_ sky130_fd_sc_hd__xnor2_1
X_552_ add_lo.A\[4\] _197_ VGND VGND VPWR VPWR _198_ sky130_fd_sc_hd__xnor2_1
X_553_ _148_ _198_ VGND VGND VPWR VPWR add_lo.S\[4\] sky130_fd_sc_hd__xnor2_1
X_554_ add_lo.A\[4\] _148_ _197_ VGND VGND VPWR VPWR _199_
+ sky130_fd_sc_hd__maj3_1
X_555_ _145_ _150_ _195_ VGND VGND VPWR VPWR _200_ sky130_fd_sc_hd__maj3_1
X_556_ _152_ _190_ _191_ VGND VGND VPWR VPWR _201_ sky130_fd_sc_hd__o21ai_0
X_557_ _138_ _185_ _187_ VGND VGND VPWR VPWR _202_ sky130_fd_sc_hd__a21oi_1
X_558_ _164_ _187_ _188_ _163_ _155_ VGND VGND VPWR VPWR _203_
+ sky130_fd_sc_hd__o32a_1
X_559_ _051_ _073_ _161_ VGND VGND VPWR VPWR _204_ sky130_fd_sc_hd__maj3_1
X_560_ _204_ VGND VGND VPWR VPWR _205_ sky130_fd_sc_hd__clkinv_1
X_561_ _156_ _157_ _158_ VGND VGND VPWR VPWR _206_ sky130_fd_sc_hd__maj3_1
X_562_ _129_ _160_ _206_ VGND VGND VPWR VPWR _207_ sky130_fd_sc_hd__a21bo_1
X_563_ _156_ _157_ _158_ VGND VGND VPWR VPWR _208_ sky130_fd_sc_hd__nor3_1
X_564_ _128_ _208_ VGND VGND VPWR VPWR _209_ sky130_fd_sc_hd__nand2_1
X_565_ _086_ _209_ _207_ VGND VGND VPWR VPWR _210_ sky130_fd_sc_hd__o21ai_0
X_566_ _073_ _210_ VGND VGND VPWR VPWR _211_ sky130_fd_sc_hd__xor2_1
X_567_ _138_ _211_ VGND VGND VPWR VPWR _212_ sky130_fd_sc_hd__xnor2_1
X_568_ _205_ _212_ VGND VGND VPWR VPWR _213_ sky130_fd_sc_hd__xnor2_1
X_569_ _166_ _168_ _181_ VGND VGND VPWR VPWR _214_ sky130_fd_sc_hd__maj3_1
X_570_ _172_ _175_ _177_ _180_ VGND VGND VPWR VPWR _215_ sky130_fd_sc_hd__a22o_1
X_571_ _172_ _175_ _177_ _180_ VGND VGND VPWR VPWR _216_ sky130_fd_sc_hd__and4_1
X_572_ _215_ _216_ VGND VGND VPWR VPWR _217_ sky130_fd_sc_hd__lpflow_isobufsrc_1
X_573_ _214_ _217_ VGND VGND VPWR VPWR _218_ sky130_fd_sc_hd__xor2_1
X_574_ _185_ _218_ VGND VGND VPWR VPWR _219_ sky130_fd_sc_hd__nor2_1
X_575_ _185_ _218_ VGND VGND VPWR VPWR _220_ sky130_fd_sc_hd__xor2_1
X_576_ _213_ _220_ VGND VGND VPWR VPWR _221_ sky130_fd_sc_hd__xnor2_1
X_577_ _203_ _221_ VGND VGND VPWR VPWR _222_ sky130_fd_sc_hd__xor2_1
X_578_ _202_ _222_ VGND VGND VPWR VPWR _223_ sky130_fd_sc_hd__xnor2_1
X_579_ _201_ _202_ _222_ VGND VGND VPWR VPWR _224_ sky130_fd_sc_hd__xor3_1
X_580_ _194_ _224_ VGND VGND VPWR VPWR _225_ sky130_fd_sc_hd__xnor2_1
X_581_ _200_ _225_ VGND VGND VPWR VPWR _226_ sky130_fd_sc_hd__xor2_1
X_582_ add_lo.A\[5\] _199_ _226_ VGND VGND VPWR VPWR add_lo.S\[5\]
+ sky130_fd_sc_hd__xor3_1
X_583_ add_lo.A\[5\] _199_ _226_ VGND VGND VPWR VPWR _227_
+ sky130_fd_sc_hd__maj3_1
X_584_ _202_ _203_ _221_ VGND VGND VPWR VPWR _228_ sky130_fd_sc_hd__maj3_1
X_585_ _205_ _212_ _220_ VGND VGND VPWR VPWR _229_ sky130_fd_sc_hd__maj3_1
X_586_ _073_ _138_ _210_ VGND VGND VPWR VPWR _230_ sky130_fd_sc_hd__maj3_1
X_587_ _128_ _208_ _086_ VGND VGND VPWR VPWR _231_ sky130_fd_sc_hd__a21oi_1
X_588_ _231_ VGND VGND VPWR VPWR _232_ sky130_fd_sc_hd__clkinv_1
X_589_ _138_ _185_ _231_ VGND VGND VPWR VPWR _233_ sky130_fd_sc_hd__xnor3_1
X_590_ _230_ _233_ VGND VGND VPWR VPWR _234_ sky130_fd_sc_hd__nand2_1
X_591_ _230_ _233_ VGND VGND VPWR VPWR _235_ sky130_fd_sc_hd__xnor2_1
X_592_ _214_ _215_ VGND VGND VPWR VPWR _236_ sky130_fd_sc_hd__nor2_1
X_593_ _214_ _216_ _236_ VGND VGND VPWR VPWR _237_ sky130_fd_sc_hd__a21o_1
X_594_ _235_ _237_ VGND VGND VPWR VPWR _238_ sky130_fd_sc_hd__xnor2_1
X_595_ _219_ _229_ _238_ VGND VGND VPWR VPWR _239_ sky130_fd_sc_hd__xor3_1
X_596_ _228_ _239_ VGND VGND VPWR VPWR _240_ sky130_fd_sc_hd__nor2_1
X_597_ _228_ _239_ VGND VGND VPWR VPWR _241_ sky130_fd_sc_hd__xor2_1
X_598_ _201_ _223_ _241_ VGND VGND VPWR VPWR _242_ sky130_fd_sc_hd__nand3_1
X_599_ _201_ _223_ _241_ VGND VGND VPWR VPWR _243_ sky130_fd_sc_hd__a21oi_1
X_600_ _242_ _243_ VGND VGND VPWR VPWR _244_ sky130_fd_sc_hd__lpflow_isobufsrc_1
X_601_ _194_ _200_ _224_ VGND VGND VPWR VPWR _245_ sky130_fd_sc_hd__maj3_1
X_602_ _244_ _245_ VGND VGND VPWR VPWR _246_ sky130_fd_sc_hd__xnor2_1
X_603_ add_lo.A\[6\] _246_ VGND VGND VPWR VPWR _247_ sky130_fd_sc_hd__xnor2_1
X_604_ _227_ _247_ VGND VGND VPWR VPWR add_lo.S\[6\] sky130_fd_sc_hd__xnor2_1
X_605_ add_lo.A\[6\] _227_ _246_ VGND VGND VPWR VPWR _248_
+ sky130_fd_sc_hd__maj3_1
X_606_ _235_ _237_ _234_ VGND VGND VPWR VPWR _249_ sky130_fd_sc_hd__o21ai_0
X_607_ _130_ _209_ VGND VGND VPWR VPWR _250_ sky130_fd_sc_hd__nand2_1
X_608_ _185_ _250_ VGND VGND VPWR VPWR _251_ sky130_fd_sc_hd__nor2_1
X_609_ _185_ _250_ VGND VGND VPWR VPWR _252_ sky130_fd_sc_hd__xor2_1
X_610_ _138_ _185_ _232_ VGND VGND VPWR VPWR _253_ sky130_fd_sc_hd__maj3_1
X_611_ _252_ _253_ VGND VGND VPWR VPWR _254_ sky130_fd_sc_hd__nor2b_1
X_612_ _252_ _253_ VGND VGND VPWR VPWR _255_ sky130_fd_sc_hd__xor2_1
X_613_ _214_ _215_ _113_ VGND VGND VPWR VPWR _256_ sky130_fd_sc_hd__o21ai_0
X_614_ _112_ _236_ VGND VGND VPWR VPWR _257_ sky130_fd_sc_hd__nand2_1
X_615_ _256_ _257_ VGND VGND VPWR VPWR _258_ sky130_fd_sc_hd__nand2_1
X_616_ _255_ _258_ VGND VGND VPWR VPWR _259_ sky130_fd_sc_hd__nor2_1
X_617_ _255_ _258_ VGND VGND VPWR VPWR _260_ sky130_fd_sc_hd__xnor2_1
X_618_ _260_ _249_ VGND VGND VPWR VPWR _261_ sky130_fd_sc_hd__lpflow_isobufsrc_1
X_619_ _249_ _260_ VGND VGND VPWR VPWR _262_ sky130_fd_sc_hd__xnor2_1
X_620_ _219_ _229_ _238_ VGND VGND VPWR VPWR _263_ sky130_fd_sc_hd__maj3_1
X_621_ _262_ _263_ VGND VGND VPWR VPWR _264_ sky130_fd_sc_hd__nor2_1
X_622_ _262_ _263_ VGND VGND VPWR VPWR _265_ sky130_fd_sc_hd__xor2_1
X_623_ _240_ _265_ VGND VGND VPWR VPWR _266_ sky130_fd_sc_hd__nand2_1
X_624_ _240_ _265_ VGND VGND VPWR VPWR _267_ sky130_fd_sc_hd__lpflow_inputiso1p_1
X_625_ _266_ _267_ VGND VGND VPWR VPWR _268_ sky130_fd_sc_hd__nand2_1
X_626_ _243_ _245_ _242_ VGND VGND VPWR VPWR _269_ sky130_fd_sc_hd__o21ai_0
X_627_ _268_ _269_ VGND VGND VPWR VPWR _270_ sky130_fd_sc_hd__xnor2_1
X_628_ add_lo.A\[7\] _270_ VGND VGND VPWR VPWR _271_ sky130_fd_sc_hd__xnor2_1
X_629_ _248_ _271_ VGND VGND VPWR VPWR add_lo.S\[7\] sky130_fd_sc_hd__xnor2_1
X_630_ add_lo.A\[0\] _022_ VGND VGND VPWR VPWR add_lo.S\[0\]
+ sky130_fd_sc_hd__xor2_1
X_631_ add_lo.A\[7\] _248_ _270_ VGND VGND VPWR VPWR _272_
+ sky130_fd_sc_hd__maj3_1
X_632_ _129_ _160_ _206_ VGND VGND VPWR VPWR _273_ sky130_fd_sc_hd__nand3_1
X_633_ _129_ _160_ _273_ VGND VGND VPWR VPWR _274_ sky130_fd_sc_hd__o21ai_0
X_634_ _251_ _274_ VGND VGND VPWR VPWR _275_ sky130_fd_sc_hd__xor2_1
X_635_ _183_ _257_ VGND VGND VPWR VPWR _276_ sky130_fd_sc_hd__xnor2_1
X_636_ _275_ _276_ VGND VGND VPWR VPWR _277_ sky130_fd_sc_hd__xnor2_1
X_637_ _254_ _259_ _277_ VGND VGND VPWR VPWR _278_ sky130_fd_sc_hd__or3_1
X_638_ _254_ _259_ _277_ VGND VGND VPWR VPWR _279_ sky130_fd_sc_hd__o21ai_0
X_639_ _278_ _279_ VGND VGND VPWR VPWR _280_ sky130_fd_sc_hd__and2_0
X_640_ _261_ _280_ VGND VGND VPWR VPWR _281_ sky130_fd_sc_hd__nor2_1
X_641_ _261_ _280_ VGND VGND VPWR VPWR _282_ sky130_fd_sc_hd__xnor2_1
X_642_ _262_ _263_ _282_ VGND VGND VPWR VPWR _283_ sky130_fd_sc_hd__nor3_1
X_643_ _264_ _282_ VGND VGND VPWR VPWR _284_ sky130_fd_sc_hd__xnor2_1
X_644_ _243_ _245_ _266_ _242_ VGND VGND VPWR VPWR _285_ sky130_fd_sc_hd__o211ai_1
X_645_ _267_ _284_ _285_ VGND VGND VPWR VPWR _286_ sky130_fd_sc_hd__nand3_1
X_646_ _267_ _285_ _284_ VGND VGND VPWR VPWR _287_ sky130_fd_sc_hd__a21o_1
X_647_ add_hi0.A\[0\] _286_ _287_ VGND VGND VPWR VPWR _288_
+ sky130_fd_sc_hd__nand3_1
X_648_ _286_ _287_ add_hi0.A\[0\] VGND VGND VPWR VPWR _289_
+ sky130_fd_sc_hd__a21o_1
X_649_ _288_ _289_ VGND VGND VPWR VPWR _290_ sky130_fd_sc_hd__nand2_1
X_650_ _290_ _272_ VGND VGND VPWR VPWR _291_ sky130_fd_sc_hd__nand2b_1
X_651_ _272_ _290_ VGND VGND VPWR VPWR hi_sum\[0\] sky130_fd_sc_hd__xnor2_1
X_652_ _251_ _274_ _276_ VGND VGND VPWR VPWR _292_ sky130_fd_sc_hd__maj3_1
X_653_ _112_ _182_ VGND VGND VPWR VPWR _293_ sky130_fd_sc_hd__nand2_1
X_654_ _215_ _293_ VGND VGND VPWR VPWR _294_ sky130_fd_sc_hd__nor2_1
X_655_ _218_ _294_ VGND VGND VPWR VPWR _295_ sky130_fd_sc_hd__nor2_1
X_656_ _207_ _295_ VGND VGND VPWR VPWR _296_ sky130_fd_sc_hd__lpflow_inputiso1p_1
X_657_ _207_ _295_ VGND VGND VPWR VPWR _297_ sky130_fd_sc_hd__xor2_1
X_658_ _292_ _297_ VGND VGND VPWR VPWR _298_ sky130_fd_sc_hd__nand2_1
X_659_ _292_ _297_ VGND VGND VPWR VPWR _299_ sky130_fd_sc_hd__xnor2_1
X_660_ _278_ _299_ VGND VGND VPWR VPWR _300_ sky130_fd_sc_hd__nand2_1
X_661_ _278_ _299_ VGND VGND VPWR VPWR _301_ sky130_fd_sc_hd__xor2_1
X_662_ _281_ _301_ VGND VGND VPWR VPWR _302_ sky130_fd_sc_hd__nand2_1
X_663_ _281_ _301_ VGND VGND VPWR VPWR _303_ sky130_fd_sc_hd__xnor2_1
X_664_ _267_ _284_ _285_ _283_ VGND VGND VPWR VPWR _304_ sky130_fd_sc_hd__a31oi_1
X_665_ _303_ _304_ VGND VGND VPWR VPWR _305_ sky130_fd_sc_hd__xnor2_1
X_666_ add_hi0.A\[1\] _305_ VGND VGND VPWR VPWR _306_ sky130_fd_sc_hd__xnor2_1
X_667_ _306_ VGND VGND VPWR VPWR _307_ sky130_fd_sc_hd__clkinv_1
X_668_ _288_ _291_ _307_ VGND VGND VPWR VPWR _308_ sky130_fd_sc_hd__nand3_1
X_669_ _288_ _291_ _307_ VGND VGND VPWR VPWR _309_ sky130_fd_sc_hd__a21oi_1
X_670_ _308_ _309_ VGND VGND VPWR VPWR hi_sum\[1\] sky130_fd_sc_hd__lpflow_isobufsrc_1
X_671_ _214_ _216_ _236_ _293_ VGND VGND VPWR VPWR _310_ sky130_fd_sc_hd__a22o_1
X_672_ _296_ _310_ VGND VGND VPWR VPWR _311_ sky130_fd_sc_hd__nor2_1
X_673_ _296_ _310_ VGND VGND VPWR VPWR _312_ sky130_fd_sc_hd__xor2_1
X_674_ _292_ _297_ _312_ VGND VGND VPWR VPWR _313_ sky130_fd_sc_hd__a21oi_1
X_675_ _298_ _310_ _313_ VGND VGND VPWR VPWR _314_ sky130_fd_sc_hd__o21bai_1
X_676_ _300_ _314_ VGND VGND VPWR VPWR _315_ sky130_fd_sc_hd__nor2_1
X_677_ _300_ _314_ VGND VGND VPWR VPWR _316_ sky130_fd_sc_hd__xor2_1
X_678_ _303_ _304_ _302_ VGND VGND VPWR VPWR _317_ sky130_fd_sc_hd__o21ai_0
X_679_ _316_ _317_ VGND VGND VPWR VPWR _318_ sky130_fd_sc_hd__xnor2_1
X_680_ add_hi0.A\[2\] _318_ VGND VGND VPWR VPWR _319_ sky130_fd_sc_hd__xnor2_1
X_681_ _002_ _288_ _305_ VGND VGND VPWR VPWR _320_ sky130_fd_sc_hd__maj3_1
X_682_ _319_ _320_ VGND VGND VPWR VPWR _321_ sky130_fd_sc_hd__xor2_1
X_683_ _291_ _307_ VGND VGND VPWR VPWR _322_ sky130_fd_sc_hd__lpflow_inputiso1p_1
X_684_ _321_ _322_ VGND VGND VPWR VPWR _323_ sky130_fd_sc_hd__nor2_1
X_685_ _321_ _322_ VGND VGND VPWR VPWR hi_sum\[2\] sky130_fd_sc_hd__xor2_1
X_686_ _003_ _318_ _320_ VGND VGND VPWR VPWR _324_ sky130_fd_sc_hd__maj3_1
X_687_ _316_ _317_ _315_ VGND VGND VPWR VPWR _325_ sky130_fd_sc_hd__a21o_1
X_688_ _236_ _293_ _311_ VGND VGND VPWR VPWR _326_ sky130_fd_sc_hd__a21oi_1
X_689_ _313_ _326_ VGND VGND VPWR VPWR _327_ sky130_fd_sc_hd__xnor2_1
X_690_ _325_ _327_ VGND VGND VPWR VPWR _328_ sky130_fd_sc_hd__xnor2_1
X_691_ add_hi0.A\[3\] _324_ _328_ VGND VGND VPWR VPWR _329_
+ sky130_fd_sc_hd__xnor3_1
X_692_ _321_ _322_ _329_ VGND VGND VPWR VPWR _330_ sky130_fd_sc_hd__nor3_1
X_693_ _323_ _329_ VGND VGND VPWR VPWR hi_sum\[3\] sky130_fd_sc_hd__xnor2_1
X_694_ _004_ _324_ _328_ VGND VGND VPWR VPWR _331_ sky130_fd_sc_hd__maj3_1
X_695_ add_hi0.A\[4\] _331_ VGND VGND VPWR VPWR _332_ sky130_fd_sc_hd__lpflow_isobufsrc_1
X_696_ add_hi0.A\[4\] _331_ VGND VGND VPWR VPWR _333_ sky130_fd_sc_hd__xnor2_1
X_697_ _330_ _333_ VGND VGND VPWR VPWR _334_ sky130_fd_sc_hd__and2_0
X_698_ _330_ _333_ VGND VGND VPWR VPWR _335_ sky130_fd_sc_hd__nor2_1
X_699_ _334_ _335_ VGND VGND VPWR VPWR hi_sum\[4\] sky130_fd_sc_hd__nor2_1
X_700_ _332_ _334_ VGND VGND VPWR VPWR _336_ sky130_fd_sc_hd__nor2_1
X_701_ _332_ _334_ add_hi0.A\[5\] VGND VGND VPWR VPWR _337_
+ sky130_fd_sc_hd__o21ai_0
X_702_ add_hi0.A\[5\] _336_ VGND VGND VPWR VPWR hi_sum\[5\]
+ sky130_fd_sc_hd__xnor2_1
X_703_ add_hi0.A\[5\] add_hi0.A\[6\] VGND VGND VPWR VPWR _338_
+ sky130_fd_sc_hd__and2_0
X_704_ _334_ _338_ VGND VGND VPWR VPWR _339_ sky130_fd_sc_hd__nand2_1
X_705_ add_hi0.A\[6\] _337_ VGND VGND VPWR VPWR hi_sum\[6\]
+ sky130_fd_sc_hd__xnor2_1
X_706_ add_hi0.A\[7\] _332_ _338_ VGND VGND VPWR VPWR _340_
+ sky130_fd_sc_hd__and3_1
X_707_ _332_ _338_ add_hi0.A\[7\] VGND VGND VPWR VPWR _341_
+ sky130_fd_sc_hd__a21o_1
X_708_ _340_ _341_ VGND VGND VPWR VPWR _342_ sky130_fd_sc_hd__nor2b_1
X_709_ _339_ _342_ VGND VGND VPWR VPWR hi_sum\[7\] sky130_fd_sc_hd__xnor2_1
X_710_ _334_ _338_ _341_ _340_ VGND VGND VPWR VPWR _343_ sky130_fd_sc_hd__a31oi_1
X_711_ net64 _343_ VGND VGND VPWR VPWR _000_ sky130_fd_sc_hd__xnor2_1
X_712_ TICK _000_ net16 VGND VGND VPWR VPWR net64 sky130_fd_sc_hd__dfrtp_1
X_713_ TICK add_lo.S\[0\] net16 VGND VGND VPWR VPWR add_lo.A\[0\]
+ sky130_fd_sc_hd__dfrtp_1
X_714_ TICK add_lo.S\[1\] net16 VGND VGND VPWR VPWR add_lo.A\[1\]
+ sky130_fd_sc_hd__dfrtp_1
X_715_ TICK add_lo.S\[2\] net16 VGND VGND VPWR VPWR add_lo.A\[2\]
+ sky130_fd_sc_hd__dfrtp_1
X_716_ TICK add_lo.S\[3\] net16 VGND VGND VPWR VPWR add_lo.A\[3\]
+ sky130_fd_sc_hd__dfrtp_1
X_717_ TICK add_lo.S\[4\] net16 VGND VGND VPWR VPWR add_lo.A\[4\]
+ sky130_fd_sc_hd__dfrtp_1
X_718_ TICK add_lo.S\[5\] net16 VGND VGND VPWR VPWR add_lo.A\[5\]
+ sky130_fd_sc_hd__dfrtp_1
X_719_ TICK add_lo.S\[6\] net16 VGND VGND VPWR VPWR add_lo.A\[6\]
+ sky130_fd_sc_hd__dfrtp_1
X_720_ TICK add_lo.S\[7\] net16 VGND VGND VPWR VPWR add_lo.A\[7\]
+ sky130_fd_sc_hd__dfrtp_1
X_721_ TICK hi_sum\[0\] net16 VGND VGND VPWR VPWR add_hi0.A\[0\]
+ sky130_fd_sc_hd__dfrtp_1
X_722_ TICK hi_sum\[1\] net16 VGND VGND VPWR VPWR add_hi0.A\[1\]
+ sky130_fd_sc_hd__dfrtp_1
X_723_ TICK hi_sum\[2\] net16 VGND VGND VPWR VPWR add_hi0.A\[2\]
+ sky130_fd_sc_hd__dfrtp_1
X_724_ TICK hi_sum\[3\] net16 VGND VGND VPWR VPWR add_hi0.A\[3\]
+ sky130_fd_sc_hd__dfrtp_1
X_725_ TICK hi_sum\[4\] net16 VGND VGND VPWR VPWR add_hi0.A\[4\]
+ sky130_fd_sc_hd__dfrtp_1
X_726_ TICK hi_sum\[5\] net16 VGND VGND VPWR VPWR add_hi0.A\[5\]
+ sky130_fd_sc_hd__dfrtp_1
X_727_ TICK hi_sum\[6\] net16 VGND VGND VPWR VPWR add_hi0.A\[6\]
+ sky130_fd_sc_hd__dfrtp_1
X_728_ TICK hi_sum\[7\] net16 VGND VGND VPWR VPWR add_hi0.A\[7\]
+ sky130_fd_sc_hd__dfrtp_1
X_729_ REF VGND VGND VPWR VPWR net63 sky130_fd_sc_hd__buf_2
X_730_ net64 VGND VGND VPWR VPWR net65 sky130_fd_sc_hd__buf_2
X_731_ bbpd.buf_nand_y.Z VGND VGND VPWR VPWR net66 sky130_fd_sc_hd__buf_2
X_732_ bbpd.buf_nand_x.Z VGND VGND VPWR VPWR net67 sky130_fd_sc_hd__buf_2
Xbbpd.buf_nand_x.impl bbpd.OUT_NANDX VGND VGND VPWR VPWR bbpd.buf_nand_x.Z
+ sky130_fd_sc_hd__buf_2
Xbbpd.buf_nand_y.impl bbpd.OUT_NANDY VGND VGND VPWR VPWR bbpd.buf_nand_y.Z
+ sky130_fd_sc_hd__buf_2
Xbbpd.nand_x.impl net64 bbpd.OUT_NANDY VGND VGND VPWR VPWR
+ bbpd.OUT_NANDX sky130_fd_sc_hd__nand2_2
Xbbpd.nand_y.impl REF bbpd.OUT_NANDX VGND VGND VPWR VPWR bbpd.OUT_NANDY
+ sky130_fd_sc_hd__nand2_2
XPHY_EDGE_ROW_0_Right_0 VGND VPWR sky130_fd_sc_hd__tapvpwrvgnd_1
XPHY_EDGE_ROW_1_Right_1 VGND VPWR sky130_fd_sc_hd__tapvpwrvgnd_1
XPHY_EDGE_ROW_2_Right_2 VGND VPWR sky130_fd_sc_hd__tapvpwrvgnd_1
XPHY_EDGE_ROW_3_Right_3 VGND VPWR sky130_fd_sc_hd__tapvpwrvgnd_1
XPHY_EDGE_ROW_4_Right_4 VGND VPWR sky130_fd_sc_hd__tapvpwrvgnd_1
XPHY_EDGE_ROW_5_Right_5 VGND VPWR sky130_fd_sc_hd__tapvpwrvgnd_1
XPHY_EDGE_ROW_6_Right_6 VGND VPWR sky130_fd_sc_hd__tapvpwrvgnd_1
XPHY_EDGE_ROW_7_Right_7 VGND VPWR sky130_fd_sc_hd__tapvpwrvgnd_1
XPHY_EDGE_ROW_8_Right_8 VGND VPWR sky130_fd_sc_hd__tapvpwrvgnd_1
XPHY_EDGE_ROW_9_Right_9 VGND VPWR sky130_fd_sc_hd__tapvpwrvgnd_1
XPHY_EDGE_ROW_10_Right_10 VGND VPWR sky130_fd_sc_hd__tapvpwrvgnd_1
XPHY_EDGE_ROW_11_Right_11 VGND VPWR sky130_fd_sc_hd__tapvpwrvgnd_1
XPHY_EDGE_ROW_12_Right_12 VGND VPWR sky130_fd_sc_hd__tapvpwrvgnd_1
XPHY_EDGE_ROW_13_Right_13 VGND VPWR sky130_fd_sc_hd__tapvpwrvgnd_1
XPHY_EDGE_ROW_14_Right_14 VGND VPWR sky130_fd_sc_hd__tapvpwrvgnd_1
XPHY_EDGE_ROW_15_Right_15 VGND VPWR sky130_fd_sc_hd__tapvpwrvgnd_1
XPHY_EDGE_ROW_16_Right_16 VGND VPWR sky130_fd_sc_hd__tapvpwrvgnd_1
XPHY_EDGE_ROW_17_Right_17 VGND VPWR sky130_fd_sc_hd__tapvpwrvgnd_1
XPHY_EDGE_ROW_18_Right_18 VGND VPWR sky130_fd_sc_hd__tapvpwrvgnd_1
XPHY_EDGE_ROW_19_Right_19 VGND VPWR sky130_fd_sc_hd__tapvpwrvgnd_1
XPHY_EDGE_ROW_20_Right_20 VGND VPWR sky130_fd_sc_hd__tapvpwrvgnd_1
XPHY_EDGE_ROW_21_Right_21 VGND VPWR sky130_fd_sc_hd__tapvpwrvgnd_1
XPHY_EDGE_ROW_22_Right_22 VGND VPWR sky130_fd_sc_hd__tapvpwrvgnd_1
XPHY_EDGE_ROW_23_Right_23 VGND VPWR sky130_fd_sc_hd__tapvpwrvgnd_1
XPHY_EDGE_ROW_24_Right_24 VGND VPWR sky130_fd_sc_hd__tapvpwrvgnd_1
XPHY_EDGE_ROW_25_Right_25 VGND VPWR sky130_fd_sc_hd__tapvpwrvgnd_1
XPHY_EDGE_ROW_26_Right_26 VGND VPWR sky130_fd_sc_hd__tapvpwrvgnd_1
XPHY_EDGE_ROW_27_Right_27 VGND VPWR sky130_fd_sc_hd__tapvpwrvgnd_1
XPHY_EDGE_ROW_28_Right_28 VGND VPWR sky130_fd_sc_hd__tapvpwrvgnd_1
XPHY_EDGE_ROW_29_Right_29 VGND VPWR sky130_fd_sc_hd__tapvpwrvgnd_1
XPHY_EDGE_ROW_30_Right_30 VGND VPWR sky130_fd_sc_hd__tapvpwrvgnd_1
XPHY_EDGE_ROW_31_Right_31 VGND VPWR sky130_fd_sc_hd__tapvpwrvgnd_1
XPHY_EDGE_ROW_32_Right_32 VGND VPWR sky130_fd_sc_hd__tapvpwrvgnd_1
XPHY_EDGE_ROW_33_Right_33 VGND VPWR sky130_fd_sc_hd__tapvpwrvgnd_1
XPHY_EDGE_ROW_34_Right_34 VGND VPWR sky130_fd_sc_hd__tapvpwrvgnd_1
XPHY_EDGE_ROW_35_Right_35 VGND VPWR sky130_fd_sc_hd__tapvpwrvgnd_1
XPHY_EDGE_ROW_36_Right_36 VGND VPWR sky130_fd_sc_hd__tapvpwrvgnd_1
XPHY_EDGE_ROW_37_Right_37 VGND VPWR sky130_fd_sc_hd__tapvpwrvgnd_1
XPHY_EDGE_ROW_38_Right_38 VGND VPWR sky130_fd_sc_hd__tapvpwrvgnd_1
XPHY_EDGE_ROW_39_Right_39 VGND VPWR sky130_fd_sc_hd__tapvpwrvgnd_1
XPHY_EDGE_ROW_40_Right_40 VGND VPWR sky130_fd_sc_hd__tapvpwrvgnd_1
XPHY_EDGE_ROW_41_Right_41 VGND VPWR sky130_fd_sc_hd__tapvpwrvgnd_1
XPHY_EDGE_ROW_42_Right_42 VGND VPWR sky130_fd_sc_hd__tapvpwrvgnd_1
XPHY_EDGE_ROW_43_Right_43 VGND VPWR sky130_fd_sc_hd__tapvpwrvgnd_1
XPHY_EDGE_ROW_0_Left_44 VGND VPWR sky130_fd_sc_hd__tapvpwrvgnd_1
XPHY_EDGE_ROW_1_Left_45 VGND VPWR sky130_fd_sc_hd__tapvpwrvgnd_1
XPHY_EDGE_ROW_2_Left_46 VGND VPWR sky130_fd_sc_hd__tapvpwrvgnd_1
XPHY_EDGE_ROW_3_Left_47 VGND VPWR sky130_fd_sc_hd__tapvpwrvgnd_1
XPHY_EDGE_ROW_4_Left_48 VGND VPWR sky130_fd_sc_hd__tapvpwrvgnd_1
XPHY_EDGE_ROW_5_Left_49 VGND VPWR sky130_fd_sc_hd__tapvpwrvgnd_1
XPHY_EDGE_ROW_6_Left_50 VGND VPWR sky130_fd_sc_hd__tapvpwrvgnd_1
XPHY_EDGE_ROW_7_Left_51 VGND VPWR sky130_fd_sc_hd__tapvpwrvgnd_1
XPHY_EDGE_ROW_8_Left_52 VGND VPWR sky130_fd_sc_hd__tapvpwrvgnd_1
XPHY_EDGE_ROW_9_Left_53 VGND VPWR sky130_fd_sc_hd__tapvpwrvgnd_1
XPHY_EDGE_ROW_10_Left_54 VGND VPWR sky130_fd_sc_hd__tapvpwrvgnd_1
XPHY_EDGE_ROW_11_Left_55 VGND VPWR sky130_fd_sc_hd__tapvpwrvgnd_1
XPHY_EDGE_ROW_12_Left_56 VGND VPWR sky130_fd_sc_hd__tapvpwrvgnd_1
XPHY_EDGE_ROW_13_Left_57 VGND VPWR sky130_fd_sc_hd__tapvpwrvgnd_1
XPHY_EDGE_ROW_14_Left_58 VGND VPWR sky130_fd_sc_hd__tapvpwrvgnd_1
XPHY_EDGE_ROW_15_Left_59 VGND VPWR sky130_fd_sc_hd__tapvpwrvgnd_1
XPHY_EDGE_ROW_16_Left_60 VGND VPWR sky130_fd_sc_hd__tapvpwrvgnd_1
XPHY_EDGE_ROW_17_Left_61 VGND VPWR sky130_fd_sc_hd__tapvpwrvgnd_1
XPHY_EDGE_ROW_18_Left_62 VGND VPWR sky130_fd_sc_hd__tapvpwrvgnd_1
XPHY_EDGE_ROW_19_Left_63 VGND VPWR sky130_fd_sc_hd__tapvpwrvgnd_1
XPHY_EDGE_ROW_20_Left_64 VGND VPWR sky130_fd_sc_hd__tapvpwrvgnd_1
XPHY_EDGE_ROW_21_Left_65 VGND VPWR sky130_fd_sc_hd__tapvpwrvgnd_1
XPHY_EDGE_ROW_22_Left_66 VGND VPWR sky130_fd_sc_hd__tapvpwrvgnd_1
XPHY_EDGE_ROW_23_Left_67 VGND VPWR sky130_fd_sc_hd__tapvpwrvgnd_1
XPHY_EDGE_ROW_24_Left_68 VGND VPWR sky130_fd_sc_hd__tapvpwrvgnd_1
XPHY_EDGE_ROW_25_Left_69 VGND VPWR sky130_fd_sc_hd__tapvpwrvgnd_1
XPHY_EDGE_ROW_26_Left_70 VGND VPWR sky130_fd_sc_hd__tapvpwrvgnd_1
XPHY_EDGE_ROW_27_Left_71 VGND VPWR sky130_fd_sc_hd__tapvpwrvgnd_1
XPHY_EDGE_ROW_28_Left_72 VGND VPWR sky130_fd_sc_hd__tapvpwrvgnd_1
XPHY_EDGE_ROW_29_Left_73 VGND VPWR sky130_fd_sc_hd__tapvpwrvgnd_1
XPHY_EDGE_ROW_30_Left_74 VGND VPWR sky130_fd_sc_hd__tapvpwrvgnd_1
XPHY_EDGE_ROW_31_Left_75 VGND VPWR sky130_fd_sc_hd__tapvpwrvgnd_1
XPHY_EDGE_ROW_32_Left_76 VGND VPWR sky130_fd_sc_hd__tapvpwrvgnd_1
XPHY_EDGE_ROW_33_Left_77 VGND VPWR sky130_fd_sc_hd__tapvpwrvgnd_1
XPHY_EDGE_ROW_34_Left_78 VGND VPWR sky130_fd_sc_hd__tapvpwrvgnd_1
XPHY_EDGE_ROW_35_Left_79 VGND VPWR sky130_fd_sc_hd__tapvpwrvgnd_1
XPHY_EDGE_ROW_36_Left_80 VGND VPWR sky130_fd_sc_hd__tapvpwrvgnd_1
XPHY_EDGE_ROW_37_Left_81 VGND VPWR sky130_fd_sc_hd__tapvpwrvgnd_1
XPHY_EDGE_ROW_38_Left_82 VGND VPWR sky130_fd_sc_hd__tapvpwrvgnd_1
XPHY_EDGE_ROW_39_Left_83 VGND VPWR sky130_fd_sc_hd__tapvpwrvgnd_1
XPHY_EDGE_ROW_40_Left_84 VGND VPWR sky130_fd_sc_hd__tapvpwrvgnd_1
XPHY_EDGE_ROW_41_Left_85 VGND VPWR sky130_fd_sc_hd__tapvpwrvgnd_1
XPHY_EDGE_ROW_42_Left_86 VGND VPWR sky130_fd_sc_hd__tapvpwrvgnd_1
XPHY_EDGE_ROW_43_Left_87 VGND VPWR sky130_fd_sc_hd__tapvpwrvgnd_1
XTAP_TAPCELL_ROW_0_88 VGND VPWR sky130_fd_sc_hd__tapvpwrvgnd_1
XTAP_TAPCELL_ROW_0_89 VGND VPWR sky130_fd_sc_hd__tapvpwrvgnd_1
XTAP_TAPCELL_ROW_0_90 VGND VPWR sky130_fd_sc_hd__tapvpwrvgnd_1
XTAP_TAPCELL_ROW_0_91 VGND VPWR sky130_fd_sc_hd__tapvpwrvgnd_1
XTAP_TAPCELL_ROW_0_92 VGND VPWR sky130_fd_sc_hd__tapvpwrvgnd_1
XTAP_TAPCELL_ROW_0_93 VGND VPWR sky130_fd_sc_hd__tapvpwrvgnd_1
XTAP_TAPCELL_ROW_1_94 VGND VPWR sky130_fd_sc_hd__tapvpwrvgnd_1
XTAP_TAPCELL_ROW_1_95 VGND VPWR sky130_fd_sc_hd__tapvpwrvgnd_1
XTAP_TAPCELL_ROW_1_96 VGND VPWR sky130_fd_sc_hd__tapvpwrvgnd_1
XTAP_TAPCELL_ROW_2_97 VGND VPWR sky130_fd_sc_hd__tapvpwrvgnd_1
XTAP_TAPCELL_ROW_2_98 VGND VPWR sky130_fd_sc_hd__tapvpwrvgnd_1
XTAP_TAPCELL_ROW_2_99 VGND VPWR sky130_fd_sc_hd__tapvpwrvgnd_1
XTAP_TAPCELL_ROW_3_100 VGND VPWR sky130_fd_sc_hd__tapvpwrvgnd_1
XTAP_TAPCELL_ROW_3_101 VGND VPWR sky130_fd_sc_hd__tapvpwrvgnd_1
XTAP_TAPCELL_ROW_3_102 VGND VPWR sky130_fd_sc_hd__tapvpwrvgnd_1
XTAP_TAPCELL_ROW_4_103 VGND VPWR sky130_fd_sc_hd__tapvpwrvgnd_1
XTAP_TAPCELL_ROW_4_104 VGND VPWR sky130_fd_sc_hd__tapvpwrvgnd_1
XTAP_TAPCELL_ROW_4_105 VGND VPWR sky130_fd_sc_hd__tapvpwrvgnd_1
XTAP_TAPCELL_ROW_5_106 VGND VPWR sky130_fd_sc_hd__tapvpwrvgnd_1
XTAP_TAPCELL_ROW_5_107 VGND VPWR sky130_fd_sc_hd__tapvpwrvgnd_1
XTAP_TAPCELL_ROW_5_108 VGND VPWR sky130_fd_sc_hd__tapvpwrvgnd_1
XTAP_TAPCELL_ROW_6_109 VGND VPWR sky130_fd_sc_hd__tapvpwrvgnd_1
XTAP_TAPCELL_ROW_6_110 VGND VPWR sky130_fd_sc_hd__tapvpwrvgnd_1
XTAP_TAPCELL_ROW_6_111 VGND VPWR sky130_fd_sc_hd__tapvpwrvgnd_1
XTAP_TAPCELL_ROW_7_112 VGND VPWR sky130_fd_sc_hd__tapvpwrvgnd_1
XTAP_TAPCELL_ROW_7_113 VGND VPWR sky130_fd_sc_hd__tapvpwrvgnd_1
XTAP_TAPCELL_ROW_7_114 VGND VPWR sky130_fd_sc_hd__tapvpwrvgnd_1
XTAP_TAPCELL_ROW_8_115 VGND VPWR sky130_fd_sc_hd__tapvpwrvgnd_1
XTAP_TAPCELL_ROW_8_116 VGND VPWR sky130_fd_sc_hd__tapvpwrvgnd_1
XTAP_TAPCELL_ROW_8_117 VGND VPWR sky130_fd_sc_hd__tapvpwrvgnd_1
XTAP_TAPCELL_ROW_9_118 VGND VPWR sky130_fd_sc_hd__tapvpwrvgnd_1
XTAP_TAPCELL_ROW_9_119 VGND VPWR sky130_fd_sc_hd__tapvpwrvgnd_1
XTAP_TAPCELL_ROW_9_120 VGND VPWR sky130_fd_sc_hd__tapvpwrvgnd_1
XTAP_TAPCELL_ROW_10_121 VGND VPWR sky130_fd_sc_hd__tapvpwrvgnd_1
XTAP_TAPCELL_ROW_10_122 VGND VPWR sky130_fd_sc_hd__tapvpwrvgnd_1
XTAP_TAPCELL_ROW_10_123 VGND VPWR sky130_fd_sc_hd__tapvpwrvgnd_1
XTAP_TAPCELL_ROW_11_124 VGND VPWR sky130_fd_sc_hd__tapvpwrvgnd_1
XTAP_TAPCELL_ROW_11_125 VGND VPWR sky130_fd_sc_hd__tapvpwrvgnd_1
XTAP_TAPCELL_ROW_11_126 VGND VPWR sky130_fd_sc_hd__tapvpwrvgnd_1
XTAP_TAPCELL_ROW_12_127 VGND VPWR sky130_fd_sc_hd__tapvpwrvgnd_1
XTAP_TAPCELL_ROW_12_128 VGND VPWR sky130_fd_sc_hd__tapvpwrvgnd_1
XTAP_TAPCELL_ROW_12_129 VGND VPWR sky130_fd_sc_hd__tapvpwrvgnd_1
XTAP_TAPCELL_ROW_13_130 VGND VPWR sky130_fd_sc_hd__tapvpwrvgnd_1
XTAP_TAPCELL_ROW_13_131 VGND VPWR sky130_fd_sc_hd__tapvpwrvgnd_1
XTAP_TAPCELL_ROW_13_132 VGND VPWR sky130_fd_sc_hd__tapvpwrvgnd_1
XTAP_TAPCELL_ROW_14_133 VGND VPWR sky130_fd_sc_hd__tapvpwrvgnd_1
XTAP_TAPCELL_ROW_14_134 VGND VPWR sky130_fd_sc_hd__tapvpwrvgnd_1
XTAP_TAPCELL_ROW_14_135 VGND VPWR sky130_fd_sc_hd__tapvpwrvgnd_1
XTAP_TAPCELL_ROW_15_136 VGND VPWR sky130_fd_sc_hd__tapvpwrvgnd_1
XTAP_TAPCELL_ROW_15_137 VGND VPWR sky130_fd_sc_hd__tapvpwrvgnd_1
XTAP_TAPCELL_ROW_15_138 VGND VPWR sky130_fd_sc_hd__tapvpwrvgnd_1
XTAP_TAPCELL_ROW_16_139 VGND VPWR sky130_fd_sc_hd__tapvpwrvgnd_1
XTAP_TAPCELL_ROW_16_140 VGND VPWR sky130_fd_sc_hd__tapvpwrvgnd_1
XTAP_TAPCELL_ROW_16_141 VGND VPWR sky130_fd_sc_hd__tapvpwrvgnd_1
XTAP_TAPCELL_ROW_17_142 VGND VPWR sky130_fd_sc_hd__tapvpwrvgnd_1
XTAP_TAPCELL_ROW_17_143 VGND VPWR sky130_fd_sc_hd__tapvpwrvgnd_1
XTAP_TAPCELL_ROW_17_144 VGND VPWR sky130_fd_sc_hd__tapvpwrvgnd_1
XTAP_TAPCELL_ROW_18_145 VGND VPWR sky130_fd_sc_hd__tapvpwrvgnd_1
XTAP_TAPCELL_ROW_18_146 VGND VPWR sky130_fd_sc_hd__tapvpwrvgnd_1
XTAP_TAPCELL_ROW_18_147 VGND VPWR sky130_fd_sc_hd__tapvpwrvgnd_1
XTAP_TAPCELL_ROW_19_148 VGND VPWR sky130_fd_sc_hd__tapvpwrvgnd_1
XTAP_TAPCELL_ROW_19_149 VGND VPWR sky130_fd_sc_hd__tapvpwrvgnd_1
XTAP_TAPCELL_ROW_19_150 VGND VPWR sky130_fd_sc_hd__tapvpwrvgnd_1
XTAP_TAPCELL_ROW_20_151 VGND VPWR sky130_fd_sc_hd__tapvpwrvgnd_1
XTAP_TAPCELL_ROW_20_152 VGND VPWR sky130_fd_sc_hd__tapvpwrvgnd_1
XTAP_TAPCELL_ROW_20_153 VGND VPWR sky130_fd_sc_hd__tapvpwrvgnd_1
XTAP_TAPCELL_ROW_21_154 VGND VPWR sky130_fd_sc_hd__tapvpwrvgnd_1
XTAP_TAPCELL_ROW_21_155 VGND VPWR sky130_fd_sc_hd__tapvpwrvgnd_1
XTAP_TAPCELL_ROW_21_156 VGND VPWR sky130_fd_sc_hd__tapvpwrvgnd_1
XTAP_TAPCELL_ROW_22_157 VGND VPWR sky130_fd_sc_hd__tapvpwrvgnd_1
XTAP_TAPCELL_ROW_22_158 VGND VPWR sky130_fd_sc_hd__tapvpwrvgnd_1
XTAP_TAPCELL_ROW_22_159 VGND VPWR sky130_fd_sc_hd__tapvpwrvgnd_1
XTAP_TAPCELL_ROW_23_160 VGND VPWR sky130_fd_sc_hd__tapvpwrvgnd_1
XTAP_TAPCELL_ROW_23_161 VGND VPWR sky130_fd_sc_hd__tapvpwrvgnd_1
XTAP_TAPCELL_ROW_23_162 VGND VPWR sky130_fd_sc_hd__tapvpwrvgnd_1
XTAP_TAPCELL_ROW_24_163 VGND VPWR sky130_fd_sc_hd__tapvpwrvgnd_1
XTAP_TAPCELL_ROW_24_164 VGND VPWR sky130_fd_sc_hd__tapvpwrvgnd_1
XTAP_TAPCELL_ROW_24_165 VGND VPWR sky130_fd_sc_hd__tapvpwrvgnd_1
XTAP_TAPCELL_ROW_25_166 VGND VPWR sky130_fd_sc_hd__tapvpwrvgnd_1
XTAP_TAPCELL_ROW_25_167 VGND VPWR sky130_fd_sc_hd__tapvpwrvgnd_1
XTAP_TAPCELL_ROW_25_168 VGND VPWR sky130_fd_sc_hd__tapvpwrvgnd_1
XTAP_TAPCELL_ROW_26_169 VGND VPWR sky130_fd_sc_hd__tapvpwrvgnd_1
XTAP_TAPCELL_ROW_26_170 VGND VPWR sky130_fd_sc_hd__tapvpwrvgnd_1
XTAP_TAPCELL_ROW_26_171 VGND VPWR sky130_fd_sc_hd__tapvpwrvgnd_1
XTAP_TAPCELL_ROW_27_172 VGND VPWR sky130_fd_sc_hd__tapvpwrvgnd_1
XTAP_TAPCELL_ROW_27_173 VGND VPWR sky130_fd_sc_hd__tapvpwrvgnd_1
XTAP_TAPCELL_ROW_27_174 VGND VPWR sky130_fd_sc_hd__tapvpwrvgnd_1
XTAP_TAPCELL_ROW_28_175 VGND VPWR sky130_fd_sc_hd__tapvpwrvgnd_1
XTAP_TAPCELL_ROW_28_176 VGND VPWR sky130_fd_sc_hd__tapvpwrvgnd_1
XTAP_TAPCELL_ROW_28_177 VGND VPWR sky130_fd_sc_hd__tapvpwrvgnd_1
XTAP_TAPCELL_ROW_29_178 VGND VPWR sky130_fd_sc_hd__tapvpwrvgnd_1
XTAP_TAPCELL_ROW_29_179 VGND VPWR sky130_fd_sc_hd__tapvpwrvgnd_1
XTAP_TAPCELL_ROW_29_180 VGND VPWR sky130_fd_sc_hd__tapvpwrvgnd_1
XTAP_TAPCELL_ROW_30_181 VGND VPWR sky130_fd_sc_hd__tapvpwrvgnd_1
XTAP_TAPCELL_ROW_30_182 VGND VPWR sky130_fd_sc_hd__tapvpwrvgnd_1
XTAP_TAPCELL_ROW_30_183 VGND VPWR sky130_fd_sc_hd__tapvpwrvgnd_1
XTAP_TAPCELL_ROW_31_184 VGND VPWR sky130_fd_sc_hd__tapvpwrvgnd_1
XTAP_TAPCELL_ROW_31_185 VGND VPWR sky130_fd_sc_hd__tapvpwrvgnd_1
XTAP_TAPCELL_ROW_31_186 VGND VPWR sky130_fd_sc_hd__tapvpwrvgnd_1
XTAP_TAPCELL_ROW_32_187 VGND VPWR sky130_fd_sc_hd__tapvpwrvgnd_1
XTAP_TAPCELL_ROW_32_188 VGND VPWR sky130_fd_sc_hd__tapvpwrvgnd_1
XTAP_TAPCELL_ROW_32_189 VGND VPWR sky130_fd_sc_hd__tapvpwrvgnd_1
XTAP_TAPCELL_ROW_33_190 VGND VPWR sky130_fd_sc_hd__tapvpwrvgnd_1
XTAP_TAPCELL_ROW_33_191 VGND VPWR sky130_fd_sc_hd__tapvpwrvgnd_1
XTAP_TAPCELL_ROW_33_192 VGND VPWR sky130_fd_sc_hd__tapvpwrvgnd_1
XTAP_TAPCELL_ROW_34_193 VGND VPWR sky130_fd_sc_hd__tapvpwrvgnd_1
XTAP_TAPCELL_ROW_34_194 VGND VPWR sky130_fd_sc_hd__tapvpwrvgnd_1
XTAP_TAPCELL_ROW_34_195 VGND VPWR sky130_fd_sc_hd__tapvpwrvgnd_1
XTAP_TAPCELL_ROW_35_196 VGND VPWR sky130_fd_sc_hd__tapvpwrvgnd_1
XTAP_TAPCELL_ROW_35_197 VGND VPWR sky130_fd_sc_hd__tapvpwrvgnd_1
XTAP_TAPCELL_ROW_35_198 VGND VPWR sky130_fd_sc_hd__tapvpwrvgnd_1
XTAP_TAPCELL_ROW_36_199 VGND VPWR sky130_fd_sc_hd__tapvpwrvgnd_1
XTAP_TAPCELL_ROW_36_200 VGND VPWR sky130_fd_sc_hd__tapvpwrvgnd_1
XTAP_TAPCELL_ROW_36_201 VGND VPWR sky130_fd_sc_hd__tapvpwrvgnd_1
XTAP_TAPCELL_ROW_37_202 VGND VPWR sky130_fd_sc_hd__tapvpwrvgnd_1
XTAP_TAPCELL_ROW_37_203 VGND VPWR sky130_fd_sc_hd__tapvpwrvgnd_1
XTAP_TAPCELL_ROW_37_204 VGND VPWR sky130_fd_sc_hd__tapvpwrvgnd_1
XTAP_TAPCELL_ROW_38_205 VGND VPWR sky130_fd_sc_hd__tapvpwrvgnd_1
XTAP_TAPCELL_ROW_38_206 VGND VPWR sky130_fd_sc_hd__tapvpwrvgnd_1
XTAP_TAPCELL_ROW_38_207 VGND VPWR sky130_fd_sc_hd__tapvpwrvgnd_1
XTAP_TAPCELL_ROW_39_208 VGND VPWR sky130_fd_sc_hd__tapvpwrvgnd_1
XTAP_TAPCELL_ROW_39_209 VGND VPWR sky130_fd_sc_hd__tapvpwrvgnd_1
XTAP_TAPCELL_ROW_39_210 VGND VPWR sky130_fd_sc_hd__tapvpwrvgnd_1
XTAP_TAPCELL_ROW_40_211 VGND VPWR sky130_fd_sc_hd__tapvpwrvgnd_1
XTAP_TAPCELL_ROW_40_212 VGND VPWR sky130_fd_sc_hd__tapvpwrvgnd_1
XTAP_TAPCELL_ROW_40_213 VGND VPWR sky130_fd_sc_hd__tapvpwrvgnd_1
XTAP_TAPCELL_ROW_41_214 VGND VPWR sky130_fd_sc_hd__tapvpwrvgnd_1
XTAP_TAPCELL_ROW_41_215 VGND VPWR sky130_fd_sc_hd__tapvpwrvgnd_1
XTAP_TAPCELL_ROW_41_216 VGND VPWR sky130_fd_sc_hd__tapvpwrvgnd_1
XTAP_TAPCELL_ROW_42_217 VGND VPWR sky130_fd_sc_hd__tapvpwrvgnd_1
XTAP_TAPCELL_ROW_42_218 VGND VPWR sky130_fd_sc_hd__tapvpwrvgnd_1
XTAP_TAPCELL_ROW_42_219 VGND VPWR sky130_fd_sc_hd__tapvpwrvgnd_1
XTAP_TAPCELL_ROW_43_220 VGND VPWR sky130_fd_sc_hd__tapvpwrvgnd_1
XTAP_TAPCELL_ROW_43_221 VGND VPWR sky130_fd_sc_hd__tapvpwrvgnd_1
XTAP_TAPCELL_ROW_43_222 VGND VPWR sky130_fd_sc_hd__tapvpwrvgnd_1
XTAP_TAPCELL_ROW_43_223 VGND VPWR sky130_fd_sc_hd__tapvpwrvgnd_1
XTAP_TAPCELL_ROW_43_224 VGND VPWR sky130_fd_sc_hd__tapvpwrvgnd_1
XTAP_TAPCELL_ROW_43_225 VGND VPWR sky130_fd_sc_hd__tapvpwrvgnd_1
Xinput1 COARSE_MUX[0] VGND VGND VPWR VPWR net1 sky130_fd_sc_hd__clkdlybuf4s50_1
Xinput2 COARSE_MUX[10] VGND VGND VPWR VPWR net2 sky130_fd_sc_hd__clkdlybuf4s50_1
Xinput3 COARSE_MUX[11] VGND VGND VPWR VPWR net3 sky130_fd_sc_hd__clkdlybuf4s50_1
Xinput4 COARSE_MUX[12] VGND VGND VPWR VPWR net4 sky130_fd_sc_hd__clkdlybuf4s50_1
Xinput5 COARSE_MUX[13] VGND VGND VPWR VPWR net5 sky130_fd_sc_hd__clkdlybuf4s50_1
Xinput6 COARSE_MUX[14] VGND VGND VPWR VPWR net6 sky130_fd_sc_hd__clkdlybuf4s50_1
Xinput7 COARSE_MUX[1] VGND VGND VPWR VPWR net7 sky130_fd_sc_hd__clkdlybuf4s50_1
Xinput8 COARSE_MUX[2] VGND VGND VPWR VPWR net8 sky130_fd_sc_hd__clkdlybuf4s50_1
Xinput9 COARSE_MUX[3] VGND VGND VPWR VPWR net9 sky130_fd_sc_hd__clkdlybuf4s50_1
Xinput10 COARSE_MUX[4] VGND VGND VPWR VPWR net10 sky130_fd_sc_hd__clkdlybuf4s50_1
Xinput11 COARSE_MUX[5] VGND VGND VPWR VPWR net11 sky130_fd_sc_hd__clkdlybuf4s50_1
Xinput12 COARSE_MUX[6] VGND VGND VPWR VPWR net12 sky130_fd_sc_hd__clkdlybuf4s50_1
Xinput13 COARSE_MUX[7] VGND VGND VPWR VPWR net13 sky130_fd_sc_hd__clkdlybuf4s50_1
Xinput14 COARSE_MUX[8] VGND VGND VPWR VPWR net14 sky130_fd_sc_hd__clkdlybuf4s50_1
Xinput15 COARSE_MUX[9] VGND VGND VPWR VPWR net15 sky130_fd_sc_hd__clkdlybuf4s50_1
Xinput16 DCO_EN VGND VGND VPWR VPWR net16 sky130_fd_sc_hd__clkdlybuf4s50_1
Xinput17 FINE_MUX[0] VGND VGND VPWR VPWR net17 sky130_fd_sc_hd__clkdlybuf4s50_1
Xinput18 FINE_MUX[10] VGND VGND VPWR VPWR net18 sky130_fd_sc_hd__clkdlybuf4s50_1
Xinput19 FINE_MUX[11] VGND VGND VPWR VPWR net19 sky130_fd_sc_hd__clkdlybuf4s50_1
Xinput20 FINE_MUX[12] VGND VGND VPWR VPWR net20 sky130_fd_sc_hd__clkdlybuf4s50_1
Xinput21 FINE_MUX[13] VGND VGND VPWR VPWR net21 sky130_fd_sc_hd__clkdlybuf4s50_1
Xinput22 FINE_MUX[14] VGND VGND VPWR VPWR net22 sky130_fd_sc_hd__clkdlybuf4s50_1
Xinput23 FINE_MUX[15] VGND VGND VPWR VPWR net23 sky130_fd_sc_hd__clkdlybuf4s50_1
Xinput24 FINE_MUX[16] VGND VGND VPWR VPWR net24 sky130_fd_sc_hd__clkdlybuf4s50_1
Xinput25 FINE_MUX[17] VGND VGND VPWR VPWR net25 sky130_fd_sc_hd__clkdlybuf4s50_1
Xinput26 FINE_MUX[18] VGND VGND VPWR VPWR net26 sky130_fd_sc_hd__clkdlybuf4s50_1
Xinput27 FINE_MUX[19] VGND VGND VPWR VPWR net27 sky130_fd_sc_hd__clkdlybuf4s50_1
Xinput28 FINE_MUX[1] VGND VGND VPWR VPWR net28 sky130_fd_sc_hd__clkdlybuf4s50_1
Xinput29 FINE_MUX[20] VGND VGND VPWR VPWR net29 sky130_fd_sc_hd__clkdlybuf4s50_1
Xinput30 FINE_MUX[21] VGND VGND VPWR VPWR net30 sky130_fd_sc_hd__clkdlybuf4s50_1
Xinput31 FINE_MUX[22] VGND VGND VPWR VPWR net31 sky130_fd_sc_hd__clkdlybuf4s50_1
Xinput32 FINE_MUX[23] VGND VGND VPWR VPWR net32 sky130_fd_sc_hd__clkdlybuf4s50_1
Xinput33 FINE_MUX[24] VGND VGND VPWR VPWR net33 sky130_fd_sc_hd__clkdlybuf4s50_1
Xinput34 FINE_MUX[25] VGND VGND VPWR VPWR net34 sky130_fd_sc_hd__clkdlybuf4s50_1
Xinput35 FINE_MUX[26] VGND VGND VPWR VPWR net35 sky130_fd_sc_hd__clkdlybuf4s50_1
Xinput36 FINE_MUX[27] VGND VGND VPWR VPWR net36 sky130_fd_sc_hd__clkdlybuf4s50_1
Xinput37 FINE_MUX[28] VGND VGND VPWR VPWR net37 sky130_fd_sc_hd__clkdlybuf4s50_1
Xinput38 FINE_MUX[29] VGND VGND VPWR VPWR net38 sky130_fd_sc_hd__clkdlybuf4s50_1
Xinput39 FINE_MUX[2] VGND VGND VPWR VPWR net39 sky130_fd_sc_hd__clkdlybuf4s50_1
Xinput40 FINE_MUX[30] VGND VGND VPWR VPWR net40 sky130_fd_sc_hd__clkdlybuf4s50_1
Xinput41 FINE_MUX[3] VGND VGND VPWR VPWR net41 sky130_fd_sc_hd__clkdlybuf4s50_1
Xinput42 FINE_MUX[4] VGND VGND VPWR VPWR net42 sky130_fd_sc_hd__clkdlybuf4s50_1
Xinput43 FINE_MUX[5] VGND VGND VPWR VPWR net43 sky130_fd_sc_hd__clkdlybuf4s50_1
Xinput44 FINE_MUX[6] VGND VGND VPWR VPWR net44 sky130_fd_sc_hd__clkdlybuf4s50_1
Xinput45 FINE_MUX[7] VGND VGND VPWR VPWR net45 sky130_fd_sc_hd__clkdlybuf4s50_1
Xinput46 FINE_MUX[8] VGND VGND VPWR VPWR net46 sky130_fd_sc_hd__clkdlybuf4s50_1
Xinput47 FINE_MUX[9] VGND VGND VPWR VPWR net47 sky130_fd_sc_hd__clkdlybuf4s50_1
Xinput48 MID_MUX[0] VGND VGND VPWR VPWR net48 sky130_fd_sc_hd__clkdlybuf4s50_1
Xinput49 MID_MUX[10] VGND VGND VPWR VPWR net49 sky130_fd_sc_hd__clkdlybuf4s50_1
Xinput50 MID_MUX[11] VGND VGND VPWR VPWR net50 sky130_fd_sc_hd__clkdlybuf4s50_1
Xinput51 MID_MUX[12] VGND VGND VPWR VPWR net51 sky130_fd_sc_hd__clkdlybuf4s50_1
Xinput52 MID_MUX[13] VGND VGND VPWR VPWR net52 sky130_fd_sc_hd__clkdlybuf4s50_1
Xinput53 MID_MUX[14] VGND VGND VPWR VPWR net53 sky130_fd_sc_hd__clkdlybuf4s50_1
Xinput54 MID_MUX[1] VGND VGND VPWR VPWR net54 sky130_fd_sc_hd__clkdlybuf4s50_1
Xinput55 MID_MUX[2] VGND VGND VPWR VPWR net55 sky130_fd_sc_hd__clkdlybuf4s50_1
Xinput56 MID_MUX[3] VGND VGND VPWR VPWR net56 sky130_fd_sc_hd__clkdlybuf4s50_1
Xinput57 MID_MUX[4] VGND VGND VPWR VPWR net57 sky130_fd_sc_hd__clkdlybuf4s50_1
Xinput58 MID_MUX[5] VGND VGND VPWR VPWR net58 sky130_fd_sc_hd__clkdlybuf4s50_1
Xinput59 MID_MUX[6] VGND VGND VPWR VPWR net59 sky130_fd_sc_hd__clkdlybuf4s50_1
Xinput60 MID_MUX[7] VGND VGND VPWR VPWR net60 sky130_fd_sc_hd__clkdlybuf4s50_1
Xinput61 MID_MUX[8] VGND VGND VPWR VPWR net61 sky130_fd_sc_hd__clkdlybuf4s50_1
Xinput62 MID_MUX[9] VGND VGND VPWR VPWR net62 sky130_fd_sc_hd__clkdlybuf4s50_1
Xoutput63 net63 VGND VGND VPWR VPWR INJ_EDGE sky130_fd_sc_hd__clkdlybuf4s50_1
Xoutput64 net64 VGND VGND VPWR VPWR MID_OUT sky130_fd_sc_hd__clkdlybuf4s50_1
Xoutput65 net65 VGND VGND VPWR VPWR OUT sky130_fd_sc_hd__clkdlybuf4s50_1
Xoutput66 net66 VGND VGND VPWR VPWR SS_BBPD[0] sky130_fd_sc_hd__clkdlybuf4s50_1
Xoutput67 net67 VGND VGND VPWR VPWR SS_BBPD[1] sky130_fd_sc_hd__clkdlybuf4s50_1
XFILLER_0_1 VGND VGND VPWR VPWR sky130_fd_sc_hd__decap_12
XFILLER_0_13 VGND VGND VPWR VPWR sky130_fd_sc_hd__decap_12
XFILLER_0_25 VGND VGND VPWR VPWR sky130_fd_sc_hd__decap_12
XFILLER_0_37 VGND VGND VPWR VPWR sky130_fd_sc_hd__decap_6
XFILLER_0_44 VGND VGND VPWR VPWR sky130_fd_sc_hd__decap_4
XFILLER_0_48 VGND VGND VPWR VPWR sky130_fd_sc_hd__fill_1
XFILLER_0_75 VGND VGND VPWR VPWR sky130_fd_sc_hd__decap_3
XFILLER_0_87 VGND VGND VPWR VPWR sky130_fd_sc_hd__decap_4
XFILLER_0_126 VGND VGND VPWR VPWR sky130_fd_sc_hd__decap_3
XFILLER_0_130 VGND VGND VPWR VPWR sky130_fd_sc_hd__decap_3
XFILLER_0_165 VGND VGND VPWR VPWR sky130_fd_sc_hd__decap_6
XFILLER_0_171 VGND VGND VPWR VPWR sky130_fd_sc_hd__fill_1
XFILLER_0_173 VGND VGND VPWR VPWR sky130_fd_sc_hd__decap_6
XFILLER_0_179 VGND VGND VPWR VPWR sky130_fd_sc_hd__fill_1
XFILLER_0_204 VGND VGND VPWR VPWR sky130_fd_sc_hd__fill_1
XFILLER_0_213 VGND VGND VPWR VPWR sky130_fd_sc_hd__fill_2
XFILLER_0_232 VGND VGND VPWR VPWR sky130_fd_sc_hd__decap_12
XFILLER_0_244 VGND VGND VPWR VPWR sky130_fd_sc_hd__decap_12
XFILLER_0_256 VGND VGND VPWR VPWR sky130_fd_sc_hd__fill_2
XFILLER_0_259 VGND VGND VPWR VPWR sky130_fd_sc_hd__decap_4
XFILLER_0_263 VGND VGND VPWR VPWR sky130_fd_sc_hd__fill_1
XFILLER_1_1 VGND VGND VPWR VPWR sky130_fd_sc_hd__decap_12
XFILLER_1_13 VGND VGND VPWR VPWR sky130_fd_sc_hd__decap_12
XFILLER_1_25 VGND VGND VPWR VPWR sky130_fd_sc_hd__decap_12
XFILLER_1_37 VGND VGND VPWR VPWR sky130_fd_sc_hd__decap_12
XFILLER_1_49 VGND VGND VPWR VPWR sky130_fd_sc_hd__decap_6
XFILLER_1_84 VGND VGND VPWR VPWR sky130_fd_sc_hd__fill_2
XFILLER_1_87 VGND VGND VPWR VPWR sky130_fd_sc_hd__fill_1
XFILLER_1_104 VGND VGND VPWR VPWR sky130_fd_sc_hd__fill_2
XFILLER_1_129 VGND VGND VPWR VPWR sky130_fd_sc_hd__decap_12
XFILLER_1_141 VGND VGND VPWR VPWR sky130_fd_sc_hd__decap_3
XFILLER_1_163 VGND VGND VPWR VPWR sky130_fd_sc_hd__fill_1
XFILLER_1_192 VGND VGND VPWR VPWR sky130_fd_sc_hd__decap_4
XFILLER_1_196 VGND VGND VPWR VPWR sky130_fd_sc_hd__fill_1
XFILLER_1_224 VGND VGND VPWR VPWR sky130_fd_sc_hd__decap_12
XFILLER_1_236 VGND VGND VPWR VPWR sky130_fd_sc_hd__decap_12
XFILLER_1_248 VGND VGND VPWR VPWR sky130_fd_sc_hd__decap_8
XFILLER_1_256 VGND VGND VPWR VPWR sky130_fd_sc_hd__fill_2
XFILLER_1_259 VGND VGND VPWR VPWR sky130_fd_sc_hd__decap_4
XFILLER_1_263 VGND VGND VPWR VPWR sky130_fd_sc_hd__fill_1
XFILLER_2_1 VGND VGND VPWR VPWR sky130_fd_sc_hd__decap_12
XFILLER_2_13 VGND VGND VPWR VPWR sky130_fd_sc_hd__decap_12
XFILLER_2_25 VGND VGND VPWR VPWR sky130_fd_sc_hd__decap_12
XFILLER_2_37 VGND VGND VPWR VPWR sky130_fd_sc_hd__decap_6
XFILLER_2_62 VGND VGND VPWR VPWR sky130_fd_sc_hd__fill_2
XFILLER_2_125 VGND VGND VPWR VPWR sky130_fd_sc_hd__decap_4
XFILLER_2_130 VGND VGND VPWR VPWR sky130_fd_sc_hd__fill_2
XFILLER_2_178 VGND VGND VPWR VPWR sky130_fd_sc_hd__decap_6
XFILLER_2_184 VGND VGND VPWR VPWR sky130_fd_sc_hd__fill_1
XFILLER_2_211 VGND VGND VPWR VPWR sky130_fd_sc_hd__decap_4
XFILLER_2_224 VGND VGND VPWR VPWR sky130_fd_sc_hd__decap_12
XFILLER_2_236 VGND VGND VPWR VPWR sky130_fd_sc_hd__decap_12
XFILLER_2_248 VGND VGND VPWR VPWR sky130_fd_sc_hd__decap_12
XFILLER_2_260 VGND VGND VPWR VPWR sky130_fd_sc_hd__decap_4
XFILLER_3_1 VGND VGND VPWR VPWR sky130_fd_sc_hd__decap_12
XFILLER_3_13 VGND VGND VPWR VPWR sky130_fd_sc_hd__decap_12
XFILLER_3_25 VGND VGND VPWR VPWR sky130_fd_sc_hd__decap_12
XFILLER_3_37 VGND VGND VPWR VPWR sky130_fd_sc_hd__decap_12
XFILLER_3_49 VGND VGND VPWR VPWR sky130_fd_sc_hd__decap_4
XFILLER_3_61 VGND VGND VPWR VPWR sky130_fd_sc_hd__fill_1
XFILLER_3_102 VGND VGND VPWR VPWR sky130_fd_sc_hd__fill_1
XFILLER_3_111 VGND VGND VPWR VPWR sky130_fd_sc_hd__fill_1
XFILLER_3_120 VGND VGND VPWR VPWR sky130_fd_sc_hd__decap_3
XFILLER_3_141 VGND VGND VPWR VPWR sky130_fd_sc_hd__decap_3
XFILLER_3_152 VGND VGND VPWR VPWR sky130_fd_sc_hd__fill_1
XFILLER_3_169 VGND VGND VPWR VPWR sky130_fd_sc_hd__decap_3
XFILLER_3_173 VGND VGND VPWR VPWR sky130_fd_sc_hd__fill_1
XFILLER_3_185 VGND VGND VPWR VPWR sky130_fd_sc_hd__fill_2
XFILLER_3_211 VGND VGND VPWR VPWR sky130_fd_sc_hd__decap_12
XFILLER_3_223 VGND VGND VPWR VPWR sky130_fd_sc_hd__decap_12
XFILLER_3_235 VGND VGND VPWR VPWR sky130_fd_sc_hd__decap_12
XFILLER_3_247 VGND VGND VPWR VPWR sky130_fd_sc_hd__decap_8
XFILLER_3_255 VGND VGND VPWR VPWR sky130_fd_sc_hd__decap_3
XFILLER_3_259 VGND VGND VPWR VPWR sky130_fd_sc_hd__decap_4
XFILLER_3_263 VGND VGND VPWR VPWR sky130_fd_sc_hd__fill_1
XFILLER_4_1 VGND VGND VPWR VPWR sky130_fd_sc_hd__decap_12
XFILLER_4_13 VGND VGND VPWR VPWR sky130_fd_sc_hd__decap_12
XFILLER_4_25 VGND VGND VPWR VPWR sky130_fd_sc_hd__decap_12
XFILLER_4_37 VGND VGND VPWR VPWR sky130_fd_sc_hd__decap_6
XFILLER_4_44 VGND VGND VPWR VPWR sky130_fd_sc_hd__decap_4
XFILLER_4_48 VGND VGND VPWR VPWR sky130_fd_sc_hd__fill_1
XFILLER_4_70 VGND VGND VPWR VPWR sky130_fd_sc_hd__decap_8
XFILLER_4_78 VGND VGND VPWR VPWR sky130_fd_sc_hd__fill_1
XFILLER_4_87 VGND VGND VPWR VPWR sky130_fd_sc_hd__fill_2
XFILLER_4_96 VGND VGND VPWR VPWR sky130_fd_sc_hd__decap_8
XFILLER_4_104 VGND VGND VPWR VPWR sky130_fd_sc_hd__fill_1
XFILLER_4_115 VGND VGND VPWR VPWR sky130_fd_sc_hd__decap_12
XFILLER_4_127 VGND VGND VPWR VPWR sky130_fd_sc_hd__fill_2
XFILLER_4_130 VGND VGND VPWR VPWR sky130_fd_sc_hd__decap_6
XFILLER_4_144 VGND VGND VPWR VPWR sky130_fd_sc_hd__decap_8
XFILLER_4_152 VGND VGND VPWR VPWR sky130_fd_sc_hd__decap_3
XFILLER_4_163 VGND VGND VPWR VPWR sky130_fd_sc_hd__decap_4
XFILLER_4_167 VGND VGND VPWR VPWR sky130_fd_sc_hd__fill_1
XFILLER_4_204 VGND VGND VPWR VPWR sky130_fd_sc_hd__decap_8
XFILLER_4_212 VGND VGND VPWR VPWR sky130_fd_sc_hd__decap_3
XFILLER_4_216 VGND VGND VPWR VPWR sky130_fd_sc_hd__decap_12
XFILLER_4_228 VGND VGND VPWR VPWR sky130_fd_sc_hd__decap_12
XFILLER_4_240 VGND VGND VPWR VPWR sky130_fd_sc_hd__decap_12
XFILLER_4_252 VGND VGND VPWR VPWR sky130_fd_sc_hd__decap_12
XFILLER_5_1 VGND VGND VPWR VPWR sky130_fd_sc_hd__decap_12
XFILLER_5_13 VGND VGND VPWR VPWR sky130_fd_sc_hd__decap_12
XFILLER_5_25 VGND VGND VPWR VPWR sky130_fd_sc_hd__decap_12
XFILLER_5_37 VGND VGND VPWR VPWR sky130_fd_sc_hd__decap_12
XFILLER_5_49 VGND VGND VPWR VPWR sky130_fd_sc_hd__decap_6
XFILLER_5_67 VGND VGND VPWR VPWR sky130_fd_sc_hd__decap_12
XFILLER_5_79 VGND VGND VPWR VPWR sky130_fd_sc_hd__decap_6
XFILLER_5_85 VGND VGND VPWR VPWR sky130_fd_sc_hd__fill_1
XFILLER_5_87 VGND VGND VPWR VPWR sky130_fd_sc_hd__decap_12
XFILLER_5_99 VGND VGND VPWR VPWR sky130_fd_sc_hd__decap_12
XFILLER_5_111 VGND VGND VPWR VPWR sky130_fd_sc_hd__decap_3
XFILLER_5_122 VGND VGND VPWR VPWR sky130_fd_sc_hd__decap_12
XFILLER_5_134 VGND VGND VPWR VPWR sky130_fd_sc_hd__decap_12
XFILLER_5_146 VGND VGND VPWR VPWR sky130_fd_sc_hd__fill_2
XFILLER_5_158 VGND VGND VPWR VPWR sky130_fd_sc_hd__decap_12
XFILLER_5_170 VGND VGND VPWR VPWR sky130_fd_sc_hd__fill_2
XFILLER_5_173 VGND VGND VPWR VPWR sky130_fd_sc_hd__decap_6
XFILLER_5_179 VGND VGND VPWR VPWR sky130_fd_sc_hd__fill_1
XFILLER_5_188 VGND VGND VPWR VPWR sky130_fd_sc_hd__decap_12
XFILLER_5_200 VGND VGND VPWR VPWR sky130_fd_sc_hd__decap_12
XFILLER_5_212 VGND VGND VPWR VPWR sky130_fd_sc_hd__decap_12
XFILLER_5_224 VGND VGND VPWR VPWR sky130_fd_sc_hd__decap_12
XFILLER_5_236 VGND VGND VPWR VPWR sky130_fd_sc_hd__decap_12
XFILLER_5_248 VGND VGND VPWR VPWR sky130_fd_sc_hd__decap_8
XFILLER_5_256 VGND VGND VPWR VPWR sky130_fd_sc_hd__fill_2
XFILLER_5_259 VGND VGND VPWR VPWR sky130_fd_sc_hd__decap_4
XFILLER_5_263 VGND VGND VPWR VPWR sky130_fd_sc_hd__fill_1
XFILLER_6_1 VGND VGND VPWR VPWR sky130_fd_sc_hd__decap_12
XFILLER_6_13 VGND VGND VPWR VPWR sky130_fd_sc_hd__decap_12
XFILLER_6_25 VGND VGND VPWR VPWR sky130_fd_sc_hd__decap_12
XFILLER_6_37 VGND VGND VPWR VPWR sky130_fd_sc_hd__decap_6
XFILLER_6_44 VGND VGND VPWR VPWR sky130_fd_sc_hd__decap_12
XFILLER_6_56 VGND VGND VPWR VPWR sky130_fd_sc_hd__decap_12
XFILLER_6_68 VGND VGND VPWR VPWR sky130_fd_sc_hd__decap_12
XFILLER_6_80 VGND VGND VPWR VPWR sky130_fd_sc_hd__decap_12
XFILLER_6_92 VGND VGND VPWR VPWR sky130_fd_sc_hd__decap_4
XFILLER_6_96 VGND VGND VPWR VPWR sky130_fd_sc_hd__fill_1
XFILLER_6_125 VGND VGND VPWR VPWR sky130_fd_sc_hd__decap_4
XFILLER_6_130 VGND VGND VPWR VPWR sky130_fd_sc_hd__decap_3
XFILLER_6_160 VGND VGND VPWR VPWR sky130_fd_sc_hd__decap_12
XFILLER_6_172 VGND VGND VPWR VPWR sky130_fd_sc_hd__decap_12
XFILLER_6_184 VGND VGND VPWR VPWR sky130_fd_sc_hd__fill_1
XFILLER_6_193 VGND VGND VPWR VPWR sky130_fd_sc_hd__decap_12
XFILLER_6_205 VGND VGND VPWR VPWR sky130_fd_sc_hd__decap_8
XFILLER_6_213 VGND VGND VPWR VPWR sky130_fd_sc_hd__fill_2
XFILLER_6_216 VGND VGND VPWR VPWR sky130_fd_sc_hd__decap_12
XFILLER_6_228 VGND VGND VPWR VPWR sky130_fd_sc_hd__decap_12
XFILLER_6_240 VGND VGND VPWR VPWR sky130_fd_sc_hd__decap_12
XFILLER_6_252 VGND VGND VPWR VPWR sky130_fd_sc_hd__decap_12
XFILLER_7_1 VGND VGND VPWR VPWR sky130_fd_sc_hd__decap_12
XFILLER_7_13 VGND VGND VPWR VPWR sky130_fd_sc_hd__decap_12
XFILLER_7_25 VGND VGND VPWR VPWR sky130_fd_sc_hd__decap_12
XFILLER_7_37 VGND VGND VPWR VPWR sky130_fd_sc_hd__decap_12
XFILLER_7_49 VGND VGND VPWR VPWR sky130_fd_sc_hd__decap_12
XFILLER_7_61 VGND VGND VPWR VPWR sky130_fd_sc_hd__decap_12
XFILLER_7_73 VGND VGND VPWR VPWR sky130_fd_sc_hd__decap_12
XFILLER_7_85 VGND VGND VPWR VPWR sky130_fd_sc_hd__fill_1
XFILLER_7_87 VGND VGND VPWR VPWR sky130_fd_sc_hd__decap_4
XFILLER_7_106 VGND VGND VPWR VPWR sky130_fd_sc_hd__decap_6
XFILLER_7_112 VGND VGND VPWR VPWR sky130_fd_sc_hd__fill_1
XFILLER_7_125 VGND VGND VPWR VPWR sky130_fd_sc_hd__decap_12
XFILLER_7_137 VGND VGND VPWR VPWR sky130_fd_sc_hd__decap_12
XFILLER_7_149 VGND VGND VPWR VPWR sky130_fd_sc_hd__decap_8
XFILLER_7_161 VGND VGND VPWR VPWR sky130_fd_sc_hd__decap_4
XFILLER_7_173 VGND VGND VPWR VPWR sky130_fd_sc_hd__decap_3
XFILLER_7_194 VGND VGND VPWR VPWR sky130_fd_sc_hd__decap_12
XFILLER_7_206 VGND VGND VPWR VPWR sky130_fd_sc_hd__decap_12
XFILLER_7_218 VGND VGND VPWR VPWR sky130_fd_sc_hd__decap_12
XFILLER_7_230 VGND VGND VPWR VPWR sky130_fd_sc_hd__decap_12
XFILLER_7_242 VGND VGND VPWR VPWR sky130_fd_sc_hd__decap_12
XFILLER_7_254 VGND VGND VPWR VPWR sky130_fd_sc_hd__decap_4
XFILLER_7_259 VGND VGND VPWR VPWR sky130_fd_sc_hd__decap_4
XFILLER_7_263 VGND VGND VPWR VPWR sky130_fd_sc_hd__fill_1
XFILLER_8_9 VGND VGND VPWR VPWR sky130_fd_sc_hd__fill_1
XFILLER_8_17 VGND VGND VPWR VPWR sky130_fd_sc_hd__decap_6
XFILLER_8_31 VGND VGND VPWR VPWR sky130_fd_sc_hd__decap_4
XFILLER_8_44 VGND VGND VPWR VPWR sky130_fd_sc_hd__decap_12
XFILLER_8_56 VGND VGND VPWR VPWR sky130_fd_sc_hd__decap_12
XFILLER_8_68 VGND VGND VPWR VPWR sky130_fd_sc_hd__decap_12
XFILLER_8_80 VGND VGND VPWR VPWR sky130_fd_sc_hd__decap_12
XFILLER_8_92 VGND VGND VPWR VPWR sky130_fd_sc_hd__decap_12
XFILLER_8_104 VGND VGND VPWR VPWR sky130_fd_sc_hd__decap_12
XFILLER_8_123 VGND VGND VPWR VPWR sky130_fd_sc_hd__decap_6
XFILLER_8_130 VGND VGND VPWR VPWR sky130_fd_sc_hd__decap_12
XFILLER_8_142 VGND VGND VPWR VPWR sky130_fd_sc_hd__decap_6
XFILLER_8_148 VGND VGND VPWR VPWR sky130_fd_sc_hd__fill_1
XFILLER_8_156 VGND VGND VPWR VPWR sky130_fd_sc_hd__fill_2
XFILLER_8_177 VGND VGND VPWR VPWR sky130_fd_sc_hd__decap_8
XFILLER_8_192 VGND VGND VPWR VPWR sky130_fd_sc_hd__decap_12
XFILLER_8_204 VGND VGND VPWR VPWR sky130_fd_sc_hd__decap_8
XFILLER_8_212 VGND VGND VPWR VPWR sky130_fd_sc_hd__decap_3
XFILLER_8_216 VGND VGND VPWR VPWR sky130_fd_sc_hd__decap_12
XFILLER_8_228 VGND VGND VPWR VPWR sky130_fd_sc_hd__decap_12
XFILLER_8_240 VGND VGND VPWR VPWR sky130_fd_sc_hd__decap_12
XFILLER_8_252 VGND VGND VPWR VPWR sky130_fd_sc_hd__decap_12
XFILLER_9_1 VGND VGND VPWR VPWR sky130_fd_sc_hd__decap_4
XFILLER_9_5 VGND VGND VPWR VPWR sky130_fd_sc_hd__fill_1
XFILLER_9_44 VGND VGND VPWR VPWR sky130_fd_sc_hd__decap_12
XFILLER_9_56 VGND VGND VPWR VPWR sky130_fd_sc_hd__decap_12
XFILLER_9_68 VGND VGND VPWR VPWR sky130_fd_sc_hd__decap_12
XFILLER_9_80 VGND VGND VPWR VPWR sky130_fd_sc_hd__decap_6
XFILLER_9_87 VGND VGND VPWR VPWR sky130_fd_sc_hd__decap_12
XFILLER_9_99 VGND VGND VPWR VPWR sky130_fd_sc_hd__decap_12
XFILLER_9_111 VGND VGND VPWR VPWR sky130_fd_sc_hd__decap_4
XFILLER_9_115 VGND VGND VPWR VPWR sky130_fd_sc_hd__fill_1
XFILLER_9_122 VGND VGND VPWR VPWR sky130_fd_sc_hd__decap_12
XFILLER_9_134 VGND VGND VPWR VPWR sky130_fd_sc_hd__decap_12
XFILLER_9_146 VGND VGND VPWR VPWR sky130_fd_sc_hd__decap_12
XFILLER_9_158 VGND VGND VPWR VPWR sky130_fd_sc_hd__decap_6
XFILLER_9_164 VGND VGND VPWR VPWR sky130_fd_sc_hd__fill_1
XFILLER_9_168 VGND VGND VPWR VPWR sky130_fd_sc_hd__decap_4
XFILLER_9_173 VGND VGND VPWR VPWR sky130_fd_sc_hd__decap_8
XFILLER_9_181 VGND VGND VPWR VPWR sky130_fd_sc_hd__fill_2
XFILLER_9_194 VGND VGND VPWR VPWR sky130_fd_sc_hd__decap_12
XFILLER_9_206 VGND VGND VPWR VPWR sky130_fd_sc_hd__fill_2
XFILLER_9_221 VGND VGND VPWR VPWR sky130_fd_sc_hd__decap_12
XFILLER_9_233 VGND VGND VPWR VPWR sky130_fd_sc_hd__decap_12
XFILLER_9_245 VGND VGND VPWR VPWR sky130_fd_sc_hd__decap_12
XFILLER_9_257 VGND VGND VPWR VPWR sky130_fd_sc_hd__fill_1
XFILLER_9_259 VGND VGND VPWR VPWR sky130_fd_sc_hd__decap_4
XFILLER_9_263 VGND VGND VPWR VPWR sky130_fd_sc_hd__fill_1
XFILLER_10_1 VGND VGND VPWR VPWR sky130_fd_sc_hd__decap_6
XFILLER_10_22 VGND VGND VPWR VPWR sky130_fd_sc_hd__decap_12
XFILLER_10_34 VGND VGND VPWR VPWR sky130_fd_sc_hd__decap_8
XFILLER_10_42 VGND VGND VPWR VPWR sky130_fd_sc_hd__fill_1
XFILLER_10_44 VGND VGND VPWR VPWR sky130_fd_sc_hd__decap_3
XFILLER_10_54 VGND VGND VPWR VPWR sky130_fd_sc_hd__decap_12
XFILLER_10_66 VGND VGND VPWR VPWR sky130_fd_sc_hd__decap_12
XFILLER_10_78 VGND VGND VPWR VPWR sky130_fd_sc_hd__decap_12
XFILLER_10_93 VGND VGND VPWR VPWR sky130_fd_sc_hd__decap_12
XFILLER_10_105 VGND VGND VPWR VPWR sky130_fd_sc_hd__decap_8
XFILLER_10_124 VGND VGND VPWR VPWR sky130_fd_sc_hd__decap_4
XFILLER_10_128 VGND VGND VPWR VPWR sky130_fd_sc_hd__fill_1
XFILLER_10_130 VGND VGND VPWR VPWR sky130_fd_sc_hd__decap_6
XFILLER_10_136 VGND VGND VPWR VPWR sky130_fd_sc_hd__fill_1
XFILLER_10_144 VGND VGND VPWR VPWR sky130_fd_sc_hd__decap_12
XFILLER_10_156 VGND VGND VPWR VPWR sky130_fd_sc_hd__fill_1
XFILLER_10_179 VGND VGND VPWR VPWR sky130_fd_sc_hd__decap_12
XFILLER_10_191 VGND VGND VPWR VPWR sky130_fd_sc_hd__decap_4
XFILLER_10_195 VGND VGND VPWR VPWR sky130_fd_sc_hd__fill_1
XFILLER_10_223 VGND VGND VPWR VPWR sky130_fd_sc_hd__decap_12
XFILLER_10_235 VGND VGND VPWR VPWR sky130_fd_sc_hd__decap_12
XFILLER_10_247 VGND VGND VPWR VPWR sky130_fd_sc_hd__decap_8
XFILLER_10_255 VGND VGND VPWR VPWR sky130_fd_sc_hd__fill_1
XFILLER_11_17 VGND VGND VPWR VPWR sky130_fd_sc_hd__decap_12
XFILLER_11_29 VGND VGND VPWR VPWR sky130_fd_sc_hd__decap_8
XFILLER_11_37 VGND VGND VPWR VPWR sky130_fd_sc_hd__decap_3
XFILLER_11_59 VGND VGND VPWR VPWR sky130_fd_sc_hd__decap_8
XFILLER_11_70 VGND VGND VPWR VPWR sky130_fd_sc_hd__decap_12
XFILLER_11_82 VGND VGND VPWR VPWR sky130_fd_sc_hd__decap_4
XFILLER_11_108 VGND VGND VPWR VPWR sky130_fd_sc_hd__decap_3
XFILLER_11_119 VGND VGND VPWR VPWR sky130_fd_sc_hd__fill_1
XFILLER_11_148 VGND VGND VPWR VPWR sky130_fd_sc_hd__decap_12
XFILLER_11_160 VGND VGND VPWR VPWR sky130_fd_sc_hd__decap_12
XFILLER_11_173 VGND VGND VPWR VPWR sky130_fd_sc_hd__decap_12
XFILLER_11_185 VGND VGND VPWR VPWR sky130_fd_sc_hd__decap_12
XFILLER_11_197 VGND VGND VPWR VPWR sky130_fd_sc_hd__decap_8
XFILLER_11_220 VGND VGND VPWR VPWR sky130_fd_sc_hd__decap_12
XFILLER_11_232 VGND VGND VPWR VPWR sky130_fd_sc_hd__fill_1
XFILLER_11_241 VGND VGND VPWR VPWR sky130_fd_sc_hd__decap_8
XFILLER_11_257 VGND VGND VPWR VPWR sky130_fd_sc_hd__fill_1
XFILLER_11_259 VGND VGND VPWR VPWR sky130_fd_sc_hd__decap_4
XFILLER_11_263 VGND VGND VPWR VPWR sky130_fd_sc_hd__fill_1
XFILLER_12_17 VGND VGND VPWR VPWR sky130_fd_sc_hd__decap_3
XFILLER_12_34 VGND VGND VPWR VPWR sky130_fd_sc_hd__decap_8
XFILLER_12_42 VGND VGND VPWR VPWR sky130_fd_sc_hd__fill_1
XFILLER_12_44 VGND VGND VPWR VPWR sky130_fd_sc_hd__fill_2
XFILLER_12_74 VGND VGND VPWR VPWR sky130_fd_sc_hd__fill_2
XFILLER_12_86 VGND VGND VPWR VPWR sky130_fd_sc_hd__decap_3
XFILLER_12_92 VGND VGND VPWR VPWR sky130_fd_sc_hd__decap_3
XFILLER_12_102 VGND VGND VPWR VPWR sky130_fd_sc_hd__fill_2
XFILLER_12_111 VGND VGND VPWR VPWR sky130_fd_sc_hd__decap_12
XFILLER_12_123 VGND VGND VPWR VPWR sky130_fd_sc_hd__decap_6
XFILLER_12_130 VGND VGND VPWR VPWR sky130_fd_sc_hd__fill_1
XFILLER_12_146 VGND VGND VPWR VPWR sky130_fd_sc_hd__decap_12
XFILLER_12_158 VGND VGND VPWR VPWR sky130_fd_sc_hd__decap_12
XFILLER_12_170 VGND VGND VPWR VPWR sky130_fd_sc_hd__decap_12
XFILLER_12_182 VGND VGND VPWR VPWR sky130_fd_sc_hd__decap_12
XFILLER_12_197 VGND VGND VPWR VPWR sky130_fd_sc_hd__decap_12
XFILLER_12_209 VGND VGND VPWR VPWR sky130_fd_sc_hd__decap_6
XFILLER_12_216 VGND VGND VPWR VPWR sky130_fd_sc_hd__decap_8
XFILLER_12_224 VGND VGND VPWR VPWR sky130_fd_sc_hd__fill_2
XFILLER_12_263 VGND VGND VPWR VPWR sky130_fd_sc_hd__fill_1
XFILLER_13_9 VGND VGND VPWR VPWR sky130_fd_sc_hd__fill_2
XFILLER_13_19 VGND VGND VPWR VPWR sky130_fd_sc_hd__decap_8
XFILLER_13_27 VGND VGND VPWR VPWR sky130_fd_sc_hd__fill_2
XFILLER_13_36 VGND VGND VPWR VPWR sky130_fd_sc_hd__decap_12
XFILLER_13_56 VGND VGND VPWR VPWR sky130_fd_sc_hd__decap_12
XFILLER_13_68 VGND VGND VPWR VPWR sky130_fd_sc_hd__decap_4
XFILLER_13_75 VGND VGND VPWR VPWR sky130_fd_sc_hd__fill_1
XFILLER_13_84 VGND VGND VPWR VPWR sky130_fd_sc_hd__fill_2
XFILLER_13_87 VGND VGND VPWR VPWR sky130_fd_sc_hd__decap_8
XFILLER_13_95 VGND VGND VPWR VPWR sky130_fd_sc_hd__fill_2
XFILLER_13_103 VGND VGND VPWR VPWR sky130_fd_sc_hd__decap_12
XFILLER_13_115 VGND VGND VPWR VPWR sky130_fd_sc_hd__decap_12
XFILLER_13_127 VGND VGND VPWR VPWR sky130_fd_sc_hd__decap_6
XFILLER_13_157 VGND VGND VPWR VPWR sky130_fd_sc_hd__decap_8
XFILLER_13_183 VGND VGND VPWR VPWR sky130_fd_sc_hd__decap_6
XFILLER_13_189 VGND VGND VPWR VPWR sky130_fd_sc_hd__fill_1
XFILLER_13_201 VGND VGND VPWR VPWR sky130_fd_sc_hd__decap_12
XFILLER_13_213 VGND VGND VPWR VPWR sky130_fd_sc_hd__decap_12
XFILLER_13_225 VGND VGND VPWR VPWR sky130_fd_sc_hd__decap_12
XFILLER_13_237 VGND VGND VPWR VPWR sky130_fd_sc_hd__decap_4
XFILLER_13_257 VGND VGND VPWR VPWR sky130_fd_sc_hd__fill_1
XFILLER_13_259 VGND VGND VPWR VPWR sky130_fd_sc_hd__decap_4
XFILLER_13_263 VGND VGND VPWR VPWR sky130_fd_sc_hd__fill_1
XFILLER_14_29 VGND VGND VPWR VPWR sky130_fd_sc_hd__decap_12
XFILLER_14_41 VGND VGND VPWR VPWR sky130_fd_sc_hd__fill_2
XFILLER_14_44 VGND VGND VPWR VPWR sky130_fd_sc_hd__decap_12
XFILLER_14_56 VGND VGND VPWR VPWR sky130_fd_sc_hd__decap_12
XFILLER_14_68 VGND VGND VPWR VPWR sky130_fd_sc_hd__fill_1
XFILLER_14_90 VGND VGND VPWR VPWR sky130_fd_sc_hd__decap_12
XFILLER_14_102 VGND VGND VPWR VPWR sky130_fd_sc_hd__decap_6
XFILLER_14_115 VGND VGND VPWR VPWR sky130_fd_sc_hd__decap_12
XFILLER_14_127 VGND VGND VPWR VPWR sky130_fd_sc_hd__fill_2
XFILLER_14_130 VGND VGND VPWR VPWR sky130_fd_sc_hd__decap_4
XFILLER_14_156 VGND VGND VPWR VPWR sky130_fd_sc_hd__decap_6
XFILLER_14_162 VGND VGND VPWR VPWR sky130_fd_sc_hd__fill_1
XFILLER_14_166 VGND VGND VPWR VPWR sky130_fd_sc_hd__fill_2
XFILLER_14_188 VGND VGND VPWR VPWR sky130_fd_sc_hd__fill_2
XFILLER_14_210 VGND VGND VPWR VPWR sky130_fd_sc_hd__decap_4
XFILLER_14_214 VGND VGND VPWR VPWR sky130_fd_sc_hd__fill_1
XFILLER_14_216 VGND VGND VPWR VPWR sky130_fd_sc_hd__decap_12
XFILLER_14_228 VGND VGND VPWR VPWR sky130_fd_sc_hd__decap_8
XFILLER_14_263 VGND VGND VPWR VPWR sky130_fd_sc_hd__fill_1
XFILLER_15_24 VGND VGND VPWR VPWR sky130_fd_sc_hd__decap_12
XFILLER_15_36 VGND VGND VPWR VPWR sky130_fd_sc_hd__decap_12
XFILLER_15_48 VGND VGND VPWR VPWR sky130_fd_sc_hd__decap_12
XFILLER_15_60 VGND VGND VPWR VPWR sky130_fd_sc_hd__decap_12
XFILLER_15_72 VGND VGND VPWR VPWR sky130_fd_sc_hd__decap_4
XFILLER_15_87 VGND VGND VPWR VPWR sky130_fd_sc_hd__decap_12
XFILLER_15_99 VGND VGND VPWR VPWR sky130_fd_sc_hd__decap_4
XFILLER_15_103 VGND VGND VPWR VPWR sky130_fd_sc_hd__fill_1
XFILLER_15_115 VGND VGND VPWR VPWR sky130_fd_sc_hd__decap_12
XFILLER_15_127 VGND VGND VPWR VPWR sky130_fd_sc_hd__decap_12
XFILLER_15_139 VGND VGND VPWR VPWR sky130_fd_sc_hd__decap_12
XFILLER_15_151 VGND VGND VPWR VPWR sky130_fd_sc_hd__decap_8
XFILLER_15_159 VGND VGND VPWR VPWR sky130_fd_sc_hd__fill_1
XFILLER_15_163 VGND VGND VPWR VPWR sky130_fd_sc_hd__fill_2
XFILLER_15_179 VGND VGND VPWR VPWR sky130_fd_sc_hd__decap_8
XFILLER_15_201 VGND VGND VPWR VPWR sky130_fd_sc_hd__decap_12
XFILLER_15_213 VGND VGND VPWR VPWR sky130_fd_sc_hd__decap_12
XFILLER_15_225 VGND VGND VPWR VPWR sky130_fd_sc_hd__decap_12
XFILLER_15_237 VGND VGND VPWR VPWR sky130_fd_sc_hd__decap_4
XFILLER_15_241 VGND VGND VPWR VPWR sky130_fd_sc_hd__fill_1
XFILLER_15_259 VGND VGND VPWR VPWR sky130_fd_sc_hd__decap_4
XFILLER_15_263 VGND VGND VPWR VPWR sky130_fd_sc_hd__fill_1
XFILLER_16_19 VGND VGND VPWR VPWR sky130_fd_sc_hd__decap_12
XFILLER_16_31 VGND VGND VPWR VPWR sky130_fd_sc_hd__decap_12
XFILLER_16_44 VGND VGND VPWR VPWR sky130_fd_sc_hd__decap_8
XFILLER_16_52 VGND VGND VPWR VPWR sky130_fd_sc_hd__decap_3
XFILLER_16_62 VGND VGND VPWR VPWR sky130_fd_sc_hd__decap_4
XFILLER_16_69 VGND VGND VPWR VPWR sky130_fd_sc_hd__fill_2
XFILLER_16_86 VGND VGND VPWR VPWR sky130_fd_sc_hd__fill_1
XFILLER_16_94 VGND VGND VPWR VPWR sky130_fd_sc_hd__decap_8
XFILLER_16_102 VGND VGND VPWR VPWR sky130_fd_sc_hd__fill_1
XFILLER_16_121 VGND VGND VPWR VPWR sky130_fd_sc_hd__decap_4
XFILLER_16_125 VGND VGND VPWR VPWR sky130_fd_sc_hd__fill_1
XFILLER_16_137 VGND VGND VPWR VPWR sky130_fd_sc_hd__decap_12
XFILLER_16_149 VGND VGND VPWR VPWR sky130_fd_sc_hd__decap_12
XFILLER_16_161 VGND VGND VPWR VPWR sky130_fd_sc_hd__decap_8
XFILLER_16_174 VGND VGND VPWR VPWR sky130_fd_sc_hd__decap_12
XFILLER_16_186 VGND VGND VPWR VPWR sky130_fd_sc_hd__fill_1
XFILLER_16_216 VGND VGND VPWR VPWR sky130_fd_sc_hd__decap_12
XFILLER_16_228 VGND VGND VPWR VPWR sky130_fd_sc_hd__decap_12
XFILLER_16_240 VGND VGND VPWR VPWR sky130_fd_sc_hd__decap_8
XFILLER_17_9 VGND VGND VPWR VPWR sky130_fd_sc_hd__fill_1
XFILLER_17_17 VGND VGND VPWR VPWR sky130_fd_sc_hd__decap_12
XFILLER_17_29 VGND VGND VPWR VPWR sky130_fd_sc_hd__decap_12
XFILLER_17_41 VGND VGND VPWR VPWR sky130_fd_sc_hd__decap_12
XFILLER_17_53 VGND VGND VPWR VPWR sky130_fd_sc_hd__fill_2
XFILLER_17_63 VGND VGND VPWR VPWR sky130_fd_sc_hd__decap_6
XFILLER_17_76 VGND VGND VPWR VPWR sky130_fd_sc_hd__decap_8
XFILLER_17_84 VGND VGND VPWR VPWR sky130_fd_sc_hd__fill_2
XFILLER_17_87 VGND VGND VPWR VPWR sky130_fd_sc_hd__decap_12
XFILLER_17_99 VGND VGND VPWR VPWR sky130_fd_sc_hd__decap_8
XFILLER_17_116 VGND VGND VPWR VPWR sky130_fd_sc_hd__decap_6
XFILLER_17_141 VGND VGND VPWR VPWR sky130_fd_sc_hd__decap_3
XFILLER_17_151 VGND VGND VPWR VPWR sky130_fd_sc_hd__decap_12
XFILLER_17_163 VGND VGND VPWR VPWR sky130_fd_sc_hd__decap_8
XFILLER_17_171 VGND VGND VPWR VPWR sky130_fd_sc_hd__fill_1
XFILLER_17_173 VGND VGND VPWR VPWR sky130_fd_sc_hd__decap_12
XFILLER_17_185 VGND VGND VPWR VPWR sky130_fd_sc_hd__decap_8
XFILLER_17_193 VGND VGND VPWR VPWR sky130_fd_sc_hd__decap_3
XFILLER_17_203 VGND VGND VPWR VPWR sky130_fd_sc_hd__decap_12
XFILLER_17_215 VGND VGND VPWR VPWR sky130_fd_sc_hd__decap_12
XFILLER_17_227 VGND VGND VPWR VPWR sky130_fd_sc_hd__decap_12
XFILLER_17_239 VGND VGND VPWR VPWR sky130_fd_sc_hd__decap_12
XFILLER_17_251 VGND VGND VPWR VPWR sky130_fd_sc_hd__decap_6
XFILLER_17_257 VGND VGND VPWR VPWR sky130_fd_sc_hd__fill_1
XFILLER_17_259 VGND VGND VPWR VPWR sky130_fd_sc_hd__decap_4
XFILLER_17_263 VGND VGND VPWR VPWR sky130_fd_sc_hd__fill_1
XFILLER_18_23 VGND VGND VPWR VPWR sky130_fd_sc_hd__fill_2
XFILLER_18_44 VGND VGND VPWR VPWR sky130_fd_sc_hd__decap_4
XFILLER_18_48 VGND VGND VPWR VPWR sky130_fd_sc_hd__fill_1
XFILLER_18_78 VGND VGND VPWR VPWR sky130_fd_sc_hd__decap_12
XFILLER_18_90 VGND VGND VPWR VPWR sky130_fd_sc_hd__decap_4
XFILLER_18_94 VGND VGND VPWR VPWR sky130_fd_sc_hd__fill_1
XFILLER_18_102 VGND VGND VPWR VPWR sky130_fd_sc_hd__decap_12
XFILLER_18_114 VGND VGND VPWR VPWR sky130_fd_sc_hd__decap_12
XFILLER_18_126 VGND VGND VPWR VPWR sky130_fd_sc_hd__decap_3
XFILLER_18_130 VGND VGND VPWR VPWR sky130_fd_sc_hd__decap_12
XFILLER_18_163 VGND VGND VPWR VPWR sky130_fd_sc_hd__decap_8
XFILLER_18_171 VGND VGND VPWR VPWR sky130_fd_sc_hd__fill_2
XFILLER_18_180 VGND VGND VPWR VPWR sky130_fd_sc_hd__decap_8
XFILLER_18_188 VGND VGND VPWR VPWR sky130_fd_sc_hd__decap_3
XFILLER_18_198 VGND VGND VPWR VPWR sky130_fd_sc_hd__decap_12
XFILLER_18_210 VGND VGND VPWR VPWR sky130_fd_sc_hd__decap_4
XFILLER_18_214 VGND VGND VPWR VPWR sky130_fd_sc_hd__fill_1
XFILLER_18_216 VGND VGND VPWR VPWR sky130_fd_sc_hd__decap_12
XFILLER_18_228 VGND VGND VPWR VPWR sky130_fd_sc_hd__decap_12
XFILLER_18_240 VGND VGND VPWR VPWR sky130_fd_sc_hd__decap_12
XFILLER_18_252 VGND VGND VPWR VPWR sky130_fd_sc_hd__decap_12
XFILLER_19_1 VGND VGND VPWR VPWR sky130_fd_sc_hd__decap_4
XFILLER_19_5 VGND VGND VPWR VPWR sky130_fd_sc_hd__fill_1
XFILLER_19_43 VGND VGND VPWR VPWR sky130_fd_sc_hd__decap_4
XFILLER_19_50 VGND VGND VPWR VPWR sky130_fd_sc_hd__decap_12
XFILLER_19_62 VGND VGND VPWR VPWR sky130_fd_sc_hd__decap_8
XFILLER_19_70 VGND VGND VPWR VPWR sky130_fd_sc_hd__fill_2
XFILLER_19_76 VGND VGND VPWR VPWR sky130_fd_sc_hd__decap_8
XFILLER_19_84 VGND VGND VPWR VPWR sky130_fd_sc_hd__fill_2
XFILLER_19_87 VGND VGND VPWR VPWR sky130_fd_sc_hd__decap_6
XFILLER_19_93 VGND VGND VPWR VPWR sky130_fd_sc_hd__fill_1
XFILLER_19_109 VGND VGND VPWR VPWR sky130_fd_sc_hd__decap_4
XFILLER_19_120 VGND VGND VPWR VPWR sky130_fd_sc_hd__decap_12
XFILLER_19_132 VGND VGND VPWR VPWR sky130_fd_sc_hd__decap_12
XFILLER_19_144 VGND VGND VPWR VPWR sky130_fd_sc_hd__fill_1
XFILLER_19_148 VGND VGND VPWR VPWR sky130_fd_sc_hd__fill_1
XFILLER_19_173 VGND VGND VPWR VPWR sky130_fd_sc_hd__decap_12
XFILLER_19_185 VGND VGND VPWR VPWR sky130_fd_sc_hd__fill_2
XFILLER_19_215 VGND VGND VPWR VPWR sky130_fd_sc_hd__decap_12
XFILLER_19_227 VGND VGND VPWR VPWR sky130_fd_sc_hd__decap_12
XFILLER_19_239 VGND VGND VPWR VPWR sky130_fd_sc_hd__decap_12
XFILLER_19_251 VGND VGND VPWR VPWR sky130_fd_sc_hd__decap_6
XFILLER_19_257 VGND VGND VPWR VPWR sky130_fd_sc_hd__fill_1
XFILLER_19_259 VGND VGND VPWR VPWR sky130_fd_sc_hd__decap_4
XFILLER_19_263 VGND VGND VPWR VPWR sky130_fd_sc_hd__fill_1
XFILLER_20_25 VGND VGND VPWR VPWR sky130_fd_sc_hd__decap_12
XFILLER_20_37 VGND VGND VPWR VPWR sky130_fd_sc_hd__decap_6
XFILLER_20_44 VGND VGND VPWR VPWR sky130_fd_sc_hd__decap_12
XFILLER_20_66 VGND VGND VPWR VPWR sky130_fd_sc_hd__fill_1
XFILLER_20_79 VGND VGND VPWR VPWR sky130_fd_sc_hd__decap_12
XFILLER_20_91 VGND VGND VPWR VPWR sky130_fd_sc_hd__fill_2
XFILLER_20_100 VGND VGND VPWR VPWR sky130_fd_sc_hd__decap_8
XFILLER_20_108 VGND VGND VPWR VPWR sky130_fd_sc_hd__fill_2
XFILLER_20_118 VGND VGND VPWR VPWR sky130_fd_sc_hd__decap_4
XFILLER_20_130 VGND VGND VPWR VPWR sky130_fd_sc_hd__decap_12
XFILLER_20_142 VGND VGND VPWR VPWR sky130_fd_sc_hd__decap_4
XFILLER_20_149 VGND VGND VPWR VPWR sky130_fd_sc_hd__decap_8
XFILLER_20_157 VGND VGND VPWR VPWR sky130_fd_sc_hd__fill_1
XFILLER_20_166 VGND VGND VPWR VPWR sky130_fd_sc_hd__decap_3
XFILLER_20_176 VGND VGND VPWR VPWR sky130_fd_sc_hd__decap_6
XFILLER_20_182 VGND VGND VPWR VPWR sky130_fd_sc_hd__fill_1
XFILLER_20_191 VGND VGND VPWR VPWR sky130_fd_sc_hd__fill_2
XFILLER_20_200 VGND VGND VPWR VPWR sky130_fd_sc_hd__decap_12
XFILLER_20_212 VGND VGND VPWR VPWR sky130_fd_sc_hd__decap_3
XFILLER_20_216 VGND VGND VPWR VPWR sky130_fd_sc_hd__decap_12
XFILLER_20_228 VGND VGND VPWR VPWR sky130_fd_sc_hd__decap_12
XFILLER_20_240 VGND VGND VPWR VPWR sky130_fd_sc_hd__decap_12
XFILLER_20_252 VGND VGND VPWR VPWR sky130_fd_sc_hd__decap_12
XFILLER_21_1 VGND VGND VPWR VPWR sky130_fd_sc_hd__decap_6
XFILLER_21_22 VGND VGND VPWR VPWR sky130_fd_sc_hd__decap_6
XFILLER_21_35 VGND VGND VPWR VPWR sky130_fd_sc_hd__decap_12
XFILLER_21_47 VGND VGND VPWR VPWR sky130_fd_sc_hd__decap_4
XFILLER_21_51 VGND VGND VPWR VPWR sky130_fd_sc_hd__fill_1
XFILLER_21_57 VGND VGND VPWR VPWR sky130_fd_sc_hd__decap_12
XFILLER_21_69 VGND VGND VPWR VPWR sky130_fd_sc_hd__fill_2
XFILLER_21_74 VGND VGND VPWR VPWR sky130_fd_sc_hd__fill_1
XFILLER_21_87 VGND VGND VPWR VPWR sky130_fd_sc_hd__decap_4
XFILLER_21_91 VGND VGND VPWR VPWR sky130_fd_sc_hd__fill_1
XFILLER_21_103 VGND VGND VPWR VPWR sky130_fd_sc_hd__decap_12
XFILLER_21_115 VGND VGND VPWR VPWR sky130_fd_sc_hd__decap_4
XFILLER_21_138 VGND VGND VPWR VPWR sky130_fd_sc_hd__decap_12
XFILLER_21_150 VGND VGND VPWR VPWR sky130_fd_sc_hd__decap_12
XFILLER_21_162 VGND VGND VPWR VPWR sky130_fd_sc_hd__decap_8
XFILLER_21_170 VGND VGND VPWR VPWR sky130_fd_sc_hd__fill_2
XFILLER_21_173 VGND VGND VPWR VPWR sky130_fd_sc_hd__decap_4
XFILLER_21_204 VGND VGND VPWR VPWR sky130_fd_sc_hd__decap_12
XFILLER_21_216 VGND VGND VPWR VPWR sky130_fd_sc_hd__decap_12
XFILLER_21_228 VGND VGND VPWR VPWR sky130_fd_sc_hd__decap_12
XFILLER_21_240 VGND VGND VPWR VPWR sky130_fd_sc_hd__decap_12
XFILLER_21_252 VGND VGND VPWR VPWR sky130_fd_sc_hd__decap_6
XFILLER_21_259 VGND VGND VPWR VPWR sky130_fd_sc_hd__decap_4
XFILLER_21_263 VGND VGND VPWR VPWR sky130_fd_sc_hd__fill_1
XFILLER_22_20 VGND VGND VPWR VPWR sky130_fd_sc_hd__decap_8
XFILLER_22_28 VGND VGND VPWR VPWR sky130_fd_sc_hd__fill_2
XFILLER_22_33 VGND VGND VPWR VPWR sky130_fd_sc_hd__decap_8
XFILLER_22_41 VGND VGND VPWR VPWR sky130_fd_sc_hd__fill_2
XFILLER_22_44 VGND VGND VPWR VPWR sky130_fd_sc_hd__decap_6
XFILLER_22_63 VGND VGND VPWR VPWR sky130_fd_sc_hd__decap_12
XFILLER_22_75 VGND VGND VPWR VPWR sky130_fd_sc_hd__decap_12
XFILLER_22_87 VGND VGND VPWR VPWR sky130_fd_sc_hd__fill_1
XFILLER_22_107 VGND VGND VPWR VPWR sky130_fd_sc_hd__decap_6
XFILLER_22_113 VGND VGND VPWR VPWR sky130_fd_sc_hd__fill_1
XFILLER_22_124 VGND VGND VPWR VPWR sky130_fd_sc_hd__fill_1
XFILLER_22_134 VGND VGND VPWR VPWR sky130_fd_sc_hd__decap_12
XFILLER_22_146 VGND VGND VPWR VPWR sky130_fd_sc_hd__fill_1
XFILLER_22_169 VGND VGND VPWR VPWR sky130_fd_sc_hd__decap_12
XFILLER_22_181 VGND VGND VPWR VPWR sky130_fd_sc_hd__decap_3
XFILLER_22_191 VGND VGND VPWR VPWR sky130_fd_sc_hd__decap_12
XFILLER_22_203 VGND VGND VPWR VPWR sky130_fd_sc_hd__decap_12
XFILLER_22_216 VGND VGND VPWR VPWR sky130_fd_sc_hd__decap_12
XFILLER_22_228 VGND VGND VPWR VPWR sky130_fd_sc_hd__decap_12
XFILLER_22_240 VGND VGND VPWR VPWR sky130_fd_sc_hd__decap_12
XFILLER_22_252 VGND VGND VPWR VPWR sky130_fd_sc_hd__decap_12
XFILLER_23_16 VGND VGND VPWR VPWR sky130_fd_sc_hd__decap_6
XFILLER_23_22 VGND VGND VPWR VPWR sky130_fd_sc_hd__fill_1
XFILLER_23_40 VGND VGND VPWR VPWR sky130_fd_sc_hd__decap_12
XFILLER_23_52 VGND VGND VPWR VPWR sky130_fd_sc_hd__fill_1
XFILLER_23_59 VGND VGND VPWR VPWR sky130_fd_sc_hd__fill_1
XFILLER_23_63 VGND VGND VPWR VPWR sky130_fd_sc_hd__decap_12
XFILLER_23_75 VGND VGND VPWR VPWR sky130_fd_sc_hd__decap_6
XFILLER_23_94 VGND VGND VPWR VPWR sky130_fd_sc_hd__decap_12
XFILLER_23_106 VGND VGND VPWR VPWR sky130_fd_sc_hd__decap_12
XFILLER_23_118 VGND VGND VPWR VPWR sky130_fd_sc_hd__decap_12
XFILLER_23_130 VGND VGND VPWR VPWR sky130_fd_sc_hd__decap_4
XFILLER_23_138 VGND VGND VPWR VPWR sky130_fd_sc_hd__decap_12
XFILLER_23_150 VGND VGND VPWR VPWR sky130_fd_sc_hd__decap_12
XFILLER_23_162 VGND VGND VPWR VPWR sky130_fd_sc_hd__decap_8
XFILLER_23_170 VGND VGND VPWR VPWR sky130_fd_sc_hd__fill_2
XFILLER_23_173 VGND VGND VPWR VPWR sky130_fd_sc_hd__decap_4
XFILLER_23_185 VGND VGND VPWR VPWR sky130_fd_sc_hd__decap_12
XFILLER_23_197 VGND VGND VPWR VPWR sky130_fd_sc_hd__decap_12
XFILLER_23_209 VGND VGND VPWR VPWR sky130_fd_sc_hd__decap_12
XFILLER_23_221 VGND VGND VPWR VPWR sky130_fd_sc_hd__decap_12
XFILLER_23_233 VGND VGND VPWR VPWR sky130_fd_sc_hd__decap_12
XFILLER_23_245 VGND VGND VPWR VPWR sky130_fd_sc_hd__decap_12
XFILLER_23_257 VGND VGND VPWR VPWR sky130_fd_sc_hd__fill_1
XFILLER_23_259 VGND VGND VPWR VPWR sky130_fd_sc_hd__decap_4
XFILLER_23_263 VGND VGND VPWR VPWR sky130_fd_sc_hd__fill_1
XFILLER_24_9 VGND VGND VPWR VPWR sky130_fd_sc_hd__decap_6
XFILLER_24_31 VGND VGND VPWR VPWR sky130_fd_sc_hd__fill_2
XFILLER_24_40 VGND VGND VPWR VPWR sky130_fd_sc_hd__decap_3
XFILLER_24_44 VGND VGND VPWR VPWR sky130_fd_sc_hd__decap_8
XFILLER_24_62 VGND VGND VPWR VPWR sky130_fd_sc_hd__decap_12
XFILLER_24_74 VGND VGND VPWR VPWR sky130_fd_sc_hd__decap_4
XFILLER_24_83 VGND VGND VPWR VPWR sky130_fd_sc_hd__decap_12
XFILLER_24_95 VGND VGND VPWR VPWR sky130_fd_sc_hd__decap_8
XFILLER_24_103 VGND VGND VPWR VPWR sky130_fd_sc_hd__fill_1
XFILLER_24_111 VGND VGND VPWR VPWR sky130_fd_sc_hd__decap_6
XFILLER_24_117 VGND VGND VPWR VPWR sky130_fd_sc_hd__fill_1
XFILLER_24_121 VGND VGND VPWR VPWR sky130_fd_sc_hd__decap_8
XFILLER_24_136 VGND VGND VPWR VPWR sky130_fd_sc_hd__fill_1
XFILLER_24_142 VGND VGND VPWR VPWR sky130_fd_sc_hd__decap_3
XFILLER_24_152 VGND VGND VPWR VPWR sky130_fd_sc_hd__fill_1
XFILLER_24_161 VGND VGND VPWR VPWR sky130_fd_sc_hd__decap_8
XFILLER_24_169 VGND VGND VPWR VPWR sky130_fd_sc_hd__decap_3
XFILLER_24_191 VGND VGND VPWR VPWR sky130_fd_sc_hd__decap_12
XFILLER_24_203 VGND VGND VPWR VPWR sky130_fd_sc_hd__decap_12
XFILLER_24_216 VGND VGND VPWR VPWR sky130_fd_sc_hd__decap_12
XFILLER_24_228 VGND VGND VPWR VPWR sky130_fd_sc_hd__decap_12
XFILLER_24_240 VGND VGND VPWR VPWR sky130_fd_sc_hd__decap_12
XFILLER_24_252 VGND VGND VPWR VPWR sky130_fd_sc_hd__decap_12
XFILLER_25_1 VGND VGND VPWR VPWR sky130_fd_sc_hd__decap_6
XFILLER_25_25 VGND VGND VPWR VPWR sky130_fd_sc_hd__fill_1
XFILLER_25_36 VGND VGND VPWR VPWR sky130_fd_sc_hd__decap_12
XFILLER_25_48 VGND VGND VPWR VPWR sky130_fd_sc_hd__decap_3
XFILLER_25_67 VGND VGND VPWR VPWR sky130_fd_sc_hd__decap_12
XFILLER_25_79 VGND VGND VPWR VPWR sky130_fd_sc_hd__decap_4
XFILLER_25_87 VGND VGND VPWR VPWR sky130_fd_sc_hd__fill_1
XFILLER_25_95 VGND VGND VPWR VPWR sky130_fd_sc_hd__fill_2
XFILLER_25_108 VGND VGND VPWR VPWR sky130_fd_sc_hd__decap_6
XFILLER_25_114 VGND VGND VPWR VPWR sky130_fd_sc_hd__fill_1
XFILLER_25_120 VGND VGND VPWR VPWR sky130_fd_sc_hd__decap_6
XFILLER_25_129 VGND VGND VPWR VPWR sky130_fd_sc_hd__decap_12
XFILLER_25_141 VGND VGND VPWR VPWR sky130_fd_sc_hd__decap_3
XFILLER_25_171 VGND VGND VPWR VPWR sky130_fd_sc_hd__fill_1
XFILLER_25_193 VGND VGND VPWR VPWR sky130_fd_sc_hd__decap_12
XFILLER_25_205 VGND VGND VPWR VPWR sky130_fd_sc_hd__decap_12
XFILLER_25_217 VGND VGND VPWR VPWR sky130_fd_sc_hd__decap_12
XFILLER_25_229 VGND VGND VPWR VPWR sky130_fd_sc_hd__decap_12
XFILLER_25_241 VGND VGND VPWR VPWR sky130_fd_sc_hd__decap_12
XFILLER_25_253 VGND VGND VPWR VPWR sky130_fd_sc_hd__decap_4
XFILLER_25_257 VGND VGND VPWR VPWR sky130_fd_sc_hd__fill_1
XFILLER_25_259 VGND VGND VPWR VPWR sky130_fd_sc_hd__decap_4
XFILLER_25_263 VGND VGND VPWR VPWR sky130_fd_sc_hd__fill_1
XFILLER_26_1 VGND VGND VPWR VPWR sky130_fd_sc_hd__decap_6
XFILLER_26_29 VGND VGND VPWR VPWR sky130_fd_sc_hd__decap_12
XFILLER_26_41 VGND VGND VPWR VPWR sky130_fd_sc_hd__fill_2
XFILLER_26_44 VGND VGND VPWR VPWR sky130_fd_sc_hd__decap_12
XFILLER_26_56 VGND VGND VPWR VPWR sky130_fd_sc_hd__decap_3
XFILLER_26_69 VGND VGND VPWR VPWR sky130_fd_sc_hd__decap_12
XFILLER_26_81 VGND VGND VPWR VPWR sky130_fd_sc_hd__decap_12
XFILLER_26_93 VGND VGND VPWR VPWR sky130_fd_sc_hd__decap_8
XFILLER_26_101 VGND VGND VPWR VPWR sky130_fd_sc_hd__fill_1
XFILLER_26_105 VGND VGND VPWR VPWR sky130_fd_sc_hd__fill_2
XFILLER_26_112 VGND VGND VPWR VPWR sky130_fd_sc_hd__fill_2
XFILLER_26_124 VGND VGND VPWR VPWR sky130_fd_sc_hd__decap_4
XFILLER_26_128 VGND VGND VPWR VPWR sky130_fd_sc_hd__fill_1
XFILLER_26_130 VGND VGND VPWR VPWR sky130_fd_sc_hd__decap_6
XFILLER_26_143 VGND VGND VPWR VPWR sky130_fd_sc_hd__decap_8
XFILLER_26_151 VGND VGND VPWR VPWR sky130_fd_sc_hd__decap_3
XFILLER_26_161 VGND VGND VPWR VPWR sky130_fd_sc_hd__decap_12
XFILLER_26_173 VGND VGND VPWR VPWR sky130_fd_sc_hd__decap_12
XFILLER_26_185 VGND VGND VPWR VPWR sky130_fd_sc_hd__decap_12
XFILLER_26_197 VGND VGND VPWR VPWR sky130_fd_sc_hd__decap_12
XFILLER_26_209 VGND VGND VPWR VPWR sky130_fd_sc_hd__decap_6
XFILLER_26_216 VGND VGND VPWR VPWR sky130_fd_sc_hd__decap_12
XFILLER_26_228 VGND VGND VPWR VPWR sky130_fd_sc_hd__decap_12
XFILLER_26_240 VGND VGND VPWR VPWR sky130_fd_sc_hd__decap_12
XFILLER_26_252 VGND VGND VPWR VPWR sky130_fd_sc_hd__decap_12
XFILLER_27_21 VGND VGND VPWR VPWR sky130_fd_sc_hd__fill_2
XFILLER_27_33 VGND VGND VPWR VPWR sky130_fd_sc_hd__decap_12
XFILLER_27_45 VGND VGND VPWR VPWR sky130_fd_sc_hd__decap_8
XFILLER_27_53 VGND VGND VPWR VPWR sky130_fd_sc_hd__fill_2
XFILLER_27_72 VGND VGND VPWR VPWR sky130_fd_sc_hd__decap_12
XFILLER_27_84 VGND VGND VPWR VPWR sky130_fd_sc_hd__fill_2
XFILLER_27_87 VGND VGND VPWR VPWR sky130_fd_sc_hd__decap_12
XFILLER_27_99 VGND VGND VPWR VPWR sky130_fd_sc_hd__decap_12
XFILLER_27_111 VGND VGND VPWR VPWR sky130_fd_sc_hd__decap_6
XFILLER_27_117 VGND VGND VPWR VPWR sky130_fd_sc_hd__fill_1
XFILLER_27_122 VGND VGND VPWR VPWR sky130_fd_sc_hd__decap_12
XFILLER_27_134 VGND VGND VPWR VPWR sky130_fd_sc_hd__decap_12
XFILLER_27_146 VGND VGND VPWR VPWR sky130_fd_sc_hd__decap_3
XFILLER_27_156 VGND VGND VPWR VPWR sky130_fd_sc_hd__decap_12
XFILLER_27_168 VGND VGND VPWR VPWR sky130_fd_sc_hd__decap_4
XFILLER_27_173 VGND VGND VPWR VPWR sky130_fd_sc_hd__decap_12
XFILLER_27_185 VGND VGND VPWR VPWR sky130_fd_sc_hd__decap_12
XFILLER_27_197 VGND VGND VPWR VPWR sky130_fd_sc_hd__decap_12
XFILLER_27_209 VGND VGND VPWR VPWR sky130_fd_sc_hd__decap_12
XFILLER_27_221 VGND VGND VPWR VPWR sky130_fd_sc_hd__decap_12
XFILLER_27_233 VGND VGND VPWR VPWR sky130_fd_sc_hd__decap_12
XFILLER_27_245 VGND VGND VPWR VPWR sky130_fd_sc_hd__decap_12
XFILLER_27_257 VGND VGND VPWR VPWR sky130_fd_sc_hd__fill_1
XFILLER_27_259 VGND VGND VPWR VPWR sky130_fd_sc_hd__decap_4
XFILLER_27_263 VGND VGND VPWR VPWR sky130_fd_sc_hd__fill_1
XFILLER_28_1 VGND VGND VPWR VPWR sky130_fd_sc_hd__decap_6
XFILLER_28_25 VGND VGND VPWR VPWR sky130_fd_sc_hd__decap_12
XFILLER_28_37 VGND VGND VPWR VPWR sky130_fd_sc_hd__decap_6
XFILLER_28_44 VGND VGND VPWR VPWR sky130_fd_sc_hd__decap_12
XFILLER_28_56 VGND VGND VPWR VPWR sky130_fd_sc_hd__decap_6
XFILLER_28_69 VGND VGND VPWR VPWR sky130_fd_sc_hd__decap_4
XFILLER_28_73 VGND VGND VPWR VPWR sky130_fd_sc_hd__fill_1
XFILLER_28_94 VGND VGND VPWR VPWR sky130_fd_sc_hd__decap_12
XFILLER_28_106 VGND VGND VPWR VPWR sky130_fd_sc_hd__decap_8
XFILLER_28_114 VGND VGND VPWR VPWR sky130_fd_sc_hd__fill_2
XFILLER_28_122 VGND VGND VPWR VPWR sky130_fd_sc_hd__fill_2
XFILLER_28_130 VGND VGND VPWR VPWR sky130_fd_sc_hd__decap_12
XFILLER_28_142 VGND VGND VPWR VPWR sky130_fd_sc_hd__decap_4
XFILLER_28_146 VGND VGND VPWR VPWR sky130_fd_sc_hd__fill_1
XFILLER_28_162 VGND VGND VPWR VPWR sky130_fd_sc_hd__decap_12
XFILLER_28_174 VGND VGND VPWR VPWR sky130_fd_sc_hd__decap_12
XFILLER_28_186 VGND VGND VPWR VPWR sky130_fd_sc_hd__decap_12
XFILLER_28_198 VGND VGND VPWR VPWR sky130_fd_sc_hd__decap_12
XFILLER_28_210 VGND VGND VPWR VPWR sky130_fd_sc_hd__decap_4
XFILLER_28_214 VGND VGND VPWR VPWR sky130_fd_sc_hd__fill_1
XFILLER_28_216 VGND VGND VPWR VPWR sky130_fd_sc_hd__decap_12
XFILLER_28_228 VGND VGND VPWR VPWR sky130_fd_sc_hd__decap_12
XFILLER_28_240 VGND VGND VPWR VPWR sky130_fd_sc_hd__decap_12
XFILLER_28_252 VGND VGND VPWR VPWR sky130_fd_sc_hd__decap_12
XFILLER_29_1 VGND VGND VPWR VPWR sky130_fd_sc_hd__decap_6
XFILLER_29_25 VGND VGND VPWR VPWR sky130_fd_sc_hd__decap_12
XFILLER_29_37 VGND VGND VPWR VPWR sky130_fd_sc_hd__decap_12
XFILLER_29_49 VGND VGND VPWR VPWR sky130_fd_sc_hd__decap_12
XFILLER_29_61 VGND VGND VPWR VPWR sky130_fd_sc_hd__decap_12
XFILLER_29_73 VGND VGND VPWR VPWR sky130_fd_sc_hd__fill_1
XFILLER_29_84 VGND VGND VPWR VPWR sky130_fd_sc_hd__fill_2
XFILLER_29_87 VGND VGND VPWR VPWR sky130_fd_sc_hd__decap_4
XFILLER_29_91 VGND VGND VPWR VPWR sky130_fd_sc_hd__fill_1
XFILLER_29_96 VGND VGND VPWR VPWR sky130_fd_sc_hd__fill_2
XFILLER_29_105 VGND VGND VPWR VPWR sky130_fd_sc_hd__decap_12
XFILLER_29_167 VGND VGND VPWR VPWR sky130_fd_sc_hd__decap_4
XFILLER_29_171 VGND VGND VPWR VPWR sky130_fd_sc_hd__fill_1
XFILLER_29_173 VGND VGND VPWR VPWR sky130_fd_sc_hd__decap_12
XFILLER_29_185 VGND VGND VPWR VPWR sky130_fd_sc_hd__decap_12
XFILLER_29_197 VGND VGND VPWR VPWR sky130_fd_sc_hd__decap_12
XFILLER_29_209 VGND VGND VPWR VPWR sky130_fd_sc_hd__decap_12
XFILLER_29_221 VGND VGND VPWR VPWR sky130_fd_sc_hd__decap_12
XFILLER_29_233 VGND VGND VPWR VPWR sky130_fd_sc_hd__decap_12
XFILLER_29_245 VGND VGND VPWR VPWR sky130_fd_sc_hd__decap_12
XFILLER_29_257 VGND VGND VPWR VPWR sky130_fd_sc_hd__fill_1
XFILLER_29_259 VGND VGND VPWR VPWR sky130_fd_sc_hd__decap_4
XFILLER_29_263 VGND VGND VPWR VPWR sky130_fd_sc_hd__fill_1
XFILLER_30_17 VGND VGND VPWR VPWR sky130_fd_sc_hd__decap_12
XFILLER_30_29 VGND VGND VPWR VPWR sky130_fd_sc_hd__decap_12
XFILLER_30_41 VGND VGND VPWR VPWR sky130_fd_sc_hd__fill_2
XFILLER_30_44 VGND VGND VPWR VPWR sky130_fd_sc_hd__decap_12
XFILLER_30_56 VGND VGND VPWR VPWR sky130_fd_sc_hd__decap_12
XFILLER_30_68 VGND VGND VPWR VPWR sky130_fd_sc_hd__decap_8
XFILLER_30_76 VGND VGND VPWR VPWR sky130_fd_sc_hd__fill_2
XFILLER_30_85 VGND VGND VPWR VPWR sky130_fd_sc_hd__decap_4
XFILLER_30_89 VGND VGND VPWR VPWR sky130_fd_sc_hd__fill_1
XFILLER_30_97 VGND VGND VPWR VPWR sky130_fd_sc_hd__decap_8
XFILLER_30_105 VGND VGND VPWR VPWR sky130_fd_sc_hd__decap_3
XFILLER_30_122 VGND VGND VPWR VPWR sky130_fd_sc_hd__decap_6
XFILLER_30_128 VGND VGND VPWR VPWR sky130_fd_sc_hd__fill_1
XFILLER_30_130 VGND VGND VPWR VPWR sky130_fd_sc_hd__decap_12
XFILLER_30_142 VGND VGND VPWR VPWR sky130_fd_sc_hd__decap_12
XFILLER_30_154 VGND VGND VPWR VPWR sky130_fd_sc_hd__decap_12
XFILLER_30_166 VGND VGND VPWR VPWR sky130_fd_sc_hd__decap_12
XFILLER_30_178 VGND VGND VPWR VPWR sky130_fd_sc_hd__decap_12
XFILLER_30_190 VGND VGND VPWR VPWR sky130_fd_sc_hd__decap_12
XFILLER_30_202 VGND VGND VPWR VPWR sky130_fd_sc_hd__decap_12
XFILLER_30_214 VGND VGND VPWR VPWR sky130_fd_sc_hd__fill_1
XFILLER_30_216 VGND VGND VPWR VPWR sky130_fd_sc_hd__decap_12
XFILLER_30_228 VGND VGND VPWR VPWR sky130_fd_sc_hd__decap_12
XFILLER_30_240 VGND VGND VPWR VPWR sky130_fd_sc_hd__decap_12
XFILLER_30_252 VGND VGND VPWR VPWR sky130_fd_sc_hd__decap_12
XFILLER_31_16 VGND VGND VPWR VPWR sky130_fd_sc_hd__decap_12
XFILLER_31_28 VGND VGND VPWR VPWR sky130_fd_sc_hd__decap_12
XFILLER_31_40 VGND VGND VPWR VPWR sky130_fd_sc_hd__decap_12
XFILLER_31_52 VGND VGND VPWR VPWR sky130_fd_sc_hd__decap_12
XFILLER_31_64 VGND VGND VPWR VPWR sky130_fd_sc_hd__decap_12
XFILLER_31_76 VGND VGND VPWR VPWR sky130_fd_sc_hd__decap_4
XFILLER_31_87 VGND VGND VPWR VPWR sky130_fd_sc_hd__decap_12
XFILLER_31_99 VGND VGND VPWR VPWR sky130_fd_sc_hd__decap_8
XFILLER_31_115 VGND VGND VPWR VPWR sky130_fd_sc_hd__fill_2
XFILLER_31_146 VGND VGND VPWR VPWR sky130_fd_sc_hd__decap_12
XFILLER_31_158 VGND VGND VPWR VPWR sky130_fd_sc_hd__decap_12
XFILLER_31_170 VGND VGND VPWR VPWR sky130_fd_sc_hd__fill_2
XFILLER_31_173 VGND VGND VPWR VPWR sky130_fd_sc_hd__decap_12
XFILLER_31_185 VGND VGND VPWR VPWR sky130_fd_sc_hd__decap_12
XFILLER_31_197 VGND VGND VPWR VPWR sky130_fd_sc_hd__decap_12
XFILLER_31_209 VGND VGND VPWR VPWR sky130_fd_sc_hd__decap_12
XFILLER_31_221 VGND VGND VPWR VPWR sky130_fd_sc_hd__decap_12
XFILLER_31_233 VGND VGND VPWR VPWR sky130_fd_sc_hd__decap_12
XFILLER_31_245 VGND VGND VPWR VPWR sky130_fd_sc_hd__decap_12
XFILLER_31_257 VGND VGND VPWR VPWR sky130_fd_sc_hd__fill_1
XFILLER_31_259 VGND VGND VPWR VPWR sky130_fd_sc_hd__decap_4
XFILLER_31_263 VGND VGND VPWR VPWR sky130_fd_sc_hd__fill_1
XFILLER_32_9 VGND VGND VPWR VPWR sky130_fd_sc_hd__decap_12
XFILLER_32_21 VGND VGND VPWR VPWR sky130_fd_sc_hd__decap_12
XFILLER_32_33 VGND VGND VPWR VPWR sky130_fd_sc_hd__decap_8
XFILLER_32_41 VGND VGND VPWR VPWR sky130_fd_sc_hd__fill_2
XFILLER_32_44 VGND VGND VPWR VPWR sky130_fd_sc_hd__decap_12
XFILLER_32_56 VGND VGND VPWR VPWR sky130_fd_sc_hd__decap_12
XFILLER_32_68 VGND VGND VPWR VPWR sky130_fd_sc_hd__decap_12
XFILLER_32_80 VGND VGND VPWR VPWR sky130_fd_sc_hd__decap_12
XFILLER_32_92 VGND VGND VPWR VPWR sky130_fd_sc_hd__decap_12
XFILLER_32_104 VGND VGND VPWR VPWR sky130_fd_sc_hd__decap_6
XFILLER_32_113 VGND VGND VPWR VPWR sky130_fd_sc_hd__decap_4
XFILLER_32_117 VGND VGND VPWR VPWR sky130_fd_sc_hd__fill_1
XFILLER_32_123 VGND VGND VPWR VPWR sky130_fd_sc_hd__decap_6
XFILLER_32_130 VGND VGND VPWR VPWR sky130_fd_sc_hd__decap_12
XFILLER_32_142 VGND VGND VPWR VPWR sky130_fd_sc_hd__decap_12
XFILLER_32_154 VGND VGND VPWR VPWR sky130_fd_sc_hd__decap_12
XFILLER_32_166 VGND VGND VPWR VPWR sky130_fd_sc_hd__decap_12
XFILLER_32_178 VGND VGND VPWR VPWR sky130_fd_sc_hd__decap_12
XFILLER_32_190 VGND VGND VPWR VPWR sky130_fd_sc_hd__decap_12
XFILLER_32_202 VGND VGND VPWR VPWR sky130_fd_sc_hd__decap_12
XFILLER_32_214 VGND VGND VPWR VPWR sky130_fd_sc_hd__fill_1
XFILLER_32_216 VGND VGND VPWR VPWR sky130_fd_sc_hd__decap_12
XFILLER_32_228 VGND VGND VPWR VPWR sky130_fd_sc_hd__decap_12
XFILLER_32_240 VGND VGND VPWR VPWR sky130_fd_sc_hd__decap_12
XFILLER_32_252 VGND VGND VPWR VPWR sky130_fd_sc_hd__decap_12
XFILLER_33_1 VGND VGND VPWR VPWR sky130_fd_sc_hd__decap_12
XFILLER_33_13 VGND VGND VPWR VPWR sky130_fd_sc_hd__decap_12
XFILLER_33_25 VGND VGND VPWR VPWR sky130_fd_sc_hd__decap_12
XFILLER_33_37 VGND VGND VPWR VPWR sky130_fd_sc_hd__decap_12
XFILLER_33_49 VGND VGND VPWR VPWR sky130_fd_sc_hd__decap_12
XFILLER_33_61 VGND VGND VPWR VPWR sky130_fd_sc_hd__decap_12
XFILLER_33_73 VGND VGND VPWR VPWR sky130_fd_sc_hd__decap_12
XFILLER_33_85 VGND VGND VPWR VPWR sky130_fd_sc_hd__fill_1
XFILLER_33_87 VGND VGND VPWR VPWR sky130_fd_sc_hd__decap_12
XFILLER_33_99 VGND VGND VPWR VPWR sky130_fd_sc_hd__decap_12
XFILLER_33_111 VGND VGND VPWR VPWR sky130_fd_sc_hd__decap_12
XFILLER_33_123 VGND VGND VPWR VPWR sky130_fd_sc_hd__decap_12
XFILLER_33_135 VGND VGND VPWR VPWR sky130_fd_sc_hd__decap_12
XFILLER_33_147 VGND VGND VPWR VPWR sky130_fd_sc_hd__decap_12
XFILLER_33_159 VGND VGND VPWR VPWR sky130_fd_sc_hd__decap_12
XFILLER_33_171 VGND VGND VPWR VPWR sky130_fd_sc_hd__fill_1
XFILLER_33_173 VGND VGND VPWR VPWR sky130_fd_sc_hd__decap_12
XFILLER_33_185 VGND VGND VPWR VPWR sky130_fd_sc_hd__decap_12
XFILLER_33_197 VGND VGND VPWR VPWR sky130_fd_sc_hd__decap_12
XFILLER_33_209 VGND VGND VPWR VPWR sky130_fd_sc_hd__decap_12
XFILLER_33_221 VGND VGND VPWR VPWR sky130_fd_sc_hd__decap_12
XFILLER_33_233 VGND VGND VPWR VPWR sky130_fd_sc_hd__decap_12
XFILLER_33_245 VGND VGND VPWR VPWR sky130_fd_sc_hd__decap_12
XFILLER_33_257 VGND VGND VPWR VPWR sky130_fd_sc_hd__fill_1
XFILLER_33_259 VGND VGND VPWR VPWR sky130_fd_sc_hd__decap_4
XFILLER_33_263 VGND VGND VPWR VPWR sky130_fd_sc_hd__fill_1
XFILLER_34_1 VGND VGND VPWR VPWR sky130_fd_sc_hd__decap_12
XFILLER_34_13 VGND VGND VPWR VPWR sky130_fd_sc_hd__decap_12
XFILLER_34_25 VGND VGND VPWR VPWR sky130_fd_sc_hd__decap_12
XFILLER_34_37 VGND VGND VPWR VPWR sky130_fd_sc_hd__decap_6
XFILLER_34_44 VGND VGND VPWR VPWR sky130_fd_sc_hd__decap_12
XFILLER_34_56 VGND VGND VPWR VPWR sky130_fd_sc_hd__decap_12
XFILLER_34_68 VGND VGND VPWR VPWR sky130_fd_sc_hd__decap_12
XFILLER_34_80 VGND VGND VPWR VPWR sky130_fd_sc_hd__decap_12
XFILLER_34_92 VGND VGND VPWR VPWR sky130_fd_sc_hd__decap_12
XFILLER_34_104 VGND VGND VPWR VPWR sky130_fd_sc_hd__fill_1
XFILLER_34_119 VGND VGND VPWR VPWR sky130_fd_sc_hd__decap_8
XFILLER_34_127 VGND VGND VPWR VPWR sky130_fd_sc_hd__fill_2
XFILLER_34_130 VGND VGND VPWR VPWR sky130_fd_sc_hd__decap_12
XFILLER_34_142 VGND VGND VPWR VPWR sky130_fd_sc_hd__decap_12
XFILLER_34_154 VGND VGND VPWR VPWR sky130_fd_sc_hd__decap_12
XFILLER_34_166 VGND VGND VPWR VPWR sky130_fd_sc_hd__decap_12
XFILLER_34_178 VGND VGND VPWR VPWR sky130_fd_sc_hd__decap_12
XFILLER_34_190 VGND VGND VPWR VPWR sky130_fd_sc_hd__decap_12
XFILLER_34_202 VGND VGND VPWR VPWR sky130_fd_sc_hd__decap_12
XFILLER_34_214 VGND VGND VPWR VPWR sky130_fd_sc_hd__fill_1
XFILLER_34_216 VGND VGND VPWR VPWR sky130_fd_sc_hd__decap_12
XFILLER_34_228 VGND VGND VPWR VPWR sky130_fd_sc_hd__decap_12
XFILLER_34_240 VGND VGND VPWR VPWR sky130_fd_sc_hd__decap_12
XFILLER_34_252 VGND VGND VPWR VPWR sky130_fd_sc_hd__decap_12
XFILLER_35_1 VGND VGND VPWR VPWR sky130_fd_sc_hd__decap_12
XFILLER_35_13 VGND VGND VPWR VPWR sky130_fd_sc_hd__decap_12
XFILLER_35_25 VGND VGND VPWR VPWR sky130_fd_sc_hd__decap_12
XFILLER_35_37 VGND VGND VPWR VPWR sky130_fd_sc_hd__decap_12
XFILLER_35_49 VGND VGND VPWR VPWR sky130_fd_sc_hd__decap_12
XFILLER_35_61 VGND VGND VPWR VPWR sky130_fd_sc_hd__decap_12
XFILLER_35_73 VGND VGND VPWR VPWR sky130_fd_sc_hd__decap_12
XFILLER_35_85 VGND VGND VPWR VPWR sky130_fd_sc_hd__fill_1
XFILLER_35_87 VGND VGND VPWR VPWR sky130_fd_sc_hd__decap_12
XFILLER_35_99 VGND VGND VPWR VPWR sky130_fd_sc_hd__decap_6
XFILLER_35_147 VGND VGND VPWR VPWR sky130_fd_sc_hd__decap_12
XFILLER_35_159 VGND VGND VPWR VPWR sky130_fd_sc_hd__decap_12
XFILLER_35_171 VGND VGND VPWR VPWR sky130_fd_sc_hd__fill_1
XFILLER_35_173 VGND VGND VPWR VPWR sky130_fd_sc_hd__decap_12
XFILLER_35_185 VGND VGND VPWR VPWR sky130_fd_sc_hd__decap_12
XFILLER_35_197 VGND VGND VPWR VPWR sky130_fd_sc_hd__decap_12
XFILLER_35_209 VGND VGND VPWR VPWR sky130_fd_sc_hd__decap_12
XFILLER_35_221 VGND VGND VPWR VPWR sky130_fd_sc_hd__decap_12
XFILLER_35_233 VGND VGND VPWR VPWR sky130_fd_sc_hd__decap_12
XFILLER_35_245 VGND VGND VPWR VPWR sky130_fd_sc_hd__decap_12
XFILLER_35_257 VGND VGND VPWR VPWR sky130_fd_sc_hd__fill_1
XFILLER_35_259 VGND VGND VPWR VPWR sky130_fd_sc_hd__decap_4
XFILLER_35_263 VGND VGND VPWR VPWR sky130_fd_sc_hd__fill_1
XFILLER_36_1 VGND VGND VPWR VPWR sky130_fd_sc_hd__decap_12
XFILLER_36_13 VGND VGND VPWR VPWR sky130_fd_sc_hd__decap_12
XFILLER_36_25 VGND VGND VPWR VPWR sky130_fd_sc_hd__decap_12
XFILLER_36_37 VGND VGND VPWR VPWR sky130_fd_sc_hd__decap_6
XFILLER_36_44 VGND VGND VPWR VPWR sky130_fd_sc_hd__decap_12
XFILLER_36_56 VGND VGND VPWR VPWR sky130_fd_sc_hd__decap_12
XFILLER_36_68 VGND VGND VPWR VPWR sky130_fd_sc_hd__decap_12
XFILLER_36_80 VGND VGND VPWR VPWR sky130_fd_sc_hd__decap_12
XFILLER_36_92 VGND VGND VPWR VPWR sky130_fd_sc_hd__decap_12
XFILLER_36_104 VGND VGND VPWR VPWR sky130_fd_sc_hd__decap_4
XFILLER_36_130 VGND VGND VPWR VPWR sky130_fd_sc_hd__fill_1
XFILLER_36_134 VGND VGND VPWR VPWR sky130_fd_sc_hd__decap_12
XFILLER_36_146 VGND VGND VPWR VPWR sky130_fd_sc_hd__decap_12
XFILLER_36_158 VGND VGND VPWR VPWR sky130_fd_sc_hd__decap_12
XFILLER_36_170 VGND VGND VPWR VPWR sky130_fd_sc_hd__decap_12
XFILLER_36_182 VGND VGND VPWR VPWR sky130_fd_sc_hd__decap_12
XFILLER_36_194 VGND VGND VPWR VPWR sky130_fd_sc_hd__decap_12
XFILLER_36_206 VGND VGND VPWR VPWR sky130_fd_sc_hd__decap_8
XFILLER_36_214 VGND VGND VPWR VPWR sky130_fd_sc_hd__fill_1
XFILLER_36_216 VGND VGND VPWR VPWR sky130_fd_sc_hd__decap_12
XFILLER_36_228 VGND VGND VPWR VPWR sky130_fd_sc_hd__decap_12
XFILLER_36_240 VGND VGND VPWR VPWR sky130_fd_sc_hd__decap_12
XFILLER_36_252 VGND VGND VPWR VPWR sky130_fd_sc_hd__decap_12
XFILLER_37_1 VGND VGND VPWR VPWR sky130_fd_sc_hd__decap_12
XFILLER_37_13 VGND VGND VPWR VPWR sky130_fd_sc_hd__decap_12
XFILLER_37_25 VGND VGND VPWR VPWR sky130_fd_sc_hd__decap_12
XFILLER_37_37 VGND VGND VPWR VPWR sky130_fd_sc_hd__decap_12
XFILLER_37_49 VGND VGND VPWR VPWR sky130_fd_sc_hd__decap_12
XFILLER_37_61 VGND VGND VPWR VPWR sky130_fd_sc_hd__decap_12
XFILLER_37_73 VGND VGND VPWR VPWR sky130_fd_sc_hd__decap_12
XFILLER_37_85 VGND VGND VPWR VPWR sky130_fd_sc_hd__fill_1
XFILLER_37_87 VGND VGND VPWR VPWR sky130_fd_sc_hd__decap_12
XFILLER_37_99 VGND VGND VPWR VPWR sky130_fd_sc_hd__decap_12
XFILLER_37_111 VGND VGND VPWR VPWR sky130_fd_sc_hd__decap_4
XFILLER_37_115 VGND VGND VPWR VPWR sky130_fd_sc_hd__fill_1
XFILLER_37_143 VGND VGND VPWR VPWR sky130_fd_sc_hd__decap_12
XFILLER_37_155 VGND VGND VPWR VPWR sky130_fd_sc_hd__decap_12
XFILLER_37_167 VGND VGND VPWR VPWR sky130_fd_sc_hd__decap_4
XFILLER_37_171 VGND VGND VPWR VPWR sky130_fd_sc_hd__fill_1
XFILLER_37_173 VGND VGND VPWR VPWR sky130_fd_sc_hd__decap_12
XFILLER_37_185 VGND VGND VPWR VPWR sky130_fd_sc_hd__decap_12
XFILLER_37_197 VGND VGND VPWR VPWR sky130_fd_sc_hd__decap_12
XFILLER_37_209 VGND VGND VPWR VPWR sky130_fd_sc_hd__decap_12
XFILLER_37_221 VGND VGND VPWR VPWR sky130_fd_sc_hd__decap_12
XFILLER_37_233 VGND VGND VPWR VPWR sky130_fd_sc_hd__decap_12
XFILLER_37_245 VGND VGND VPWR VPWR sky130_fd_sc_hd__decap_12
XFILLER_37_257 VGND VGND VPWR VPWR sky130_fd_sc_hd__fill_1
XFILLER_37_259 VGND VGND VPWR VPWR sky130_fd_sc_hd__decap_4
XFILLER_37_263 VGND VGND VPWR VPWR sky130_fd_sc_hd__fill_1
XFILLER_38_1 VGND VGND VPWR VPWR sky130_fd_sc_hd__decap_12
XFILLER_38_13 VGND VGND VPWR VPWR sky130_fd_sc_hd__decap_12
XFILLER_38_25 VGND VGND VPWR VPWR sky130_fd_sc_hd__decap_12
XFILLER_38_37 VGND VGND VPWR VPWR sky130_fd_sc_hd__decap_6
XFILLER_38_44 VGND VGND VPWR VPWR sky130_fd_sc_hd__decap_12
XFILLER_38_56 VGND VGND VPWR VPWR sky130_fd_sc_hd__decap_12
XFILLER_38_68 VGND VGND VPWR VPWR sky130_fd_sc_hd__decap_12
XFILLER_38_80 VGND VGND VPWR VPWR sky130_fd_sc_hd__decap_12
XFILLER_38_92 VGND VGND VPWR VPWR sky130_fd_sc_hd__decap_12
XFILLER_38_104 VGND VGND VPWR VPWR sky130_fd_sc_hd__decap_12
XFILLER_38_116 VGND VGND VPWR VPWR sky130_fd_sc_hd__decap_4
XFILLER_38_120 VGND VGND VPWR VPWR sky130_fd_sc_hd__fill_1
XFILLER_38_130 VGND VGND VPWR VPWR sky130_fd_sc_hd__decap_12
XFILLER_38_142 VGND VGND VPWR VPWR sky130_fd_sc_hd__decap_12
XFILLER_38_154 VGND VGND VPWR VPWR sky130_fd_sc_hd__decap_12
XFILLER_38_166 VGND VGND VPWR VPWR sky130_fd_sc_hd__decap_12
XFILLER_38_178 VGND VGND VPWR VPWR sky130_fd_sc_hd__decap_12
XFILLER_38_190 VGND VGND VPWR VPWR sky130_fd_sc_hd__decap_12
XFILLER_38_202 VGND VGND VPWR VPWR sky130_fd_sc_hd__decap_12
XFILLER_38_214 VGND VGND VPWR VPWR sky130_fd_sc_hd__fill_1
XFILLER_38_216 VGND VGND VPWR VPWR sky130_fd_sc_hd__decap_12
XFILLER_38_228 VGND VGND VPWR VPWR sky130_fd_sc_hd__decap_12
XFILLER_38_240 VGND VGND VPWR VPWR sky130_fd_sc_hd__decap_12
XFILLER_38_252 VGND VGND VPWR VPWR sky130_fd_sc_hd__decap_12
XFILLER_39_1 VGND VGND VPWR VPWR sky130_fd_sc_hd__decap_12
XFILLER_39_13 VGND VGND VPWR VPWR sky130_fd_sc_hd__decap_12
XFILLER_39_25 VGND VGND VPWR VPWR sky130_fd_sc_hd__decap_12
XFILLER_39_37 VGND VGND VPWR VPWR sky130_fd_sc_hd__decap_12
XFILLER_39_49 VGND VGND VPWR VPWR sky130_fd_sc_hd__decap_12
XFILLER_39_61 VGND VGND VPWR VPWR sky130_fd_sc_hd__decap_12
XFILLER_39_73 VGND VGND VPWR VPWR sky130_fd_sc_hd__decap_12
XFILLER_39_85 VGND VGND VPWR VPWR sky130_fd_sc_hd__fill_1
XFILLER_39_87 VGND VGND VPWR VPWR sky130_fd_sc_hd__decap_12
XFILLER_39_99 VGND VGND VPWR VPWR sky130_fd_sc_hd__decap_12
XFILLER_39_111 VGND VGND VPWR VPWR sky130_fd_sc_hd__decap_12
XFILLER_39_123 VGND VGND VPWR VPWR sky130_fd_sc_hd__decap_6
XFILLER_39_129 VGND VGND VPWR VPWR sky130_fd_sc_hd__fill_1
XFILLER_39_135 VGND VGND VPWR VPWR sky130_fd_sc_hd__decap_12
XFILLER_39_147 VGND VGND VPWR VPWR sky130_fd_sc_hd__decap_6
XFILLER_39_153 VGND VGND VPWR VPWR sky130_fd_sc_hd__fill_1
XFILLER_39_161 VGND VGND VPWR VPWR sky130_fd_sc_hd__fill_2
XFILLER_39_168 VGND VGND VPWR VPWR sky130_fd_sc_hd__decap_4
XFILLER_39_173 VGND VGND VPWR VPWR sky130_fd_sc_hd__decap_12
XFILLER_39_185 VGND VGND VPWR VPWR sky130_fd_sc_hd__decap_12
XFILLER_39_197 VGND VGND VPWR VPWR sky130_fd_sc_hd__decap_12
XFILLER_39_209 VGND VGND VPWR VPWR sky130_fd_sc_hd__decap_12
XFILLER_39_221 VGND VGND VPWR VPWR sky130_fd_sc_hd__decap_12
XFILLER_39_233 VGND VGND VPWR VPWR sky130_fd_sc_hd__decap_12
XFILLER_39_245 VGND VGND VPWR VPWR sky130_fd_sc_hd__decap_12
XFILLER_39_257 VGND VGND VPWR VPWR sky130_fd_sc_hd__fill_1
XFILLER_39_259 VGND VGND VPWR VPWR sky130_fd_sc_hd__decap_4
XFILLER_39_263 VGND VGND VPWR VPWR sky130_fd_sc_hd__fill_1
XFILLER_40_1 VGND VGND VPWR VPWR sky130_fd_sc_hd__decap_12
XFILLER_40_13 VGND VGND VPWR VPWR sky130_fd_sc_hd__decap_12
XFILLER_40_25 VGND VGND VPWR VPWR sky130_fd_sc_hd__decap_12
XFILLER_40_37 VGND VGND VPWR VPWR sky130_fd_sc_hd__decap_6
XFILLER_40_44 VGND VGND VPWR VPWR sky130_fd_sc_hd__decap_12
XFILLER_40_56 VGND VGND VPWR VPWR sky130_fd_sc_hd__decap_12
XFILLER_40_68 VGND VGND VPWR VPWR sky130_fd_sc_hd__decap_12
XFILLER_40_80 VGND VGND VPWR VPWR sky130_fd_sc_hd__decap_12
XFILLER_40_92 VGND VGND VPWR VPWR sky130_fd_sc_hd__decap_12
XFILLER_40_104 VGND VGND VPWR VPWR sky130_fd_sc_hd__decap_12
XFILLER_40_116 VGND VGND VPWR VPWR sky130_fd_sc_hd__decap_8
XFILLER_40_124 VGND VGND VPWR VPWR sky130_fd_sc_hd__fill_2
XFILLER_40_130 VGND VGND VPWR VPWR sky130_fd_sc_hd__fill_2
XFILLER_40_144 VGND VGND VPWR VPWR sky130_fd_sc_hd__fill_2
XFILLER_40_170 VGND VGND VPWR VPWR sky130_fd_sc_hd__decap_3
XFILLER_40_185 VGND VGND VPWR VPWR sky130_fd_sc_hd__decap_12
XFILLER_40_197 VGND VGND VPWR VPWR sky130_fd_sc_hd__decap_12
XFILLER_40_209 VGND VGND VPWR VPWR sky130_fd_sc_hd__decap_6
XFILLER_40_216 VGND VGND VPWR VPWR sky130_fd_sc_hd__decap_12
XFILLER_40_228 VGND VGND VPWR VPWR sky130_fd_sc_hd__decap_4
XFILLER_40_236 VGND VGND VPWR VPWR sky130_fd_sc_hd__decap_12
XFILLER_40_248 VGND VGND VPWR VPWR sky130_fd_sc_hd__decap_12
XFILLER_40_260 VGND VGND VPWR VPWR sky130_fd_sc_hd__decap_4
XFILLER_41_1 VGND VGND VPWR VPWR sky130_fd_sc_hd__decap_12
XFILLER_41_13 VGND VGND VPWR VPWR sky130_fd_sc_hd__decap_12
XFILLER_41_25 VGND VGND VPWR VPWR sky130_fd_sc_hd__decap_12
XFILLER_41_37 VGND VGND VPWR VPWR sky130_fd_sc_hd__decap_12
XFILLER_41_49 VGND VGND VPWR VPWR sky130_fd_sc_hd__decap_12
XFILLER_41_61 VGND VGND VPWR VPWR sky130_fd_sc_hd__decap_12
XFILLER_41_73 VGND VGND VPWR VPWR sky130_fd_sc_hd__decap_12
XFILLER_41_85 VGND VGND VPWR VPWR sky130_fd_sc_hd__fill_1
XFILLER_41_87 VGND VGND VPWR VPWR sky130_fd_sc_hd__decap_12
XFILLER_41_99 VGND VGND VPWR VPWR sky130_fd_sc_hd__decap_12
XFILLER_41_111 VGND VGND VPWR VPWR sky130_fd_sc_hd__decap_12
XFILLER_41_163 VGND VGND VPWR VPWR sky130_fd_sc_hd__decap_4
XFILLER_41_193 VGND VGND VPWR VPWR sky130_fd_sc_hd__decap_4
XFILLER_41_204 VGND VGND VPWR VPWR sky130_fd_sc_hd__decap_12
XFILLER_41_216 VGND VGND VPWR VPWR sky130_fd_sc_hd__decap_8
XFILLER_41_224 VGND VGND VPWR VPWR sky130_fd_sc_hd__fill_1
XFILLER_41_243 VGND VGND VPWR VPWR sky130_fd_sc_hd__decap_12
XFILLER_41_255 VGND VGND VPWR VPWR sky130_fd_sc_hd__decap_3
XFILLER_41_259 VGND VGND VPWR VPWR sky130_fd_sc_hd__decap_4
XFILLER_41_263 VGND VGND VPWR VPWR sky130_fd_sc_hd__fill_1
XFILLER_42_1 VGND VGND VPWR VPWR sky130_fd_sc_hd__decap_12
XFILLER_42_13 VGND VGND VPWR VPWR sky130_fd_sc_hd__decap_12
XFILLER_42_25 VGND VGND VPWR VPWR sky130_fd_sc_hd__decap_12
XFILLER_42_37 VGND VGND VPWR VPWR sky130_fd_sc_hd__decap_6
XFILLER_42_44 VGND VGND VPWR VPWR sky130_fd_sc_hd__decap_12
XFILLER_42_56 VGND VGND VPWR VPWR sky130_fd_sc_hd__decap_12
XFILLER_42_68 VGND VGND VPWR VPWR sky130_fd_sc_hd__decap_12
XFILLER_42_80 VGND VGND VPWR VPWR sky130_fd_sc_hd__decap_12
XFILLER_42_92 VGND VGND VPWR VPWR sky130_fd_sc_hd__decap_12
XFILLER_42_104 VGND VGND VPWR VPWR sky130_fd_sc_hd__decap_12
XFILLER_42_116 VGND VGND VPWR VPWR sky130_fd_sc_hd__decap_12
XFILLER_42_128 VGND VGND VPWR VPWR sky130_fd_sc_hd__fill_1
XFILLER_42_133 VGND VGND VPWR VPWR sky130_fd_sc_hd__decap_8
XFILLER_42_141 VGND VGND VPWR VPWR sky130_fd_sc_hd__decap_3
XFILLER_42_154 VGND VGND VPWR VPWR sky130_fd_sc_hd__decap_12
XFILLER_42_166 VGND VGND VPWR VPWR sky130_fd_sc_hd__decap_4
XFILLER_42_170 VGND VGND VPWR VPWR sky130_fd_sc_hd__fill_1
XFILLER_42_185 VGND VGND VPWR VPWR sky130_fd_sc_hd__decap_8
XFILLER_42_193 VGND VGND VPWR VPWR sky130_fd_sc_hd__fill_2
XFILLER_42_216 VGND VGND VPWR VPWR sky130_fd_sc_hd__decap_4
XFILLER_42_220 VGND VGND VPWR VPWR sky130_fd_sc_hd__fill_1
XFILLER_42_229 VGND VGND VPWR VPWR sky130_fd_sc_hd__fill_2
XFILLER_42_251 VGND VGND VPWR VPWR sky130_fd_sc_hd__decap_12
XFILLER_42_263 VGND VGND VPWR VPWR sky130_fd_sc_hd__fill_1
XFILLER_43_1 VGND VGND VPWR VPWR sky130_fd_sc_hd__decap_12
XFILLER_43_13 VGND VGND VPWR VPWR sky130_fd_sc_hd__decap_12
XFILLER_43_25 VGND VGND VPWR VPWR sky130_fd_sc_hd__decap_12
XFILLER_43_37 VGND VGND VPWR VPWR sky130_fd_sc_hd__decap_6
XFILLER_43_44 VGND VGND VPWR VPWR sky130_fd_sc_hd__decap_12
XFILLER_43_56 VGND VGND VPWR VPWR sky130_fd_sc_hd__decap_12
XFILLER_43_68 VGND VGND VPWR VPWR sky130_fd_sc_hd__decap_12
XFILLER_43_80 VGND VGND VPWR VPWR sky130_fd_sc_hd__decap_6
XFILLER_43_87 VGND VGND VPWR VPWR sky130_fd_sc_hd__decap_12
XFILLER_43_99 VGND VGND VPWR VPWR sky130_fd_sc_hd__decap_12
XFILLER_43_111 VGND VGND VPWR VPWR sky130_fd_sc_hd__decap_12
XFILLER_43_123 VGND VGND VPWR VPWR sky130_fd_sc_hd__decap_6
XFILLER_43_130 VGND VGND VPWR VPWR sky130_fd_sc_hd__decap_12
XFILLER_43_142 VGND VGND VPWR VPWR sky130_fd_sc_hd__decap_12
XFILLER_43_154 VGND VGND VPWR VPWR sky130_fd_sc_hd__decap_12
XFILLER_43_166 VGND VGND VPWR VPWR sky130_fd_sc_hd__decap_6
XFILLER_43_173 VGND VGND VPWR VPWR sky130_fd_sc_hd__decap_12
XFILLER_43_185 VGND VGND VPWR VPWR sky130_fd_sc_hd__decap_12
XFILLER_43_197 VGND VGND VPWR VPWR sky130_fd_sc_hd__decap_12
XFILLER_43_209 VGND VGND VPWR VPWR sky130_fd_sc_hd__decap_6
XFILLER_43_216 VGND VGND VPWR VPWR sky130_fd_sc_hd__decap_6
XFILLER_43_222 VGND VGND VPWR VPWR sky130_fd_sc_hd__fill_1
XFILLER_43_255 VGND VGND VPWR VPWR sky130_fd_sc_hd__decap_3
XFILLER_43_259 VGND VGND VPWR VPWR sky130_fd_sc_hd__decap_4
XFILLER_43_263 VGND VGND VPWR VPWR sky130_fd_sc_hd__fill_1
.ENDS PLL_COUNTER_DCO_PHYS
