* Extracted by KLayout with SKY130 LVS runset on : 01/11/2026 01:07

.SUBCKT PLL_COUNTER_DCO_PHYS MID_MUX[14] MID_MUX[3] FINE_MUX[27] FINE_MUX[24]
+ FINE_MUX[22] FINE_MUX[23] FINE_MUX[19] FINE_MUX[17] FINE_MUX[28] FINE_MUX[26]
+ FINE_MUX[15] FINE_MUX[13] FINE_MUX[11] MID_MUX[9] FINE_MUX[4] FINE_MUX[8]
+ FINE_MUX[12] FINE_MUX[29] FINE_MUX[10] FINE_MUX[16] FINE_MUX[14] FINE_MUX[20]
+ FINE_MUX[18] VPWR FINE_MUX[2] MID_MUX[7] MID_MUX[0] MID_MUX[5] MID_MUX[1]
+ FINE_MUX[6] FINE_MUX[21] FINE_MUX[25] MID_MUX[10] MID_MUX[13] FINE_MUX[9]
+ MID_MUX[12] MID_MUX[11] FINE_MUX[7] MID_MUX[8] FINE_MUX[30] FINE_MUX[5] TICK
+ FINE_MUX[3] MID_MUX[6] FINE_MUX[1] FINE_MUX[0] MID_MUX[4] MID_MUX[2]
+ COARSE_MUX[13] COARSE_MUX[8] COARSE_MUX[6] COARSE_MUX[2] COARSE_MUX[4]
+ COARSE_MUX[12] COARSE_MUX[11] COARSE_MUX[10] COARSE_MUX[9] COARSE_MUX[7]
+ COARSE_MUX[5] COARSE_MUX[14] COARSE_MUX[3] COARSE_MUX[1] COARSE_MUX[0] REF
+ MID_OUT SS_BBPD[1] DCO_EN OUT INJ_EDGE SS_BBPD[0] VGND
X$1 VPWR MID_MUX[14] VGND VPWR \$63 VGND sky130_fd_sc_hd__clkdlybuf4s50_1
X$2 VPWR MID_MUX[3] VGND VPWR \$49 VGND sky130_fd_sc_hd__clkdlybuf4s50_1
X$3 VPWR FINE_MUX[27] VGND VPWR \$27 VGND sky130_fd_sc_hd__clkdlybuf4s50_1
X$4 VPWR FINE_MUX[24] VGND VPWR \$60 VGND sky130_fd_sc_hd__clkdlybuf4s50_1
X$5 VPWR FINE_MUX[22] VGND VPWR \$57 VGND sky130_fd_sc_hd__clkdlybuf4s50_1
X$6 VPWR FINE_MUX[23] VGND VPWR \$28 VGND sky130_fd_sc_hd__clkdlybuf4s50_1
X$7 VPWR FINE_MUX[19] VGND VPWR \$44 VGND sky130_fd_sc_hd__clkdlybuf4s50_1
X$8 VPWR FINE_MUX[17] VGND VPWR \$51 VGND sky130_fd_sc_hd__clkdlybuf4s50_1
X$9 VPWR FINE_MUX[28] VGND VPWR \$80 VGND sky130_fd_sc_hd__clkdlybuf4s50_1
X$10 VPWR FINE_MUX[26] VGND VPWR \$89 VGND sky130_fd_sc_hd__clkdlybuf4s50_1
X$11 VPWR FINE_MUX[15] VGND VPWR \$32 VGND sky130_fd_sc_hd__clkdlybuf4s50_1
X$12 VPWR FINE_MUX[13] VGND VPWR \$46 VGND sky130_fd_sc_hd__clkdlybuf4s50_1
X$13 VPWR FINE_MUX[11] VGND VPWR \$31 VGND sky130_fd_sc_hd__clkdlybuf4s50_1
X$14 VPWR MID_MUX[9] VGND VPWR \$17 VGND sky130_fd_sc_hd__clkdlybuf4s50_1
X$15 VGND \$71 \$17 \$18 \$33 VPWR VPWR VGND sky130_fd_sc_hd__xnor3_1
X$16 VPWR \$52 VGND \$17 \$18 \$33 VPWR VGND sky130_fd_sc_hd__maj3_1
X$17 VPWR MID_MUX[5] VGND VPWR \$18 VGND sky130_fd_sc_hd__clkdlybuf4s50_1
X$18 VPWR FINE_MUX[4] VGND VPWR \$34 VGND sky130_fd_sc_hd__clkdlybuf4s50_1
X$19 VPWR FINE_MUX[8] VGND VPWR \$35 VGND sky130_fd_sc_hd__clkdlybuf4s50_1
X$20 VPWR FINE_MUX[12] VGND VPWR \$36 VGND sky130_fd_sc_hd__clkdlybuf4s50_1
X$21 VPWR FINE_MUX[29] VGND VPWR \$37 VGND sky130_fd_sc_hd__clkdlybuf4s50_1
X$22 VPWR FINE_MUX[10] VGND VPWR \$24 VGND sky130_fd_sc_hd__clkdlybuf4s50_1
X$23 VPWR VPWR VGND \$38 \$24 VGND sky130_fd_sc_hd__clkinv_1
X$24 VPWR FINE_MUX[16] VGND VPWR \$39 VGND sky130_fd_sc_hd__clkdlybuf4s50_1
X$25 VPWR FINE_MUX[14] VGND VPWR \$40 VGND sky130_fd_sc_hd__clkdlybuf4s50_1
X$26 VGND \$59 \$27 \$28 \$43 VPWR VPWR VGND sky130_fd_sc_hd__xor3_1
X$27 VPWR \$42 VGND \$27 \$28 \$43 VPWR VGND sky130_fd_sc_hd__maj3_1
X$28 VPWR FINE_MUX[20] VGND VPWR \$30 VGND sky130_fd_sc_hd__clkdlybuf4s50_1
X$29 VPWR VPWR VGND \$95 \$30 VGND sky130_fd_sc_hd__clkinv_1
X$30 VGND \$70 \$32 \$31 \$46 VPWR VPWR VGND sky130_fd_sc_hd__xor3_1
X$31 VPWR \$47 VGND \$32 \$31 \$46 VPWR VGND sky130_fd_sc_hd__maj3_1
X$32 VPWR MID_MUX[7] VGND VPWR \$33 VGND sky130_fd_sc_hd__clkdlybuf4s50_1
X$33 VPWR VGND \$82 \$34 VPWR \$86 VGND sky130_fd_sc_hd__xor2_1
X$34 VPWR \$121 VGND \$82 \$64 \$34 VPWR VGND sky130_fd_sc_hd__maj3_1
X$35 VGND \$82 \$66 \$35 \$56 VPWR VPWR VGND sky130_fd_sc_hd__xor3_1
X$36 VPWR \$65 VGND \$66 \$35 \$56 VPWR VGND sky130_fd_sc_hd__maj3_1
X$37 VPWR VPWR \$58 \$36 VGND \$57 VGND sky130_fd_sc_hd__xnor2_1
X$38 VPWR \$67 VGND \$37 \$36 \$57 VPWR VGND sky130_fd_sc_hd__maj3_1
X$39 VPWR VPWR \$68 \$58 VGND \$37 VGND sky130_fd_sc_hd__xnor2_1
X$40 VPWR \$87 VGND \$77 \$83 \$38 VPWR VGND sky130_fd_sc_hd__maj3_1
X$41 VGND \$66 \$77 \$83 \$38 VPWR VPWR VGND sky130_fd_sc_hd__xnor3_1
X$42 VGND \$84 \$78 \$39 \$79 VPWR VPWR VGND sky130_fd_sc_hd__xor3_1
X$43 VPWR \$94 VGND \$78 \$39 \$79 VPWR VGND sky130_fd_sc_hd__maj3_1
X$44 VPWR \$114 VGND \$88 \$84 \$40 VPWR VGND sky130_fd_sc_hd__maj3_1
X$45 VGND \$77 \$88 \$84 \$40 VPWR VPWR VGND sky130_fd_sc_hd__xnor3_1
X$46 VPWR FINE_MUX[18] VGND VPWR \$79 VGND sky130_fd_sc_hd__clkdlybuf4s50_1
X$47 VPWR VGND \$94 \$42 VPWR \$105 VGND sky130_fd_sc_hd__xor2_1
X$48 VPWR \$109 VPWR VGND \$42 \$94 VGND sky130_fd_sc_hd__nand2_1
X$49 VPWR FINE_MUX[25] VGND VPWR \$43 VGND sky130_fd_sc_hd__clkdlybuf4s50_1
X$50 VGND \$69 \$61 \$51 \$44 VPWR VPWR VGND sky130_fd_sc_hd__xor3_1
X$51 VPWR \$45 VGND \$61 \$51 \$44 VPWR VGND sky130_fd_sc_hd__maj3_1
X$52 VPWR \$125 VGND \$97 \$45 \$50 VPWR VGND sky130_fd_sc_hd__maj3_1
X$53 VGND \$116 \$97 \$45 \$50 VPWR VPWR VGND sky130_fd_sc_hd__xnor3_1
X$54 VPWR \$147 VPWR VGND \$47 \$166 VGND sky130_fd_sc_hd__nand2_1
X$55 VPWR VPWR \$160 \$166 VGND \$47 VGND sky130_fd_sc_hd__xnor2_1
X$56 VPWR COARSE_MUX[14] VGND VPWR \$475 VGND sky130_fd_sc_hd__clkdlybuf4s50_1
X$58 VPWR COARSE_MUX[1] VGND VPWR \$456 VGND sky130_fd_sc_hd__clkdlybuf4s50_1
X$59 VPWR VPWR VGND VGND sky130_fd_sc_hd__decap_12
X$60 VPWR VPWR VGND VGND sky130_fd_sc_hd__decap_12
X$63 VPWR VPWR VGND VGND sky130_fd_sc_hd__decap_12
X$64 VPWR VPWR VGND VGND sky130_fd_sc_hd__decap_12
X$65 VPWR VPWR VGND VGND sky130_fd_sc_hd__decap_8
X$67 VPWR VPWR \$485 \$466 VGND \$484 VGND sky130_fd_sc_hd__xnor2_1
X$68 VPWR VGND VPWR VGND sky130_fd_sc_hd__decap_4
X$70 VPWR VPWR \$487 \$486 VGND \$476 VGND sky130_fd_sc_hd__xnor2_1
X$71 VPWR VPWR VGND VGND sky130_fd_sc_hd__decap_8
X$72 VPWR VGND VPWR VGND sky130_fd_sc_hd__decap_3
X$73 VPWR VPWR \$489 \$481 VGND \$488 VGND sky130_fd_sc_hd__xnor2_1
X$74 VPWR VPWR VGND \$490 \$489 VGND sky130_fd_sc_hd__clkinv_1
X$75 VPWR \$492 VPWR VGND \$490 \$471 \$452 VGND sky130_fd_sc_hd__nand3_1
X$76 VPWR VPWR VGND VGND sky130_fd_sc_hd__decap_6
X$79 VPWR VPWR VGND VGND sky130_fd_sc_hd__decap_12
X$80 VPWR VPWR VGND VGND sky130_fd_sc_hd__decap_12
X$81 VPWR VPWR VGND VGND sky130_fd_sc_hd__decap_12
X$82 VPWR VPWR VGND VGND sky130_fd_sc_hd__decap_12
X$83 VPWR VPWR VGND VGND sky130_fd_sc_hd__decap_12
X$84 VPWR VPWR VGND VGND sky130_fd_sc_hd__decap_12
X$85 VPWR VPWR VGND VGND sky130_fd_sc_hd__decap_12
X$88 VPWR VPWR VGND VGND sky130_fd_sc_hd__decap_12
X$89 VPWR VPWR VGND VGND sky130_fd_sc_hd__decap_12
X$90 VPWR VPWR VGND VGND sky130_fd_sc_hd__decap_12
X$91 VPWR VPWR VGND VGND sky130_fd_sc_hd__decap_12
X$94 VPWR COARSE_MUX[3] VGND VPWR \$455 VGND sky130_fd_sc_hd__clkdlybuf4s50_1
X$95 VPWR VGND \$464 \$456 VPWR \$465 VGND sky130_fd_sc_hd__xor2_1
X$96 VPWR VPWR VGND VGND sky130_fd_sc_hd__decap_12
X$97 VPWR VPWR VGND VGND sky130_fd_sc_hd__decap_12
X$98 VPWR VPWR VGND VGND sky130_fd_sc_hd__decap_12
X$99 VPWR VPWR VGND VGND sky130_fd_sc_hd__decap_12
X$100 VPWR VPWR VGND VGND sky130_fd_sc_hd__decap_12
X$101 VPWR VGND VPWR VGND sky130_fd_sc_hd__decap_4
X$102 VPWR VGND \$486 VPWR \$476 \$480 \$484 VGND sky130_fd_sc_hd__a21o_1
X$104 VPWR VPWR VGND VGND sky130_fd_sc_hd__decap_12
X$105 VPWR VPWR VGND VGND sky130_fd_sc_hd__decap_8
X$106 VPWR \$494 VGND \$481 \$452 \$493 VPWR VGND sky130_fd_sc_hd__maj3_1
X$108 VPWR VGND \$471 VPWR \$452 \$496 \$490 VGND sky130_fd_sc_hd__a21oi_1
X$109 VPWR VGND \$495 \$492 VPWR \$496 VGND sky130_fd_sc_hd__lpflow_isobufsrc_1
X$110 VGND \$241 \$488 TICK \$495 VPWR VPWR VGND sky130_fd_sc_hd__dfrtp_1
X$111 VPWR VPWR VGND VGND sky130_fd_sc_hd__decap_12
X$112 VPWR VPWR VGND VGND sky130_fd_sc_hd__decap_12
X$115 VPWR VPWR VGND VGND sky130_fd_sc_hd__decap_12
X$116 VPWR VPWR VGND VGND sky130_fd_sc_hd__decap_12
X$117 VPWR VPWR VGND VGND sky130_fd_sc_hd__decap_12
X$118 VPWR VPWR VGND VGND sky130_fd_sc_hd__decap_12
X$119 VPWR VPWR VGND VGND sky130_fd_sc_hd__decap_12
X$120 VPWR VPWR VGND VGND sky130_fd_sc_hd__decap_12
X$121 VPWR VPWR VGND VGND sky130_fd_sc_hd__decap_12
X$124 VPWR VGND VPWR VGND sky130_fd_sc_hd__decap_4
X$127 VPWR COARSE_MUX[9] VGND VPWR \$406 VGND sky130_fd_sc_hd__clkdlybuf4s50_1
X$129 VPWR VPWR VGND VGND sky130_fd_sc_hd__decap_6
X$130 VPWR VGND \$407 \$418 VPWR \$408 VGND sky130_fd_sc_hd__xor2_1
X$131 VPWR \$400 VPWR \$394 \$408 VGND VGND sky130_fd_sc_hd__and2_0
X$132 VPWR VPWR \$401 \$400 VGND \$379 \$387 VGND sky130_fd_sc_hd__o21ai_0
X$134 VPWR VGND VPWR \$364 \$380 \$401 \$388 \$409 VGND sky130_fd_sc_hd__and4_1
X$135 VPWR VGND VPWR VGND sky130_fd_sc_hd__decap_3
X$137 VPWR VPWR VGND VGND sky130_fd_sc_hd__decap_8
X$138 VPWR VGND \$331 \$339 VPWR \$372 \$402 \$364 VGND sky130_fd_sc_hd__a22o_1
X$139 VPWR \$411 VGND \$402 VPWR \$410 VGND sky130_fd_sc_hd__nor2_1
X$140 VPWR VPWR VGND VGND sky130_fd_sc_hd__decap_12
X$141 VPWR VGND VPWR VGND sky130_fd_sc_hd__decap_4
X$142 VPWR \$412 VPWR \$332 \$333 VGND VGND sky130_fd_sc_hd__and2_0
X$143 VPWR VPWR VGND VGND sky130_fd_sc_hd__decap_12
X$144 VPWR VPWR VGND VGND sky130_fd_sc_hd__decap_8
X$146 VPWR VGND \$357 \$397 VPWR \$413 VGND sky130_fd_sc_hd__xor2_1
X$147 VPWR VPWR VGND VGND sky130_fd_sc_hd__decap_6
X$149 VPWR \$414 VPWR VGND \$381 \$413 VGND sky130_fd_sc_hd__nand2_1
X$150 VPWR VPWR VGND VGND sky130_fd_sc_hd__decap_8
X$152 VPWR \$414 \$435 VPWR \$382 VGND \$384 \$383 VGND
+ sky130_fd_sc_hd__o211ai_1
X$154 VPWR VGND \$403 \$383 VPWR \$382 VGND sky130_fd_sc_hd__lpflow_isobufsrc_1
X$155 VPWR VGND VPWR VGND sky130_fd_sc_hd__decap_3
X$156 VPWR VPWR \$404 \$384 VGND \$403 VGND sky130_fd_sc_hd__xnor2_1
X$158 VPWR \$462 VGND \$404 \$415 \$416 VPWR VGND sky130_fd_sc_hd__maj3_1
X$159 VPWR VPWR VGND VGND sky130_fd_sc_hd__decap_8
X$160 VPWR VGND VPWR VGND sky130_fd_sc_hd__decap_3
X$161 VGND \$417 \$386 \$350 \$405 VPWR VPWR VGND sky130_fd_sc_hd__xor3_1
X$162 VPWR VPWR VGND VGND sky130_fd_sc_hd__decap_12
X$163 VPWR VPWR VGND VGND sky130_fd_sc_hd__decap_12
X$165 VPWR VPWR VGND VGND sky130_fd_sc_hd__decap_12
X$166 VPWR VPWR VGND VGND sky130_fd_sc_hd__decap_12
X$167 VPWR VPWR VGND VGND sky130_fd_sc_hd__decap_12
X$168 VPWR VPWR VGND VGND sky130_fd_sc_hd__decap_12
X$171 VPWR VPWR VGND VGND sky130_fd_sc_hd__decap_6
X$172 VGND \$362 \$407 \$418 \$394 VPWR VPWR VGND sky130_fd_sc_hd__xnor3_1
X$174 VPWR VGND \$419 \$425 VPWR \$387 VGND sky130_fd_sc_hd__xor2_1
X$175 VPWR \$388 VPWR VGND \$425 \$419 VGND sky130_fd_sc_hd__nand2_1
X$176 VPWR VPWR VGND VGND sky130_fd_sc_hd__decap_12
X$177 VPWR VGND VPWR VGND sky130_fd_sc_hd__decap_3
X$178 VPWR VGND \$331 VPWR \$339 \$420 \$411 VGND sky130_fd_sc_hd__a21oi_1
X$179 VPWR \$410 VGND \$209 \$396 VPWR VGND sky130_fd_sc_hd__lpflow_inputiso1p_1
X$180 VPWR VGND \$396 \$209 VPWR \$421 VGND sky130_fd_sc_hd__xor2_1
X$181 VPWR VPWR VGND VGND sky130_fd_sc_hd__decap_12
X$182 VPWR VGND VPWR VGND sky130_fd_sc_hd__decap_4
X$183 VPWR \$459 VGND \$412 VPWR \$393 VGND sky130_fd_sc_hd__nor2_1
X$186 VPWR VPWR \$422 \$412 VGND \$393 VGND sky130_fd_sc_hd__xnor2_1
X$188 VPWR \$422 \$430 VGND \$357 VPWR \$397 VGND sky130_fd_sc_hd__nor3_1
X$189 VPWR VPWR \$423 \$422 VGND \$426 VGND sky130_fd_sc_hd__xnor2_1
X$190 VPWR VPWR VGND VGND sky130_fd_sc_hd__decap_6
X$192 VPWR \$431 VGND \$381 \$413 VPWR VGND sky130_fd_sc_hd__lpflow_inputiso1p_1
X$193 VPWR VPWR VGND VGND sky130_fd_sc_hd__decap_6
X$194 VPWR \$432 VPWR VGND \$414 \$431 VGND sky130_fd_sc_hd__nand2_1
X$195 VPWR VPWR VGND VGND sky130_fd_sc_hd__decap_12
X$196 VPWR VGND VPWR VGND sky130_fd_sc_hd__decap_3
X$197 VPWR VPWR \$427 \$424 VGND \$415 VGND sky130_fd_sc_hd__xnor2_1
X$198 VGND \$241 \$416 TICK \$427 VPWR VPWR VGND sky130_fd_sc_hd__dfrtp_1
X$201 VGND \$241 \$405 TICK \$417 VPWR VPWR VGND sky130_fd_sc_hd__dfrtp_1
X$202 VPWR VPWR VGND VGND sky130_fd_sc_hd__decap_12
X$203 VPWR VPWR VGND VGND sky130_fd_sc_hd__decap_12
X$204 VPWR VPWR VGND VGND sky130_fd_sc_hd__decap_12
X$205 VPWR VPWR VGND VGND sky130_fd_sc_hd__decap_12
X$206 VPWR VPWR VGND VGND sky130_fd_sc_hd__decap_12
X$207 VPWR VGND VPWR VGND sky130_fd_sc_hd__decap_4
X$210 VPWR VGND VPWR VGND sky130_fd_sc_hd__decap_4
X$213 VPWR MID_MUX[2] VGND VPWR \$238 VGND sky130_fd_sc_hd__clkdlybuf4s50_1
X$215 VPWR VPWR \$284 \$278 VGND \$274 VGND sky130_fd_sc_hd__xnor2_1
X$216 VPWR VPWR VGND \$217 \$263 VGND sky130_fd_sc_hd__clkinv_1
X$217 VPWR VPWR VGND VGND sky130_fd_sc_hd__decap_12
X$218 VPWR VPWR VGND VGND sky130_fd_sc_hd__decap_12
X$220 VPWR VPWR VGND VGND sky130_fd_sc_hd__decap_8
X$221 VPWR VGND VPWR VGND sky130_fd_sc_hd__decap_3
X$222 VPWR VGND \$230 \$275 VPWR \$285 VGND sky130_fd_sc_hd__xor2_1
X$223 VPWR VGND VPWR VGND sky130_fd_sc_hd__decap_4
X$224 VPWR \$275 VGND \$276 VPWR \$163 VGND sky130_fd_sc_hd__nor2_1
X$226 VPWR \$286 VGND \$248 \$163 \$188 VPWR VGND sky130_fd_sc_hd__maj3_1
X$227 VPWR VPWR \$366 \$264 VGND \$231 VGND sky130_fd_sc_hd__xnor2_1
X$229 VPWR VPWR \$287 \$254 VGND \$188 VGND sky130_fd_sc_hd__xnor2_1
X$230 VPWR VPWR VGND VGND sky130_fd_sc_hd__decap_8
X$232 VGND \$277 \$266 \$265 \$249 VPWR VPWR VGND sky130_fd_sc_hd__xnor3_1
X$233 VPWR VGND VPWR VGND sky130_fd_sc_hd__decap_4
X$235 VPWR \$279 VPWR VGND \$191 \$277 VGND sky130_fd_sc_hd__nand2_1
X$237 VPWR VPWR \$288 \$250 VGND \$280 \$279 VGND sky130_fd_sc_hd__o21ai_0
X$238 VPWR \$280 VGND \$277 VPWR \$191 VGND sky130_fd_sc_hd__nor2_1
X$239 VPWR VPWR VGND VGND sky130_fd_sc_hd__decap_12
X$240 VPWR VPWR VGND VGND sky130_fd_sc_hd__decap_12
X$241 VPWR VPWR VGND VGND sky130_fd_sc_hd__decap_8
X$242 VPWR \$258 VGND \$201 \$257 VPWR VGND sky130_fd_sc_hd__lpflow_inputiso1p_1
X$243 VPWR VPWR VGND VGND sky130_fd_sc_hd__decap_12
X$245 VPWR \$289 VGND \$259 \$281 \$282 VPWR VGND sky130_fd_sc_hd__maj3_1
X$246 VGND \$241 \$282 TICK \$283 VPWR VPWR VGND sky130_fd_sc_hd__dfrtp_1
X$248 VPWR VPWR VGND VGND sky130_fd_sc_hd__decap_12
X$249 VPWR VPWR VGND VGND sky130_fd_sc_hd__decap_12
X$250 VPWR VPWR VGND VGND sky130_fd_sc_hd__decap_8
X$251 VPWR FINE_MUX[3] VGND VPWR \$236 VGND sky130_fd_sc_hd__clkdlybuf4s50_1
X$252 VPWR FINE_MUX[0] VGND VPWR \$228 VGND sky130_fd_sc_hd__clkdlybuf4s50_1
X$255 VPWR COARSE_MUX[13] VGND VPWR \$292 VGND sky130_fd_sc_hd__clkdlybuf4s50_1
X$257 VPWR VPWR \$294 \$284 VGND \$293 VGND sky130_fd_sc_hd__xnor2_1
X$258 VPWR VPWR VGND VGND sky130_fd_sc_hd__decap_12
X$259 VPWR VPWR VGND VGND sky130_fd_sc_hd__decap_12
X$260 VPWR VPWR VGND VGND sky130_fd_sc_hd__decap_12
X$262 VPWR \$295 VGND \$309 \$230 \$275 VPWR VGND sky130_fd_sc_hd__maj3_1
X$263 VPWR VPWR VGND VGND sky130_fd_sc_hd__decap_6
X$264 VPWR VGND \$276 \$163 VPWR \$303 VGND sky130_fd_sc_hd__xor2_1
X$265 VPWR VPWR VGND VGND sky130_fd_sc_hd__decap_8
X$268 VPWR VPWR VGND VGND sky130_fd_sc_hd__decap_12
X$269 VPWR VPWR VGND VGND sky130_fd_sc_hd__decap_8
X$270 VPWR \$267 VPWR \$265 \$266 VGND VGND sky130_fd_sc_hd__and2_0
X$271 VPWR VGND \$163 VPWR \$188 \$343 \$267 VGND sky130_fd_sc_hd__a21oi_1
X$272 VPWR VPWR VGND VGND sky130_fd_sc_hd__decap_6
X$273 VGND \$290 \$277 \$191 \$250 VPWR VPWR VGND sky130_fd_sc_hd__xor3_1
X$274 VPWR VGND VPWR VGND sky130_fd_sc_hd__decap_3
X$275 VPWR VPWR \$298 \$290 VGND \$235 VGND sky130_fd_sc_hd__xnor2_1
X$276 VPWR VPWR VGND VGND sky130_fd_sc_hd__decap_12
X$277 VPWR VPWR VGND VGND sky130_fd_sc_hd__decap_8
X$280 VPWR VPWR VGND VGND sky130_fd_sc_hd__decap_12
X$281 VPWR VPWR VGND VGND sky130_fd_sc_hd__decap_8
X$282 VPWR VGND VPWR VGND sky130_fd_sc_hd__decap_3
X$283 VPWR VPWR \$283 \$272 VGND \$281 VGND sky130_fd_sc_hd__xnor2_1
X$284 VPWR VPWR VGND VGND sky130_fd_sc_hd__decap_12
X$285 VPWR VPWR VGND VGND sky130_fd_sc_hd__decap_12
X$286 VPWR VPWR VGND VGND sky130_fd_sc_hd__decap_12
X$287 VPWR VPWR VGND VGND sky130_fd_sc_hd__decap_12
X$288 VPWR VPWR VGND VGND sky130_fd_sc_hd__decap_6
X$291 VPWR VGND VPWR VGND sky130_fd_sc_hd__decap_4
X$294 VPWR COARSE_MUX[11] VGND VPWR \$360 VGND sky130_fd_sc_hd__clkdlybuf4s50_1
X$296 VPWR COARSE_MUX[12] VGND VPWR \$361 VGND sky130_fd_sc_hd__clkdlybuf4s50_1
X$297 VPWR \$379 VGND \$305 VPWR \$362 VGND sky130_fd_sc_hd__nor2_1
X$298 VPWR VPWR VGND VGND sky130_fd_sc_hd__decap_8
X$300 VPWR \$380 VPWR VGND \$363 \$353 VGND sky130_fd_sc_hd__nand2_1
X$301 VPWR VPWR VGND VGND sky130_fd_sc_hd__decap_8
X$304 VPWR VPWR VGND VGND sky130_fd_sc_hd__decap_6
X$305 VPWR VGND \$364 VPWR \$372 \$339 \$365 VGND sky130_fd_sc_hd__a21o_1
X$306 VPWR VGND \$367 \$372 VPWR \$348 VGND sky130_fd_sc_hd__xor2_1
X$307 VPWR VPWR VGND VGND sky130_fd_sc_hd__decap_12
X$308 VPWR VPWR VGND VGND sky130_fd_sc_hd__decap_12
X$310 VGND \$373 \$354 \$356 \$355 VPWR VPWR VGND sky130_fd_sc_hd__xor3_1
X$311 VPWR VPWR VGND VGND sky130_fd_sc_hd__decap_6
X$313 VPWR \$381 VGND \$373 VPWR \$374 VGND sky130_fd_sc_hd__nor2_1
X$314 VPWR VGND \$373 \$374 VPWR \$375 VGND sky130_fd_sc_hd__xor2_1
X$316 VPWR VGND \$376 VPWR \$288 \$382 \$375 VGND sky130_fd_sc_hd__a21oi_1
X$318 VPWR \$383 VPWR VGND \$375 \$376 \$288 VGND sky130_fd_sc_hd__nand3_1
X$319 VPWR VPWR VGND VGND sky130_fd_sc_hd__decap_12
X$321 VPWR \$384 VGND \$370 \$377 \$378 VPWR VGND sky130_fd_sc_hd__maj3_1
X$322 VPWR VPWR \$385 \$370 VGND \$378 VGND sky130_fd_sc_hd__xnor2_1
X$323 VPWR VGND \$385 \$377 VPWR \$386 VGND sky130_fd_sc_hd__xor2_1
X$324 VPWR VPWR VGND VGND sky130_fd_sc_hd__decap_12
X$325 VPWR VGND VPWR VGND sky130_fd_sc_hd__decap_3
X$326 VPWR VPWR \$358 \$349 VGND \$351 VGND sky130_fd_sc_hd__xnor2_1
X$327 VPWR VPWR VGND VGND sky130_fd_sc_hd__decap_12
X$328 VPWR VPWR VGND VGND sky130_fd_sc_hd__decap_12
X$330 VPWR VPWR VGND VGND sky130_fd_sc_hd__decap_12
X$331 VPWR VPWR VGND VGND sky130_fd_sc_hd__decap_12
X$332 VPWR VPWR VGND VGND sky130_fd_sc_hd__decap_12
X$333 VPWR VPWR VGND VGND sky130_fd_sc_hd__decap_12
X$336 VPWR COARSE_MUX[10] VGND VPWR \$394 VGND sky130_fd_sc_hd__clkdlybuf4s50_1
X$337 VPWR VGND \$361 \$360 VPWR \$304 VGND sky130_fd_sc_hd__xor2_1
X$338 VPWR VPWR VGND VGND sky130_fd_sc_hd__decap_6
X$340 VPWR \$392 VGND \$379 VPWR \$400 VGND sky130_fd_sc_hd__nor2_1
X$341 VPWR VPWR \$363 \$387 VGND \$392 VGND sky130_fd_sc_hd__xnor2_1
X$342 VPWR VGND \$380 \$401 VPWR \$409 \$346 \$388 VGND sky130_fd_sc_hd__a22o_1
X$343 VPWR VPWR VGND VGND sky130_fd_sc_hd__decap_12
X$345 VPWR \$339 VGND \$346 VPWR \$372 VGND sky130_fd_sc_hd__nor2_1
X$346 VPWR \$389 VGND \$331 VPWR \$346 VGND sky130_fd_sc_hd__nor2_1
X$348 VPWR \$396 VGND \$389 VPWR \$348 VGND sky130_fd_sc_hd__nor2_1
X$349 VPWR VPWR VGND VGND sky130_fd_sc_hd__decap_12
X$350 VPWR VPWR VGND VGND sky130_fd_sc_hd__decap_6
X$351 VPWR VGND \$393 \$390 VPWR \$368 VGND sky130_fd_sc_hd__lpflow_isobufsrc_1
X$353 VPWR VPWR \$397 \$390 VGND \$368 VGND sky130_fd_sc_hd__xnor2_1
X$354 VPWR VPWR VGND VGND sky130_fd_sc_hd__decap_12
X$355 VPWR VPWR VGND VGND sky130_fd_sc_hd__decap_12
X$356 VPWR VPWR VGND VGND sky130_fd_sc_hd__decap_12
X$357 VPWR VGND VPWR VGND sky130_fd_sc_hd__decap_4
X$358 VPWR VPWR \$398 \$382 VGND \$384 \$383 VGND sky130_fd_sc_hd__o21ai_0
X$359 VPWR VPWR VGND VGND sky130_fd_sc_hd__decap_12
X$360 VPWR VPWR VGND VGND sky130_fd_sc_hd__decap_12
X$361 VPWR VPWR VGND VGND sky130_fd_sc_hd__decap_8
X$364 VPWR VGND VPWR VGND sky130_fd_sc_hd__decap_4
X$365 VPWR \$415 VGND \$386 \$350 \$405 VPWR VGND sky130_fd_sc_hd__maj3_1
X$366 VPWR VPWR VGND VGND sky130_fd_sc_hd__decap_12
X$367 VPWR VPWR VGND VGND sky130_fd_sc_hd__decap_12
X$368 VPWR VPWR VGND VGND sky130_fd_sc_hd__decap_12
X$369 VPWR VPWR VGND VGND sky130_fd_sc_hd__decap_12
X$370 VPWR VPWR VGND VGND sky130_fd_sc_hd__decap_12
X$371 VPWR VPWR VGND VGND sky130_fd_sc_hd__decap_12
X$374 VPWR VGND VPWR VGND sky130_fd_sc_hd__decap_4
X$377 VPWR VPWR VGND VGND sky130_fd_sc_hd__decap_12
X$379 VPWR VPWR VGND VGND sky130_fd_sc_hd__decap_12
X$380 VPWR VPWR VGND VGND sky130_fd_sc_hd__decap_12
X$381 VPWR VPWR VGND VGND sky130_fd_sc_hd__decap_6
X$383 VPWR VGND VPWR VGND sky130_fd_sc_hd__decap_4
X$385 VPWR VGND VPWR VGND sky130_fd_sc_hd__decap_3
X$387 VPWR VGND VPWR VGND sky130_fd_sc_hd__decap_4
X$388 VPWR VGND VPWR VGND sky130_fd_sc_hd__decap_3
X$390 VPWR VGND VPWR VGND sky130_fd_sc_hd__decap_3
X$391 VPWR VPWR VGND VGND sky130_fd_sc_hd__decap_6
X$394 VPWR VPWR VGND VGND sky130_fd_sc_hd__decap_6
X$399 VPWR VPWR VGND VGND sky130_fd_sc_hd__decap_12
X$400 VPWR VPWR VGND VGND sky130_fd_sc_hd__decap_12
X$403 VPWR VGND VPWR VGND sky130_fd_sc_hd__decap_4
X$407 VPWR VPWR VGND VGND sky130_fd_sc_hd__decap_12
X$408 VPWR VPWR VGND VGND sky130_fd_sc_hd__decap_12
X$409 VPWR VPWR VGND VGND sky130_fd_sc_hd__decap_12
X$410 VPWR VPWR VGND VGND sky130_fd_sc_hd__decap_12
X$411 VPWR VPWR VGND VGND sky130_fd_sc_hd__decap_6
X$412 VPWR VPWR VGND \$62 \$63 VGND sky130_fd_sc_hd__clkinv_1
X$413 VGND \$72 \$49 \$53 \$54 VPWR VPWR VGND sky130_fd_sc_hd__xnor3_1
X$417 VPWR FINE_MUX[2] VGND VPWR \$64 VGND sky130_fd_sc_hd__clkdlybuf4s50_1
X$419 VPWR VPWR VGND VGND sky130_fd_sc_hd__decap_12
X$420 VPWR VGND VPWR VGND sky130_fd_sc_hd__decap_3
X$422 VPWR \$50 VGND \$69 \$59 \$60 VPWR VGND sky130_fd_sc_hd__maj3_1
X$424 VPWR VGND VPWR VGND sky130_fd_sc_hd__decap_4
X$426 VPWR VPWR VGND VGND sky130_fd_sc_hd__decap_12
X$427 VPWR VPWR VGND VGND sky130_fd_sc_hd__decap_12
X$428 VPWR VPWR VGND VGND sky130_fd_sc_hd__decap_8
X$431 VPWR VGND VPWR VGND sky130_fd_sc_hd__decap_4
X$436 VPWR VPWR VGND VGND sky130_fd_sc_hd__decap_6
X$437 VPWR VPWR VGND VGND sky130_fd_sc_hd__decap_6
X$438 VPWR \$447 VGND \$455 \$464 \$456 VPWR VGND sky130_fd_sc_hd__maj3_1
X$439 VGND \$418 \$465 \$475 \$455 VPWR VPWR VGND sky130_fd_sc_hd__xnor3_1
X$440 VPWR VGND \$465 \$455 VPWR \$457 VGND sky130_fd_sc_hd__xor2_1
X$441 VPWR \$446 VPWR VGND \$475 \$457 VGND sky130_fd_sc_hd__nand2_1
X$442 VPWR VPWR VGND VGND sky130_fd_sc_hd__decap_12
X$443 VPWR VPWR VGND VGND sky130_fd_sc_hd__decap_12
X$444 VPWR VPWR VGND VGND sky130_fd_sc_hd__decap_12
X$445 VPWR VPWR VGND VGND sky130_fd_sc_hd__decap_6
X$447 VPWR VPWR VGND VGND sky130_fd_sc_hd__decap_12
X$448 VPWR VPWR VGND VGND sky130_fd_sc_hd__decap_12
X$449 VPWR VPWR VGND VGND sky130_fd_sc_hd__decap_6
X$450 VPWR VPWR VGND VGND sky130_fd_sc_hd__decap_12
X$451 VPWR VPWR \$466 \$420 VGND \$445 VGND sky130_fd_sc_hd__xnor2_1
X$452 VPWR VGND VPWR VGND sky130_fd_sc_hd__decap_4
X$455 VPWR \$480 VGND \$450 VPWR \$467 VGND sky130_fd_sc_hd__nor2_1
X$456 VPWR \$467 VPWR VGND \$332 \$451 VGND sky130_fd_sc_hd__nand2_1
X$457 VPWR VGND \$450 \$467 VPWR \$476 VGND sky130_fd_sc_hd__xor2_1
X$458 VPWR VGND \$451 \$332 VPWR \$458 VGND sky130_fd_sc_hd__xor2_1
X$460 VPWR \$468 VPWR VGND \$459 \$458 VGND sky130_fd_sc_hd__nand2_1
X$462 VPWR VPWR \$469 \$458 VGND \$459 VGND sky130_fd_sc_hd__xnor2_1
X$463 VPWR VGND VPWR VGND sky130_fd_sc_hd__decap_4
X$465 VPWR VPWR \$486 \$469 VGND \$477 \$468 VGND sky130_fd_sc_hd__o21ai_0
X$466 VPWR VPWR VGND VGND sky130_fd_sc_hd__decap_12
X$468 VPWR VPWR \$481 \$477 VGND \$469 VGND sky130_fd_sc_hd__xnor2_1
X$469 VPWR VPWR VGND VGND sky130_fd_sc_hd__decap_12
X$470 VPWR VPWR VGND VGND sky130_fd_sc_hd__decap_8
X$472 VPWR VGND \$442 VPWR \$443 \$460 \$470 VGND sky130_fd_sc_hd__a21o_1
X$473 VPWR \$478 VPWR VGND \$452 \$470 VGND sky130_fd_sc_hd__nand2_1
X$474 VPWR VPWR \$479 \$478 VGND \$461 VGND sky130_fd_sc_hd__xnor2_1
X$476 VPWR \$471 \$461 VPWR VGND \$478 VGND sky130_fd_sc_hd__nand2b_1
X$477 VGND \$241 \$460 TICK \$479 VPWR VPWR VGND sky130_fd_sc_hd__dfrtp_1
X$479 VPWR VPWR VGND VGND sky130_fd_sc_hd__decap_12
X$480 VPWR VGND VPWR VGND sky130_fd_sc_hd__decap_4
X$482 VPWR \$461 VGND \$444 \$462 \$449 VPWR VGND sky130_fd_sc_hd__maj3_1
X$483 VGND \$241 \$449 TICK \$472 VPWR VPWR VGND sky130_fd_sc_hd__dfrtp_1
X$484 VPWR VPWR \$472 \$453 VGND \$462 VGND sky130_fd_sc_hd__xnor2_1
X$485 VPWR VPWR VGND VGND sky130_fd_sc_hd__decap_12
X$486 VPWR VGND VPWR VGND sky130_fd_sc_hd__decap_4
X$489 VPWR VPWR VGND VGND sky130_fd_sc_hd__decap_12
X$490 VPWR VPWR VGND VGND sky130_fd_sc_hd__decap_12
X$491 VPWR VPWR VGND VGND sky130_fd_sc_hd__decap_12
X$492 VPWR VPWR VGND VGND sky130_fd_sc_hd__decap_12
X$493 VPWR VPWR VGND VGND sky130_fd_sc_hd__decap_12
X$494 VPWR VPWR VGND VGND sky130_fd_sc_hd__decap_12
X$495 VPWR VPWR VGND VGND sky130_fd_sc_hd__decap_12
X$496 VPWR VGND VPWR VGND sky130_fd_sc_hd__decap_4
X$499 VPWR VPWR VGND VGND sky130_fd_sc_hd__decap_12
X$500 VPWR VPWR VGND VGND sky130_fd_sc_hd__decap_12
X$501 VPWR VPWR VGND VGND sky130_fd_sc_hd__decap_12
X$502 VPWR VPWR VGND VGND sky130_fd_sc_hd__decap_12
X$503 VPWR VPWR VGND VGND sky130_fd_sc_hd__decap_12
X$504 VPWR VPWR VGND VGND sky130_fd_sc_hd__decap_12
X$505 VPWR VPWR VGND VGND sky130_fd_sc_hd__decap_12
X$508 VPWR VGND VPWR VGND sky130_fd_sc_hd__decap_4
X$514 VPWR VPWR VGND VGND sky130_fd_sc_hd__decap_12
X$515 VPWR VPWR VGND VGND sky130_fd_sc_hd__decap_12
X$516 VPWR VPWR VGND VGND sky130_fd_sc_hd__decap_12
X$517 VPWR VPWR VGND VGND sky130_fd_sc_hd__decap_12
X$518 VPWR VPWR VGND VGND sky130_fd_sc_hd__decap_12
X$519 VPWR VPWR VGND VGND sky130_fd_sc_hd__decap_12
X$520 VPWR VPWR VGND VGND sky130_fd_sc_hd__decap_6
X$521 VPWR VPWR VGND VGND sky130_fd_sc_hd__decap_6
X$524 VPWR VPWR VGND VGND sky130_fd_sc_hd__decap_12
X$525 VPWR VPWR VGND VGND sky130_fd_sc_hd__decap_12
X$526 VPWR VPWR VGND VGND sky130_fd_sc_hd__decap_12
X$527 VPWR VPWR VGND VGND sky130_fd_sc_hd__decap_12
X$528 VPWR VPWR VGND VGND sky130_fd_sc_hd__decap_12
X$529 VPWR VPWR VGND VGND sky130_fd_sc_hd__decap_12
X$530 VPWR VPWR VGND VGND sky130_fd_sc_hd__decap_12
X$531 VPWR VPWR VGND VGND sky130_fd_sc_hd__decap_6
X$533 VPWR VPWR VGND VGND sky130_fd_sc_hd__decap_12
X$534 VPWR VPWR VGND VGND sky130_fd_sc_hd__decap_12
X$535 VPWR VPWR VGND VGND sky130_fd_sc_hd__decap_12
X$536 VPWR VPWR VGND VGND sky130_fd_sc_hd__decap_12
X$537 VPWR VPWR VGND VGND sky130_fd_sc_hd__decap_12
X$538 VPWR VPWR VGND VGND sky130_fd_sc_hd__decap_12
X$539 VPWR VPWR VGND VGND sky130_fd_sc_hd__decap_6
X$543 VPWR VPWR VGND VGND sky130_fd_sc_hd__decap_12
X$544 VPWR \$535 VGND \$523 VPWR \$512 VGND sky130_fd_sc_hd__nor2_1
X$545 VPWR VPWR VGND VGND sky130_fd_sc_hd__decap_8
X$546 VPWR VGND VPWR VGND sky130_fd_sc_hd__decap_3
X$547 VPWR VPWR VGND VGND sky130_fd_sc_hd__decap_12
X$548 VPWR \$544 VGND \$512 VPWR \$518 VGND sky130_fd_sc_hd__nor2_1
X$549 VPWR VPWR \$536 \$544 VGND \$524 VGND sky130_fd_sc_hd__xnor2_1
X$550 VPWR VPWR VGND VGND sky130_fd_sc_hd__decap_12
X$551 VPWR VPWR VGND VGND sky130_fd_sc_hd__decap_12
X$552 VPWR VGND VPWR VGND sky130_fd_sc_hd__decap_4
X$553 VPWR VPWR VGND VGND sky130_fd_sc_hd__decap_6
X$555 VPWR \$519 VPWR VGND \$512 \$516 VGND sky130_fd_sc_hd__nand2_1
X$557 VPWR VPWR VGND VGND sky130_fd_sc_hd__decap_12
X$558 VPWR VGND \$516 VPWR \$518 \$537 \$520 VGND sky130_fd_sc_hd__a21o_1
X$559 VPWR \$520 VGND \$516 VPWR \$512 \$530 \$521 VGND sky130_fd_sc_hd__a31oi_1
X$560 VPWR VPWR VGND VGND sky130_fd_sc_hd__decap_12
X$561 VPWR VPWR VGND VGND sky130_fd_sc_hd__decap_8
X$563 VGND \$241 \$531 TICK \$528 VPWR VPWR VGND sky130_fd_sc_hd__dfrtp_1
X$564 VPWR VPWR VGND VGND sky130_fd_sc_hd__decap_12
X$565 VPWR VPWR VGND VGND sky130_fd_sc_hd__decap_6
X$568 VPWR VPWR VGND VGND sky130_fd_sc_hd__decap_6
X$569 VPWR VGND VPWR VGND sky130_fd_sc_hd__decap_4
X$571 VPWR VGND \$542 VPWR \$543 VGND sky130_fd_sc_hd__buf_2
X$573 VPWR DCO_EN VGND VPWR \$241 VGND sky130_fd_sc_hd__clkdlybuf4s50_1
X$574 VPWR VGND \$545 VPWR \$531 VGND sky130_fd_sc_hd__buf_2
X$576 VPWR \$531 VGND VPWR MID_OUT VGND sky130_fd_sc_hd__clkdlybuf4s50_1
X$577 VPWR \$545 VGND VPWR OUT VGND sky130_fd_sc_hd__clkdlybuf4s50_1
X$578 VPWR \$527 VGND VPWR INJ_EDGE VGND sky130_fd_sc_hd__clkdlybuf4s50_1
X$579 VPWR \$542 VGND VPWR SS_BBPD[1] VGND sky130_fd_sc_hd__clkdlybuf4s50_1
X$580 VPWR \$539 VGND VPWR SS_BBPD[0] VGND sky130_fd_sc_hd__clkdlybuf4s50_1
X$581 VPWR VGND \$534 VPWR \$529 VGND sky130_fd_sc_hd__buf_2
X$582 VPWR VPWR VGND VGND sky130_fd_sc_hd__decap_12
X$583 VPWR VGND VPWR VGND sky130_fd_sc_hd__decap_3
X$585 VPWR VGND VPWR VGND sky130_fd_sc_hd__decap_4
X$592 VPWR VPWR VGND VGND sky130_fd_sc_hd__decap_12
X$593 VPWR VPWR VGND VGND sky130_fd_sc_hd__decap_12
X$594 VPWR VPWR VGND VGND sky130_fd_sc_hd__decap_12
X$595 VPWR VPWR VGND VGND sky130_fd_sc_hd__decap_12
X$596 VPWR VPWR VGND VGND sky130_fd_sc_hd__decap_12
X$597 VPWR VPWR VGND VGND sky130_fd_sc_hd__decap_12
X$598 VPWR VPWR VGND VGND sky130_fd_sc_hd__decap_6
X$599 VPWR VPWR VGND VGND sky130_fd_sc_hd__decap_12
X$601 VPWR VPWR VGND VGND sky130_fd_sc_hd__decap_12
X$602 VPWR VPWR VGND VGND sky130_fd_sc_hd__decap_12
X$603 VPWR VPWR VGND VGND sky130_fd_sc_hd__decap_12
X$604 VPWR VPWR VGND VGND sky130_fd_sc_hd__decap_12
X$605 VPWR VPWR VGND VGND sky130_fd_sc_hd__decap_12
X$606 VPWR VPWR VGND VGND sky130_fd_sc_hd__decap_12
X$607 VPWR VPWR VGND VGND sky130_fd_sc_hd__decap_12
X$610 VPWR VPWR VGND VGND sky130_fd_sc_hd__decap_12
X$611 VPWR VPWR VGND VGND sky130_fd_sc_hd__decap_12
X$612 VPWR VPWR VGND VGND sky130_fd_sc_hd__decap_6
X$614 VPWR VPWR VGND \$501 \$498 VGND sky130_fd_sc_hd__clkinv_1
X$615 VPWR VPWR \$499 \$487 VGND \$498 VGND sky130_fd_sc_hd__xnor2_1
X$616 VPWR \$503 VGND \$494 \$487 \$501 VPWR VGND sky130_fd_sc_hd__maj3_1
X$617 VPWR VGND \$494 \$499 VPWR \$502 VGND sky130_fd_sc_hd__xor2_1
X$618 VPWR \$504 \$500 VGND \$497 VPWR \$502 VGND sky130_fd_sc_hd__nor3_1
X$619 VPWR VPWR VGND VGND sky130_fd_sc_hd__decap_8
X$620 VPWR VGND \$497 \$502 VPWR \$505 VGND sky130_fd_sc_hd__xor2_1
X$622 VGND \$241 \$498 TICK \$505 VPWR VPWR VGND sky130_fd_sc_hd__dfrtp_1
X$624 VPWR VPWR VGND VGND sky130_fd_sc_hd__decap_12
X$625 VPWR VPWR VGND VGND sky130_fd_sc_hd__decap_12
X$626 VPWR VPWR VGND VGND sky130_fd_sc_hd__decap_12
X$627 VPWR VPWR VGND VGND sky130_fd_sc_hd__decap_12
X$628 VPWR VPWR VGND VGND sky130_fd_sc_hd__decap_12
X$629 VPWR VPWR VGND VGND sky130_fd_sc_hd__decap_12
X$632 VPWR VPWR VGND VGND sky130_fd_sc_hd__decap_12
X$633 VPWR VPWR VGND VGND sky130_fd_sc_hd__decap_12
X$634 VPWR VPWR VGND VGND sky130_fd_sc_hd__decap_12
X$635 VPWR VPWR VGND VGND sky130_fd_sc_hd__decap_12
X$636 VPWR VPWR VGND VGND sky130_fd_sc_hd__decap_12
X$637 VPWR VPWR VGND VGND sky130_fd_sc_hd__decap_12
X$638 VPWR VPWR VGND VGND sky130_fd_sc_hd__decap_12
X$641 VPWR VPWR VGND VGND sky130_fd_sc_hd__decap_12
X$642 VPWR VPWR VGND VGND sky130_fd_sc_hd__decap_12
X$643 VPWR VPWR VGND VGND sky130_fd_sc_hd__decap_12
X$644 VPWR VPWR VGND VGND sky130_fd_sc_hd__decap_12
X$645 VPWR VPWR VGND VGND sky130_fd_sc_hd__decap_12
X$646 VPWR VPWR VGND VGND sky130_fd_sc_hd__decap_12
X$647 VPWR VPWR VGND VGND sky130_fd_sc_hd__decap_12
X$650 VPWR VGND VPWR VGND sky130_fd_sc_hd__decap_4
X$656 VPWR COARSE_MUX[7] VGND VPWR \$434 VGND sky130_fd_sc_hd__clkdlybuf4s50_1
X$657 VPWR VPWR VGND VGND sky130_fd_sc_hd__decap_6
X$658 VPWR \$419 VGND \$406 \$438 \$434 VPWR VGND sky130_fd_sc_hd__maj3_1
X$659 VPWR COARSE_MUX[5] VGND VPWR \$438 VGND sky130_fd_sc_hd__clkdlybuf4s50_1
X$660 VPWR VGND \$438 \$434 VPWR \$439 VGND sky130_fd_sc_hd__xor2_1
X$661 VPWR VPWR \$448 \$418 VGND \$407 \$446 VGND sky130_fd_sc_hd__o21ai_0
X$663 VPWR VPWR \$407 \$439 VGND \$406 VGND sky130_fd_sc_hd__xnor2_1
X$664 VPWR VGND \$447 \$448 VPWR \$425 VGND sky130_fd_sc_hd__xor2_1
X$665 VPWR VPWR VGND VGND sky130_fd_sc_hd__decap_12
X$666 VPWR \$409 VPWR VGND \$448 \$447 VGND sky130_fd_sc_hd__nand2_1
X$667 VPWR VPWR VGND VGND sky130_fd_sc_hd__decap_12
X$670 VPWR VPWR VGND VGND sky130_fd_sc_hd__decap_12
X$671 VPWR VPWR VGND VGND sky130_fd_sc_hd__decap_8
X$673 VPWR VGND \$421 VPWR \$295 \$445 \$440 VGND sky130_fd_sc_hd__a21oi_1
X$674 VPWR VGND VPWR VGND sky130_fd_sc_hd__decap_3
X$675 VPWR VGND \$402 \$410 VPWR \$440 VGND sky130_fd_sc_hd__xor2_1
X$676 VPWR VPWR \$441 \$402 \$450 \$445 VGND VGND sky130_fd_sc_hd__o21bai_1
X$677 VPWR VPWR \$451 \$421 VGND \$295 VGND sky130_fd_sc_hd__xnor2_1
X$678 VPWR \$441 VPWR VGND \$295 \$421 VGND sky130_fd_sc_hd__nand2_1
X$679 VPWR VPWR VGND VGND sky130_fd_sc_hd__decap_12
X$680 VPWR VPWR VGND VGND sky130_fd_sc_hd__decap_12
X$681 VPWR VPWR VGND VGND sky130_fd_sc_hd__decap_12
X$684 VPWR VPWR VGND VGND sky130_fd_sc_hd__decap_12
X$685 VPWR VPWR VGND VGND sky130_fd_sc_hd__decap_8
X$686 VPWR VPWR VGND VGND sky130_fd_sc_hd__decap_12
X$688 VPWR \$426 VGND \$357 VPWR \$397 VGND sky130_fd_sc_hd__nor2_1
X$690 VPWR \$435 VGND \$423 VPWR \$431 \$477 \$430 VGND sky130_fd_sc_hd__a31oi_1
X$691 VPWR VPWR VGND VGND sky130_fd_sc_hd__decap_6
X$693 VPWR VGND \$435 VPWR \$431 \$423 \$442 VGND sky130_fd_sc_hd__a21o_1
X$695 VPWR \$452 VPWR VGND \$442 \$443 \$460 VGND sky130_fd_sc_hd__nand3_1
X$696 VPWR \$443 VPWR VGND \$435 \$423 \$431 VGND sky130_fd_sc_hd__nand3_1
X$697 VPWR VPWR VGND VGND sky130_fd_sc_hd__decap_12
X$698 VPWR VGND VPWR VGND sky130_fd_sc_hd__decap_4
X$701 VPWR VPWR VGND VGND sky130_fd_sc_hd__decap_6
X$702 VPWR VPWR VGND VGND sky130_fd_sc_hd__decap_12
X$703 VPWR VPWR \$444 \$398 VGND \$432 VGND sky130_fd_sc_hd__xnor2_1
X$704 VPWR VPWR VGND VGND sky130_fd_sc_hd__decap_8
X$705 VPWR VGND VPWR VGND sky130_fd_sc_hd__decap_3
X$706 VPWR VPWR \$453 \$444 VGND \$449 VGND sky130_fd_sc_hd__xnor2_1
X$707 VPWR VGND VPWR VGND sky130_fd_sc_hd__decap_3
X$708 VPWR VPWR \$424 \$404 VGND \$416 VGND sky130_fd_sc_hd__xnor2_1
X$709 VPWR VPWR VGND VGND sky130_fd_sc_hd__decap_12
X$710 VPWR VPWR VGND VGND sky130_fd_sc_hd__decap_12
X$711 VPWR VGND VPWR VGND sky130_fd_sc_hd__decap_4
X$713 VPWR VPWR VGND VGND sky130_fd_sc_hd__decap_12
X$714 VPWR VPWR VGND VGND sky130_fd_sc_hd__decap_12
X$715 VPWR VPWR VGND VGND sky130_fd_sc_hd__decap_12
X$716 VPWR VPWR VGND VGND sky130_fd_sc_hd__decap_12
X$717 VPWR VPWR VGND VGND sky130_fd_sc_hd__decap_12
X$718 VPWR VPWR VGND VGND sky130_fd_sc_hd__decap_12
X$719 VPWR VPWR VGND VGND sky130_fd_sc_hd__decap_12
X$720 VPWR VPWR VGND VGND sky130_fd_sc_hd__decap_6
X$722 VPWR VPWR VGND VGND sky130_fd_sc_hd__decap_12
X$723 VPWR VPWR VGND VGND sky130_fd_sc_hd__decap_12
X$724 VPWR VPWR VGND VGND sky130_fd_sc_hd__decap_12
X$725 VPWR VPWR VGND VGND sky130_fd_sc_hd__decap_12
X$726 VPWR VPWR VGND VGND sky130_fd_sc_hd__decap_12
X$727 VPWR VPWR VGND VGND sky130_fd_sc_hd__decap_12
X$728 VPWR VPWR VGND VGND sky130_fd_sc_hd__decap_12
X$731 VPWR VGND VPWR VGND sky130_fd_sc_hd__decap_4
X$737 VPWR VGND VPWR VGND sky130_fd_sc_hd__decap_4
X$738 VPWR MID_MUX[10] VGND VPWR \$134 VGND sky130_fd_sc_hd__clkdlybuf4s50_1
X$740 VGND \$148 \$135 \$137 \$134 VPWR VPWR VGND sky130_fd_sc_hd__xor3_1
X$742 VPWR VPWR \$135 \$139 VGND \$136 VGND sky130_fd_sc_hd__xnor2_1
X$743 VPWR VPWR VGND VGND sky130_fd_sc_hd__decap_6
X$744 VPWR \$140 VGND \$135 \$137 \$134 VPWR VGND sky130_fd_sc_hd__maj3_1
X$745 VGND \$197 \$138 \$140 \$141 VPWR VPWR VGND sky130_fd_sc_hd__xor3_1
X$746 VPWR VGND VPWR VGND sky130_fd_sc_hd__decap_4
X$747 VPWR \$142 VGND \$138 \$140 \$141 VPWR VGND sky130_fd_sc_hd__maj3_1
X$749 VPWR VPWR VGND VGND sky130_fd_sc_hd__decap_12
X$750 VPWR VPWR VGND VGND sky130_fd_sc_hd__decap_12
X$751 VPWR VPWR VGND VGND sky130_fd_sc_hd__decap_12
X$752 VPWR VPWR VGND VGND sky130_fd_sc_hd__decap_12
X$753 VPWR VPWR VGND VGND sky130_fd_sc_hd__decap_12
X$754 VPWR VPWR VGND VGND sky130_fd_sc_hd__decap_12
X$755 VPWR VPWR VGND VGND sky130_fd_sc_hd__decap_12
X$756 VPWR VPWR VGND VGND sky130_fd_sc_hd__decap_6
X$758 VPWR VPWR VGND VGND sky130_fd_sc_hd__decap_12
X$759 VPWR VPWR VGND VGND sky130_fd_sc_hd__decap_12
X$760 VPWR VPWR VGND VGND sky130_fd_sc_hd__decap_12
X$761 VPWR VPWR VGND VGND sky130_fd_sc_hd__decap_12
X$762 VPWR VGND VPWR VGND sky130_fd_sc_hd__decap_4
X$764 VPWR VPWR \$195 \$128 VGND \$130 VGND sky130_fd_sc_hd__xnor2_1
X$765 VPWR VGND \$128 VPWR \$130 \$129 \$156 VGND sky130_fd_sc_hd__a21o_1
X$766 VPWR VPWR VGND VGND sky130_fd_sc_hd__decap_12
X$767 VPWR VPWR VGND VGND sky130_fd_sc_hd__decap_6
X$769 VPWR VPWR VGND VGND sky130_fd_sc_hd__decap_12
X$770 VPWR VPWR VGND VGND sky130_fd_sc_hd__decap_12
X$771 VPWR VPWR VGND VGND sky130_fd_sc_hd__decap_6
X$772 VPWR VPWR VGND VGND sky130_fd_sc_hd__decap_12
X$774 VPWR VPWR \$122 \$123 VGND \$109 VGND sky130_fd_sc_hd__xnor2_1
X$776 VPWR VPWR VGND VGND sky130_fd_sc_hd__decap_6
X$777 VGND \$123 \$125 \$126 \$119 VPWR VPWR VGND sky130_fd_sc_hd__xor3_1
X$779 VPWR \$124 VPWR VGND \$119 \$132 VGND sky130_fd_sc_hd__nand2_1
X$780 VPWR VGND VPWR VGND sky130_fd_sc_hd__decap_4
X$782 VPWR VPWR VGND VGND sky130_fd_sc_hd__decap_8
X$783 VPWR VPWR VGND VGND sky130_fd_sc_hd__decap_8
X$785 VPWR \$158 VGND \$125 \$144 \$145 VPWR VGND sky130_fd_sc_hd__maj3_1
X$786 VPWR VGND \$144 \$120 VPWR \$126 VGND sky130_fd_sc_hd__xor2_1
X$787 VPWR VPWR VGND \$145 \$120 VGND sky130_fd_sc_hd__clkinv_1
X$788 VPWR VPWR VGND VGND sky130_fd_sc_hd__decap_12
X$789 VPWR VPWR VGND VGND sky130_fd_sc_hd__decap_12
X$790 VPWR VPWR VGND VGND sky130_fd_sc_hd__decap_8
X$792 VPWR \$159 VPWR VGND \$149 \$146 \$147 VGND sky130_fd_sc_hd__and3b_1
X$793 VPWR VGND VPWR VGND sky130_fd_sc_hd__decap_3
X$795 VPWR \$149 VGND \$147 VPWR \$150 \$146 VGND sky130_fd_sc_hd__a21boi_0
X$796 VPWR VPWR VGND VGND sky130_fd_sc_hd__decap_12
X$797 VPWR VPWR VGND VGND sky130_fd_sc_hd__decap_12
X$798 VPWR VPWR VGND VGND sky130_fd_sc_hd__decap_12
X$799 VPWR VPWR VGND VGND sky130_fd_sc_hd__decap_12
X$800 VPWR VPWR VGND VGND sky130_fd_sc_hd__decap_12
X$801 VPWR VPWR VGND VGND sky130_fd_sc_hd__decap_12
X$802 VPWR VPWR VGND VGND sky130_fd_sc_hd__decap_12
X$805 VPWR VGND VPWR VGND sky130_fd_sc_hd__decap_4
X$811 VPWR COARSE_MUX[2] VGND VPWR \$320 VGND sky130_fd_sc_hd__clkdlybuf4s50_1
X$812 VPWR VPWR VGND VGND sky130_fd_sc_hd__decap_6
X$813 VPWR \$353 VGND \$292 \$361 \$360 VPWR VGND sky130_fd_sc_hd__maj3_1
X$814 VPWR COARSE_MUX[4] VGND VPWR \$300 VGND sky130_fd_sc_hd__clkdlybuf4s50_1
X$815 VPWR VGND \$305 \$362 VPWR \$278 VGND sky130_fd_sc_hd__xor2_1
X$816 VPWR COARSE_MUX[6] VGND VPWR \$274 VGND sky130_fd_sc_hd__clkdlybuf4s50_1
X$817 VPWR VPWR VGND VGND sky130_fd_sc_hd__decap_6
X$818 VPWR VPWR VGND VGND sky130_fd_sc_hd__decap_12
X$819 VPWR VPWR \$301 \$353 VGND \$363 VGND sky130_fd_sc_hd__xnor2_1
X$820 VPWR VPWR VGND VGND sky130_fd_sc_hd__decap_12
X$821 VPWR VPWR VGND VGND sky130_fd_sc_hd__decap_6
X$823 VPWR VPWR VGND VGND sky130_fd_sc_hd__decap_12
X$824 VPWR VGND VPWR VGND sky130_fd_sc_hd__decap_4
X$826 VPWR VGND \$367 \$346 VPWR \$364 VGND sky130_fd_sc_hd__lpflow_isobufsrc_1
X$827 VPWR \$308 VPWR VGND \$321 \$339 VGND sky130_fd_sc_hd__nand2_1
X$828 VPWR VPWR VGND VGND sky130_fd_sc_hd__decap_12
X$829 VPWR VPWR \$340 \$372 VGND \$346 \$318 VGND sky130_fd_sc_hd__o21ai_0
X$830 VPWR \$347 VPWR VGND \$340 \$308 VGND sky130_fd_sc_hd__nand2_1
X$832 VPWR \$332 VPWR VGND \$311 \$327 \$310 VGND sky130_fd_sc_hd__or3_1
X$834 VPWR \$327 VGND \$347 VPWR \$342 VGND sky130_fd_sc_hd__nor2_1
X$835 VPWR VPWR \$390 \$347 VGND \$342 VGND sky130_fd_sc_hd__xnor2_1
X$837 VPWR VPWR \$368 \$366 VGND \$365 \$269 VGND sky130_fd_sc_hd__o21ai_0
X$838 VPWR VPWR \$354 \$365 VGND \$366 VGND sky130_fd_sc_hd__xnor2_1
X$839 VPWR VPWR VGND VGND sky130_fd_sc_hd__decap_12
X$841 VPWR VGND VPWR VGND sky130_fd_sc_hd__decap_4
X$844 VPWR \$355 VGND \$348 VPWR \$163 VGND sky130_fd_sc_hd__nor2_1
X$845 VPWR VGND \$348 \$163 VPWR \$328 VGND sky130_fd_sc_hd__xor2_1
X$846 VPWR \$357 VGND \$354 \$356 \$355 VPWR VGND sky130_fd_sc_hd__maj3_1
X$847 VPWR VPWR VGND VGND sky130_fd_sc_hd__decap_8
X$848 VPWR VPWR VGND VGND sky130_fd_sc_hd__decap_12
X$850 VPWR \$374 VGND \$322 \$270 \$343 VPWR VGND sky130_fd_sc_hd__maj3_1
X$851 VPWR VGND VPWR VGND sky130_fd_sc_hd__decap_4
X$852 VPWR VGND VPWR VGND sky130_fd_sc_hd__decap_4
X$853 VGND \$370 \$323 \$343 \$288 VPWR VPWR VGND sky130_fd_sc_hd__xor3_1
X$854 VPWR VPWR \$376 \$323 VGND \$343 VGND sky130_fd_sc_hd__xnor2_1
X$856 VPWR VPWR VGND VGND sky130_fd_sc_hd__decap_12
X$857 VPWR VPWR VGND VGND sky130_fd_sc_hd__decap_12
X$858 VPWR VGND VPWR VGND sky130_fd_sc_hd__decap_4
X$859 VPWR VPWR VGND \$378 \$313 VGND sky130_fd_sc_hd__clkinv_1
X$860 VPWR VPWR VGND VGND sky130_fd_sc_hd__decap_8
X$861 VPWR VPWR VGND VGND sky130_fd_sc_hd__decap_12
X$863 VPWR \$377 VGND \$298 \$334 \$344 VPWR VGND sky130_fd_sc_hd__maj3_1
X$864 VPWR VPWR VGND VGND sky130_fd_sc_hd__decap_8
X$865 VPWR VGND VPWR VGND sky130_fd_sc_hd__decap_3
X$866 VPWR VPWR \$349 \$335 VGND \$344 VGND sky130_fd_sc_hd__xnor2_1
X$869 VPWR VGND VPWR VGND sky130_fd_sc_hd__decap_4
X$870 VPWR VPWR VGND VGND sky130_fd_sc_hd__decap_6
X$871 VPWR VPWR \$352 \$358 VGND \$336 VGND sky130_fd_sc_hd__xnor2_1
X$873 VPWR \$350 VGND \$349 \$336 \$351 VPWR VGND sky130_fd_sc_hd__maj3_1
X$874 VGND \$241 \$351 TICK \$352 VPWR VPWR VGND sky130_fd_sc_hd__dfrtp_1
X$876 VPWR VPWR \$337 \$316 VGND \$289 VGND sky130_fd_sc_hd__xnor2_1
X$877 VPWR VPWR VGND VGND sky130_fd_sc_hd__decap_12
X$878 VPWR VPWR VGND VGND sky130_fd_sc_hd__decap_12
X$879 VPWR VGND VPWR VGND sky130_fd_sc_hd__decap_3
X$881 VPWR VPWR VGND VGND sky130_fd_sc_hd__decap_12
X$882 VPWR VPWR VGND VGND sky130_fd_sc_hd__decap_12
X$883 VPWR VPWR VGND VGND sky130_fd_sc_hd__decap_12
X$884 VPWR VPWR VGND VGND sky130_fd_sc_hd__decap_12
X$885 VPWR VPWR VGND VGND sky130_fd_sc_hd__decap_12
X$886 VPWR VPWR VGND VGND sky130_fd_sc_hd__decap_12
X$887 VPWR VPWR VGND VGND sky130_fd_sc_hd__decap_6
X$888 VPWR VPWR VGND VGND sky130_fd_sc_hd__decap_12
X$890 VPWR VGND VPWR VGND sky130_fd_sc_hd__decap_4
X$896 VPWR VGND VPWR VGND sky130_fd_sc_hd__decap_4
X$897 VPWR COARSE_MUX[8] VGND VPWR \$293 VGND sky130_fd_sc_hd__clkdlybuf4s50_1
X$899 VPWR \$307 VGND \$278 \$293 \$274 VPWR VGND sky130_fd_sc_hd__maj3_1
X$900 VPWR VPWR \$305 \$304 VGND \$292 VGND sky130_fd_sc_hd__xnor2_1
X$901 VPWR \$330 VGND \$294 \$320 \$300 VPWR VGND sky130_fd_sc_hd__maj3_1
X$902 VPWR VGND \$294 \$300 VPWR \$306 VGND sky130_fd_sc_hd__xor2_1
X$903 VPWR VPWR \$321 \$306 VGND \$320 VGND sky130_fd_sc_hd__xnor2_1
X$905 VGND \$302 \$301 \$307 \$317 VPWR VPWR VGND sky130_fd_sc_hd__xnor3_1
X$906 VPWR VPWR VGND \$317 \$330 VGND sky130_fd_sc_hd__clkinv_1
X$907 VPWR VPWR VGND \$326 \$307 VGND sky130_fd_sc_hd__clkinv_1
X$908 VPWR \$372 VGND \$301 \$326 \$317 VPWR VGND sky130_fd_sc_hd__maj3_1
X$910 VPWR VGND VPWR VGND sky130_fd_sc_hd__decap_4
X$911 VPWR VGND VPWR VGND sky130_fd_sc_hd__decap_4
X$912 VPWR \$331 VPWR VGND \$321 \$302 VGND sky130_fd_sc_hd__nand2_1
X$914 VPWR VPWR VGND \$265 \$302 VGND sky130_fd_sc_hd__clkinv_1
X$915 VPWR VPWR VGND VGND sky130_fd_sc_hd__decap_12
X$916 VPWR VPWR \$309 \$308 VGND \$265 VGND sky130_fd_sc_hd__xnor2_1
X$917 VPWR VPWR \$310 \$309 VGND \$285 VGND sky130_fd_sc_hd__xnor2_1
X$918 VPWR VPWR VGND VGND sky130_fd_sc_hd__decap_8
X$919 VPWR VGND \$311 \$286 VPWR \$303 VGND sky130_fd_sc_hd__nor2b_1
X$921 VPWR VGND \$286 \$303 VPWR \$342 VGND sky130_fd_sc_hd__xor2_1
X$922 VPWR VPWR \$333 \$311 VGND \$327 \$310 VGND sky130_fd_sc_hd__o21ai_0
X$923 VPWR VPWR VGND VGND sky130_fd_sc_hd__decap_8
X$924 VPWR VPWR VGND VGND sky130_fd_sc_hd__decap_12
X$927 VPWR VPWR VGND VGND sky130_fd_sc_hd__decap_6
X$928 VPWR VGND VPWR VGND sky130_fd_sc_hd__decap_4
X$931 VPWR \$356 VGND \$328 \$287 \$232 VPWR VGND sky130_fd_sc_hd__maj3_1
X$932 VPWR VPWR \$312 \$287 VGND \$232 VGND sky130_fd_sc_hd__xnor2_1
X$933 VPWR VPWR VGND VGND sky130_fd_sc_hd__decap_12
X$934 VPWR VPWR \$322 \$328 VGND \$312 VGND sky130_fd_sc_hd__xnor2_1
X$935 VPWR VGND VPWR VGND sky130_fd_sc_hd__decap_4
X$936 VPWR VGND \$322 \$270 VPWR \$323 VGND sky130_fd_sc_hd__xor2_1
X$937 VPWR VPWR VGND VGND sky130_fd_sc_hd__decap_12
X$938 VPWR VPWR VGND VGND sky130_fd_sc_hd__decap_12
X$939 VPWR VGND VPWR VGND sky130_fd_sc_hd__decap_3
X$941 VPWR VPWR VGND VGND sky130_fd_sc_hd__decap_12
X$942 VPWR VPWR VGND VGND sky130_fd_sc_hd__decap_12
X$943 VPWR \$313 VGND \$290 VPWR \$235 VGND sky130_fd_sc_hd__nor2_1
X$945 VPWR VPWR VGND \$318 \$321 VGND sky130_fd_sc_hd__clkinv_1
X$946 VGND \$314 \$251 \$321 \$271 VPWR VPWR VGND sky130_fd_sc_hd__xnor3_1
X$948 VPWR \$324 VGND \$251 \$318 \$271 VPWR VGND sky130_fd_sc_hd__maj3_1
X$949 VPWR VPWR VGND \$334 \$324 VGND sky130_fd_sc_hd__clkinv_1
X$950 VPWR VPWR \$335 \$298 VGND \$324 VGND sky130_fd_sc_hd__xnor2_1
X$951 VPWR VPWR VGND VGND sky130_fd_sc_hd__decap_8
X$952 VPWR \$344 \$314 VPWR VGND \$258 VGND sky130_fd_sc_hd__nand2b_1
X$955 VPWR VPWR VGND VGND sky130_fd_sc_hd__decap_12
X$956 VPWR VPWR \$315 \$314 VGND \$258 VGND sky130_fd_sc_hd__xnor2_1
X$957 VPWR VPWR VGND VGND sky130_fd_sc_hd__decap_8
X$959 VPWR \$336 VGND \$315 \$289 \$319 VPWR VGND sky130_fd_sc_hd__maj3_1
X$960 VPWR VGND VPWR VGND sky130_fd_sc_hd__decap_3
X$961 VPWR VPWR \$316 \$315 VGND \$319 VGND sky130_fd_sc_hd__xnor2_1
X$962 VGND \$241 \$319 TICK \$337 VPWR VPWR VGND sky130_fd_sc_hd__dfrtp_1
X$963 VPWR VPWR VGND VGND sky130_fd_sc_hd__decap_12
X$964 VPWR VGND VPWR VGND sky130_fd_sc_hd__decap_4
X$967 VPWR VPWR VGND VGND sky130_fd_sc_hd__decap_12
X$968 VPWR VPWR VGND VGND sky130_fd_sc_hd__decap_12
X$969 VPWR VPWR VGND VGND sky130_fd_sc_hd__decap_12
X$970 VPWR VPWR VGND VGND sky130_fd_sc_hd__decap_12
X$971 VPWR VPWR VGND VGND sky130_fd_sc_hd__decap_12
X$972 VPWR VPWR VGND VGND sky130_fd_sc_hd__decap_12
X$973 VPWR VPWR VGND VGND sky130_fd_sc_hd__decap_6
X$974 VPWR VPWR VGND VGND sky130_fd_sc_hd__decap_12
X$977 VPWR VGND VPWR VGND sky130_fd_sc_hd__decap_4
X$983 VPWR MID_MUX[4] VGND VPWR \$263 VGND sky130_fd_sc_hd__clkdlybuf4s50_1
X$984 VPWR VPWR VGND \$224 \$238 VGND sky130_fd_sc_hd__clkinv_1
X$985 VGND \$229 \$148 \$203 \$207 VPWR VPWR VGND sky130_fd_sc_hd__xnor3_1
X$986 VPWR MID_MUX[6] VGND VPWR \$207 VGND sky130_fd_sc_hd__clkdlybuf4s50_1
X$987 VPWR VPWR \$245 \$229 VGND \$263 VGND sky130_fd_sc_hd__xnor2_1
X$988 VPWR VPWR \$199 \$245 VGND \$238 VGND sky130_fd_sc_hd__xnor2_1
X$989 VPWR VPWR VGND VGND sky130_fd_sc_hd__decap_12
X$990 VPWR VPWR VGND VGND sky130_fd_sc_hd__decap_12
X$991 VPWR VPWR VGND VGND sky130_fd_sc_hd__decap_12
X$994 VPWR VPWR VGND VGND sky130_fd_sc_hd__decap_12
X$995 VPWR VPWR VGND VGND sky130_fd_sc_hd__decap_12
X$996 VPWR VPWR VGND VGND sky130_fd_sc_hd__decap_12
X$997 VPWR VPWR VGND VGND sky130_fd_sc_hd__decap_12
X$999 VPWR VPWR VGND \$248 \$210 VGND sky130_fd_sc_hd__clkinv_1
X$1000 VGND \$264 \$210 \$163 \$188 VPWR VPWR VGND sky130_fd_sc_hd__xnor3_1
X$1001 VPWR VGND VPWR VGND sky130_fd_sc_hd__decap_4
X$1002 VPWR \$269 VPWR VGND \$231 \$264 VGND sky130_fd_sc_hd__nand2_1
X$1003 VPWR VGND \$211 \$195 VPWR \$254 VGND sky130_fd_sc_hd__xor2_1
X$1005 VPWR VPWR VGND VGND sky130_fd_sc_hd__decap_12
X$1006 VPWR VPWR VGND VGND sky130_fd_sc_hd__decap_12
X$1007 VPWR VGND VPWR VGND sky130_fd_sc_hd__decap_4
X$1008 VPWR VPWR VGND VGND sky130_fd_sc_hd__decap_6
X$1010 VPWR \$255 VGND \$266 VPWR \$265 VGND sky130_fd_sc_hd__nor2_1
X$1011 VGND \$270 \$249 \$267 \$255 \$233 \$212 VPWR VPWR VGND
+ sky130_fd_sc_hd__o32a_1
X$1012 VPWR VPWR \$249 \$212 VGND \$233 VGND sky130_fd_sc_hd__xnor2_1
X$1013 VPWR VPWR VGND VGND sky130_fd_sc_hd__decap_12
X$1014 VPWR VPWR VGND VGND sky130_fd_sc_hd__decap_12
X$1015 VPWR VPWR VGND VGND sky130_fd_sc_hd__decap_12
X$1018 VPWR VGND VPWR VGND sky130_fd_sc_hd__decap_4
X$1019 VPWR VGND \$188 VPWR \$164 \$250 \$240 VGND sky130_fd_sc_hd__a21oi_1
X$1020 VGND \$251 \$200 \$234 \$240 VPWR VPWR VGND sky130_fd_sc_hd__xnor3_1
X$1021 VPWR VPWR VGND VGND sky130_fd_sc_hd__decap_12
X$1022 VPWR VPWR VGND VGND sky130_fd_sc_hd__decap_8
X$1023 VPWR VPWR VGND VGND sky130_fd_sc_hd__decap_6
X$1025 VPWR \$271 VPWR VGND \$268 \$256 VGND sky130_fd_sc_hd__nand2_1
X$1028 VPWR \$268 VGND \$127 VPWR \$154 VGND sky130_fd_sc_hd__nor2_1
X$1029 VPWR VGND \$256 \$268 VPWR \$257 VGND sky130_fd_sc_hd__xor2_1
X$1031 VGND \$241 \$226 TICK \$220 VPWR VPWR VGND sky130_fd_sc_hd__dfrtp_1
X$1033 VPWR \$256 VGND \$258 VPWR \$259 \$201 VGND sky130_fd_sc_hd__a21boi_0
X$1034 VPWR VPWR VGND VGND sky130_fd_sc_hd__decap_8
X$1035 VPWR VPWR \$221 \$201 VGND \$202 VGND sky130_fd_sc_hd__xnor2_1
X$1037 VGND \$241 \$202 TICK \$222 VPWR VPWR VGND sky130_fd_sc_hd__dfrtp_1
X$1038 VPWR VPWR \$272 \$259 VGND \$282 VGND sky130_fd_sc_hd__xnor2_1
X$1039 VPWR VPWR VGND VGND sky130_fd_sc_hd__decap_12
X$1040 VPWR VGND VPWR VGND sky130_fd_sc_hd__decap_4
X$1041 VPWR VPWR VGND VGND sky130_fd_sc_hd__decap_12
X$1044 VPWR VPWR VGND VGND sky130_fd_sc_hd__decap_12
X$1045 VPWR VPWR VGND VGND sky130_fd_sc_hd__decap_12
X$1046 VPWR VPWR VGND VGND sky130_fd_sc_hd__decap_8
X$1047 VPWR FINE_MUX[5] VGND VPWR \$181 VGND sky130_fd_sc_hd__clkdlybuf4s50_1
X$1048 VPWR VGND VPWR VGND sky130_fd_sc_hd__decap_4
X$1050 VPWR FINE_MUX[30] VGND VPWR \$179 VGND sky130_fd_sc_hd__clkdlybuf4s50_1
X$1051 VGND \$173 \$236 \$228 \$243 VPWR VPWR VGND sky130_fd_sc_hd__xor3_1
X$1052 VPWR FINE_MUX[1] VGND VPWR \$243 VGND sky130_fd_sc_hd__clkdlybuf4s50_1
X$1054 VPWR VGND VPWR VGND sky130_fd_sc_hd__decap_4
X$1061 VPWR COARSE_MUX[0] VGND VPWR \$464 VGND sky130_fd_sc_hd__clkdlybuf4s50_1
X$1062 VPWR VPWR VGND VGND sky130_fd_sc_hd__decap_12
X$1063 VPWR VPWR VGND VGND sky130_fd_sc_hd__decap_12
X$1064 VPWR VPWR VGND VGND sky130_fd_sc_hd__decap_12
X$1065 VPWR VPWR VGND VGND sky130_fd_sc_hd__decap_12
X$1066 VPWR VPWR VGND VGND sky130_fd_sc_hd__decap_12
X$1067 VPWR VPWR VGND VGND sky130_fd_sc_hd__decap_8
X$1068 VPWR VPWR VGND VGND sky130_fd_sc_hd__decap_12
X$1071 VPWR VPWR VGND VGND sky130_fd_sc_hd__decap_12
X$1072 VPWR VPWR VGND VGND sky130_fd_sc_hd__decap_12
X$1073 VPWR VPWR VGND VGND sky130_fd_sc_hd__decap_12
X$1074 VPWR VPWR VGND VGND sky130_fd_sc_hd__decap_12
X$1075 VPWR VPWR VGND VGND sky130_fd_sc_hd__decap_12
X$1076 VPWR VPWR VGND VGND sky130_fd_sc_hd__decap_12
X$1077 VPWR VPWR VGND VGND sky130_fd_sc_hd__decap_12
X$1080 VPWR VPWR VGND VGND sky130_fd_sc_hd__decap_12
X$1081 VPWR VPWR VGND VGND sky130_fd_sc_hd__decap_12
X$1082 VPWR VPWR VGND VGND sky130_fd_sc_hd__decap_12
X$1083 VPWR VPWR VGND VGND sky130_fd_sc_hd__decap_6
X$1084 VPWR VPWR VGND \$493 \$488 VGND sky130_fd_sc_hd__clkinv_1
X$1085 VPWR VPWR VGND VGND sky130_fd_sc_hd__decap_12
X$1086 VPWR VGND VPWR VGND sky130_fd_sc_hd__decap_4
X$1088 VPWR \$497 VGND \$471 \$490 VPWR VGND
+ sky130_fd_sc_hd__lpflow_inputiso1p_1
X$1089 VPWR VPWR VGND VGND sky130_fd_sc_hd__decap_6
X$1090 VPWR VPWR VGND VGND sky130_fd_sc_hd__decap_12
X$1092 VPWR VPWR VGND VGND sky130_fd_sc_hd__decap_12
X$1093 VPWR VPWR VGND VGND sky130_fd_sc_hd__decap_12
X$1094 VPWR VPWR VGND VGND sky130_fd_sc_hd__decap_12
X$1095 VPWR VPWR VGND VGND sky130_fd_sc_hd__decap_12
X$1096 VPWR VPWR VGND VGND sky130_fd_sc_hd__decap_12
X$1097 VPWR VPWR VGND VGND sky130_fd_sc_hd__decap_12
X$1098 VPWR VPWR VGND VGND sky130_fd_sc_hd__decap_12
X$1101 VPWR VPWR VGND VGND sky130_fd_sc_hd__decap_12
X$1102 VPWR VPWR VGND VGND sky130_fd_sc_hd__decap_12
X$1103 VPWR VPWR VGND VGND sky130_fd_sc_hd__decap_12
X$1104 VPWR VPWR VGND VGND sky130_fd_sc_hd__decap_12
X$1105 VPWR VPWR VGND VGND sky130_fd_sc_hd__decap_12
X$1106 VPWR VPWR VGND VGND sky130_fd_sc_hd__decap_12
X$1107 VPWR VPWR VGND VGND sky130_fd_sc_hd__decap_12
X$1110 VPWR VPWR VGND VGND sky130_fd_sc_hd__decap_12
X$1111 VPWR VPWR VGND VGND sky130_fd_sc_hd__decap_12
X$1112 VPWR VPWR VGND VGND sky130_fd_sc_hd__decap_12
X$1113 VPWR VPWR VGND VGND sky130_fd_sc_hd__decap_12
X$1114 VPWR VPWR VGND VGND sky130_fd_sc_hd__decap_12
X$1115 VPWR VPWR VGND VGND sky130_fd_sc_hd__decap_12
X$1116 VPWR VPWR VGND VGND sky130_fd_sc_hd__decap_12
X$1119 VPWR VGND VPWR VGND sky130_fd_sc_hd__decap_4
X$1125 VPWR MID_MUX[8] VGND VPWR \$203 VGND sky130_fd_sc_hd__clkdlybuf4s50_1
X$1126 VPWR MID_MUX[11] VGND VPWR \$152 VGND sky130_fd_sc_hd__clkdlybuf4s50_1
X$1127 VPWR \$192 VGND \$148 \$203 \$207 VPWR VGND sky130_fd_sc_hd__maj3_1
X$1129 VPWR \$218 VGND \$229 \$224 \$217 VPWR VGND sky130_fd_sc_hd__maj3_1
X$1130 VPWR VGND VPWR VGND sky130_fd_sc_hd__decap_3
X$1131 VPWR VPWR VGND VGND sky130_fd_sc_hd__decap_8
X$1132 VPWR \$205 VPWR VGND \$192 \$197 VGND sky130_fd_sc_hd__nand2_1
X$1133 VPWR VPWR \$204 \$197 VGND \$192 VGND sky130_fd_sc_hd__xnor2_1
X$1135 VPWR VPWR \$176 \$204 VGND \$218 VGND sky130_fd_sc_hd__xnor2_1
X$1136 VPWR VPWR \$175 \$218 VGND \$204 \$205 VGND sky130_fd_sc_hd__o21ai_0
X$1137 VPWR VPWR VGND VGND sky130_fd_sc_hd__decap_8
X$1138 VPWR VPWR VGND VGND sky130_fd_sc_hd__decap_12
X$1142 VPWR \$198 VPWR \$199 \$176 VGND VGND sky130_fd_sc_hd__and2_0
X$1143 VPWR \$219 VPWR VGND \$183 \$184 \$198 VGND sky130_fd_sc_hd__nand3_1
X$1144 VGND \$183 \$209 \$198 \$184 VPWR VPWR VGND sky130_fd_sc_hd__a21bo_1
X$1145 VPWR VPWR \$230 \$198 VGND \$184 \$219 VGND sky130_fd_sc_hd__o21ai_0
X$1146 VPWR VPWR VGND VGND sky130_fd_sc_hd__decap_12
X$1147 VPWR VPWR \$185 \$184 VGND \$198 VGND sky130_fd_sc_hd__xnor2_1
X$1148 VPWR VGND \$170 VPWR \$176 \$210 \$193 VGND sky130_fd_sc_hd__a21oi_1
X$1149 VPWR VGND VPWR VGND sky130_fd_sc_hd__decap_4
X$1150 VPWR VPWR \$211 \$193 VGND \$186 \$209 VGND sky130_fd_sc_hd__o21ai_0
X$1151 VPWR \$276 VPWR VGND \$153 \$186 VGND sky130_fd_sc_hd__nand2_1
X$1154 VPWR VPWR VGND \$193 \$199 VGND sky130_fd_sc_hd__clkinv_1
X$1155 VPWR \$231 VGND \$211 \$188 \$195 VPWR VGND sky130_fd_sc_hd__maj3_1
X$1156 VPWR VPWR \$153 \$176 VGND \$199 VGND sky130_fd_sc_hd__xnor2_1
X$1158 VPWR VGND VPWR VGND sky130_fd_sc_hd__decap_3
X$1160 VPWR VPWR VGND VGND sky130_fd_sc_hd__decap_8
X$1161 VPWR \$190 VPWR VGND \$193 \$168 VGND sky130_fd_sc_hd__nand2_1
X$1162 VPWR VGND VPWR VGND sky130_fd_sc_hd__decap_3
X$1163 VPWR VPWR \$196 \$199 VGND \$154 VGND sky130_fd_sc_hd__xnor2_1
X$1165 VPWR VPWR VGND \$232 \$187 VGND sky130_fd_sc_hd__clkinv_1
X$1166 VPWR \$233 VGND \$153 VPWR \$154 VGND sky130_fd_sc_hd__nor2_1
X$1168 VPWR VPWR VGND VGND sky130_fd_sc_hd__decap_12
X$1169 VPWR VPWR \$212 \$177 VGND \$195 VGND sky130_fd_sc_hd__xnor2_1
X$1170 VPWR VPWR VGND VGND sky130_fd_sc_hd__decap_12
X$1171 VPWR VPWR VGND VGND sky130_fd_sc_hd__decap_12
X$1172 VPWR VPWR VGND VGND sky130_fd_sc_hd__decap_6
X$1173 VPWR VPWR VGND VGND sky130_fd_sc_hd__decap_6
X$1176 VPWR VGND \$188 \$164 VPWR \$189 VGND sky130_fd_sc_hd__xor2_1
X$1177 VPWR \$225 VPWR VGND \$127 \$195 VGND sky130_fd_sc_hd__nand2_1
X$1178 VPWR \$240 VPWR \$127 \$195 VGND VGND sky130_fd_sc_hd__and2_0
X$1179 VPWR VPWR \$213 \$164 VGND \$196 \$200 VGND sky130_fd_sc_hd__o21ai_0
X$1180 VPWR \$214 VPWR \$235 VGND \$213 \$225 VGND sky130_fd_sc_hd__o21a_1
X$1181 VPWR \$200 \$214 VGND \$196 VPWR \$164 VGND sky130_fd_sc_hd__nor3_1
X$1182 VPWR VPWR VGND VGND sky130_fd_sc_hd__decap_12
X$1183 VPWR \$234 VGND \$196 VPWR \$164 VGND sky130_fd_sc_hd__nor2_1
X$1184 VPWR VGND \$196 \$164 VPWR \$256 VGND sky130_fd_sc_hd__xor2_1
X$1185 VPWR VPWR VGND VGND sky130_fd_sc_hd__decap_8
X$1186 VPWR VPWR VGND VGND sky130_fd_sc_hd__decap_12
X$1187 VPWR VGND \$127 \$154 VPWR \$201 VGND sky130_fd_sc_hd__xor2_1
X$1188 VPWR VPWR VGND VGND sky130_fd_sc_hd__decap_12
X$1190 VPWR VGND \$154 \$226 VPWR \$220 VGND sky130_fd_sc_hd__xor2_1
X$1191 VPWR \$227 VPWR VGND \$226 \$154 VGND sky130_fd_sc_hd__nand2_1
X$1192 VPWR VPWR VGND VGND sky130_fd_sc_hd__decap_12
X$1193 VPWR VPWR VGND VGND sky130_fd_sc_hd__decap_6
X$1195 VPWR VGND \$221 \$227 VPWR \$222 VGND sky130_fd_sc_hd__xor2_1
X$1196 VPWR \$215 VPWR VGND \$202 \$201 VGND sky130_fd_sc_hd__nand2_1
X$1197 VPWR VPWR VGND VGND sky130_fd_sc_hd__decap_12
X$1198 VPWR VPWR \$281 \$227 VGND \$221 \$215 VGND sky130_fd_sc_hd__o21ai_0
X$1199 VPWR VPWR VGND VGND sky130_fd_sc_hd__decap_12
X$1200 VPWR VPWR VGND VGND sky130_fd_sc_hd__decap_6
X$1201 VPWR VPWR VGND VGND sky130_fd_sc_hd__decap_12
X$1203 VPWR VPWR VGND VGND sky130_fd_sc_hd__decap_8
X$1205 VPWR VPWR VGND VGND sky130_fd_sc_hd__decap_12
X$1206 VGND \$100 \$173 \$178 \$179 VPWR VPWR VGND sky130_fd_sc_hd__xnor3_1
X$1207 VPWR VGND VPWR VGND sky130_fd_sc_hd__decap_4
X$1208 VPWR FINE_MUX[7] VGND VPWR \$206 VGND sky130_fd_sc_hd__clkdlybuf4s50_1
X$1209 VGND \$178 \$180 \$181 \$206 VPWR VPWR VGND sky130_fd_sc_hd__xor3_1
X$1210 VPWR \$149 VGND \$236 \$228 \$243 VPWR VGND sky130_fd_sc_hd__maj3_1
X$1213 VPWR VGND VPWR VGND sky130_fd_sc_hd__decap_4
X$1220 VPWR VPWR VGND VGND sky130_fd_sc_hd__decap_12
X$1221 VPWR VPWR VGND VGND sky130_fd_sc_hd__decap_12
X$1222 VPWR VPWR VGND VGND sky130_fd_sc_hd__decap_12
X$1223 VPWR VPWR VGND VGND sky130_fd_sc_hd__decap_12
X$1224 VPWR VPWR VGND VGND sky130_fd_sc_hd__decap_12
X$1225 VPWR VPWR VGND VGND sky130_fd_sc_hd__decap_12
X$1226 VPWR VPWR VGND VGND sky130_fd_sc_hd__decap_6
X$1227 VPWR VPWR VGND VGND sky130_fd_sc_hd__decap_12
X$1229 VPWR VPWR VGND VGND sky130_fd_sc_hd__decap_12
X$1230 VPWR VPWR VGND VGND sky130_fd_sc_hd__decap_12
X$1231 VPWR VPWR VGND VGND sky130_fd_sc_hd__decap_12
X$1232 VPWR VPWR VGND VGND sky130_fd_sc_hd__decap_12
X$1233 VPWR VPWR VGND VGND sky130_fd_sc_hd__decap_12
X$1234 VPWR VPWR VGND VGND sky130_fd_sc_hd__decap_12
X$1235 VPWR VPWR VGND VGND sky130_fd_sc_hd__decap_12
X$1238 VPWR VPWR VGND VGND sky130_fd_sc_hd__decap_12
X$1239 VPWR VPWR VGND VGND sky130_fd_sc_hd__decap_12
X$1240 VPWR VPWR VGND VGND sky130_fd_sc_hd__decap_12
X$1241 VPWR VGND VPWR VGND sky130_fd_sc_hd__decap_4
X$1242 VPWR \$506 VGND \$497 VPWR \$502 VGND sky130_fd_sc_hd__nor2_1
X$1243 VGND \$504 \$485 \$503 \$507 VPWR VPWR VGND sky130_fd_sc_hd__xnor3_1
X$1244 VPWR VGND VPWR VGND sky130_fd_sc_hd__decap_4
X$1246 VPWR VPWR \$509 \$504 VGND \$506 VGND sky130_fd_sc_hd__xnor2_1
X$1247 VGND \$241 \$507 TICK \$509 VPWR VPWR VGND sky130_fd_sc_hd__dfrtp_1
X$1250 VPWR VPWR VGND \$508 \$507 VGND sky130_fd_sc_hd__clkinv_1
X$1251 VPWR VPWR VGND VGND sky130_fd_sc_hd__decap_12
X$1252 VPWR VPWR VGND VGND sky130_fd_sc_hd__decap_12
X$1253 VPWR VPWR VGND VGND sky130_fd_sc_hd__decap_12
X$1254 VPWR VPWR VGND VGND sky130_fd_sc_hd__decap_12
X$1255 VPWR VPWR VGND VGND sky130_fd_sc_hd__decap_12
X$1256 VPWR VGND VPWR VGND sky130_fd_sc_hd__decap_4
X$1257 VPWR VPWR VGND VGND sky130_fd_sc_hd__decap_12
X$1260 VPWR VPWR VGND VGND sky130_fd_sc_hd__decap_12
X$1261 VPWR VPWR VGND VGND sky130_fd_sc_hd__decap_12
X$1262 VPWR VPWR VGND VGND sky130_fd_sc_hd__decap_12
X$1263 VPWR VPWR VGND VGND sky130_fd_sc_hd__decap_12
X$1264 VPWR VPWR VGND VGND sky130_fd_sc_hd__decap_12
X$1265 VPWR VPWR VGND VGND sky130_fd_sc_hd__decap_8
X$1266 VPWR VPWR VGND VGND sky130_fd_sc_hd__decap_12
X$1269 VPWR VPWR VGND VGND sky130_fd_sc_hd__decap_12
X$1270 VPWR VPWR VGND VGND sky130_fd_sc_hd__decap_12
X$1271 VPWR VPWR VGND VGND sky130_fd_sc_hd__decap_12
X$1272 VPWR VPWR VGND VGND sky130_fd_sc_hd__decap_12
X$1273 VPWR VPWR VGND VGND sky130_fd_sc_hd__decap_12
X$1274 VPWR VPWR VGND VGND sky130_fd_sc_hd__decap_12
X$1275 VPWR VPWR VGND VGND sky130_fd_sc_hd__decap_12
X$1278 VPWR VGND VPWR VGND sky130_fd_sc_hd__decap_4
X$1284 VPWR VPWR VGND VGND sky130_fd_sc_hd__decap_12
X$1285 VPWR VPWR VGND VGND sky130_fd_sc_hd__decap_12
X$1286 VPWR VPWR VGND VGND sky130_fd_sc_hd__decap_12
X$1287 VPWR VPWR VGND VGND sky130_fd_sc_hd__decap_12
X$1288 VPWR VPWR VGND VGND sky130_fd_sc_hd__decap_12
X$1289 VPWR VPWR VGND VGND sky130_fd_sc_hd__decap_12
X$1290 VPWR VPWR VGND VGND sky130_fd_sc_hd__decap_6
X$1291 VPWR VPWR VGND VGND sky130_fd_sc_hd__decap_12
X$1293 VPWR VPWR VGND VGND sky130_fd_sc_hd__decap_12
X$1294 VPWR VPWR VGND VGND sky130_fd_sc_hd__decap_12
X$1295 VPWR VPWR VGND VGND sky130_fd_sc_hd__decap_12
X$1296 VPWR VPWR VGND VGND sky130_fd_sc_hd__decap_12
X$1297 VPWR VPWR VGND VGND sky130_fd_sc_hd__decap_12
X$1298 VPWR VPWR VGND VGND sky130_fd_sc_hd__decap_12
X$1299 VPWR VPWR VGND VGND sky130_fd_sc_hd__decap_12
X$1302 VPWR VPWR VGND VGND sky130_fd_sc_hd__decap_12
X$1303 VPWR VPWR VGND VGND sky130_fd_sc_hd__decap_12
X$1304 VPWR VPWR VGND VGND sky130_fd_sc_hd__decap_12
X$1305 VPWR VPWR VGND VGND sky130_fd_sc_hd__decap_12
X$1306 VPWR VPWR VGND VGND sky130_fd_sc_hd__decap_12
X$1307 VPWR VPWR VGND VGND sky130_fd_sc_hd__decap_8
X$1308 VGND \$241 \$517 TICK \$535 VPWR VPWR VGND sky130_fd_sc_hd__dfrtp_1
X$1310 VPWR \$523 VGND \$511 VPWR \$500 VGND sky130_fd_sc_hd__nor2_1
X$1313 VPWR VPWR \$511 \$510 VGND \$517 VGND sky130_fd_sc_hd__xnor2_1
X$1314 VPWR VGND \$518 \$517 VPWR \$510 VGND sky130_fd_sc_hd__lpflow_isobufsrc_1
X$1315 VGND \$241 \$524 TICK \$536 VPWR VPWR VGND sky130_fd_sc_hd__dfrtp_1
X$1317 VPWR VPWR \$514 \$518 VGND \$512 \$524 VGND sky130_fd_sc_hd__o21ai_0
X$1318 VGND \$241 \$515 TICK \$513 VPWR VPWR VGND sky130_fd_sc_hd__dfrtp_1
X$1319 VPWR VGND VPWR VGND sky130_fd_sc_hd__decap_4
X$1320 VPWR \$537 \$516 \$521 VPWR VGND \$518 VGND sky130_fd_sc_hd__and3_1
X$1321 VPWR VGND VPWR VGND sky130_fd_sc_hd__decap_3
X$1323 VPWR VPWR \$526 \$525 VGND \$519 VGND sky130_fd_sc_hd__xnor2_1
X$1324 VGND \$241 \$537 TICK \$526 VPWR VPWR VGND sky130_fd_sc_hd__dfrtp_1
X$1325 VPWR VGND \$525 \$520 VPWR \$521 VGND sky130_fd_sc_hd__nor2b_1
X$1326 VPWR VPWR VGND VGND sky130_fd_sc_hd__decap_12
X$1327 VPWR VGND VPWR VGND sky130_fd_sc_hd__decap_4
X$1328 VPWR VPWR \$528 \$530 VGND \$531 VGND sky130_fd_sc_hd__xnor2_1
X$1329 VPWR VPWR VGND VGND sky130_fd_sc_hd__decap_12
X$1330 VPWR VPWR VGND VGND sky130_fd_sc_hd__decap_12
X$1331 VPWR VPWR VGND VGND sky130_fd_sc_hd__decap_6
X$1333 VPWR VPWR VGND VGND sky130_fd_sc_hd__decap_12
X$1334 VPWR VPWR VGND VGND sky130_fd_sc_hd__decap_8
X$1336 VPWR VPWR \$532 \$529 VGND \$531 VGND sky130_fd_sc_hd__nand2_2
X$1337 VPWR VGND VPWR VGND sky130_fd_sc_hd__decap_4
X$1338 VPWR VPWR \$529 \$532 VGND REF VGND sky130_fd_sc_hd__nand2_2
X$1339 VPWR VGND \$527 VPWR REF VGND sky130_fd_sc_hd__buf_2
X$1340 VPWR VGND \$539 VPWR \$534 VGND sky130_fd_sc_hd__buf_2
X$1341 VPWR VPWR VGND VGND sky130_fd_sc_hd__decap_12
X$1342 VPWR VGND \$543 VPWR \$532 VGND sky130_fd_sc_hd__buf_2
X$1343 VPWR VPWR VGND VGND sky130_fd_sc_hd__decap_12
X$1344 VPWR VPWR VGND VGND sky130_fd_sc_hd__decap_12
X$1345 VPWR VGND VPWR VGND sky130_fd_sc_hd__decap_3
X$1347 VPWR VGND VPWR VGND sky130_fd_sc_hd__decap_4
X$1348 VPWR VGND VPWR VGND sky130_fd_sc_hd__decap_4
X$1354 VPWR MID_MUX[12] VGND VPWR \$162 VGND sky130_fd_sc_hd__clkdlybuf4s50_1
X$1355 VPWR VPWR VGND VGND sky130_fd_sc_hd__decap_6
X$1356 VPWR \$141 VGND \$136 \$162 \$152 VPWR VGND sky130_fd_sc_hd__maj3_1
X$1357 VPWR MID_MUX[13] VGND VPWR \$136 VGND sky130_fd_sc_hd__clkdlybuf4s50_1
X$1358 VPWR VPWR \$139 \$162 VGND \$152 VGND sky130_fd_sc_hd__xnor2_1
X$1359 VPWR VPWR VGND VGND sky130_fd_sc_hd__decap_12
X$1360 VPWR VPWR VGND VGND sky130_fd_sc_hd__decap_12
X$1361 VPWR VPWR VGND VGND sky130_fd_sc_hd__decap_8
X$1362 VPWR VPWR VGND VGND sky130_fd_sc_hd__decap_8
X$1363 VPWR VGND VPWR VGND sky130_fd_sc_hd__decap_3
X$1364 VPWR \$106 \$170 VGND \$142 VPWR \$175 VGND sky130_fd_sc_hd__nor3_1
X$1367 VPWR VGND VPWR VGND sky130_fd_sc_hd__decap_3
X$1368 VPWR \$183 VGND \$106 \$142 \$175 VPWR VGND sky130_fd_sc_hd__maj3_1
X$1369 VPWR VGND \$106 \$142 VPWR \$167 VGND sky130_fd_sc_hd__xor2_1
X$1370 VPWR VPWR \$184 \$167 VGND \$175 VGND sky130_fd_sc_hd__xnor2_1
X$1371 VPWR VPWR VGND VGND sky130_fd_sc_hd__decap_12
X$1372 VPWR VPWR VGND VGND sky130_fd_sc_hd__decap_8
X$1373 VPWR VPWR VGND VGND sky130_fd_sc_hd__decap_12
X$1374 VPWR \$186 VPWR VGND \$176 \$170 VGND sky130_fd_sc_hd__nand2_1
X$1375 VPWR VPWR VGND VGND sky130_fd_sc_hd__decap_12
X$1376 VPWR VPWR VGND VGND sky130_fd_sc_hd__decap_12
X$1377 VPWR VGND VPWR VGND sky130_fd_sc_hd__decap_4
X$1379 VPWR \$176 VPWR \$171 VGND \$168 \$154 VGND sky130_fd_sc_hd__o21a_1
X$1380 VPWR \$168 VPWR VGND \$154 \$153 VGND sky130_fd_sc_hd__nand2_1
X$1381 VPWR \$187 VGND \$185 \$195 \$127 VPWR VGND sky130_fd_sc_hd__maj3_1
X$1382 VPWR VPWR VGND VGND sky130_fd_sc_hd__decap_12
X$1383 VPWR VGND \$185 \$127 VPWR \$177 VGND sky130_fd_sc_hd__xor2_1
X$1384 VPWR VPWR VGND VGND sky130_fd_sc_hd__decap_8
X$1385 VPWR VGND VPWR VGND sky130_fd_sc_hd__decap_3
X$1386 VPWR \$155 \$266 \$163 VPWR VGND \$188 VGND sky130_fd_sc_hd__mux2i_1
X$1387 VPWR VGND \$157 VPWR \$156 \$163 \$155 VGND sky130_fd_sc_hd__a21oi_1
X$1388 VPWR VPWR \$188 \$157 VGND \$156 VGND sky130_fd_sc_hd__xnor2_1
X$1390 VGND \$191 \$189 \$190 \$171 VPWR VPWR VGND sky130_fd_sc_hd__mux2_1
X$1391 VPWR VGND VPWR VGND sky130_fd_sc_hd__decap_4
X$1394 VGND \$200 \$188 \$171 \$164 VPWR VPWR VGND sky130_fd_sc_hd__xor3_1
X$1395 VPWR VPWR VGND VGND sky130_fd_sc_hd__decap_6
X$1397 VPWR VGND \$195 \$127 VPWR \$164 VGND sky130_fd_sc_hd__xor2_1
X$1398 VPWR VPWR VGND VGND sky130_fd_sc_hd__decap_12
X$1399 VPWR VPWR VGND VGND sky130_fd_sc_hd__decap_12
X$1401 VPWR VPWR \$157 \$165 VGND \$131 VGND sky130_fd_sc_hd__xnor2_1
X$1402 VPWR VPWR VGND VGND sky130_fd_sc_hd__decap_12
X$1403 VPWR \$155 VGND \$158 \$131 \$159 VPWR VGND sky130_fd_sc_hd__maj3_1
X$1404 VPWR VPWR \$165 \$158 VGND \$159 VGND sky130_fd_sc_hd__xnor2_1
X$1406 VPWR VPWR VGND VGND sky130_fd_sc_hd__decap_12
X$1407 VPWR VPWR VGND VGND sky130_fd_sc_hd__decap_12
X$1408 VPWR VPWR VGND VGND sky130_fd_sc_hd__decap_12
X$1409 VPWR VGND VPWR VGND sky130_fd_sc_hd__decap_4
X$1411 VGND \$111 \$149 \$146 \$160 VPWR VPWR VGND sky130_fd_sc_hd__xor3_1
X$1412 VPWR VPWR VGND VGND sky130_fd_sc_hd__decap_8
X$1413 VPWR \$159 VPWR \$144 \$150 \$172 \$160 VGND VGND
+ sky130_fd_sc_hd__o22ai_1
X$1414 VPWR VPWR \$172 \$149 VGND \$146 VGND sky130_fd_sc_hd__xnor2_1
X$1416 VPWR VPWR VGND VGND sky130_fd_sc_hd__decap_12
X$1417 VPWR VPWR VGND VGND sky130_fd_sc_hd__decap_12
X$1419 VPWR \$146 VGND \$173 \$178 \$179 VPWR VGND sky130_fd_sc_hd__maj3_1
X$1420 VPWR VPWR VGND VGND sky130_fd_sc_hd__decap_12
X$1421 VPWR VPWR VGND VGND sky130_fd_sc_hd__decap_8
X$1422 VPWR VPWR VGND VGND sky130_fd_sc_hd__decap_8
X$1423 VPWR \$166 VGND \$180 \$181 \$206 VPWR VGND sky130_fd_sc_hd__maj3_1
X$1425 VPWR FINE_MUX[9] VGND VPWR \$180 VGND sky130_fd_sc_hd__clkdlybuf4s50_1
X$1428 VPWR VGND VPWR VGND sky130_fd_sc_hd__decap_4
X$1434 VPWR VPWR VGND VGND sky130_fd_sc_hd__decap_12
X$1435 VPWR VPWR VGND VGND sky130_fd_sc_hd__decap_12
X$1436 VPWR VPWR VGND VGND sky130_fd_sc_hd__decap_12
X$1437 VPWR VPWR VGND VGND sky130_fd_sc_hd__decap_12
X$1438 VPWR VPWR VGND VGND sky130_fd_sc_hd__decap_12
X$1439 VPWR VPWR VGND VGND sky130_fd_sc_hd__decap_12
X$1440 VPWR VPWR VGND VGND sky130_fd_sc_hd__decap_6
X$1441 VPWR VPWR VGND VGND sky130_fd_sc_hd__decap_12
X$1443 VPWR VPWR VGND VGND sky130_fd_sc_hd__decap_12
X$1444 VPWR VPWR VGND VGND sky130_fd_sc_hd__decap_12
X$1445 VPWR VPWR VGND VGND sky130_fd_sc_hd__decap_12
X$1446 VPWR VPWR VGND VGND sky130_fd_sc_hd__decap_12
X$1447 VPWR VPWR VGND VGND sky130_fd_sc_hd__decap_12
X$1448 VPWR VPWR VGND VGND sky130_fd_sc_hd__decap_12
X$1449 VPWR VPWR VGND VGND sky130_fd_sc_hd__decap_12
X$1452 VPWR VGND VPWR VGND sky130_fd_sc_hd__decap_4
X$1453 VPWR VPWR \$127 \$117 VGND \$121 VGND sky130_fd_sc_hd__xnor2_1
X$1454 VPWR VGND VPWR VGND sky130_fd_sc_hd__decap_4
X$1456 VPWR VGND \$112 \$65 VPWR \$117 VGND sky130_fd_sc_hd__xor2_1
X$1457 VPWR \$128 VGND \$112 \$65 \$121 VPWR VGND sky130_fd_sc_hd__maj3_1
X$1458 VGND \$112 \$104 \$87 \$67 VPWR VPWR VGND sky130_fd_sc_hd__xnor3_1
X$1459 VPWR VPWR VGND VGND sky130_fd_sc_hd__decap_6
X$1461 VPWR VGND \$129 \$108 VPWR \$122 VGND sky130_fd_sc_hd__lpflow_isobufsrc_1
X$1462 VPWR VPWR \$130 \$122 VGND \$108 VGND sky130_fd_sc_hd__xnor2_1
X$1463 VPWR VPWR VGND \$103 \$87 VGND sky130_fd_sc_hd__clkinv_1
X$1464 VPWR VPWR VGND VGND sky130_fd_sc_hd__decap_12
X$1465 VPWR VGND VPWR VGND sky130_fd_sc_hd__decap_4
X$1467 VPWR VGND VPWR VGND sky130_fd_sc_hd__decap_3
X$1468 VGND \$104 \$115 \$114 \$105 VPWR VPWR VGND sky130_fd_sc_hd__xor3_1
X$1469 VPWR VPWR VGND VGND sky130_fd_sc_hd__decap_12
X$1470 VPWR VPWR VGND VGND sky130_fd_sc_hd__decap_8
X$1471 VPWR \$119 VGND \$115 \$114 \$105 VPWR VGND sky130_fd_sc_hd__maj3_1
X$1472 VPWR VPWR \$131 \$109 VGND \$123 \$124 VGND sky130_fd_sc_hd__o21ai_0
X$1473 VPWR VPWR VGND VGND sky130_fd_sc_hd__decap_12
X$1474 VPWR VGND VPWR VGND sky130_fd_sc_hd__decap_4
X$1475 VPWR VPWR \$132 \$125 VGND \$126 VGND sky130_fd_sc_hd__xnor2_1
X$1477 VPWR VPWR VGND VGND sky130_fd_sc_hd__decap_12
X$1478 VPWR VGND VPWR VGND sky130_fd_sc_hd__decap_3
X$1479 VGND \$115 \$111 \$110 \$116 VPWR VPWR VGND sky130_fd_sc_hd__xnor3_1
X$1481 VPWR \$120 VGND \$111 \$110 \$116 VPWR VGND sky130_fd_sc_hd__maj3_1
X$1482 VPWR VPWR VGND VGND sky130_fd_sc_hd__decap_12
X$1483 VPWR VPWR VGND VGND sky130_fd_sc_hd__decap_12
X$1484 VPWR VPWR VGND VGND sky130_fd_sc_hd__decap_8
X$1485 VPWR VPWR VGND VGND sky130_fd_sc_hd__decap_12
X$1488 VPWR VPWR VGND VGND sky130_fd_sc_hd__decap_12
X$1489 VPWR VPWR VGND VGND sky130_fd_sc_hd__decap_12
X$1490 VPWR VPWR VGND VGND sky130_fd_sc_hd__decap_12
X$1491 VPWR VPWR VGND VGND sky130_fd_sc_hd__decap_12
X$1492 VPWR VPWR VGND VGND sky130_fd_sc_hd__decap_12
X$1493 VPWR VPWR VGND VGND sky130_fd_sc_hd__decap_12
X$1494 VPWR VPWR VGND VGND sky130_fd_sc_hd__decap_12
X$1495 VPWR VGND VPWR VGND sky130_fd_sc_hd__decap_4
X$1497 VPWR VGND VPWR VGND sky130_fd_sc_hd__decap_4
X$1503 VPWR VPWR VGND VGND sky130_fd_sc_hd__decap_12
X$1504 VPWR VPWR VGND VGND sky130_fd_sc_hd__decap_12
X$1505 VPWR VPWR VGND VGND sky130_fd_sc_hd__decap_12
X$1506 VPWR VPWR VGND VGND sky130_fd_sc_hd__decap_12
X$1507 VPWR VPWR VGND VGND sky130_fd_sc_hd__decap_12
X$1508 VPWR VPWR VGND VGND sky130_fd_sc_hd__decap_12
X$1509 VPWR VPWR VGND VGND sky130_fd_sc_hd__decap_6
X$1510 VPWR VPWR VGND VGND sky130_fd_sc_hd__decap_12
X$1512 VPWR VPWR VGND VGND sky130_fd_sc_hd__decap_12
X$1513 VPWR VPWR VGND VGND sky130_fd_sc_hd__decap_12
X$1514 VPWR VPWR VGND VGND sky130_fd_sc_hd__decap_12
X$1515 VPWR VPWR VGND VGND sky130_fd_sc_hd__decap_12
X$1516 VPWR VPWR VGND VGND sky130_fd_sc_hd__decap_12
X$1517 VPWR VPWR VGND VGND sky130_fd_sc_hd__decap_12
X$1518 VPWR VPWR VGND VGND sky130_fd_sc_hd__decap_12
X$1521 VPWR VPWR VGND VGND sky130_fd_sc_hd__decap_12
X$1522 VPWR VPWR VGND VGND sky130_fd_sc_hd__decap_12
X$1523 VPWR VPWR VGND VGND sky130_fd_sc_hd__decap_12
X$1524 VPWR VPWR VGND VGND sky130_fd_sc_hd__decap_12
X$1525 VPWR VPWR VGND VGND sky130_fd_sc_hd__decap_12
X$1526 VPWR VGND VPWR VGND sky130_fd_sc_hd__decap_4
X$1528 VPWR \$510 VGND \$485 \$503 \$508 VPWR VGND sky130_fd_sc_hd__maj3_1
X$1529 VPWR VPWR VGND VGND sky130_fd_sc_hd__decap_6
X$1532 VPWR VPWR VGND VGND sky130_fd_sc_hd__decap_12
X$1533 VPWR \$512 VPWR \$500 \$511 VGND VGND sky130_fd_sc_hd__and2_0
X$1534 VPWR VPWR VGND VGND sky130_fd_sc_hd__decap_12
X$1535 VPWR VPWR VGND VGND sky130_fd_sc_hd__decap_12
X$1536 VPWR VPWR VGND VGND sky130_fd_sc_hd__decap_6
X$1538 VPWR VPWR VGND VGND sky130_fd_sc_hd__decap_12
X$1539 VPWR VPWR \$513 \$514 VGND \$515 VGND sky130_fd_sc_hd__xnor2_1
X$1541 VPWR \$516 VPWR \$524 \$515 VGND VGND sky130_fd_sc_hd__and2_0
X$1542 VPWR VPWR VGND VGND sky130_fd_sc_hd__decap_12
X$1543 VPWR VGND VPWR VGND sky130_fd_sc_hd__decap_4
X$1545 VPWR VPWR VGND VGND sky130_fd_sc_hd__decap_12
X$1546 VPWR VPWR VGND VGND sky130_fd_sc_hd__decap_12
X$1547 VPWR VPWR VGND VGND sky130_fd_sc_hd__decap_12
X$1548 VPWR VPWR VGND VGND sky130_fd_sc_hd__decap_12
X$1549 VPWR VPWR VGND VGND sky130_fd_sc_hd__decap_12
X$1550 VPWR VPWR VGND VGND sky130_fd_sc_hd__decap_12
X$1551 VPWR VPWR VGND VGND sky130_fd_sc_hd__decap_12
X$1554 VPWR VPWR VGND VGND sky130_fd_sc_hd__decap_12
X$1555 VPWR VPWR VGND VGND sky130_fd_sc_hd__decap_12
X$1556 VPWR VPWR VGND VGND sky130_fd_sc_hd__decap_12
X$1557 VPWR VPWR VGND VGND sky130_fd_sc_hd__decap_12
X$1558 VPWR VPWR VGND VGND sky130_fd_sc_hd__decap_12
X$1559 VPWR VPWR VGND VGND sky130_fd_sc_hd__decap_12
X$1560 VPWR VPWR VGND VGND sky130_fd_sc_hd__decap_12
X$1563 VPWR VGND VPWR VGND sky130_fd_sc_hd__decap_4
X$1567 VPWR VPWR VGND VGND sky130_fd_sc_hd__decap_12
X$1569 VPWR VPWR VGND VGND sky130_fd_sc_hd__decap_12
X$1570 VPWR VPWR VGND VGND sky130_fd_sc_hd__decap_12
X$1571 VPWR VPWR VGND VGND sky130_fd_sc_hd__decap_6
X$1573 VGND \$137 \$71 \$72 \$62 VPWR VPWR VGND sky130_fd_sc_hd__xnor3_1
X$1575 VPWR \$81 VGND \$49 \$53 \$54 VPWR VGND sky130_fd_sc_hd__maj3_1
X$1576 VPWR MID_MUX[0] VGND VPWR \$53 VGND sky130_fd_sc_hd__clkdlybuf4s50_1
X$1577 VPWR VGND VPWR VGND sky130_fd_sc_hd__decap_4
X$1580 VGND \$78 \$69 \$59 \$60 VPWR VPWR VGND sky130_fd_sc_hd__xor3_1
X$1581 VPWR VPWR VGND VGND sky130_fd_sc_hd__decap_6
X$1583 VGND \$85 \$70 \$89 \$80 VPWR VPWR VGND sky130_fd_sc_hd__xnor3_1
X$1584 VPWR VGND VPWR VGND sky130_fd_sc_hd__decap_4
X$1586 VPWR VPWR VGND VGND sky130_fd_sc_hd__decap_12
X$1587 VPWR VPWR VGND VGND sky130_fd_sc_hd__decap_12
X$1588 VPWR VPWR VGND VGND sky130_fd_sc_hd__decap_12
X$1589 VPWR VGND VPWR VGND sky130_fd_sc_hd__decap_4
X$1592 VPWR VPWR VGND VGND sky130_fd_sc_hd__decap_12
X$1593 VPWR VPWR VGND VGND sky130_fd_sc_hd__decap_12
X$1594 VPWR VPWR VGND VGND sky130_fd_sc_hd__decap_12
X$1595 VPWR VPWR VGND VGND sky130_fd_sc_hd__decap_12
X$1596 VPWR VGND VPWR VGND sky130_fd_sc_hd__decap_4
X$1597 VPWR \$90 VGND \$71 \$72 \$62 VPWR VGND sky130_fd_sc_hd__maj3_1
X$1599 VPWR MID_MUX[1] VGND VPWR \$54 VGND sky130_fd_sc_hd__clkdlybuf4s50_1
X$1602 VPWR FINE_MUX[6] VGND VPWR \$56 VGND sky130_fd_sc_hd__clkdlybuf4s50_1
X$1604 VPWR VGND VPWR VGND sky130_fd_sc_hd__decap_3
X$1605 VPWR VGND VPWR VGND sky130_fd_sc_hd__decap_3
X$1607 VPWR VGND VPWR VGND sky130_fd_sc_hd__decap_3
X$1610 VPWR FINE_MUX[21] VGND VPWR \$61 VGND sky130_fd_sc_hd__clkdlybuf4s50_1
X$1612 VPWR \$97 VGND \$70 \$89 \$80 VPWR VGND sky130_fd_sc_hd__maj3_1
X$1613 VPWR VPWR VGND VGND sky130_fd_sc_hd__decap_12
X$1614 VPWR VPWR VGND VGND sky130_fd_sc_hd__decap_12
X$1615 VPWR VPWR VGND VGND sky130_fd_sc_hd__decap_12
X$1616 VPWR VPWR VGND VGND sky130_fd_sc_hd__decap_8
X$1617 VPWR VGND VPWR VGND sky130_fd_sc_hd__decap_3
X$1619 VPWR VGND VPWR VGND sky130_fd_sc_hd__decap_4
X$1622 VPWR VPWR VGND VGND sky130_fd_sc_hd__decap_12
X$1624 VPWR VPWR VGND VGND sky130_fd_sc_hd__decap_12
X$1625 VPWR VPWR VGND VGND sky130_fd_sc_hd__decap_12
X$1626 VPWR VPWR VGND VGND sky130_fd_sc_hd__decap_6
X$1628 VPWR VGND VPWR VGND sky130_fd_sc_hd__decap_4
X$1630 VGND \$138 \$52 \$81 \$90 VPWR VPWR VGND sky130_fd_sc_hd__xnor3_1
X$1631 VPWR VPWR VGND \$102 \$81 VGND sky130_fd_sc_hd__clkinv_1
X$1632 VPWR VPWR VGND VGND sky130_fd_sc_hd__decap_8
X$1635 VPWR VPWR \$154 \$86 VGND \$64 VGND sky130_fd_sc_hd__xnor2_1
X$1636 VPWR VPWR VGND VGND sky130_fd_sc_hd__decap_8
X$1638 VPWR VPWR VGND \$83 \$68 VGND sky130_fd_sc_hd__clkinv_1
X$1639 VPWR VPWR VGND VGND sky130_fd_sc_hd__decap_12
X$1642 VPWR VPWR VGND VGND sky130_fd_sc_hd__decap_6
X$1643 VPWR VPWR VGND VGND sky130_fd_sc_hd__decap_8
X$1644 VPWR VGND VPWR VGND sky130_fd_sc_hd__decap_3
X$1645 VPWR VGND VPWR VGND sky130_fd_sc_hd__decap_4
X$1647 VGND \$88 \$100 \$85 \$95 VPWR VPWR VGND sky130_fd_sc_hd__xnor3_1
X$1648 VPWR VPWR VGND VGND sky130_fd_sc_hd__decap_8
X$1649 VPWR VGND VPWR VGND sky130_fd_sc_hd__decap_3
X$1651 VPWR VPWR VGND VGND sky130_fd_sc_hd__decap_12
X$1652 VPWR VPWR VGND VGND sky130_fd_sc_hd__decap_12
X$1653 VPWR VPWR VGND VGND sky130_fd_sc_hd__decap_12
X$1654 VPWR VPWR VGND VGND sky130_fd_sc_hd__decap_12
X$1657 VPWR VPWR VGND VGND sky130_fd_sc_hd__decap_12
X$1658 VPWR VPWR VGND VGND sky130_fd_sc_hd__decap_12
X$1659 VPWR VPWR VGND VGND sky130_fd_sc_hd__decap_12
X$1660 VPWR VPWR VGND VGND sky130_fd_sc_hd__decap_12
X$1661 VPWR VPWR VGND VGND sky130_fd_sc_hd__decap_6
X$1662 VPWR VGND \$52 VPWR \$107 \$101 \$106 VGND sky130_fd_sc_hd__a21o_1
X$1663 VPWR \$101 VGND \$102 VPWR \$90 VGND sky130_fd_sc_hd__nor2_1
X$1664 VPWR \$107 VPWR VGND \$90 \$102 VGND sky130_fd_sc_hd__nand2_1
X$1665 VPWR VPWR VGND VGND sky130_fd_sc_hd__decap_12
X$1666 VPWR VPWR VGND VGND sky130_fd_sc_hd__decap_6
X$1669 VPWR VPWR VGND VGND sky130_fd_sc_hd__decap_12
X$1670 VPWR VPWR VGND VGND sky130_fd_sc_hd__decap_12
X$1671 VPWR VGND VPWR VGND sky130_fd_sc_hd__decap_3
X$1672 VPWR \$108 VGND \$104 \$103 \$67 VPWR VGND sky130_fd_sc_hd__maj3_1
X$1673 VPWR VPWR VGND VGND sky130_fd_sc_hd__decap_12
X$1674 VPWR VPWR VGND VGND sky130_fd_sc_hd__decap_12
X$1676 VPWR VPWR VGND VGND sky130_fd_sc_hd__decap_12
X$1679 VPWR VPWR VGND VGND sky130_fd_sc_hd__decap_6
X$1681 VPWR \$110 VGND \$100 \$85 \$95 VPWR VGND sky130_fd_sc_hd__maj3_1
X$1682 VPWR VPWR VGND VGND sky130_fd_sc_hd__decap_12
X$1683 VPWR VPWR VGND VGND sky130_fd_sc_hd__decap_12
X$1684 VPWR VPWR VGND VGND sky130_fd_sc_hd__decap_12
X$1685 VPWR VPWR VGND VGND sky130_fd_sc_hd__decap_12
X$1686 VPWR VPWR VGND VGND sky130_fd_sc_hd__decap_12
X$1687 VPWR VPWR VGND VGND sky130_fd_sc_hd__decap_8
X$1690 VPWR VGND VPWR VGND sky130_fd_sc_hd__decap_4
.ENDS PLL_COUNTER_DCO_PHYS

.SUBCKT sky130_fd_sc_hd__and3b_1 VPB X VPWR VGND C B A_N sky130_gnd
M$1 \$3 C VPWR VPB sky130_fd_pr__pfet_01v8_hvt L=0.15 W=0.42 AS=0.074375
+ AD=0.142225 PS=0.815 PD=1.335
M$2 \$3 \$8 VPWR VPB sky130_fd_pr__pfet_01v8_hvt L=0.15 W=0.42 AS=0.1085
+ AD=0.0567 PS=1.36 PD=0.69
M$3 \$3 B VPWR VPB sky130_fd_pr__pfet_01v8_hvt L=0.15 W=0.42 AS=0.074375
+ AD=0.0567 PS=0.815 PD=0.69
M$4 VPWR \$3 X VPB sky130_fd_pr__pfet_01v8_hvt L=0.15 W=1 AS=0.142225 AD=0.26
+ PS=1.335 PD=2.52
M$5 VPWR A_N \$8 VPB sky130_fd_pr__pfet_01v8_hvt L=0.15 W=0.42 AS=0.1092
+ AD=0.1087 PS=1.36 PD=1.36
M$6 \$3 \$8 \$12 sky130_gnd sky130_fd_pr__nfet_01v8 L=0.15 W=0.42 AS=0.107825
+ AD=0.0441 PS=1.36 PD=0.63
M$7 \$12 B \$11 sky130_gnd sky130_fd_pr__nfet_01v8 L=0.15 W=0.42 AS=0.0441
+ AD=0.05355 PS=0.63 PD=0.675
M$8 VGND C \$11 sky130_gnd sky130_fd_pr__nfet_01v8 L=0.15 W=0.42 AS=0.122275
+ AD=0.05355 PS=1.08 PD=0.675
M$9 VGND \$3 X sky130_gnd sky130_fd_pr__nfet_01v8 L=0.15 W=0.65 AS=0.122275
+ AD=0.169 PS=1.08 PD=1.82
M$10 VGND A_N \$8 sky130_gnd sky130_fd_pr__nfet_01v8 L=0.15 W=0.42 AS=0.1092
+ AD=0.10785 PS=1.36 PD=1.36
.ENDS sky130_fd_sc_hd__and3b_1

.SUBCKT sky130_fd_sc_hd__a21boi_0 VPB A2 VGND B1_N VPWR Y A1 sky130_gnd
M$1 Y \$5 \$3 VPB sky130_fd_pr__pfet_01v8_hvt L=0.15 W=0.64 AS=0.1696 AD=0.0896
+ PS=1.81 PD=0.92
M$2 \$3 A1 VPWR VPB sky130_fd_pr__pfet_01v8_hvt L=0.15 W=0.64 AS=0.0896
+ AD=0.0896 PS=0.92 PD=0.92
M$3 VPWR A2 \$3 VPB sky130_fd_pr__pfet_01v8_hvt L=0.15 W=0.64 AS=0.0896
+ AD=0.1696 PS=0.92 PD=1.81
M$4 \$5 B1_N VPWR VPB sky130_fd_pr__pfet_01v8_hvt L=0.15 W=0.42 AS=0.1113
+ AD=0.1113 PS=1.37 PD=1.37
M$5 \$5 B1_N VGND sky130_gnd sky130_fd_pr__nfet_01v8 L=0.15 W=0.42 AS=0.1113
+ AD=0.1302 PS=1.37 PD=1.04
M$6 VGND \$5 Y sky130_gnd sky130_fd_pr__nfet_01v8 L=0.15 W=0.42 AS=0.1302
+ AD=0.1113 PS=1.04 PD=0.95
M$7 Y A1 \$11 sky130_gnd sky130_fd_pr__nfet_01v8 L=0.15 W=0.42 AS=0.1113
+ AD=0.0441 PS=0.95 PD=0.63
M$8 \$11 A2 VGND sky130_gnd sky130_fd_pr__nfet_01v8 L=0.15 W=0.42 AS=0.0441
+ AD=0.1113 PS=0.63 PD=1.37
.ENDS sky130_fd_sc_hd__a21boi_0

.SUBCKT sky130_fd_sc_hd__o22ai_1 VPB B1 VPWR Y B2 A2 A1 VGND sky130_gnd
M$1 VPWR B1 \$12 VPB sky130_fd_pr__pfet_01v8_hvt L=0.15 W=1 AS=0.26 AD=0.1125
+ PS=2.52 PD=1.225
M$2 \$12 B2 Y VPB sky130_fd_pr__pfet_01v8_hvt L=0.15 W=1 AS=0.1125 AD=0.2325
+ PS=1.225 PD=1.465
M$3 Y A2 \$11 VPB sky130_fd_pr__pfet_01v8_hvt L=0.15 W=1 AS=0.2325 AD=0.105
+ PS=1.465 PD=1.21
M$4 \$11 A1 VPWR VPB sky130_fd_pr__pfet_01v8_hvt L=0.15 W=1 AS=0.105 AD=0.27
+ PS=1.21 PD=2.54
M$5 \$4 B1 Y sky130_gnd sky130_fd_pr__nfet_01v8 L=0.15 W=0.65 AS=0.169
+ AD=0.092625 PS=1.82 PD=0.935
M$6 Y B2 \$4 sky130_gnd sky130_fd_pr__nfet_01v8 L=0.15 W=0.65 AS=0.092625
+ AD=0.115375 PS=0.935 PD=1.005
M$7 \$4 A2 VGND sky130_gnd sky130_fd_pr__nfet_01v8 L=0.15 W=0.65 AS=0.115375
+ AD=0.08775 PS=1.005 PD=0.92
M$8 VGND A1 \$4 sky130_gnd sky130_fd_pr__nfet_01v8 L=0.15 W=0.65 AS=0.08775
+ AD=0.169 PS=0.92 PD=1.82
.ENDS sky130_fd_sc_hd__o22ai_1

.SUBCKT sky130_fd_sc_hd__a21bo_1 VGND B1_N X A1 A2 VPWR VPB sky130_gnd
M$1 \$5 \$4 \$11 VPB sky130_fd_pr__pfet_01v8_hvt L=0.15 W=1 AS=0.265 AD=0.135
+ PS=2.53 PD=1.27
M$2 \$11 A1 VPWR VPB sky130_fd_pr__pfet_01v8_hvt L=0.15 W=1 AS=0.135 AD=0.14
+ PS=1.27 PD=1.28
M$3 VPWR A2 \$11 VPB sky130_fd_pr__pfet_01v8_hvt L=0.15 W=1 AS=0.14 AD=0.265
+ PS=1.28 PD=2.53
M$4 VPWR \$5 X VPB sky130_fd_pr__pfet_01v8_hvt L=0.15 W=1 AS=0.26 AD=0.26
+ PS=2.52 PD=2.52
M$5 \$4 B1_N VPWR VPB sky130_fd_pr__pfet_01v8_hvt L=0.15 W=0.42 AS=0.1092
+ AD=0.1092 PS=1.36 PD=1.36
M$6 \$4 B1_N VGND sky130_gnd sky130_fd_pr__nfet_01v8 L=0.15 W=0.42 AS=0.1113
+ AD=0.1359 PS=1.37 PD=1.1
M$7 VGND \$4 \$5 sky130_gnd sky130_fd_pr__nfet_01v8 L=0.15 W=0.65 AS=0.1359
+ AD=0.08775 PS=1.1 PD=0.92
M$8 \$5 A1 \$9 sky130_gnd sky130_fd_pr__nfet_01v8 L=0.15 W=0.65 AS=0.08775
+ AD=0.091 PS=0.92 PD=0.93
M$9 \$9 A2 VGND sky130_gnd sky130_fd_pr__nfet_01v8 L=0.15 W=0.65 AS=0.091
+ AD=0.258375 PS=0.93 PD=1.445
M$10 VGND \$5 X sky130_gnd sky130_fd_pr__nfet_01v8 L=0.15 W=0.65 AS=0.258375
+ AD=0.169 PS=1.445 PD=1.82
.ENDS sky130_fd_sc_hd__a21bo_1

.SUBCKT sky130_fd_sc_hd__or3_1 VPB X VPWR VGND A B C sky130_gnd
M$1 \$6 C \$11 VPB sky130_fd_pr__pfet_01v8_hvt L=0.15 W=0.42 AS=0.1092
+ AD=0.0441 PS=1.36 PD=0.63
M$2 \$11 B \$10 VPB sky130_fd_pr__pfet_01v8_hvt L=0.15 W=0.42 AS=0.0441
+ AD=0.0693 PS=0.63 PD=0.75
M$3 \$10 A VPWR VPB sky130_fd_pr__pfet_01v8_hvt L=0.15 W=0.42 AS=0.0693
+ AD=0.14825 PS=0.75 PD=1.34
M$4 VPWR \$6 X VPB sky130_fd_pr__pfet_01v8_hvt L=0.15 W=1 AS=0.14825 AD=0.28
+ PS=1.34 PD=2.56
M$5 \$6 C VGND sky130_gnd sky130_fd_pr__nfet_01v8 L=0.15 W=0.42 AS=0.1092
+ AD=0.0567 PS=1.36 PD=0.69
M$6 VGND B \$6 sky130_gnd sky130_fd_pr__nfet_01v8 L=0.15 W=0.42 AS=0.0567
+ AD=0.0567 PS=0.69 PD=0.69
M$7 VGND A \$6 sky130_gnd sky130_fd_pr__nfet_01v8 L=0.15 W=0.42 AS=0.101875
+ AD=0.0567 PS=0.99 PD=0.69
M$8 VGND \$6 X sky130_gnd sky130_fd_pr__nfet_01v8 L=0.15 W=0.65 AS=0.101875
+ AD=0.182 PS=0.99 PD=1.86
.ENDS sky130_fd_sc_hd__or3_1

.SUBCKT sky130_fd_sc_hd__o32a_1 VGND X A1 A2 A3 B2 B1 VPWR VPB sky130_gnd
M$1 X \$5 VPWR VPB sky130_fd_pr__pfet_01v8_hvt L=0.15 W=1 AS=0.335 AD=0.135
+ PS=2.67 PD=1.27
M$2 VPWR A1 \$12 VPB sky130_fd_pr__pfet_01v8_hvt L=0.15 W=1 AS=0.135 AD=0.165
+ PS=1.27 PD=1.33
M$3 \$12 A2 \$13 VPB sky130_fd_pr__pfet_01v8_hvt L=0.15 W=1 AS=0.165 AD=0.195
+ PS=1.33 PD=1.39
M$4 \$13 A3 \$5 VPB sky130_fd_pr__pfet_01v8_hvt L=0.15 W=1 AS=0.195 AD=0.195
+ PS=1.39 PD=1.39
M$5 \$5 B2 \$14 VPB sky130_fd_pr__pfet_01v8_hvt L=0.15 W=1 AS=0.195 AD=0.205
+ PS=1.39 PD=1.41
M$6 \$14 B1 VPWR VPB sky130_fd_pr__pfet_01v8_hvt L=0.15 W=1 AS=0.205 AD=0.29
+ PS=1.41 PD=2.58
M$7 X \$5 VGND sky130_gnd sky130_fd_pr__nfet_01v8 L=0.15 W=0.65 AS=0.169
+ AD=0.08775 PS=1.82 PD=0.92
M$8 VGND A1 \$4 sky130_gnd sky130_fd_pr__nfet_01v8 L=0.15 W=0.65 AS=0.08775
+ AD=0.10725 PS=0.92 PD=0.98
M$9 \$4 A2 VGND sky130_gnd sky130_fd_pr__nfet_01v8 L=0.15 W=0.65 AS=0.10725
+ AD=0.12675 PS=0.98 PD=1.04
M$10 VGND A3 \$4 sky130_gnd sky130_fd_pr__nfet_01v8 L=0.15 W=0.65 AS=0.12675
+ AD=0.12675 PS=1.04 PD=1.04
M$11 \$4 B2 \$5 sky130_gnd sky130_fd_pr__nfet_01v8 L=0.15 W=0.65 AS=0.12675
+ AD=0.13325 PS=1.04 PD=1.06
M$12 \$5 B1 \$4 sky130_gnd sky130_fd_pr__nfet_01v8 L=0.15 W=0.65 AS=0.13325
+ AD=0.1885 PS=1.06 PD=1.88
.ENDS sky130_fd_sc_hd__o32a_1

.SUBCKT sky130_fd_sc_hd__mux2i_1 VPB A0 Y A1 VPWR VGND S sky130_gnd
M$1 \$8 S VPWR VPB sky130_fd_pr__pfet_01v8_hvt L=0.15 W=1 AS=0.29 AD=0.26
+ PS=2.58 PD=2.52
M$2 \$4 A0 Y VPB sky130_fd_pr__pfet_01v8_hvt L=0.15 W=1 AS=0.28 AD=0.1525
+ PS=2.56 PD=1.305
M$3 Y A1 \$13 VPB sky130_fd_pr__pfet_01v8_hvt L=0.15 W=1 AS=0.1525 AD=0.1975
+ PS=1.305 PD=1.395
M$4 \$13 \$8 VPWR VPB sky130_fd_pr__pfet_01v8_hvt L=0.15 W=1 AS=0.1975 AD=0.3
+ PS=1.395 PD=1.6
M$5 VPWR S \$4 VPB sky130_fd_pr__pfet_01v8_hvt L=0.15 W=1 AS=0.3 AD=0.26 PS=1.6
+ PD=2.52
M$6 \$8 S VGND sky130_gnd sky130_fd_pr__nfet_01v8 L=0.15 W=0.65 AS=0.169
+ AD=0.169 PS=1.82 PD=1.82
M$7 \$2 \$8 VGND sky130_gnd sky130_fd_pr__nfet_01v8 L=0.15 W=0.65 AS=0.169
+ AD=0.08775 PS=1.82 PD=0.92
M$8 VGND S \$7 sky130_gnd sky130_fd_pr__nfet_01v8 L=0.15 W=0.65 AS=0.08775
+ AD=0.169 PS=0.92 PD=1.82
M$9 \$2 A0 Y sky130_gnd sky130_fd_pr__nfet_01v8 L=0.15 W=0.65 AS=0.169
+ AD=0.08775 PS=1.82 PD=0.92
M$10 Y A1 \$7 sky130_gnd sky130_fd_pr__nfet_01v8 L=0.15 W=0.65 AS=0.08775
+ AD=0.182 PS=0.92 PD=1.86
.ENDS sky130_fd_sc_hd__mux2i_1

.SUBCKT sky130_fd_sc_hd__mux2_1 VGND X A1 A0 S VPWR VPB sky130_gnd
M$1 VPWR S \$13 VPB sky130_fd_pr__pfet_01v8_hvt L=0.15 W=0.42 AS=0.15835
+ AD=0.07665 PS=1.395 PD=0.785
M$2 \$13 A0 \$5 VPB sky130_fd_pr__pfet_01v8_hvt L=0.15 W=0.42 AS=0.07665
+ AD=0.1932 PS=0.785 PD=1.34
M$3 \$5 A1 \$14 VPB sky130_fd_pr__pfet_01v8_hvt L=0.15 W=0.42 AS=0.1932
+ AD=0.0441 PS=1.34 PD=0.63
M$4 \$14 \$7 VPWR VPB sky130_fd_pr__pfet_01v8_hvt L=0.15 W=0.42 AS=0.0441
+ AD=0.0693 PS=0.63 PD=0.75
M$5 VPWR S \$7 VPB sky130_fd_pr__pfet_01v8_hvt L=0.15 W=0.42 AS=0.0693
+ AD=0.1176 PS=0.75 PD=1.4
M$6 X \$5 VPWR VPB sky130_fd_pr__pfet_01v8_hvt L=0.15 W=1 AS=0.26 AD=0.15835
+ PS=2.52 PD=1.395
M$7 VGND S \$8 sky130_gnd sky130_fd_pr__nfet_01v8 L=0.15 W=0.42 AS=0.11285
+ AD=0.0693 PS=1.045 PD=0.75
M$8 \$8 A1 \$5 sky130_gnd sky130_fd_pr__nfet_01v8 L=0.15 W=0.42 AS=0.0693
+ AD=0.09975 PS=0.75 PD=0.895
M$9 \$5 A0 \$9 sky130_gnd sky130_fd_pr__nfet_01v8 L=0.15 W=0.42 AS=0.09975
+ AD=0.0693 PS=0.895 PD=0.75
M$10 \$9 \$7 VGND sky130_gnd sky130_fd_pr__nfet_01v8 L=0.15 W=0.42 AS=0.0693
+ AD=0.1449 PS=0.75 PD=1.11
M$11 VGND S \$7 sky130_gnd sky130_fd_pr__nfet_01v8 L=0.15 W=0.42 AS=0.1449
+ AD=0.1092 PS=1.11 PD=1.36
M$12 X \$5 VGND sky130_gnd sky130_fd_pr__nfet_01v8 L=0.15 W=0.65 AS=0.169
+ AD=0.11285 PS=1.82 PD=1.045
.ENDS sky130_fd_sc_hd__mux2_1

.SUBCKT sky130_fd_sc_hd__o21a_1 VPB A2 VPWR X VGND B1 A1 sky130_gnd
M$1 X \$7 VPWR VPB sky130_fd_pr__pfet_01v8_hvt L=0.15 W=1 AS=0.28 AD=0.3275
+ PS=2.56 PD=1.655
M$2 VPWR B1 \$7 VPB sky130_fd_pr__pfet_01v8_hvt L=0.15 W=1 AS=0.3275 AD=0.195
+ PS=1.655 PD=1.39
M$3 \$7 A2 \$11 VPB sky130_fd_pr__pfet_01v8_hvt L=0.15 W=1 AS=0.195 AD=0.1525
+ PS=1.39 PD=1.305
M$4 \$11 A1 VPWR VPB sky130_fd_pr__pfet_01v8_hvt L=0.15 W=1 AS=0.1525 AD=0.26
+ PS=1.305 PD=2.52
M$5 \$7 B1 \$4 sky130_gnd sky130_fd_pr__nfet_01v8 L=0.15 W=0.65 AS=0.169
+ AD=0.10075 PS=1.82 PD=0.96
M$6 \$4 A2 VGND sky130_gnd sky130_fd_pr__nfet_01v8 L=0.15 W=0.65 AS=0.10075
+ AD=0.08775 PS=0.96 PD=0.92
M$7 VGND A1 \$4 sky130_gnd sky130_fd_pr__nfet_01v8 L=0.15 W=0.65 AS=0.08775
+ AD=0.169 PS=0.92 PD=1.82
M$8 X \$7 VGND sky130_gnd sky130_fd_pr__nfet_01v8 L=0.15 W=0.65 AS=0.169
+ AD=0.169 PS=1.82 PD=1.82
.ENDS sky130_fd_sc_hd__o21a_1

.SUBCKT sky130_fd_sc_hd__nand2b_1 VPB Y B VPWR VGND A_N sky130_gnd
M$1 \$2 A_N VPWR VPB sky130_fd_pr__pfet_01v8_hvt L=0.15 W=0.42 AS=0.1092
+ AD=0.14575 PS=1.36 PD=1.335
M$2 VPWR B Y VPB sky130_fd_pr__pfet_01v8_hvt L=0.15 W=1 AS=0.14575 AD=0.135
+ PS=1.335 PD=1.27
M$3 Y \$2 VPWR VPB sky130_fd_pr__pfet_01v8_hvt L=0.15 W=1 AS=0.135 AD=0.265
+ PS=1.27 PD=2.53
M$4 VGND A_N \$2 sky130_gnd sky130_fd_pr__nfet_01v8 L=0.15 W=0.42 AS=0.10025
+ AD=0.1092 PS=0.985 PD=1.36
M$5 VGND B \$9 sky130_gnd sky130_fd_pr__nfet_01v8 L=0.15 W=0.65 AS=0.10025
+ AD=0.08775 PS=0.985 PD=0.92
M$6 \$9 \$2 Y sky130_gnd sky130_fd_pr__nfet_01v8 L=0.15 W=0.65 AS=0.08775
+ AD=0.169 PS=0.92 PD=1.82
.ENDS sky130_fd_sc_hd__nand2b_1

.SUBCKT sky130_fd_sc_hd__and4_1 VPB VGND VPWR X D C B A sky130_gnd
M$1 VPWR A \$5 VPB sky130_fd_pr__pfet_01v8_hvt L=0.15 W=0.42 AS=0.1092
+ AD=0.0735 PS=1.36 PD=0.77
M$2 \$5 B VPWR VPB sky130_fd_pr__pfet_01v8_hvt L=0.15 W=0.42 AS=0.0735
+ AD=0.0777 PS=0.77 PD=0.79
M$3 VPWR C \$5 VPB sky130_fd_pr__pfet_01v8_hvt L=0.15 W=0.42 AS=0.0777
+ AD=0.0588 PS=0.79 PD=0.7
M$4 VPWR D \$5 VPB sky130_fd_pr__pfet_01v8_hvt L=0.15 W=0.42 AS=0.31245
+ AD=0.0588 PS=1.68 PD=0.7
M$5 VPWR \$5 X VPB sky130_fd_pr__pfet_01v8_hvt L=0.15 W=1 AS=0.31245 AD=0.26
+ PS=1.68 PD=2.52
M$6 \$5 A \$13 sky130_gnd sky130_fd_pr__nfet_01v8 L=0.15 W=0.42 AS=0.1092
+ AD=0.0609 PS=1.36 PD=0.71
M$7 \$13 B \$11 sky130_gnd sky130_fd_pr__nfet_01v8 L=0.15 W=0.42 AS=0.0609
+ AD=0.0798 PS=0.71 PD=0.8
M$8 \$11 C \$12 sky130_gnd sky130_fd_pr__nfet_01v8 L=0.15 W=0.42 AS=0.0798
+ AD=0.0693 PS=0.8 PD=0.75
M$9 \$12 D VGND sky130_gnd sky130_fd_pr__nfet_01v8 L=0.15 W=0.42 AS=0.0693
+ AD=0.196275 PS=0.75 PD=1.33
M$10 VGND \$5 X sky130_gnd sky130_fd_pr__nfet_01v8 L=0.15 W=0.65 AS=0.196275
+ AD=0.169 PS=1.33 PD=1.82
.ENDS sky130_fd_sc_hd__and4_1

.SUBCKT sky130_fd_sc_hd__o21bai_1 VPB VPWR A1 A2 Y B1_N VGND sky130_gnd
M$1 VPWR B1_N \$7 VPB sky130_fd_pr__pfet_01v8_hvt L=0.15 W=0.42 AS=0.17825
+ AD=0.1092 PS=1.4 PD=1.36
M$2 VPWR \$7 Y VPB sky130_fd_pr__pfet_01v8_hvt L=0.15 W=1 AS=0.17825 AD=0.1525
+ PS=1.4 PD=1.305
M$3 Y A2 \$11 VPB sky130_fd_pr__pfet_01v8_hvt L=0.15 W=1 AS=0.1525 AD=0.1275
+ PS=1.305 PD=1.255
M$4 \$11 A1 VPWR VPB sky130_fd_pr__pfet_01v8_hvt L=0.15 W=1 AS=0.1275 AD=0.28
+ PS=1.255 PD=2.56
M$5 Y \$7 \$2 sky130_gnd sky130_fd_pr__nfet_01v8 L=0.15 W=0.65 AS=0.169
+ AD=0.10075 PS=1.82 PD=0.96
M$6 \$2 A2 VGND sky130_gnd sky130_fd_pr__nfet_01v8 L=0.15 W=0.65 AS=0.10075
+ AD=0.08775 PS=0.96 PD=0.92
M$7 VGND A1 \$2 sky130_gnd sky130_fd_pr__nfet_01v8 L=0.15 W=0.65 AS=0.08775
+ AD=0.169 PS=0.92 PD=1.82
M$8 VGND B1_N \$7 sky130_gnd sky130_fd_pr__nfet_01v8 L=0.15 W=0.42 AS=0.1092
+ AD=0.1092 PS=1.36 PD=1.36
.ENDS sky130_fd_sc_hd__o21bai_1

.SUBCKT sky130_fd_sc_hd__a22o_1 VPB VGND B2 B1 VPWR A1 X A2 sky130_gnd
M$1 VPWR A1 \$4 VPB sky130_fd_pr__pfet_01v8_hvt L=0.15 W=1 AS=0.2529 AD=0.16
+ PS=2.52 PD=1.32
M$2 \$4 A2 VPWR VPB sky130_fd_pr__pfet_01v8_hvt L=0.15 W=1 AS=0.16 AD=0.155
+ PS=1.32 PD=1.31
M$3 VPWR \$6 X VPB sky130_fd_pr__pfet_01v8_hvt L=0.15 W=1 AS=0.155 AD=0.26
+ PS=1.31 PD=2.52
M$4 \$6 B2 \$4 VPB sky130_fd_pr__pfet_01v8_hvt L=0.15 W=1 AS=0.26 AD=0.135
+ PS=2.52 PD=1.27
M$5 \$4 B1 \$6 VPB sky130_fd_pr__pfet_01v8_hvt L=0.15 W=1 AS=0.135 AD=0.25285
+ PS=1.27 PD=2.52
M$6 \$6 A1 \$12 sky130_gnd sky130_fd_pr__nfet_01v8 L=0.15 W=0.65 AS=0.169
+ AD=0.11375 PS=1.82 PD=1
M$7 \$12 A2 VGND sky130_gnd sky130_fd_pr__nfet_01v8 L=0.15 W=0.65 AS=0.11375
+ AD=0.10075 PS=1 PD=0.96
M$8 VGND \$6 X sky130_gnd sky130_fd_pr__nfet_01v8 L=0.15 W=0.65 AS=0.10075
+ AD=0.169 PS=0.96 PD=1.82
M$9 VGND B2 \$13 sky130_gnd sky130_fd_pr__nfet_01v8 L=0.15 W=0.65 AS=0.169
+ AD=0.07475 PS=1.82 PD=0.88
M$10 \$13 B1 \$6 sky130_gnd sky130_fd_pr__nfet_01v8 L=0.15 W=0.65 AS=0.07475
+ AD=0.169 PS=0.88 PD=1.82
.ENDS sky130_fd_sc_hd__a22o_1

.SUBCKT sky130_fd_sc_hd__nor3_1 VPB C Y VGND B VPWR A sky130_gnd
M$1 Y C \$10 VPB sky130_fd_pr__pfet_01v8_hvt L=0.15 W=1 AS=0.26 AD=0.135
+ PS=2.52 PD=1.27
M$2 \$10 B \$9 VPB sky130_fd_pr__pfet_01v8_hvt L=0.15 W=1 AS=0.135 AD=0.135
+ PS=1.27 PD=1.27
M$3 \$9 A VPWR VPB sky130_fd_pr__pfet_01v8_hvt L=0.15 W=1 AS=0.135 AD=0.26
+ PS=1.27 PD=2.52
M$4 Y C VGND sky130_gnd sky130_fd_pr__nfet_01v8 L=0.15 W=0.65 AS=0.169
+ AD=0.08775 PS=1.82 PD=0.92
M$5 VGND B Y sky130_gnd sky130_fd_pr__nfet_01v8 L=0.15 W=0.65 AS=0.08775
+ AD=0.08775 PS=0.92 PD=0.92
M$6 Y A VGND sky130_gnd sky130_fd_pr__nfet_01v8 L=0.15 W=0.65 AS=0.08775
+ AD=0.169 PS=0.92 PD=1.82
.ENDS sky130_fd_sc_hd__nor3_1

.SUBCKT sky130_fd_sc_hd__lpflow_inputiso1p_1 VPB X VGND A SLEEP VPWR sky130_gnd
M$1 \$5 A \$9 VPB sky130_fd_pr__pfet_01v8_hvt L=0.15 W=0.42 AS=0.1092 AD=0.0441
+ PS=1.36 PD=0.63
M$2 \$9 SLEEP VPWR VPB sky130_fd_pr__pfet_01v8_hvt L=0.15 W=0.42 AS=0.0441
+ AD=0.14575 PS=0.63 PD=1.335
M$3 VPWR \$5 X VPB sky130_fd_pr__pfet_01v8_hvt L=0.15 W=1 AS=0.14575 AD=0.34
+ PS=1.335 PD=2.68
M$4 VGND A \$5 sky130_gnd sky130_fd_pr__nfet_01v8 L=0.15 W=0.42 AS=0.1092
+ AD=0.0567 PS=1.36 PD=0.69
M$5 \$5 SLEEP VGND sky130_gnd sky130_fd_pr__nfet_01v8 L=0.15 W=0.42 AS=0.0567
+ AD=0.10025 PS=0.69 PD=0.985
M$6 VGND \$5 X sky130_gnd sky130_fd_pr__nfet_01v8 L=0.15 W=0.65 AS=0.10025
+ AD=0.169 PS=0.985 PD=1.82
.ENDS sky130_fd_sc_hd__lpflow_inputiso1p_1

.SUBCKT sky130_fd_sc_hd__nor2b_1 VPB VGND Y B_N VPWR A sky130_gnd
M$1 \$4 B_N VPWR VPB sky130_fd_pr__pfet_01v8_hvt L=0.15 W=0.42 AS=0.1092
+ AD=0.1573 PS=1.36 PD=1.39
M$2 VPWR A \$9 VPB sky130_fd_pr__pfet_01v8_hvt L=0.15 W=1 AS=0.1573 AD=0.105
+ PS=1.39 PD=1.21
M$3 \$9 \$4 Y VPB sky130_fd_pr__pfet_01v8_hvt L=0.15 W=1 AS=0.105 AD=0.26
+ PS=1.21 PD=2.52
M$4 \$4 B_N VGND sky130_gnd sky130_fd_pr__nfet_01v8 L=0.15 W=0.42 AS=0.1092
+ AD=0.10025 PS=1.36 PD=0.985
M$5 VGND A Y sky130_gnd sky130_fd_pr__nfet_01v8 L=0.15 W=0.65 AS=0.10025
+ AD=0.08775 PS=0.985 PD=0.92
M$6 Y \$4 VGND sky130_gnd sky130_fd_pr__nfet_01v8 L=0.15 W=0.65 AS=0.08775
+ AD=0.169 PS=0.92 PD=1.82
.ENDS sky130_fd_sc_hd__nor2b_1

.SUBCKT sky130_fd_sc_hd__a31oi_1 VPB A3 VGND A2 VPWR A1 Y B1 sky130_gnd
M$1 VPWR A3 \$4 VPB sky130_fd_pr__pfet_01v8_hvt L=0.15 W=1 AS=0.26 AD=0.135
+ PS=2.52 PD=1.27
M$2 \$4 A2 VPWR VPB sky130_fd_pr__pfet_01v8_hvt L=0.15 W=1 AS=0.135 AD=0.1525
+ PS=1.27 PD=1.305
M$3 VPWR A1 \$4 VPB sky130_fd_pr__pfet_01v8_hvt L=0.15 W=1 AS=0.1525 AD=0.1625
+ PS=1.305 PD=1.325
M$4 \$4 B1 Y VPB sky130_fd_pr__pfet_01v8_hvt L=0.15 W=1 AS=0.1625 AD=0.27
+ PS=1.325 PD=2.54
M$5 VGND A3 \$12 sky130_gnd sky130_fd_pr__nfet_01v8 L=0.15 W=0.65 AS=0.169
+ AD=0.06825 PS=1.82 PD=0.86
M$6 \$12 A2 \$11 sky130_gnd sky130_fd_pr__nfet_01v8 L=0.15 W=0.65 AS=0.06825
+ AD=0.118625 PS=0.86 PD=1.015
M$7 \$11 A1 Y sky130_gnd sky130_fd_pr__nfet_01v8 L=0.15 W=0.65 AS=0.118625
+ AD=0.105625 PS=1.015 PD=0.975
M$8 Y B1 VGND sky130_gnd sky130_fd_pr__nfet_01v8 L=0.15 W=0.65 AS=0.105625
+ AD=0.1755 PS=0.975 PD=1.84
.ENDS sky130_fd_sc_hd__a31oi_1

.SUBCKT sky130_fd_sc_hd__and3_1 VPB A C X VPWR VGND B sky130_gnd
M$1 \$3 A VPWR VPB sky130_fd_pr__pfet_01v8_hvt L=0.15 W=0.42 AS=0.1092
+ AD=0.0567 PS=1.36 PD=0.69
M$2 VPWR B \$3 VPB sky130_fd_pr__pfet_01v8_hvt L=0.15 W=0.42 AS=0.0567
+ AD=0.06615 PS=0.69 PD=0.735
M$3 VPWR C \$3 VPB sky130_fd_pr__pfet_01v8_hvt L=0.15 W=0.42 AS=0.142225
+ AD=0.06615 PS=1.335 PD=0.735
M$4 VPWR \$3 X VPB sky130_fd_pr__pfet_01v8_hvt L=0.15 W=1 AS=0.142225 AD=0.26
+ PS=1.335 PD=2.52
M$5 \$3 A \$11 sky130_gnd sky130_fd_pr__nfet_01v8 L=0.15 W=0.42 AS=0.1092
+ AD=0.0441 PS=1.36 PD=0.63
M$6 \$11 B \$10 sky130_gnd sky130_fd_pr__nfet_01v8 L=0.15 W=0.42 AS=0.0441
+ AD=0.0441 PS=0.63 PD=0.63
M$7 \$10 C VGND sky130_gnd sky130_fd_pr__nfet_01v8 L=0.15 W=0.42 AS=0.0441
+ AD=0.13165 PS=0.63 PD=1.14
M$8 VGND \$3 X sky130_gnd sky130_fd_pr__nfet_01v8 L=0.15 W=0.65 AS=0.13165
+ AD=0.169 PS=1.14 PD=1.82
.ENDS sky130_fd_sc_hd__and3_1

.SUBCKT sky130_fd_sc_hd__nand2_2 VPB VPWR Y B VGND A sky130_gnd
M$1 VPWR B Y VPB sky130_fd_pr__pfet_01v8_hvt L=0.15 W=1 AS=0.26 AD=0.135
+ PS=2.52 PD=1.27
M$2 Y B VPWR VPB sky130_fd_pr__pfet_01v8_hvt L=0.15 W=1 AS=0.135 AD=0.135
+ PS=1.27 PD=1.27
M$3 VPWR A Y VPB sky130_fd_pr__pfet_01v8_hvt L=0.15 W=1 AS=0.135 AD=0.135
+ PS=1.27 PD=1.27
M$4 Y A VPWR VPB sky130_fd_pr__pfet_01v8_hvt L=0.15 W=1 AS=0.135 AD=0.26
+ PS=1.27 PD=2.52
M$5 \$3 B VGND sky130_gnd sky130_fd_pr__nfet_01v8 L=0.15 W=0.65 AS=0.169
+ AD=0.08775 PS=1.82 PD=0.92
M$6 VGND B \$3 sky130_gnd sky130_fd_pr__nfet_01v8 L=0.15 W=0.65 AS=0.08775
+ AD=0.08775 PS=0.92 PD=0.92
M$7 \$3 A Y sky130_gnd sky130_fd_pr__nfet_01v8 L=0.15 W=0.65 AS=0.08775
+ AD=0.08775 PS=0.92 PD=0.92
M$8 Y A \$3 sky130_gnd sky130_fd_pr__nfet_01v8 L=0.15 W=0.65 AS=0.08775
+ AD=0.169 PS=0.92 PD=1.82
.ENDS sky130_fd_sc_hd__nand2_2

.SUBCKT sky130_fd_sc_hd__buf_2 VPB VGND X VPWR A sky130_gnd
M$1 VPWR A \$3 VPB sky130_fd_pr__pfet_01v8_hvt L=0.15 W=0.64 AS=0.149 AD=0.1664
+ PS=1.325 PD=1.8
M$2 VPWR \$3 X VPB sky130_fd_pr__pfet_01v8_hvt L=0.15 W=1 AS=0.149 AD=0.135
+ PS=1.325 PD=1.27
M$3 X \$3 VPWR VPB sky130_fd_pr__pfet_01v8_hvt L=0.15 W=1 AS=0.135 AD=0.265
+ PS=1.27 PD=2.53
M$4 \$3 A VGND sky130_gnd sky130_fd_pr__nfet_01v8 L=0.15 W=0.42 AS=0.1092
+ AD=0.097 PS=1.36 PD=0.975
M$5 VGND \$3 X sky130_gnd sky130_fd_pr__nfet_01v8 L=0.15 W=0.65 AS=0.097
+ AD=0.08775 PS=0.975 PD=0.92
M$6 X \$3 VGND sky130_gnd sky130_fd_pr__nfet_01v8 L=0.15 W=0.65 AS=0.08775
+ AD=0.17225 PS=0.92 PD=1.83
.ENDS sky130_fd_sc_hd__buf_2

.SUBCKT sky130_fd_sc_hd__and2_0 VPB X VPWR A B VGND sky130_gnd
M$1 VPWR A \$4 VPB sky130_fd_pr__pfet_01v8_hvt L=0.15 W=0.42 AS=0.1113
+ AD=0.0609 PS=1.37 PD=0.71
M$2 VPWR B \$4 VPB sky130_fd_pr__pfet_01v8_hvt L=0.15 W=0.42 AS=0.1841
+ AD=0.0609 PS=1.26 PD=0.71
M$3 VPWR \$4 X VPB sky130_fd_pr__pfet_01v8_hvt L=0.15 W=0.64 AS=0.1841
+ AD=0.1696 PS=1.26 PD=1.81
M$4 \$4 A \$9 sky130_gnd sky130_fd_pr__nfet_01v8 L=0.15 W=0.42 AS=0.1113
+ AD=0.0441 PS=1.37 PD=0.63
M$5 \$9 B VGND sky130_gnd sky130_fd_pr__nfet_01v8 L=0.15 W=0.42 AS=0.0441
+ AD=0.0966 PS=0.63 PD=0.88
M$6 VGND \$4 X sky130_gnd sky130_fd_pr__nfet_01v8 L=0.15 W=0.42 AS=0.0966
+ AD=0.1113 PS=0.88 PD=1.37
.ENDS sky130_fd_sc_hd__and2_0

.SUBCKT sky130_fd_sc_hd__clkinv_1 VPB VPWR VGND Y A sky130_gnd
M$1 VPWR A Y VPB sky130_fd_pr__pfet_01v8_hvt L=0.15 W=0.84 AS=0.2184 AD=0.1134
+ PS=2.2 PD=1.11
M$2 Y A VPWR VPB sky130_fd_pr__pfet_01v8_hvt L=0.15 W=0.84 AS=0.1134 AD=0.2352
+ PS=1.11 PD=2.24
M$3 Y A VGND sky130_gnd sky130_fd_pr__nfet_01v8 L=0.15 W=0.42 AS=0.1092
+ AD=0.1197 PS=1.36 PD=1.41
.ENDS sky130_fd_sc_hd__clkinv_1

.SUBCKT sky130_fd_sc_hd__o211ai_1 VPB B1 Y VPWR A1 VGND A2 C1 sky130_gnd
M$1 VPWR A1 \$12 VPB sky130_fd_pr__pfet_01v8_hvt L=0.15 W=1 AS=0.265 AD=0.105
+ PS=2.53 PD=1.21
M$2 \$12 A2 Y VPB sky130_fd_pr__pfet_01v8_hvt L=0.15 W=1 AS=0.105 AD=0.195
+ PS=1.21 PD=1.39
M$3 Y B1 VPWR VPB sky130_fd_pr__pfet_01v8_hvt L=0.15 W=1 AS=0.195 AD=0.195
+ PS=1.39 PD=1.39
M$4 VPWR C1 Y VPB sky130_fd_pr__pfet_01v8_hvt L=0.15 W=1 AS=0.195 AD=0.635
+ PS=1.39 PD=3.27
M$5 \$2 A1 VGND sky130_gnd sky130_fd_pr__nfet_01v8 L=0.15 W=0.65 AS=0.17225
+ AD=0.12675 PS=1.83 PD=1.04
M$6 VGND A2 \$2 sky130_gnd sky130_fd_pr__nfet_01v8 L=0.15 W=0.65 AS=0.12675
+ AD=0.12675 PS=1.04 PD=1.04
M$7 \$2 B1 \$11 sky130_gnd sky130_fd_pr__nfet_01v8 L=0.15 W=0.65 AS=0.12675
+ AD=0.06825 PS=1.04 PD=0.86
M$8 \$11 C1 Y sky130_gnd sky130_fd_pr__nfet_01v8 L=0.15 W=0.65 AS=0.06825
+ AD=0.39325 PS=0.86 PD=2.51
.ENDS sky130_fd_sc_hd__o211ai_1

.SUBCKT sky130_fd_sc_hd__nand3_1 VPB Y VPWR VGND C B A sky130_gnd
M$1 VPWR C Y VPB sky130_fd_pr__pfet_01v8_hvt L=0.15 W=1 AS=0.26 AD=0.135
+ PS=2.52 PD=1.27
M$2 Y B VPWR VPB sky130_fd_pr__pfet_01v8_hvt L=0.15 W=1 AS=0.135 AD=0.165
+ PS=1.27 PD=1.33
M$3 VPWR A Y VPB sky130_fd_pr__pfet_01v8_hvt L=0.15 W=1 AS=0.165 AD=0.26
+ PS=1.33 PD=2.52
M$4 VGND C \$10 sky130_gnd sky130_fd_pr__nfet_01v8 L=0.15 W=0.65 AS=0.169
+ AD=0.08775 PS=1.82 PD=0.92
M$5 \$10 B \$9 sky130_gnd sky130_fd_pr__nfet_01v8 L=0.15 W=0.65 AS=0.08775
+ AD=0.10725 PS=0.92 PD=0.98
M$6 \$9 A Y sky130_gnd sky130_fd_pr__nfet_01v8 L=0.15 W=0.65 AS=0.10725
+ AD=0.169 PS=0.98 PD=1.82
.ENDS sky130_fd_sc_hd__nand3_1

.SUBCKT sky130_fd_sc_hd__a21oi_1 VPB VGND A2 VPWR A1 Y B1 sky130_gnd
M$1 Y B1 \$3 VPB sky130_fd_pr__pfet_01v8_hvt L=0.15 W=1 AS=0.265 AD=0.14
+ PS=2.53 PD=1.28
M$2 \$3 A1 VPWR VPB sky130_fd_pr__pfet_01v8_hvt L=0.15 W=1 AS=0.14 AD=0.1475
+ PS=1.28 PD=1.295
M$3 VPWR A2 \$3 VPB sky130_fd_pr__pfet_01v8_hvt L=0.15 W=1 AS=0.1475 AD=0.265
+ PS=1.295 PD=2.53
M$4 VGND B1 Y sky130_gnd sky130_fd_pr__nfet_01v8 L=0.15 W=0.65 AS=0.17225
+ AD=0.091 PS=1.83 PD=0.93
M$5 Y A1 \$10 sky130_gnd sky130_fd_pr__nfet_01v8 L=0.15 W=0.65 AS=0.091
+ AD=0.095875 PS=0.93 PD=0.945
M$6 \$10 A2 VGND sky130_gnd sky130_fd_pr__nfet_01v8 L=0.15 W=0.65 AS=0.095875
+ AD=0.17225 PS=0.945 PD=1.83
.ENDS sky130_fd_sc_hd__a21oi_1

.SUBCKT sky130_fd_sc_hd__a21o_1 VPB VGND A2 VPWR A1 B1 X sky130_gnd
M$1 \$7 B1 \$3 VPB sky130_fd_pr__pfet_01v8_hvt L=0.15 W=1 AS=0.26 AD=0.1375
+ PS=2.52 PD=1.275
M$2 \$3 A1 VPWR VPB sky130_fd_pr__pfet_01v8_hvt L=0.15 W=1 AS=0.1375 AD=0.14
+ PS=1.275 PD=1.28
M$3 VPWR A2 \$3 VPB sky130_fd_pr__pfet_01v8_hvt L=0.15 W=1 AS=0.14 AD=0.265
+ PS=1.28 PD=2.53
M$4 X \$7 VPWR VPB sky130_fd_pr__pfet_01v8_hvt L=0.15 W=1 AS=0.26 AD=0.26
+ PS=2.52 PD=2.52
M$5 X \$7 VGND sky130_gnd sky130_fd_pr__nfet_01v8 L=0.15 W=0.65 AS=0.169
+ AD=0.25675 PS=1.82 PD=1.44
M$6 VGND B1 \$7 sky130_gnd sky130_fd_pr__nfet_01v8 L=0.15 W=0.65 AS=0.25675
+ AD=0.089375 PS=1.44 PD=0.925
M$7 \$7 A1 \$11 sky130_gnd sky130_fd_pr__nfet_01v8 L=0.15 W=0.65 AS=0.089375
+ AD=0.091 PS=0.925 PD=0.93
M$8 \$11 A2 VGND sky130_gnd sky130_fd_pr__nfet_01v8 L=0.15 W=0.65 AS=0.091
+ AD=0.17225 PS=0.93 PD=1.83
.ENDS sky130_fd_sc_hd__a21o_1

.SUBCKT sky130_fd_sc_hd__nand2_1 VPB Y VPWR VGND A B sky130_gnd
M$1 VPWR B Y VPB sky130_fd_pr__pfet_01v8_hvt L=0.15 W=1 AS=0.26 AD=0.135
+ PS=2.52 PD=1.27
M$2 Y A VPWR VPB sky130_fd_pr__pfet_01v8_hvt L=0.15 W=1 AS=0.135 AD=0.26
+ PS=1.27 PD=2.52
M$3 VGND B \$8 sky130_gnd sky130_fd_pr__nfet_01v8 L=0.15 W=0.65 AS=0.169
+ AD=0.08775 PS=1.82 PD=0.92
M$4 \$8 A Y sky130_gnd sky130_fd_pr__nfet_01v8 L=0.15 W=0.65 AS=0.08775
+ AD=0.169 PS=0.92 PD=1.82
.ENDS sky130_fd_sc_hd__nand2_1

.SUBCKT sky130_fd_sc_hd__clkdlybuf4s50_1 VPB A VGND VPWR X sky130_gnd
M$1 VPWR \$6 \$7 VPB sky130_fd_pr__pfet_01v8_hvt L=0.5 W=0.82 AS=0.15575
+ AD=0.2173 PS=1.325 PD=2.17
M$2 VPWR \$7 X VPB sky130_fd_pr__pfet_01v8_hvt L=0.15 W=1 AS=0.15575 AD=0.355
+ PS=1.325 PD=2.71
M$3 \$5 A VPWR VPB sky130_fd_pr__pfet_01v8_hvt L=0.15 W=1 AS=0.27 AD=0.1701
+ PS=2.54 PD=1.36
M$4 VPWR \$5 \$6 VPB sky130_fd_pr__pfet_01v8_hvt L=0.5 W=0.82 AS=0.1701
+ AD=0.2173 PS=1.36 PD=2.17
M$5 VGND \$7 X sky130_gnd sky130_fd_pr__nfet_01v8 L=0.15 W=0.42 AS=0.097
+ AD=0.1491 PS=0.975 PD=1.55
M$6 \$7 \$6 VGND sky130_gnd sky130_fd_pr__nfet_01v8 L=0.5 W=0.65 AS=0.17225
+ AD=0.097 PS=1.83 PD=0.975
M$7 \$5 A VGND sky130_gnd sky130_fd_pr__nfet_01v8 L=0.15 W=0.42 AS=0.1134
+ AD=0.10435 PS=1.38 PD=1.01
M$8 VGND \$5 \$6 sky130_gnd sky130_fd_pr__nfet_01v8 L=0.5 W=0.65 AS=0.10435
+ AD=0.169 PS=1.01 PD=1.82
.ENDS sky130_fd_sc_hd__clkdlybuf4s50_1

.SUBCKT sky130_fd_sc_hd__dfrtp_1 VGND RESET_B Q CLK D VPWR VPB sky130_gnd
M$1 VPWR D \$5 VPB sky130_fd_pr__pfet_01v8_hvt L=0.15 W=0.42 AS=0.1092
+ AD=0.0651 PS=1.36 PD=0.73
M$2 \$5 \$4 \$6 VPB sky130_fd_pr__pfet_01v8_hvt L=0.15 W=0.42 AS=0.0651
+ AD=0.07245 PS=0.73 PD=0.765
M$3 \$6 \$3 \$19 VPB sky130_fd_pr__pfet_01v8_hvt L=0.15 W=0.42 AS=0.07245
+ AD=0.1155 PS=0.765 PD=0.97
M$4 \$19 \$17 VPWR VPB sky130_fd_pr__pfet_01v8_hvt L=0.15 W=0.42 AS=0.1155
+ AD=0.07035 PS=0.97 PD=0.755
M$5 VPWR RESET_B \$19 VPB sky130_fd_pr__pfet_01v8_hvt L=0.15 W=0.42 AS=0.07035
+ AD=0.1092 PS=0.755 PD=1.36
M$6 VPWR \$6 \$17 VPB sky130_fd_pr__pfet_01v8_hvt L=0.15 W=0.84 AS=0.2184
+ AD=0.12915 PS=2.2 PD=1.185
M$7 \$17 \$3 \$8 VPB sky130_fd_pr__pfet_01v8_hvt L=0.15 W=0.42 AS=0.12915
+ AD=0.0588 PS=1.185 PD=0.7
M$8 \$8 \$4 \$21 VPB sky130_fd_pr__pfet_01v8_hvt L=0.15 W=0.42 AS=0.0588
+ AD=0.0567 PS=0.7 PD=0.69
M$9 \$21 \$9 VPWR VPB sky130_fd_pr__pfet_01v8_hvt L=0.15 W=0.42 AS=0.0567
+ AD=0.0819 PS=0.69 PD=0.81
M$10 VPWR RESET_B \$9 VPB sky130_fd_pr__pfet_01v8_hvt L=0.15 W=0.42 AS=0.0819
+ AD=0.0567 PS=0.81 PD=0.69
M$11 \$9 \$8 VPWR VPB sky130_fd_pr__pfet_01v8_hvt L=0.15 W=0.42 AS=0.0567
+ AD=0.1134 PS=0.69 PD=1.38
M$12 \$3 CLK VPWR VPB sky130_fd_pr__pfet_01v8_hvt L=0.15 W=0.64 AS=0.1664
+ AD=0.0864 PS=1.8 PD=0.91
M$13 VPWR \$3 \$4 VPB sky130_fd_pr__pfet_01v8_hvt L=0.15 W=0.64 AS=0.0864
+ AD=0.1664 PS=0.91 PD=1.8
M$14 VPWR \$9 Q VPB sky130_fd_pr__pfet_01v8_hvt L=0.15 W=1 AS=0.3012 AD=0.26
+ PS=2.66 PD=2.52
M$15 VGND \$9 Q sky130_gnd sky130_fd_pr__nfet_01v8 L=0.15 W=0.65 AS=0.2087
+ AD=0.169 PS=2.02 PD=1.82
M$16 \$3 CLK VGND sky130_gnd sky130_fd_pr__nfet_01v8 L=0.15 W=0.42 AS=0.1092
+ AD=0.0567 PS=1.36 PD=0.69
M$17 VGND \$3 \$4 sky130_gnd sky130_fd_pr__nfet_01v8 L=0.15 W=0.42 AS=0.0567
+ AD=0.1092 PS=0.69 PD=1.36
M$18 \$5 \$3 \$6 sky130_gnd sky130_fd_pr__nfet_01v8 L=0.15 W=0.36 AS=0.066
+ AD=0.0594 PS=0.745 PD=0.69
M$19 \$6 \$4 \$13 sky130_gnd sky130_fd_pr__nfet_01v8 L=0.15 W=0.36 AS=0.0594
+ AD=0.1401 PS=0.69 PD=1.1
M$20 \$17 \$4 \$8 sky130_gnd sky130_fd_pr__nfet_01v8 L=0.15 W=0.36 AS=0.0999
+ AD=0.0711 PS=0.985 PD=0.755
M$21 \$8 \$3 \$12 sky130_gnd sky130_fd_pr__nfet_01v8 L=0.15 W=0.36 AS=0.0711
+ AD=0.0669 PS=0.755 PD=0.75
M$22 VGND D \$5 sky130_gnd sky130_fd_pr__nfet_01v8 L=0.15 W=0.42 AS=0.2205
+ AD=0.066 PS=1.89 PD=0.745
M$23 \$13 \$17 \$14 sky130_gnd sky130_fd_pr__nfet_01v8 L=0.15 W=0.42 AS=0.1401
+ AD=0.0441 PS=1.1 PD=0.63
M$24 \$14 RESET_B VGND sky130_gnd sky130_fd_pr__nfet_01v8 L=0.15 W=0.42
+ AS=0.0441 AD=0.1346 PS=0.63 PD=1.15
M$25 \$12 \$9 VGND sky130_gnd sky130_fd_pr__nfet_01v8 L=0.15 W=0.42 AS=0.0669
+ AD=0.12495 PS=0.75 PD=1.015
M$26 VGND RESET_B \$11 sky130_gnd sky130_fd_pr__nfet_01v8 L=0.15 W=0.42
+ AS=0.12495 AD=0.06405 PS=1.015 PD=0.725
M$27 \$11 \$8 \$9 sky130_gnd sky130_fd_pr__nfet_01v8 L=0.15 W=0.42 AS=0.06405
+ AD=0.1092 PS=0.725 PD=1.36
M$28 VGND \$6 \$17 sky130_gnd sky130_fd_pr__nfet_01v8 L=0.15 W=0.64 AS=0.1346
+ AD=0.0999 PS=1.15 PD=0.985
.ENDS sky130_fd_sc_hd__dfrtp_1

.SUBCKT sky130_fd_sc_hd__decap_8 VPB VPWR VGND sky130_gnd
M$1 VPWR VGND VPWR VPB sky130_fd_pr__pfet_01v8_hvt L=2.89 W=0.87 AS=0.2262
+ AD=0.2262 PS=2.26 PD=2.26
M$2 VGND VPWR VGND sky130_gnd sky130_fd_pr__nfet_01v8 L=2.89 W=0.55 AS=0.143
+ AD=0.143 PS=1.62 PD=1.62
.ENDS sky130_fd_sc_hd__decap_8

.SUBCKT sky130_fd_sc_hd__nor2_1 VPB Y VGND B VPWR A sky130_gnd
M$1 Y B \$8 VPB sky130_fd_pr__pfet_01v8_hvt L=0.15 W=1 AS=0.26 AD=0.105 PS=2.52
+ PD=1.21
M$2 \$8 A VPWR VPB sky130_fd_pr__pfet_01v8_hvt L=0.15 W=1 AS=0.105 AD=0.26
+ PS=1.21 PD=2.52
M$3 VGND B Y sky130_gnd sky130_fd_pr__nfet_01v8 L=0.15 W=0.65 AS=0.169
+ AD=0.08775 PS=1.82 PD=0.92
M$4 Y A VGND sky130_gnd sky130_fd_pr__nfet_01v8 L=0.15 W=0.65 AS=0.08775
+ AD=0.169 PS=0.92 PD=1.82
.ENDS sky130_fd_sc_hd__nor2_1

.SUBCKT sky130_fd_sc_hd__lpflow_isobufsrc_1 VPB VGND X A VPWR SLEEP sky130_gnd
M$1 \$4 A VPWR VPB sky130_fd_pr__pfet_01v8_hvt L=0.15 W=0.42 AS=0.1092
+ AD=0.1573 PS=1.36 PD=1.39
M$2 VPWR SLEEP \$9 VPB sky130_fd_pr__pfet_01v8_hvt L=0.15 W=1 AS=0.1573
+ AD=0.105 PS=1.39 PD=1.21
M$3 \$9 \$4 X VPB sky130_fd_pr__pfet_01v8_hvt L=0.15 W=1 AS=0.105 AD=0.26
+ PS=1.21 PD=2.52
M$4 \$4 A VGND sky130_gnd sky130_fd_pr__nfet_01v8 L=0.15 W=0.42 AS=0.1092
+ AD=0.10025 PS=1.36 PD=0.985
M$5 VGND SLEEP X sky130_gnd sky130_fd_pr__nfet_01v8 L=0.15 W=0.65 AS=0.10025
+ AD=0.08775 PS=0.985 PD=0.92
M$6 X \$4 VGND sky130_gnd sky130_fd_pr__nfet_01v8 L=0.15 W=0.65 AS=0.08775
+ AD=0.169 PS=0.92 PD=1.82
.ENDS sky130_fd_sc_hd__lpflow_isobufsrc_1

.SUBCKT sky130_fd_sc_hd__xnor2_1 VPB VPWR Y B VGND A sky130_gnd
M$1 VPWR B \$8 VPB sky130_fd_pr__pfet_01v8_hvt L=0.15 W=1 AS=0.3 AD=0.135
+ PS=2.6 PD=1.27
M$2 \$8 A VPWR VPB sky130_fd_pr__pfet_01v8_hvt L=0.15 W=1 AS=0.135 AD=0.365
+ PS=1.27 PD=1.73
M$3 VPWR A \$11 VPB sky130_fd_pr__pfet_01v8_hvt L=0.15 W=1 AS=0.365 AD=0.105
+ PS=1.73 PD=1.21
M$4 \$11 B Y VPB sky130_fd_pr__pfet_01v8_hvt L=0.15 W=1 AS=0.105 AD=0.165
+ PS=1.21 PD=1.33
M$5 Y \$8 VPWR VPB sky130_fd_pr__pfet_01v8_hvt L=0.15 W=1 AS=0.165 AD=0.36
+ PS=1.33 PD=2.72
M$6 VGND B \$3 sky130_gnd sky130_fd_pr__nfet_01v8 L=0.15 W=0.65 AS=0.169
+ AD=0.08775 PS=1.82 PD=0.92
M$7 \$3 \$8 Y sky130_gnd sky130_fd_pr__nfet_01v8 L=0.15 W=0.65 AS=0.08775
+ AD=0.195 PS=0.92 PD=1.9
M$8 \$8 B \$10 sky130_gnd sky130_fd_pr__nfet_01v8 L=0.15 W=0.65 AS=0.169
+ AD=0.06825 PS=1.82 PD=0.86
M$9 \$10 A VGND sky130_gnd sky130_fd_pr__nfet_01v8 L=0.15 W=0.65 AS=0.06825
+ AD=0.08775 PS=0.86 PD=0.92
M$10 VGND A \$3 sky130_gnd sky130_fd_pr__nfet_01v8 L=0.15 W=0.65 AS=0.08775
+ AD=0.169 PS=0.92 PD=1.82
.ENDS sky130_fd_sc_hd__xnor2_1

.SUBCKT sky130_fd_sc_hd__maj3_1 VPB X VGND C B A VPWR sky130_gnd
M$1 \$5 C \$14 VPB sky130_fd_pr__pfet_01v8_hvt L=0.15 W=0.42 AS=0.1092
+ AD=0.0441 PS=1.36 PD=0.63
M$2 \$14 A VPWR VPB sky130_fd_pr__pfet_01v8_hvt L=0.15 W=0.42 AS=0.0441
+ AD=0.0567 PS=0.63 PD=0.69
M$3 VPWR A \$13 VPB sky130_fd_pr__pfet_01v8_hvt L=0.15 W=0.42 AS=0.0567
+ AD=0.0441 PS=0.69 PD=0.63
M$4 \$13 B \$5 VPB sky130_fd_pr__pfet_01v8_hvt L=0.15 W=0.42 AS=0.0441
+ AD=0.0567 PS=0.63 PD=0.69
M$5 \$5 B \$15 VPB sky130_fd_pr__pfet_01v8_hvt L=0.15 W=0.42 AS=0.0567
+ AD=0.0441 PS=0.69 PD=0.63
M$6 VPWR C \$15 VPB sky130_fd_pr__pfet_01v8_hvt L=0.15 W=0.42 AS=0.2492
+ AD=0.0441 PS=1.565 PD=0.63
M$7 VPWR \$5 X VPB sky130_fd_pr__pfet_01v8_hvt L=0.15 W=1 AS=0.2492 AD=0.365
+ PS=1.565 PD=2.73
M$8 \$5 C \$12 sky130_gnd sky130_fd_pr__nfet_01v8 L=0.15 W=0.42 AS=0.1092
+ AD=0.0441 PS=1.36 PD=0.63
M$9 \$12 A VGND sky130_gnd sky130_fd_pr__nfet_01v8 L=0.15 W=0.42 AS=0.0441
+ AD=0.0567 PS=0.63 PD=0.69
M$10 VGND A \$11 sky130_gnd sky130_fd_pr__nfet_01v8 L=0.15 W=0.42 AS=0.0567
+ AD=0.0441 PS=0.69 PD=0.63
M$11 \$11 B \$5 sky130_gnd sky130_fd_pr__nfet_01v8 L=0.15 W=0.42 AS=0.0441
+ AD=0.0567 PS=0.63 PD=0.69
M$12 \$5 B \$10 sky130_gnd sky130_fd_pr__nfet_01v8 L=0.15 W=0.42 AS=0.0567
+ AD=0.0441 PS=0.69 PD=0.63
M$13 \$10 C VGND sky130_gnd sky130_fd_pr__nfet_01v8 L=0.15 W=0.42 AS=0.0441
+ AD=0.1474 PS=0.63 PD=1.215
M$14 VGND \$5 X sky130_gnd sky130_fd_pr__nfet_01v8 L=0.15 W=0.65 AS=0.1474
+ AD=0.23725 PS=1.215 PD=2.03
.ENDS sky130_fd_sc_hd__maj3_1

.SUBCKT sky130_fd_sc_hd__o21ai_0 VPB VPWR Y A1 VGND A2 B1 sky130_gnd
M$1 VPWR A1 \$10 VPB sky130_fd_pr__pfet_01v8_hvt L=0.15 W=0.64 AS=0.1696
+ AD=0.0768 PS=1.81 PD=0.88
M$2 \$10 A2 Y VPB sky130_fd_pr__pfet_01v8_hvt L=0.15 W=0.64 AS=0.0768 AD=0.0896
+ PS=0.88 PD=0.92
M$3 Y B1 VPWR VPB sky130_fd_pr__pfet_01v8_hvt L=0.15 W=0.64 AS=0.0896 AD=0.1824
+ PS=0.92 PD=1.85
M$4 \$5 A1 VGND sky130_gnd sky130_fd_pr__nfet_01v8 L=0.15 W=0.42 AS=0.1113
+ AD=0.0588 PS=1.37 PD=0.7
M$5 VGND A2 \$5 sky130_gnd sky130_fd_pr__nfet_01v8 L=0.15 W=0.42 AS=0.0588
+ AD=0.0588 PS=0.7 PD=0.7
M$6 \$5 B1 Y sky130_gnd sky130_fd_pr__nfet_01v8 L=0.15 W=0.42 AS=0.0588
+ AD=0.1113 PS=0.7 PD=1.37
.ENDS sky130_fd_sc_hd__o21ai_0

.SUBCKT sky130_fd_sc_hd__decap_4 VPB VGND VPWR sky130_gnd
M$1 VPWR VGND VPWR VPB sky130_fd_pr__pfet_01v8_hvt L=1.05 W=0.87 AS=0.2262
+ AD=0.2262 PS=2.26 PD=2.26
M$2 VGND VPWR VGND sky130_gnd sky130_fd_pr__nfet_01v8 L=1.05 W=0.55 AS=0.143
+ AD=0.143 PS=1.62 PD=1.62
.ENDS sky130_fd_sc_hd__decap_4

.SUBCKT sky130_fd_sc_hd__xor2_1 VPB VGND B A VPWR X sky130_gnd
M$1 \$6 \$2 X VPB sky130_fd_pr__pfet_01v8_hvt L=0.15 W=1 AS=0.26 AD=0.3 PS=2.52
+ PD=2.6
M$2 \$2 B \$11 VPB sky130_fd_pr__pfet_01v8_hvt L=0.15 W=1 AS=0.26 AD=0.135
+ PS=2.52 PD=1.27
M$3 \$11 A VPWR VPB sky130_fd_pr__pfet_01v8_hvt L=0.15 W=1 AS=0.135 AD=0.135
+ PS=1.27 PD=1.27
M$4 VPWR A \$6 VPB sky130_fd_pr__pfet_01v8_hvt L=0.15 W=1 AS=0.135 AD=0.135
+ PS=1.27 PD=1.27
M$5 \$6 B VPWR VPB sky130_fd_pr__pfet_01v8_hvt L=0.15 W=1 AS=0.135 AD=0.26
+ PS=1.27 PD=2.52
M$6 VGND B \$2 sky130_gnd sky130_fd_pr__nfet_01v8 L=0.15 W=0.65 AS=0.169
+ AD=0.08775 PS=1.82 PD=0.92
M$7 \$2 A VGND sky130_gnd sky130_fd_pr__nfet_01v8 L=0.15 W=0.65 AS=0.08775
+ AD=0.08775 PS=0.92 PD=0.92
M$8 VGND A \$10 sky130_gnd sky130_fd_pr__nfet_01v8 L=0.15 W=0.65 AS=0.08775
+ AD=0.08775 PS=0.92 PD=0.92
M$9 \$10 B X sky130_gnd sky130_fd_pr__nfet_01v8 L=0.15 W=0.65 AS=0.08775
+ AD=0.25025 PS=0.92 PD=1.42
M$10 X \$2 VGND sky130_gnd sky130_fd_pr__nfet_01v8 L=0.15 W=0.65 AS=0.25025
+ AD=0.208 PS=1.42 PD=1.94
.ENDS sky130_fd_sc_hd__xor2_1

.SUBCKT sky130_fd_sc_hd__decap_6 VPB VPWR VGND sky130_gnd
M$1 VPWR VGND VPWR VPB sky130_fd_pr__pfet_01v8_hvt L=1.97 W=0.87 AS=0.2262
+ AD=0.2262 PS=2.26 PD=2.26
M$2 VGND VPWR VGND sky130_gnd sky130_fd_pr__nfet_01v8 L=1.97 W=0.55 AS=0.143
+ AD=0.143 PS=1.62 PD=1.62
.ENDS sky130_fd_sc_hd__decap_6

.SUBCKT sky130_fd_sc_hd__xnor3_1 VGND X C B A VPWR VPB sky130_gnd
M$1 VPWR C \$8 VPB sky130_fd_pr__pfet_01v8_hvt L=0.15 W=0.64 AS=0.169 AD=0.1792
+ PS=1.365 PD=1.84
M$2 X \$6 VPWR VPB sky130_fd_pr__pfet_01v8_hvt L=0.15 W=1 AS=0.28 AD=0.169
+ PS=2.56 PD=1.365
M$3 VPWR B \$10 VPB sky130_fd_pr__pfet_01v8_hvt L=0.15 W=1 AS=0.25655 AD=0.26
+ PS=2.52 PD=2.52
M$4 \$6 \$8 \$9 VPB sky130_fd_pr__pfet_01v8_hvt L=0.15 W=0.84 AS=0.15295
+ AD=0.32235 PS=1.315 PD=2.45
M$5 \$6 C \$4 VPB sky130_fd_pr__pfet_01v8_hvt L=0.15 W=0.84 AS=0.15295 AD=0.273
+ PS=1.315 PD=2.33
M$6 \$9 \$10 \$11 VPB sky130_fd_pr__pfet_01v8_hvt L=0.15 W=0.64 AS=0.2431
+ AD=0.246 PS=1.445 PD=1.525
M$7 \$11 B \$4 VPB sky130_fd_pr__pfet_01v8_hvt L=0.15 W=0.64 AS=0.246 AD=0.1458
+ PS=1.525 PD=1.205
M$8 \$5 B \$9 VPB sky130_fd_pr__pfet_01v8_hvt L=0.15 W=0.84 AS=0.3528 AD=0.2431
+ PS=2.52 PD=1.445
M$9 \$5 \$10 \$4 VPB sky130_fd_pr__pfet_01v8_hvt L=0.15 W=0.84 AS=0.1715
+ AD=0.1458 PS=1.355 PD=1.205
M$10 \$5 A VPWR VPB sky130_fd_pr__pfet_01v8_hvt L=0.15 W=1 AS=0.1715 AD=0.135
+ PS=1.355 PD=1.27
M$11 VPWR \$5 \$11 VPB sky130_fd_pr__pfet_01v8_hvt L=0.15 W=1 AS=0.135 AD=0.285
+ PS=1.27 PD=2.57
M$12 X \$6 VGND sky130_gnd sky130_fd_pr__nfet_01v8 L=0.15 W=0.65 AS=0.169
+ AD=0.1165 PS=1.82 PD=1.035
M$13 VGND C \$8 sky130_gnd sky130_fd_pr__nfet_01v8 L=0.15 W=0.42 AS=0.1165
+ AD=0.1785 PS=1.035 PD=1.69
M$14 \$9 C \$6 sky130_gnd sky130_fd_pr__nfet_01v8 L=0.15 W=0.64 AS=0.1728
+ AD=0.0928 PS=1.82 PD=0.93
M$15 \$6 \$8 \$4 sky130_gnd sky130_fd_pr__nfet_01v8 L=0.15 W=0.64 AS=0.0928
+ AD=0.224 PS=0.93 PD=1.98
M$16 \$4 \$10 \$11 sky130_gnd sky130_fd_pr__nfet_01v8 L=0.15 W=0.42 AS=0.18205
+ AD=0.19265 PS=1.245 PD=1.285
M$17 \$9 \$10 \$5 sky130_gnd sky130_fd_pr__nfet_01v8 L=0.15 W=0.6 AS=0.140825
+ AD=0.11 PS=1.1 PD=0.99
M$18 \$5 A VGND sky130_gnd sky130_fd_pr__nfet_01v8 L=0.15 W=0.64 AS=0.11
+ AD=0.0864 PS=0.99 PD=0.91
M$19 VGND \$5 \$11 sky130_gnd sky130_fd_pr__nfet_01v8 L=0.15 W=0.64 AS=0.0864
+ AD=0.1824 PS=0.91 PD=1.85
M$20 \$5 B \$4 sky130_gnd sky130_fd_pr__nfet_01v8 L=0.15 W=0.64 AS=0.16275
+ AD=0.18205 PS=1.8 PD=1.245
M$21 \$9 B \$11 sky130_gnd sky130_fd_pr__nfet_01v8 L=0.15 W=0.64 AS=0.140825
+ AD=0.19265 PS=1.1 PD=1.285
M$22 VGND B \$10 sky130_gnd sky130_fd_pr__nfet_01v8 L=0.15 W=0.65 AS=0.1885
+ AD=0.16515 PS=1.88 PD=1.82
.ENDS sky130_fd_sc_hd__xnor3_1

.SUBCKT sky130_fd_sc_hd__xor3_1 VGND X C B A VPWR VPB sky130_gnd
M$1 VPWR B \$10 VPB sky130_fd_pr__pfet_01v8_hvt L=0.15 W=1 AS=0.26 AD=0.2526
+ PS=2.52 PD=2.52
M$2 \$9 \$10 \$11 VPB sky130_fd_pr__pfet_01v8_hvt L=0.15 W=0.64 AS=0.2452
+ AD=0.246 PS=1.45 PD=1.525
M$3 \$11 B \$8 VPB sky130_fd_pr__pfet_01v8_hvt L=0.15 W=0.64 AS=0.246 AD=0.1458
+ PS=1.525 PD=1.205
M$4 \$4 B \$9 VPB sky130_fd_pr__pfet_01v8_hvt L=0.15 W=0.84 AS=0.3536 AD=0.2452
+ PS=2.53 PD=1.45
M$5 \$4 \$10 \$8 VPB sky130_fd_pr__pfet_01v8_hvt L=0.15 W=0.84 AS=0.1715
+ AD=0.1458 PS=1.355 PD=1.205
M$6 \$4 A VPWR VPB sky130_fd_pr__pfet_01v8_hvt L=0.15 W=1 AS=0.1715 AD=0.135
+ PS=1.355 PD=1.27
M$7 VPWR \$4 \$11 VPB sky130_fd_pr__pfet_01v8_hvt L=0.15 W=1 AS=0.135 AD=0.285
+ PS=1.27 PD=2.57
M$8 VPWR C \$7 VPB sky130_fd_pr__pfet_01v8_hvt L=0.15 W=0.64 AS=0.2115
+ AD=0.1792 PS=1.45 PD=1.84
M$9 X \$5 VPWR VPB sky130_fd_pr__pfet_01v8_hvt L=0.15 W=1 AS=0.28 AD=0.2115
+ PS=2.56 PD=1.45
M$10 \$9 C \$5 VPB sky130_fd_pr__pfet_01v8_hvt L=0.15 W=0.84 AS=0.2688
+ AD=0.1596 PS=2.32 PD=1.22
M$11 \$5 \$7 \$8 VPB sky130_fd_pr__pfet_01v8_hvt L=0.15 W=0.84 AS=0.1596
+ AD=0.441 PS=1.22 PD=2.73
M$12 X \$5 VGND sky130_gnd sky130_fd_pr__nfet_01v8 L=0.15 W=0.65 AS=0.169
+ AD=0.144125 PS=1.82 PD=1.12
M$13 VGND C \$7 sky130_gnd sky130_fd_pr__nfet_01v8 L=0.15 W=0.42 AS=0.144125
+ AD=0.1764 PS=1.12 PD=1.68
M$14 \$8 C \$5 sky130_gnd sky130_fd_pr__nfet_01v8 L=0.15 W=0.64 AS=0.1728
+ AD=0.128 PS=1.82 PD=1.04
M$15 \$5 \$7 \$9 sky130_gnd sky130_fd_pr__nfet_01v8 L=0.15 W=0.64 AS=0.128
+ AD=0.3168 PS=1.04 PD=2.27
M$16 \$8 \$10 \$11 sky130_gnd sky130_fd_pr__nfet_01v8 L=0.15 W=0.42 AS=0.18365
+ AD=0.19265 PS=1.25 PD=1.285
M$17 \$9 \$10 \$4 sky130_gnd sky130_fd_pr__nfet_01v8 L=0.15 W=0.6 AS=0.140825
+ AD=0.11 PS=1.1 PD=0.99
M$18 \$4 A VGND sky130_gnd sky130_fd_pr__nfet_01v8 L=0.15 W=0.64 AS=0.11
+ AD=0.0864 PS=0.99 PD=0.91
M$19 VGND \$4 \$11 sky130_gnd sky130_fd_pr__nfet_01v8 L=0.15 W=0.64 AS=0.0864
+ AD=0.1824 PS=0.91 PD=1.85
M$20 \$4 B \$8 sky130_gnd sky130_fd_pr__nfet_01v8 L=0.15 W=0.64 AS=0.1628
+ AD=0.18365 PS=1.8 PD=1.25
M$21 \$9 B \$11 sky130_gnd sky130_fd_pr__nfet_01v8 L=0.15 W=0.64 AS=0.140825
+ AD=0.19265 PS=1.1 PD=1.285
M$22 VGND B \$10 sky130_gnd sky130_fd_pr__nfet_01v8 L=0.15 W=0.65 AS=0.195
+ AD=0.1653 PS=1.9 PD=1.82
.ENDS sky130_fd_sc_hd__xor3_1

.SUBCKT sky130_fd_sc_hd__decap_12 VPB VPWR VGND sky130_gnd
M$1 VPWR VGND VPWR VPB sky130_fd_pr__pfet_01v8_hvt L=4.73 W=0.87 AS=0.2262
+ AD=0.2262 PS=2.26 PD=2.26
M$2 VGND VPWR VGND sky130_gnd sky130_fd_pr__nfet_01v8 L=4.73 W=0.55 AS=0.143
+ AD=0.143 PS=1.62 PD=1.62
.ENDS sky130_fd_sc_hd__decap_12

.SUBCKT sky130_fd_sc_hd__decap_3 VPB VGND VPWR sky130_gnd
M$1 VPWR VGND VPWR VPB sky130_fd_pr__pfet_01v8_hvt L=0.59 W=0.87 AS=0.2262
+ AD=0.2262 PS=2.26 PD=2.26
M$2 VGND VPWR VGND sky130_gnd sky130_fd_pr__nfet_01v8 L=0.59 W=0.55 AS=0.143
+ AD=0.143 PS=1.62 PD=1.62
.ENDS sky130_fd_sc_hd__decap_3
