* Extracted by KLayout with SKY130 LVS runset on : 31/10/2026 17:43

.SUBCKT PLL_COUNTER_DCO_PHYS MID_MUX[14] MID_MUX[13] MID_MUX[12] MID_MUX[11]
+ MID_MUX[10] MID_MUX[9] MID_MUX[7] MID_MUX[8] MID_MUX[6] MID_MUX[5] MID_MUX[4]
+ MID_MUX[3] MID_MUX[2] MID_MUX[1] COARSE_MUX[14] COARSE_MUX[11] COARSE_MUX[10]
+ COARSE_MUX[12] COARSE_MUX[8] COARSE_MUX[7] COARSE_MUX[13] COARSE_MUX[9]
+ MID_MUX[0] VPWR FINE_MUX[2] COARSE_MUX[6] FINE_MUX[0] COARSE_MUX[5]
+ FINE_MUX[1] COARSE_MUX[4] COARSE_MUX[1] COARSE_MUX[3] COARSE_MUX[2]
+ COARSE_MUX[0] FINE_MUX[4] FINE_MUX[3] FINE_MUX[5] FINE_MUX[6] FINE_MUX[8]
+ FINE_MUX[7] REF FINE_MUX[9] INJ_EDGE SS_BBPD[1] OUT SS_BBPD[0] MID_OUT
+ FINE_MUX[10] DCO_EN TICK FINE_MUX[11] FINE_MUX[12] FINE_MUX[13] FINE_MUX[14]
+ FINE_MUX[21] FINE_MUX[15] FINE_MUX[16] FINE_MUX[17] FINE_MUX[18] FINE_MUX[19]
+ FINE_MUX[20] FINE_MUX[22] FINE_MUX[23] FINE_MUX[24] FINE_MUX[25] FINE_MUX[26]
+ FINE_MUX[27] FINE_MUX[28] FINE_MUX[29] FINE_MUX[30] VGND
X$3 VPWR MID_MUX[14] VGND \$71 VPWR VGND sky130_fd_sc_hd__clkdlybuf4s50_1
X$6 VPWR MID_MUX[13] VGND \$632 VPWR VGND sky130_fd_sc_hd__clkdlybuf4s50_1
X$9 VPWR MID_MUX[12] VGND \$288 VPWR VGND sky130_fd_sc_hd__clkdlybuf4s50_1
X$12 VPWR MID_MUX[11] VGND \$207 VPWR VGND sky130_fd_sc_hd__clkdlybuf4s50_1
X$15 VPWR MID_MUX[10] VGND \$98 VPWR VGND sky130_fd_sc_hd__clkdlybuf4s50_1
X$18 VPWR MID_MUX[9] VGND \$83 VPWR VGND sky130_fd_sc_hd__clkdlybuf4s50_1
X$21 VPWR MID_MUX[7] VGND \$103 VPWR VGND sky130_fd_sc_hd__clkdlybuf4s50_1
X$24 VPWR MID_MUX[8] VGND \$105 VPWR VGND sky130_fd_sc_hd__clkdlybuf4s50_1
X$27 VPWR MID_MUX[6] VGND \$89 VPWR VGND sky130_fd_sc_hd__clkdlybuf4s50_1
X$30 VPWR MID_MUX[5] VGND \$108 VPWR VGND sky130_fd_sc_hd__clkdlybuf4s50_1
X$33 VPWR MID_MUX[4] VGND \$84 VPWR VGND sky130_fd_sc_hd__clkdlybuf4s50_1
X$36 VPWR MID_MUX[3] VGND \$77 VPWR VGND sky130_fd_sc_hd__clkdlybuf4s50_1
X$39 VPWR MID_MUX[2] VGND \$116 VPWR VGND sky130_fd_sc_hd__clkdlybuf4s50_1
X$42 VPWR MID_MUX[1] VGND \$51 VPWR VGND sky130_fd_sc_hd__clkdlybuf4s50_1
X$45 VPWR COARSE_MUX[14] VGND \$53 VPWR VGND sky130_fd_sc_hd__clkdlybuf4s50_1
X$48 VPWR COARSE_MUX[11] VGND \$125 VPWR VGND sky130_fd_sc_hd__clkdlybuf4s50_1
X$51 VPWR COARSE_MUX[10] VGND \$59 VPWR VGND sky130_fd_sc_hd__clkdlybuf4s50_1
X$54 VPWR COARSE_MUX[12] VGND \$64 VPWR VGND sky130_fd_sc_hd__clkdlybuf4s50_1
X$56 VPWR COARSE_MUX[8] VGND \$188 VPWR VGND sky130_fd_sc_hd__clkdlybuf4s50_1
X$60 VPWR COARSE_MUX[7] VGND \$264 VPWR VGND sky130_fd_sc_hd__clkdlybuf4s50_1
X$63 VPWR COARSE_MUX[13] VGND \$66 VPWR VGND sky130_fd_sc_hd__clkdlybuf4s50_1
X$66 VPWR COARSE_MUX[9] VGND \$62 VPWR VGND sky130_fd_sc_hd__clkdlybuf4s50_1
X$71 VPWR MID_MUX[0] VGND \$118 VPWR VGND sky130_fd_sc_hd__clkdlybuf4s50_1
X$72 VGND \$1564 \$1441 \$1260 \$1328 VPWR VPWR VGND sky130_fd_sc_hd__xor3_1
X$74 VPWR \$1565 VGND \$1328 \$1260 \$1441 VPWR VGND sky130_fd_sc_hd__or3_1
X$75 VPWR VPWR VGND VGND sky130_fd_sc_hd__decap_8
X$76 VPWR VGND VPWR VGND sky130_fd_sc_hd__decap_3
X$77 VPWR \$1573 VPWR VGND \$1441 \$1260 \$1328 VGND sky130_fd_sc_hd__nand3_1
X$78 VPWR VGND VPWR VGND sky130_fd_sc_hd__decap_3
X$80 VPWR \$1572 VGND \$1441 \$1260 \$1328 VPWR VGND sky130_fd_sc_hd__maj3_1
X$81 VPWR VPWR VGND VGND sky130_fd_sc_hd__decap_8
X$83 VPWR VPWR \$1589 \$1545 VGND \$1485 VGND sky130_fd_sc_hd__xnor2_1
X$84 VPWR VGND \$1592 \$1485 \$1545 VPWR VGND
+ sky130_fd_sc_hd__lpflow_isobufsrc_1
X$85 VPWR VPWR VGND VGND sky130_fd_sc_hd__decap_12
X$86 VPWR VPWR VGND VGND sky130_fd_sc_hd__decap_12
X$87 VPWR VGND VPWR VGND sky130_fd_sc_hd__decap_4
X$89 VPWR \$1602 VPWR VGND \$1446 \$1504 VGND sky130_fd_sc_hd__nand2_1
X$90 VPWR VPWR VGND VGND sky130_fd_sc_hd__decap_12
X$91 VPWR VPWR VGND VGND sky130_fd_sc_hd__decap_8
X$92 VPWR VGND VPWR VGND sky130_fd_sc_hd__decap_3
X$94 VPWR VPWR VGND VGND sky130_fd_sc_hd__decap_8
X$96 VPWR \$1607 VPWR VGND \$1548 \$1452 VGND sky130_fd_sc_hd__nand2_1
X$97 VPWR VPWR VGND VGND sky130_fd_sc_hd__decap_12
X$99 VPWR \$1611 VPWR VGND \$1550 \$1551 VGND sky130_fd_sc_hd__nand2_1
X$101 VPWR VGND \$1535 \$1552 \$1551 VPWR VGND sky130_fd_sc_hd__xor2_1
X$102 VPWR VPWR \$1552 \$1534 VGND \$1597 VGND sky130_fd_sc_hd__xnor2_1
X$103 VPWR VGND \$1604 \$1534 \$1597 VPWR VGND
+ sky130_fd_sc_hd__lpflow_isobufsrc_1
X$104 VPWR VPWR VGND VGND sky130_fd_sc_hd__decap_12
X$105 VPWR VPWR VGND VGND sky130_fd_sc_hd__decap_12
X$106 VPWR VPWR VGND VGND sky130_fd_sc_hd__decap_8
X$107 VPWR VGND VPWR VGND sky130_fd_sc_hd__decap_3
X$109 VPWR VPWR VGND VGND sky130_fd_sc_hd__decap_12
X$110 VPWR VPWR VGND VGND sky130_fd_sc_hd__decap_12
X$111 VPWR VPWR VGND VGND sky130_fd_sc_hd__decap_12
X$112 VPWR VPWR VGND VGND sky130_fd_sc_hd__decap_12
X$113 VPWR VPWR VGND VGND sky130_fd_sc_hd__decap_12
X$114 VPWR VPWR VGND VGND sky130_fd_sc_hd__decap_12
X$115 VPWR VPWR VGND VGND sky130_fd_sc_hd__decap_12
X$118 VPWR VPWR VGND VGND sky130_fd_sc_hd__decap_12
X$119 VPWR VPWR VGND VGND sky130_fd_sc_hd__decap_12
X$120 VPWR VPWR VGND VGND sky130_fd_sc_hd__decap_12
X$121 VPWR VPWR VGND VGND sky130_fd_sc_hd__decap_12
X$122 VPWR VPWR VGND VGND sky130_fd_sc_hd__decap_12
X$123 VPWR VPWR VGND VGND sky130_fd_sc_hd__decap_12
X$124 VPWR VPWR VGND VGND sky130_fd_sc_hd__decap_6
X$125 VPWR VGND \$1585 \$1641 \$1559 VPWR VGND sky130_fd_sc_hd__xor2_1
X$127 VPWR \$1461 VGND \$1559 \$1463 \$1637 VPWR VGND sky130_fd_sc_hd__maj3_1
X$128 VPWR VGND VPWR VGND sky130_fd_sc_hd__decap_4
X$132 VPWR FINE_MUX[1] VGND \$1328 VPWR VGND sky130_fd_sc_hd__clkdlybuf4s50_1
X$133 VPWR VPWR VGND VGND sky130_fd_sc_hd__decap_6
X$136 VPWR \$1649 VPWR VGND \$1565 \$1573 VGND sky130_fd_sc_hd__nand2_1
X$137 VPWR \$1793 VPWR \$1565 \$1573 VGND VGND sky130_fd_sc_hd__and2_0
X$138 VPWR VGND \$1437 \$1573 \$1651 VPWR VGND sky130_fd_sc_hd__xor2_1
X$139 VPWR VPWR VGND VGND sky130_fd_sc_hd__decap_12
X$140 VPWR \$1654 VGND \$1437 VPWR \$1573 VGND sky130_fd_sc_hd__nor2_1
X$141 VPWR VPWR VGND VGND sky130_fd_sc_hd__decap_8
X$143 VPWR \$1667 \$1661 VPWR VGND \$1437 \$1841 \$1576 VGND
+ sky130_fd_sc_hd__o31ai_1
X$144 VPWR VPWR VGND VGND sky130_fd_sc_hd__decap_12
X$145 VPWR VPWR VGND VGND sky130_fd_sc_hd__decap_8
X$146 VPWR VPWR VGND \$1672 \$1621 VGND sky130_fd_sc_hd__clkinv_1
X$147 VPWR VGND VPWR VGND sky130_fd_sc_hd__decap_3
X$149 VPWR VPWR VGND VGND sky130_fd_sc_hd__decap_6
X$150 VPWR \$1680 \$1446 VPWR \$1601 VGND \$1696 \$1504 VGND
+ sky130_fd_sc_hd__o2bb2a_1
X$152 VPWR VPWR VGND VGND sky130_fd_sc_hd__decap_8
X$154 VPWR \$1626 VGND \$1625 VPWR \$1602 VGND sky130_fd_sc_hd__nor2_1
X$155 VPWR \$1627 \$1700 VGND \$1625 \$1602 VPWR VGND sky130_fd_sc_hd__nor3_1
X$156 VPWR VPWR \$1627 \$1514 VGND \$1548 VGND sky130_fd_sc_hd__xnor2_1
X$157 VPWR VGND \$1514 VPWR \$1626 \$1674 \$1548 VGND sky130_fd_sc_hd__a21oi_1
X$158 VPWR VPWR VGND VGND sky130_fd_sc_hd__decap_12
X$161 VPWR \$1757 VPWR VGND \$1607 \$1668 VGND sky130_fd_sc_hd__nand2_1
X$162 VPWR VPWR VGND VGND sky130_fd_sc_hd__decap_6
X$164 VPWR VPWR \$1668 \$1551 VGND \$1550 VGND sky130_fd_sc_hd__xnor2_1
X$165 VPWR \$1666 VPWR VGND \$1611 \$1664 VGND sky130_fd_sc_hd__nand2_1
X$166 VPWR VPWR VGND VGND sky130_fd_sc_hd__decap_8
X$169 VPWR VPWR VGND VGND sky130_fd_sc_hd__decap_12
X$171 VPWR VPWR VGND VGND sky130_fd_sc_hd__decap_12
X$172 VPWR VPWR VGND VGND sky130_fd_sc_hd__decap_12
X$173 VPWR VPWR VGND VGND sky130_fd_sc_hd__decap_12
X$174 VPWR VPWR VGND VGND sky130_fd_sc_hd__decap_12
X$176 VPWR VPWR VGND VGND sky130_fd_sc_hd__decap_12
X$177 VPWR VPWR VGND VGND sky130_fd_sc_hd__decap_12
X$180 VPWR VPWR VGND VGND sky130_fd_sc_hd__decap_12
X$181 VPWR VPWR VGND VGND sky130_fd_sc_hd__decap_12
X$183 VPWR VPWR VGND VGND sky130_fd_sc_hd__decap_12
X$184 VPWR VPWR VGND VGND sky130_fd_sc_hd__decap_12
X$185 VPWR VPWR VGND VGND sky130_fd_sc_hd__decap_12
X$187 VPWR VPWR VGND VGND sky130_fd_sc_hd__decap_12
X$188 VPWR VPWR VGND VGND sky130_fd_sc_hd__decap_12
X$191 VPWR VPWR VGND VGND sky130_fd_sc_hd__decap_12
X$192 VPWR VPWR VGND VGND sky130_fd_sc_hd__decap_12
X$194 VPWR VPWR VGND VGND sky130_fd_sc_hd__decap_6
X$195 VGND \$1460 \$1585 \$1637 \$1641 VPWR VPWR VGND sky130_fd_sc_hd__xnor3_1
X$196 VPWR COARSE_MUX[3] VGND \$1641 VPWR VGND sky130_fd_sc_hd__clkdlybuf4s50_1
X$216 VPWR VPWR VGND VGND sky130_fd_sc_hd__decap_8
X$218 VPWR \$2103 VPWR VGND \$1981 \$1950 VGND sky130_fd_sc_hd__nand2_1
X$219 VPWR \$1984 VPWR VGND \$1794 \$1950 \$1981 VGND sky130_fd_sc_hd__nand3_1
X$220 VPWR VPWR VGND VGND sky130_fd_sc_hd__decap_12
X$222 VPWR \$1986 VGND \$2025 VPWR \$1985 VGND sky130_fd_sc_hd__nor2_1
X$223 VPWR \$2107 VGND \$1926 VPWR \$1984 VGND sky130_fd_sc_hd__nor2_1
X$225 VPWR \$1988 VPWR VGND \$1965 \$1986 VGND sky130_fd_sc_hd__nand2_1
X$226 VPWR \$2035 VPWR VGND \$1981 \$1988 VGND sky130_fd_sc_hd__nand2_1
X$228 VPWR VPWR VGND VGND sky130_fd_sc_hd__decap_12
X$229 VPWR VPWR VGND VGND sky130_fd_sc_hd__decap_8
X$230 VPWR \$1992 VGND \$2071 \$2035 \$1991 VPWR VGND sky130_fd_sc_hd__or3_1
X$231 VPWR VPWR VGND VGND sky130_fd_sc_hd__decap_6
X$233 VPWR \$2077 VGND \$1810 VPWR \$1992 VGND sky130_fd_sc_hd__nor2_1
X$234 VPWR VPWR \$2076 \$2046 VGND \$1992 VGND sky130_fd_sc_hd__xnor2_1
X$236 VPWR VGND \$1896 \$1996 \$2182 VPWR VGND sky130_fd_sc_hd__xor2_1
X$237 VPWR \$2002 VPWR \$2077 \$1896 VGND VGND sky130_fd_sc_hd__and2_0
X$238 VPWR VPWR VGND VGND sky130_fd_sc_hd__decap_6
X$239 VPWR \$2082 VPWR \$1905 \$2002 VGND VGND sky130_fd_sc_hd__and2_0
X$240 VPWR VPWR VGND VGND sky130_fd_sc_hd__decap_12
X$241 VPWR VPWR VGND VGND sky130_fd_sc_hd__decap_6
X$244 VPWR \$2089 \$1817 VPWR VGND \$1969 VGND sky130_fd_sc_hd__nand2b_1
X$245 VPWR VPWR \$2089 \$2111 \$1747 \$2174 \$2112 \$2115 VGND VGND
+ sky130_fd_sc_hd__o2111ai_1
X$246 VPWR VGND \$2112 \$1969 \$1817 VPWR VGND
+ sky130_fd_sc_hd__lpflow_isobufsrc_1
X$247 VPWR VPWR VGND VGND sky130_fd_sc_hd__decap_12
X$248 VPWR VPWR VGND VGND sky130_fd_sc_hd__decap_12
X$249 VPWR VPWR VGND VGND sky130_fd_sc_hd__decap_12
X$250 VPWR VPWR VGND VGND sky130_fd_sc_hd__decap_12
X$251 VPWR VPWR VGND VGND sky130_fd_sc_hd__decap_12
X$252 VPWR VPWR VGND VGND sky130_fd_sc_hd__decap_6
X$255 VPWR VPWR VGND VGND sky130_fd_sc_hd__decap_12
X$256 VPWR VPWR VGND VGND sky130_fd_sc_hd__decap_12
X$257 VPWR VPWR VGND VGND sky130_fd_sc_hd__decap_12
X$258 VPWR VPWR VGND VGND sky130_fd_sc_hd__decap_12
X$259 VPWR VPWR VGND VGND sky130_fd_sc_hd__decap_12
X$260 VPWR VPWR VGND VGND sky130_fd_sc_hd__decap_12
X$261 VPWR VPWR VGND VGND sky130_fd_sc_hd__decap_12
X$264 VPWR VPWR VGND VGND sky130_fd_sc_hd__decap_12
X$265 VPWR VPWR VGND VGND sky130_fd_sc_hd__decap_12
X$266 VPWR VPWR VGND VGND sky130_fd_sc_hd__decap_12
X$267 VPWR VPWR VGND VGND sky130_fd_sc_hd__decap_12
X$268 VPWR VPWR VGND VGND sky130_fd_sc_hd__decap_12
X$269 VPWR VPWR VGND VGND sky130_fd_sc_hd__decap_12
X$270 VPWR VPWR VGND VGND sky130_fd_sc_hd__decap_12
X$273 VPWR VPWR VGND VGND sky130_fd_sc_hd__decap_12
X$277 VPWR FINE_MUX[5] VGND \$1981 VPWR VGND sky130_fd_sc_hd__clkdlybuf4s50_1
X$278 VPWR VPWR \$2130 \$1950 VGND \$1981 VGND sky130_fd_sc_hd__xnor2_1
X$280 VPWR VPWR VGND VGND sky130_fd_sc_hd__decap_12
X$281 VPWR VPWR VGND VGND sky130_fd_sc_hd__decap_6
X$282 VPWR VPWR \$2136 \$1965 VGND \$2107 VGND sky130_fd_sc_hd__xnor2_1
X$283 VPWR VPWR VGND VGND sky130_fd_sc_hd__decap_12
X$286 VPWR \$2244 VPWR \$2071 \$2035 VGND VGND sky130_fd_sc_hd__and2_0
X$287 VPWR \$2140 VGND \$2035 VPWR \$2071 VGND sky130_fd_sc_hd__nor2_1
X$288 VPWR VPWR VGND VGND sky130_fd_sc_hd__decap_12
X$289 VPWR VPWR VGND VGND sky130_fd_sc_hd__decap_8
X$290 VPWR VPWR VGND \$2079 \$2049 VGND sky130_fd_sc_hd__clkinv_1
X$292 VPWR VGND \$2076 VPWR \$2079 \$2143 \$2077 VGND sky130_fd_sc_hd__a21oi_1
X$293 VPWR \$2085 VPWR VGND \$1896 \$2076 \$2079 VGND sky130_fd_sc_hd__nand3_1
X$294 VPWR VPWR VGND VGND sky130_fd_sc_hd__decap_12
X$296 VPWR VGND VPWR VGND sky130_fd_sc_hd__decap_4
X$297 VPWR \$2085 \$2087 \$2059 VGND \$1973 \$2082 VPWR VGND
+ sky130_fd_sc_hd__or4_1
X$299 VPWR VPWR VGND \$2086 \$2082 VGND sky130_fd_sc_hd__clkinv_1
X$300 VPWR VGND VPWR VGND sky130_fd_sc_hd__decap_3
X$301 VPWR \$2115 VGND \$2088 \$2087 \$2086 VPWR VGND sky130_fd_sc_hd__maj3_1
X$302 VPWR VGND VPWR VGND sky130_fd_sc_hd__decap_4
X$304 VPWR VPWR \$2172 \$2115 VGND \$2054 VGND sky130_fd_sc_hd__xnor2_1
X$306 VPWR VPWR VGND VGND sky130_fd_sc_hd__decap_12
X$307 VPWR VPWR VGND VGND sky130_fd_sc_hd__decap_12
X$308 VPWR VGND VPWR VGND sky130_fd_sc_hd__decap_4
X$310 VPWR VPWR VGND VGND sky130_fd_sc_hd__decap_12
X$312 VPWR VPWR VGND VGND sky130_fd_sc_hd__decap_12
X$313 VPWR VPWR VGND VGND sky130_fd_sc_hd__decap_12
X$314 VPWR VPWR VGND VGND sky130_fd_sc_hd__decap_12
X$315 VPWR VPWR VGND VGND sky130_fd_sc_hd__decap_12
X$317 VPWR VPWR VGND VGND sky130_fd_sc_hd__decap_12
X$318 VPWR VPWR VGND VGND sky130_fd_sc_hd__decap_12
X$321 VPWR VPWR VGND VGND sky130_fd_sc_hd__decap_12
X$322 VPWR VPWR VGND VGND sky130_fd_sc_hd__decap_12
X$324 VPWR VPWR VGND VGND sky130_fd_sc_hd__decap_12
X$325 VPWR VPWR VGND VGND sky130_fd_sc_hd__decap_12
X$326 VPWR VPWR VGND VGND sky130_fd_sc_hd__decap_12
X$328 VPWR VPWR VGND VGND sky130_fd_sc_hd__decap_12
X$329 VPWR VPWR VGND VGND sky130_fd_sc_hd__decap_12
X$332 VPWR VPWR VGND VGND sky130_fd_sc_hd__decap_12
X$333 VPWR VPWR VGND VGND sky130_fd_sc_hd__decap_12
X$335 VPWR VPWR VGND VGND sky130_fd_sc_hd__decap_12
X$336 VPWR VPWR VGND VGND sky130_fd_sc_hd__decap_12
X$337 VPWR VPWR VGND VGND sky130_fd_sc_hd__decap_8
X$357 VPWR VPWR VGND VGND sky130_fd_sc_hd__decap_8
X$359 VPWR FINE_MUX[15] VGND \$3861 VPWR VGND sky130_fd_sc_hd__clkdlybuf4s50_1
X$360 VPWR VPWR VGND VGND sky130_fd_sc_hd__decap_12
X$361 VPWR VPWR VGND VGND sky130_fd_sc_hd__decap_12
X$364 VPWR VPWR VGND VGND sky130_fd_sc_hd__decap_12
X$365 VPWR VPWR VGND VGND sky130_fd_sc_hd__decap_12
X$366 VPWR VPWR VGND VGND sky130_fd_sc_hd__decap_12
X$367 VPWR VPWR VGND VGND sky130_fd_sc_hd__decap_6
X$369 VPWR VPWR VGND VGND sky130_fd_sc_hd__decap_12
X$370 VPWR VPWR VGND VGND sky130_fd_sc_hd__decap_12
X$371 VPWR FINE_MUX[16] VGND \$4127 VPWR VGND sky130_fd_sc_hd__clkdlybuf4s50_1
X$372 VPWR VPWR VGND VGND sky130_fd_sc_hd__decap_8
X$375 VPWR FINE_MUX[17] VGND \$4109 VPWR VGND sky130_fd_sc_hd__clkdlybuf4s50_1
X$376 VPWR VPWR VGND VGND sky130_fd_sc_hd__decap_12
X$377 VPWR VGND VPWR VGND sky130_fd_sc_hd__decap_4
X$379 VPWR FINE_MUX[18] VGND \$4268 VPWR VGND sky130_fd_sc_hd__clkdlybuf4s50_1
X$381 VPWR FINE_MUX[19] VGND \$4414 VPWR VGND sky130_fd_sc_hd__clkdlybuf4s50_1
X$383 VPWR VPWR VGND VGND sky130_fd_sc_hd__decap_6
X$384 VPWR FINE_MUX[20] VGND \$4896 VPWR VGND sky130_fd_sc_hd__clkdlybuf4s50_1
X$385 VPWR VPWR VGND VGND sky130_fd_sc_hd__decap_12
X$387 VPWR VPWR VGND \$4652 \$4666 VGND sky130_fd_sc_hd__clkinv_1
X$389 VPWR FINE_MUX[22] VGND \$4666 VPWR VGND sky130_fd_sc_hd__clkdlybuf4s50_1
X$392 VPWR VPWR VGND VGND sky130_fd_sc_hd__decap_12
X$393 VPWR VGND VPWR VGND sky130_fd_sc_hd__decap_3
X$394 VPWR FINE_MUX[23] VGND \$4318 VPWR VGND sky130_fd_sc_hd__clkdlybuf4s50_1
X$396 VPWR FINE_MUX[24] VGND \$4322 VPWR VGND sky130_fd_sc_hd__clkdlybuf4s50_1
X$397 VPWR VPWR VGND VGND sky130_fd_sc_hd__decap_6
X$398 VPWR \$4677 VPWR VGND \$4786 \$4759 VGND sky130_fd_sc_hd__nand2_1
X$400 VPWR FINE_MUX[25] VGND \$4221 VPWR VGND sky130_fd_sc_hd__clkdlybuf4s50_1
X$402 VPWR FINE_MUX[26] VGND \$4423 VPWR VGND sky130_fd_sc_hd__clkdlybuf4s50_1
X$403 VPWR VGND VPWR VGND sky130_fd_sc_hd__decap_4
X$404 VPWR FINE_MUX[27] VGND \$4510 VPWR VGND sky130_fd_sc_hd__clkdlybuf4s50_1
X$405 VPWR VGND VPWR VGND sky130_fd_sc_hd__decap_4
X$406 VPWR FINE_MUX[28] VGND \$4679 VPWR VGND sky130_fd_sc_hd__clkdlybuf4s50_1
X$408 VPWR VPWR VGND VGND sky130_fd_sc_hd__decap_6
X$410 VPWR FINE_MUX[29] VGND \$4687 VPWR VGND sky130_fd_sc_hd__clkdlybuf4s50_1
X$411 VPWR VPWR VGND VGND sky130_fd_sc_hd__decap_8
X$412 VPWR FINE_MUX[30] VGND \$4522 VPWR VGND sky130_fd_sc_hd__clkdlybuf4s50_1
X$413 VPWR VPWR VGND VGND sky130_fd_sc_hd__decap_8
X$414 VPWR VGND VPWR VGND sky130_fd_sc_hd__decap_3
X$416 VPWR VPWR VGND VGND sky130_fd_sc_hd__decap_12
X$417 VPWR VPWR VGND VGND sky130_fd_sc_hd__decap_12
X$418 VPWR VPWR VGND VGND sky130_fd_sc_hd__decap_12
X$419 VPWR VPWR VGND VGND sky130_fd_sc_hd__decap_6
X$421 VPWR VPWR VGND VGND sky130_fd_sc_hd__decap_12
X$451 VPWR FINE_MUX[10] VGND \$2728 VPWR VGND sky130_fd_sc_hd__clkdlybuf4s50_1
X$454 VPWR VGND \$2692 \$2728 \$2864 VPWR VGND sky130_fd_sc_hd__xor2_1
X$455 VPWR VPWR VGND VGND sky130_fd_sc_hd__decap_12
X$456 VPWR VPWR VGND VGND sky130_fd_sc_hd__decap_6
X$457 VPWR VPWR VGND \$2622 \$2697 VGND sky130_fd_sc_hd__clkinv_1
X$458 VPWR \$2767 VPWR VGND \$2697 \$2549 VGND sky130_fd_sc_hd__nand2_1
X$461 VPWR VPWR VGND VGND sky130_fd_sc_hd__decap_12
X$462 VPWR VPWR VGND VGND sky130_fd_sc_hd__decap_12
X$464 VPWR \$2772 VPWR VGND \$2771 \$2676 VGND sky130_fd_sc_hd__nand2_1
X$466 VPWR \$2774 VGND \$2773 VPWR \$2772 VGND sky130_fd_sc_hd__nor2_1
X$467 VPWR VGND \$2773 \$2810 \$2836 VPWR VGND sky130_fd_sc_hd__xor2_1
X$468 VPWR VPWR VGND VGND sky130_fd_sc_hd__decap_12
X$469 VPWR VGND VPWR VGND sky130_fd_sc_hd__decap_4
X$471 VPWR \$2821 VGND \$2774 VPWR \$2537 VGND sky130_fd_sc_hd__nor2_1
X$472 VPWR VPWR VGND VGND sky130_fd_sc_hd__decap_12
X$473 VPWR VPWR VGND VGND sky130_fd_sc_hd__decap_12
X$476 VPWR VPWR VGND VGND sky130_fd_sc_hd__decap_12
X$477 VPWR VPWR VGND VGND sky130_fd_sc_hd__decap_12
X$478 VPWR VPWR VGND VGND sky130_fd_sc_hd__decap_12
X$479 VPWR VPWR VGND VGND sky130_fd_sc_hd__decap_12
X$480 VPWR VPWR VGND VGND sky130_fd_sc_hd__decap_12
X$481 VPWR VPWR VGND VGND sky130_fd_sc_hd__decap_12
X$482 VPWR VPWR VGND VGND sky130_fd_sc_hd__decap_12
X$485 VPWR VPWR VGND VGND sky130_fd_sc_hd__decap_12
X$486 VPWR VPWR VGND VGND sky130_fd_sc_hd__decap_12
X$487 VPWR VPWR VGND VGND sky130_fd_sc_hd__decap_12
X$488 VPWR VPWR VGND VGND sky130_fd_sc_hd__decap_12
X$489 VPWR VPWR VGND VGND sky130_fd_sc_hd__decap_12
X$490 VPWR VPWR VGND VGND sky130_fd_sc_hd__decap_12
X$491 VPWR VPWR VGND VGND sky130_fd_sc_hd__decap_12
X$494 VPWR VGND VPWR VGND sky130_fd_sc_hd__decap_3
X$495 VGND \$2782 \$2887 TICK \$2892 VPWR VPWR VGND sky130_fd_sc_hd__dfrtp_1
X$496 VPWR VPWR VGND VGND sky130_fd_sc_hd__decap_8
X$497 VPWR VGND VPWR VGND sky130_fd_sc_hd__decap_3
X$498 VGND \$2782 \$2875 TICK \$2883 VPWR VPWR VGND sky130_fd_sc_hd__dfrtp_1
X$499 VPWR VPWR VGND VGND sky130_fd_sc_hd__decap_6
X$500 VPWR VGND \$2867 \$2815 \$2786 VPWR VGND sky130_fd_sc_hd__nor2b_1
X$501 VPWR VGND VPWR VGND sky130_fd_sc_hd__decap_4
X$502 VPWR VPWR VGND \$2809 \$2814 VGND sky130_fd_sc_hd__clkinv_1
X$503 VPWR VPWR VGND VGND sky130_fd_sc_hd__decap_6
X$504 VPWR VGND \$2786 \$2715 \$2806 VPWR VGND sky130_fd_sc_hd__xor2_1
X$506 VPWR VGND VPWR VGND sky130_fd_sc_hd__decap_4
X$508 VPWR \$2715 VGND MID_OUT VPWR VGND sky130_fd_sc_hd__clkdlybuf4s50_1
X$511 VPWR VPWR VGND VGND sky130_fd_sc_hd__decap_12
X$513 VPWR VPWR VGND VGND sky130_fd_sc_hd__decap_12
X$514 VPWR VPWR VGND VGND sky130_fd_sc_hd__decap_12
X$515 VPWR VPWR VGND VGND sky130_fd_sc_hd__decap_12
X$516 VPWR VPWR VGND VGND sky130_fd_sc_hd__decap_8
X$518 VPWR VGND \$2771 \$2835 \$2911 VPWR VGND sky130_fd_sc_hd__nor2b_1
X$519 VPWR VGND VPWR VGND sky130_fd_sc_hd__decap_3
X$520 VPWR VPWR \$2879 \$2676 VGND \$2771 VGND sky130_fd_sc_hd__xnor2_1
X$521 VPWR VPWR VGND VGND sky130_fd_sc_hd__decap_8
X$522 VPWR VGND VPWR VGND sky130_fd_sc_hd__decap_3
X$523 VPWR \$2706 VGND \$2836 VPWR \$2912 VGND sky130_fd_sc_hd__nor2_1
X$525 VPWR VGND VPWR VGND sky130_fd_sc_hd__decap_4
X$526 VGND \$3005 \$2774 \$2537 \$2706 VPWR VPWR VGND sky130_fd_sc_hd__xnor3_1
X$528 VPWR \$2687 VPWR VGND \$3049 \$2759 VGND sky130_fd_sc_hd__nand2_1
X$529 VPWR VPWR VGND VGND sky130_fd_sc_hd__decap_12
X$530 VPWR VPWR VGND VGND sky130_fd_sc_hd__decap_8
X$532 VPWR VGND \$2827 \$2896 \$2919 VPWR VGND sky130_fd_sc_hd__xor2_1
X$534 VPWR VPWR VGND VGND sky130_fd_sc_hd__decap_12
X$535 VPWR VPWR VGND VGND sky130_fd_sc_hd__decap_12
X$536 VPWR VPWR VGND VGND sky130_fd_sc_hd__decap_6
X$539 VPWR VPWR VGND VGND sky130_fd_sc_hd__decap_12
X$541 VPWR VPWR VGND VGND sky130_fd_sc_hd__decap_12
X$542 VPWR VPWR VGND VGND sky130_fd_sc_hd__decap_12
X$543 VPWR VPWR VGND VGND sky130_fd_sc_hd__decap_12
X$544 VPWR VPWR VGND VGND sky130_fd_sc_hd__decap_12
X$546 VPWR VPWR VGND VGND sky130_fd_sc_hd__decap_12
X$547 VPWR VPWR VGND VGND sky130_fd_sc_hd__decap_12
X$550 VPWR VPWR VGND VGND sky130_fd_sc_hd__decap_12
X$551 VPWR VPWR VGND VGND sky130_fd_sc_hd__decap_12
X$553 VPWR VPWR VGND VGND sky130_fd_sc_hd__decap_6
X$555 VGND \$2782 \$2927 TICK \$2972 VPWR VPWR VGND sky130_fd_sc_hd__dfrtp_1
X$556 VPWR VPWR \$2892 \$2969 VGND \$2887 VGND sky130_fd_sc_hd__xnor2_1
X$558 VPWR VGND VPWR VGND sky130_fd_sc_hd__decap_3
X$559 VPWR VPWR \$2885 \$3021 VGND \$2951 VGND sky130_fd_sc_hd__xnor2_1
X$560 VPWR VPWR VGND VGND sky130_fd_sc_hd__decap_8
X$562 VPWR VPWR \$2883 \$2855 VGND \$2875 VGND sky130_fd_sc_hd__xnor2_1
X$564 VPWR VPWR VGND VGND sky130_fd_sc_hd__decap_6
X$566 VPWR VPWR VGND \$2881 \$2875 VGND sky130_fd_sc_hd__clkinv_1
X$567 VPWR VPWR \$2815 \$2881 VGND \$2855 \$2809 VGND sky130_fd_sc_hd__o21ai_0
X$569 VGND \$2782 \$2814 TICK \$2867 VPWR VPWR VGND sky130_fd_sc_hd__dfrtp_1
X$570 VPWR VPWR VGND VGND sky130_fd_sc_hd__decap_12
X$572 VPWR DCO_EN VGND \$2782 VPWR VGND sky130_fd_sc_hd__clkdlybuf4s50_1
X$592 VPWR FINE_MUX[6] VGND \$2191 VPWR VGND sky130_fd_sc_hd__clkdlybuf4s50_1
X$594 VPWR VPWR \$2263 \$2130 VGND \$2191 VGND sky130_fd_sc_hd__xnor2_1
X$596 VPWR VPWR \$2265 \$2190 VGND \$2189 VGND sky130_fd_sc_hd__xnor2_1
X$597 VPWR VGND VPWR VGND sky130_fd_sc_hd__decap_3
X$598 VPWR VGND \$2269 \$2190 \$2189 VPWR VGND sky130_fd_sc_hd__nor2b_1
X$599 VPWR VGND VPWR VGND sky130_fd_sc_hd__decap_4
X$601 VPWR \$2305 VGND \$2193 \$1965 VPWR VGND
+ sky130_fd_sc_hd__lpflow_inputiso1p_1
X$603 VPWR VPWR VGND VGND sky130_fd_sc_hd__decap_12
X$604 VPWR VPWR VGND VGND sky130_fd_sc_hd__decap_12
X$605 VPWR VPWR VGND VGND sky130_fd_sc_hd__decap_6
X$607 VGND \$2402 \$2076 \$2273 \$2049 VPWR VPWR VGND sky130_fd_sc_hd__xnor3_1
X$608 VPWR \$2276 VPWR VGND \$2199 \$2201 \$2273 VGND sky130_fd_sc_hd__nand3_1
X$609 VPWR \$2320 VPWR VGND \$2273 \$2201 VGND sky130_fd_sc_hd__nand2_1
X$610 VPWR VGND VPWR VGND sky130_fd_sc_hd__decap_3
X$611 VGND \$2318 \$2316 \$2085 \$2276 VPWR VPWR VGND sky130_fd_sc_hd__xor3_1
X$612 VPWR VPWR \$2312 \$2276 VGND \$2205 \$2087 VGND sky130_fd_sc_hd__o21ai_0
X$613 VPWR VGND VPWR VGND sky130_fd_sc_hd__decap_3
X$615 VPWR VPWR VGND VGND sky130_fd_sc_hd__decap_12
X$616 VPWR VPWR VGND VGND sky130_fd_sc_hd__decap_12
X$617 VPWR VPWR VGND VGND sky130_fd_sc_hd__decap_12
X$618 VPWR VPWR VGND VGND sky130_fd_sc_hd__decap_12
X$619 VPWR VPWR VGND VGND sky130_fd_sc_hd__decap_12
X$620 VPWR VPWR VGND VGND sky130_fd_sc_hd__decap_12
X$621 VPWR VPWR VGND VGND sky130_fd_sc_hd__decap_12
X$624 VPWR VPWR VGND VGND sky130_fd_sc_hd__decap_12
X$625 VPWR VPWR VGND VGND sky130_fd_sc_hd__decap_12
X$626 VPWR VPWR VGND VGND sky130_fd_sc_hd__decap_12
X$627 VPWR VPWR VGND VGND sky130_fd_sc_hd__decap_12
X$628 VPWR VPWR VGND VGND sky130_fd_sc_hd__decap_12
X$629 VPWR VPWR VGND VGND sky130_fd_sc_hd__decap_12
X$630 VPWR VPWR VGND VGND sky130_fd_sc_hd__decap_12
X$633 VPWR VPWR VGND VGND sky130_fd_sc_hd__decap_12
X$634 VPWR VPWR VGND VGND sky130_fd_sc_hd__decap_12
X$635 VPWR VPWR VGND VGND sky130_fd_sc_hd__decap_12
X$636 VPWR VPWR VGND VGND sky130_fd_sc_hd__decap_12
X$637 VPWR VPWR VGND VGND sky130_fd_sc_hd__decap_12
X$638 VPWR VPWR VGND VGND sky130_fd_sc_hd__decap_12
X$639 VPWR VPWR VGND VGND sky130_fd_sc_hd__decap_12
X$642 VPWR VPWR VGND VGND sky130_fd_sc_hd__decap_12
X$646 VPWR VPWR VGND VGND sky130_fd_sc_hd__decap_12
X$649 VPWR \$2264 VPWR VGND \$2265 \$2294 \$2263 VGND sky130_fd_sc_hd__nand3_1
X$650 VPWR VPWR VGND VGND sky130_fd_sc_hd__decap_12
X$651 VPWR \$2266 VPWR \$2269 \$1965 VGND VGND sky130_fd_sc_hd__and2_0
X$652 VPWR VPWR \$2304 VGND \$2136 \$2193 \$2266 \$2264 VGND
+ sky130_fd_sc_hd__a211o_1
X$653 VPWR \$2305 \$2307 VPWR \$2269 VGND \$2136 \$2333 VGND
+ sky130_fd_sc_hd__o211ai_1
X$654 VPWR VPWR VGND VGND sky130_fd_sc_hd__decap_12
X$657 VPWR \$2313 \$2271 VPWR VGND \$2337 VGND sky130_fd_sc_hd__nand2b_1
X$658 VPWR VGND VPWR VGND sky130_fd_sc_hd__decap_3
X$659 VPWR \$2273 VGND \$2251 VPWR \$2313 VGND sky130_fd_sc_hd__nor2_1
X$660 VPWR VPWR VGND VGND sky130_fd_sc_hd__decap_12
X$663 VPWR VGND VPWR VGND sky130_fd_sc_hd__decap_3
X$664 VPWR VPWR \$2339 \$2199 VGND \$2320 VGND sky130_fd_sc_hd__xnor2_1
X$665 VPWR VPWR VGND VGND sky130_fd_sc_hd__decap_12
X$667 VPWR VPWR VGND VGND sky130_fd_sc_hd__decap_12
X$668 VPWR VGND \$2312 \$2204 \$2373 VPWR VGND sky130_fd_sc_hd__xor2_1
X$669 VPWR VPWR VGND VGND sky130_fd_sc_hd__decap_12
X$670 VPWR VPWR VGND VGND sky130_fd_sc_hd__decap_12
X$672 VPWR VPWR VGND VGND sky130_fd_sc_hd__decap_12
X$673 VPWR VPWR VGND VGND sky130_fd_sc_hd__decap_8
X$675 VPWR VPWR VGND VGND sky130_fd_sc_hd__decap_12
X$677 VPWR VPWR VGND VGND sky130_fd_sc_hd__decap_12
X$678 VPWR VPWR VGND VGND sky130_fd_sc_hd__decap_12
X$679 VPWR VPWR VGND VGND sky130_fd_sc_hd__decap_12
X$680 VPWR VPWR VGND VGND sky130_fd_sc_hd__decap_12
X$682 VPWR VPWR VGND VGND sky130_fd_sc_hd__decap_12
X$683 VPWR VPWR VGND VGND sky130_fd_sc_hd__decap_12
X$686 VPWR VPWR VGND VGND sky130_fd_sc_hd__decap_12
X$687 VPWR VPWR VGND VGND sky130_fd_sc_hd__decap_12
X$689 VPWR VPWR VGND VGND sky130_fd_sc_hd__decap_12
X$690 VPWR VPWR VGND VGND sky130_fd_sc_hd__decap_12
X$691 VPWR VPWR VGND VGND sky130_fd_sc_hd__decap_12
X$693 VPWR VPWR VGND VGND sky130_fd_sc_hd__decap_12
X$694 VPWR VPWR VGND VGND sky130_fd_sc_hd__decap_12
X$697 VPWR VPWR VGND VGND sky130_fd_sc_hd__decap_12
X$698 VPWR VPWR VGND VGND sky130_fd_sc_hd__decap_12
X$700 VPWR VPWR VGND VGND sky130_fd_sc_hd__decap_12
X$701 VPWR VPWR VGND VGND sky130_fd_sc_hd__decap_12
X$702 VPWR VPWR VGND VGND sky130_fd_sc_hd__decap_8
X$722 VPWR FINE_MUX[14] VGND \$3489 VPWR VGND sky130_fd_sc_hd__clkdlybuf4s50_1
X$724 VPWR VPWR VGND VGND sky130_fd_sc_hd__decap_12
X$725 VPWR VPWR VGND VGND sky130_fd_sc_hd__decap_12
X$726 VPWR VPWR VGND VGND sky130_fd_sc_hd__decap_8
X$729 VPWR VGND VPWR VGND sky130_fd_sc_hd__decap_4
X$730 VPWR \$3489 \$3597 VPWR VGND \$3231 \$3401 \$3543 VGND
+ sky130_fd_sc_hd__o31ai_1
X$731 VPWR VPWR VGND VGND sky130_fd_sc_hd__decap_8
X$732 VGND \$3764 \$3491 \$3401 \$3394 VPWR VPWR VGND sky130_fd_sc_hd__xnor3_1
X$733 VPWR VGND VPWR VGND sky130_fd_sc_hd__decap_3
X$734 VGND \$3657 \$3195 \$3493 \$3430 VPWR VPWR VGND sky130_fd_sc_hd__xnor3_1
X$735 VPWR VPWR VGND VGND sky130_fd_sc_hd__decap_12
X$736 VPWR VGND \$3496 VPWR \$3409 \$3562 \$3144 VGND sky130_fd_sc_hd__a21oi_1
X$737 VPWR VPWR VGND VGND sky130_fd_sc_hd__decap_12
X$739 VPWR VGND VPWR VGND sky130_fd_sc_hd__decap_4
X$741 VPWR VGND \$3435 \$3497 \$3500 VPWR VGND sky130_fd_sc_hd__xor2_1
X$742 VPWR VGND VPWR VGND sky130_fd_sc_hd__decap_3
X$743 VPWR \$3609 \$3500 VPWR VGND \$3676 VGND sky130_fd_sc_hd__nand2b_1
X$745 VPWR \$3248 VGND \$3501 \$3502 \$3609 VPWR VGND sky130_fd_sc_hd__maj3_1
X$746 VPWR VGND VPWR VGND sky130_fd_sc_hd__decap_3
X$747 VPWR VGND \$3438 \$3503 \$3439 VPWR VGND sky130_fd_sc_hd__xor2_1
X$748 VPWR \$3152 VGND \$3441 \$3438 \$3503 VPWR VGND sky130_fd_sc_hd__maj3_1
X$750 VGND \$3512 \$3417 \$3507 \$3439 VPWR VPWR VGND sky130_fd_sc_hd__xnor3_1
X$751 VPWR VGND VPWR VGND sky130_fd_sc_hd__decap_4
X$752 VPWR VPWR VGND \$3589 \$3471 VGND sky130_fd_sc_hd__clkinv_1
X$753 VPWR \$3359 VGND \$3512 VPWR \$3471 VGND sky130_fd_sc_hd__nor2_1
X$755 VPWR VPWR \$3615 \$3700 VGND \$3614 VGND sky130_fd_sc_hd__xnor2_1
X$758 VPWR \$3512 \$3331 VGND \$3615 \$3513 VPWR VGND sky130_fd_sc_hd__nor3_1
X$759 VPWR VPWR \$3515 \$3696 VGND \$3512 VGND sky130_fd_sc_hd__xnor2_1
X$760 VPWR VGND VPWR VGND sky130_fd_sc_hd__decap_4
X$762 VPWR \$3259 VPWR \$3617 \$3515 VGND VGND sky130_fd_sc_hd__and2_0
X$764 VPWR VPWR \$3444 \$3515 VGND \$3677 VGND sky130_fd_sc_hd__xnor2_1
X$765 VPWR VPWR VGND VGND sky130_fd_sc_hd__decap_6
X$767 VPWR VPWR \$3445 \$3447 \$3621 \$3571 VGND VGND sky130_fd_sc_hd__o21bai_1
X$768 VPWR VPWR \$3392 \$3444 VGND \$3621 VGND sky130_fd_sc_hd__xnor2_1
X$770 VPWR \$3523 \$3519 VPWR VGND \$3520 \$3521 VGND sky130_fd_sc_hd__nand3b_1
X$771 VPWR \$3521 VPWR VGND \$3445 \$3447 VGND sky130_fd_sc_hd__nand2_1
X$772 VPWR VPWR VGND VGND sky130_fd_sc_hd__decap_12
X$773 VPWR VPWR VGND VGND sky130_fd_sc_hd__decap_8
X$774 VPWR VGND VPWR VGND sky130_fd_sc_hd__decap_3
X$776 VGND \$3549 \$3626 \$3627 \$3547 VPWR VPWR VGND sky130_fd_sc_hd__xor3_1
X$778 VGND \$2782 \$3528 TICK \$3374 VPWR VPWR VGND sky130_fd_sc_hd__dfrtp_1
X$779 VPWR VPWR VGND VGND sky130_fd_sc_hd__decap_12
X$780 VPWR VPWR VGND VGND sky130_fd_sc_hd__decap_12
X$781 VPWR VPWR VGND VGND sky130_fd_sc_hd__decap_12
X$782 VPWR VPWR VGND VGND sky130_fd_sc_hd__decap_8
X$785 VPWR VPWR VGND VGND sky130_fd_sc_hd__decap_12
X$789 VPWR VPWR VGND VGND sky130_fd_sc_hd__decap_12
X$791 VPWR VPWR VGND VGND sky130_fd_sc_hd__decap_12
X$792 VPWR VPWR VGND VGND sky130_fd_sc_hd__decap_8
X$794 VPWR \$3639 VPWR VGND \$3592 \$3343 VGND sky130_fd_sc_hd__nand2_1
X$795 VPWR VGND \$3592 \$3489 \$3543 VPWR VGND
+ sky130_fd_sc_hd__lpflow_isobufsrc_1
X$796 VPWR VGND VPWR VGND sky130_fd_sc_hd__decap_4
X$797 VPWR VPWR \$3594 \$3543 VGND \$3489 VGND sky130_fd_sc_hd__xnor2_1
X$798 VPWR VGND VPWR VGND sky130_fd_sc_hd__decap_3
X$800 VPWR \$3597 VPWR \$3466 \$3395 VGND VGND sky130_fd_sc_hd__and2_0
X$801 VPWR VPWR VGND VGND sky130_fd_sc_hd__decap_12
X$802 VPWR \$3491 \$3429 VGND \$3655 \$3430 VPWR VGND sky130_fd_sc_hd__nor3_1
X$803 VPWR VGND VPWR VGND sky130_fd_sc_hd__decap_3
X$804 VPWR \$3657 VPWR \$3603 VGND \$3431 \$3429 VGND sky130_fd_sc_hd__o21a_1
X$806 VPWR VPWR VGND VGND sky130_fd_sc_hd__decap_12
X$809 VGND \$3667 \$3299 \$3409 \$3431 VPWR VPWR VGND sky130_fd_sc_hd__xnor3_1
X$810 VPWR VPWR VGND VGND sky130_fd_sc_hd__decap_8
X$811 VPWR VGND VPWR VGND sky130_fd_sc_hd__decap_3
X$812 VPWR \$3670 VPWR VGND \$3668 \$3603 VGND sky130_fd_sc_hd__nand2_1
X$813 VPWR VPWR VGND VGND sky130_fd_sc_hd__decap_8
X$815 VPWR VGND VPWR VGND sky130_fd_sc_hd__decap_3
X$816 VPWR VPWR \$3682 \$3500 VGND \$3676 VGND sky130_fd_sc_hd__xnor2_1
X$817 VPWR VPWR \$3683 \$3501 VGND \$3609 VGND sky130_fd_sc_hd__xnor2_1
X$818 VPWR VPWR VGND VGND sky130_fd_sc_hd__decap_12
X$821 VPWR VPWR VGND VGND sky130_fd_sc_hd__decap_8
X$822 VPWR VGND VPWR VGND sky130_fd_sc_hd__decap_3
X$823 VPWR VPWR VGND \$3507 \$3441 VGND sky130_fd_sc_hd__clkinv_1
X$825 VPWR VPWR VGND VGND sky130_fd_sc_hd__decap_12
X$826 VPWR VPWR VGND VGND sky130_fd_sc_hd__decap_6
X$827 VGND \$3689 \$3700 \$3513 \$3614 VPWR VPWR VGND sky130_fd_sc_hd__xor3_1
X$828 VPWR VPWR VGND VGND sky130_fd_sc_hd__decap_12
X$830 VPWR VGND VPWR VGND sky130_fd_sc_hd__decap_4
X$831 VPWR VGND \$3574 VPWR \$3618 \$3677 \$3617 VGND sky130_fd_sc_hd__a21oi_1
X$832 VPWR VPWR VGND VGND sky130_fd_sc_hd__decap_12
X$835 VGND \$3625 \$3447 \$3520 \$3445 VPWR VPWR VGND sky130_fd_sc_hd__xor3_1
X$837 VPWR VGND VPWR VGND sky130_fd_sc_hd__decap_4
X$839 VPWR \$3366 VPWR VGND \$3649 \$3625 VGND sky130_fd_sc_hd__nand2_1
X$840 VPWR VPWR \$3626 \$3625 VGND \$3649 VGND sky130_fd_sc_hd__xnor2_1
X$841 VPWR VPWR VGND VGND sky130_fd_sc_hd__decap_12
X$842 VPWR VPWR VGND VGND sky130_fd_sc_hd__decap_6
X$843 VPWR \$3379 VGND \$3626 \$3627 \$3547 VPWR VGND sky130_fd_sc_hd__maj3_1
X$846 VPWR VPWR \$3635 \$3525 VGND \$3528 VGND sky130_fd_sc_hd__xnor2_1
X$847 VPWR VPWR VGND VGND sky130_fd_sc_hd__decap_12
X$848 VPWR VGND VPWR VGND sky130_fd_sc_hd__decap_4
X$851 VPWR VPWR VGND VGND sky130_fd_sc_hd__decap_12
X$852 VPWR VPWR VGND VGND sky130_fd_sc_hd__decap_12
X$854 VPWR VPWR VGND VGND sky130_fd_sc_hd__decap_12
X$855 VPWR VPWR VGND VGND sky130_fd_sc_hd__decap_12
X$856 VPWR VPWR VGND VGND sky130_fd_sc_hd__decap_8
X$876 VPWR FINE_MUX[2] VGND \$1441 VPWR VGND sky130_fd_sc_hd__clkdlybuf4s50_1
X$878 VPWR VPWR VGND VGND sky130_fd_sc_hd__decap_12
X$879 VPWR VPWR VGND VGND sky130_fd_sc_hd__decap_12
X$880 VPWR VPWR VGND VGND sky130_fd_sc_hd__decap_8
X$883 VPWR VPWR VGND VGND sky130_fd_sc_hd__decap_8
X$885 VPWR \$1439 VGND \$1437 VPWR \$1326 VGND sky130_fd_sc_hd__nor2_1
X$886 VPWR \$1326 VPWR VGND \$1328 \$1260 VGND sky130_fd_sc_hd__nand2_1
X$887 VPWR VPWR VGND VGND sky130_fd_sc_hd__decap_8
X$888 VPWR \$1443 VPWR VGND \$1328 \$1253 VGND sky130_fd_sc_hd__nand2_1
X$889 VPWR VPWR VGND VGND sky130_fd_sc_hd__decap_8
X$891 VPWR \$1488 VPWR VGND \$1330 \$1443 VGND sky130_fd_sc_hd__nand2_1
X$892 VPWR \$1446 VGND \$1444 VPWR \$1443 VGND sky130_fd_sc_hd__nor2_1
X$893 VPWR \$1334 VGND \$1444 VPWR \$1330 VGND sky130_fd_sc_hd__nor2_1
X$894 VPWR VPWR VGND VGND sky130_fd_sc_hd__decap_8
X$896 VPWR VPWR \$1504 \$1264 VGND \$1401 VGND sky130_fd_sc_hd__xnor2_1
X$897 VPWR \$1449 VPWR VGND \$1334 \$1264 VGND sky130_fd_sc_hd__nand2_1
X$898 VPWR VGND VPWR VGND sky130_fd_sc_hd__decap_4
X$899 VPWR VPWR \$1625 \$1404 VGND \$1337 VGND sky130_fd_sc_hd__xnor2_1
X$900 VPWR \$1548 VGND \$1337 VPWR \$1449 VGND sky130_fd_sc_hd__nor2_1
X$901 VPWR VGND VPWR VGND sky130_fd_sc_hd__decap_4
X$902 VPWR \$1515 VGND \$1337 VPWR \$1408 VGND sky130_fd_sc_hd__nor2_1
X$905 VPWR \$1516 VPWR VGND \$1192 \$1339 VGND sky130_fd_sc_hd__nand2_1
X$906 VPWR VGND VPWR VGND sky130_fd_sc_hd__decap_4
X$907 VPWR VPWR VGND \$1452 \$1519 VGND sky130_fd_sc_hd__clkinv_1
X$909 VGND \$1519 \$1344 \$1195 \$1287 VPWR VPWR VGND sky130_fd_sc_hd__xnor3_1
X$910 VPWR VPWR VGND VGND sky130_fd_sc_hd__decap_12
X$911 VGND \$1534 \$1295 \$1427 \$1344 \$1533 \$1195 VPWR VPWR VGND
+ sky130_fd_sc_hd__a32o_1
X$912 VPWR VPWR VGND VGND sky130_fd_sc_hd__decap_12
X$914 VPWR \$1350 VGND \$1348 VPWR \$1295 VGND sky130_fd_sc_hd__nor2_1
X$915 VPWR VPWR \$1348 \$1352 VGND \$1351 VGND sky130_fd_sc_hd__xnor2_1
X$916 VPWR \$1503 \$1505 \$1350 VGND \$1454 \$1455 VPWR VGND
+ sky130_fd_sc_hd__or4_1
X$917 VPWR VGND VPWR VGND sky130_fd_sc_hd__decap_4
X$919 VPWR \$1455 VGND \$1409 \$1223 \$1300 VPWR VGND sky130_fd_sc_hd__maj3_1
X$920 VPWR VPWR VGND VGND sky130_fd_sc_hd__decap_12
X$921 VPWR VPWR VGND VGND sky130_fd_sc_hd__decap_12
X$922 VPWR VPWR VGND VGND sky130_fd_sc_hd__decap_12
X$923 VPWR VPWR VGND VGND sky130_fd_sc_hd__decap_12
X$924 VPWR VPWR VGND VGND sky130_fd_sc_hd__decap_12
X$925 VPWR VPWR VGND VGND sky130_fd_sc_hd__decap_12
X$926 VPWR VGND VPWR VGND sky130_fd_sc_hd__decap_4
X$929 VPWR VPWR VGND VGND sky130_fd_sc_hd__decap_12
X$930 VPWR VPWR VGND VGND sky130_fd_sc_hd__decap_12
X$931 VPWR VPWR VGND VGND sky130_fd_sc_hd__decap_12
X$932 VPWR VPWR VGND VGND sky130_fd_sc_hd__decap_12
X$933 VPWR VPWR VGND VGND sky130_fd_sc_hd__decap_12
X$934 VPWR VPWR VGND VGND sky130_fd_sc_hd__decap_12
X$935 VPWR VPWR VGND VGND sky130_fd_sc_hd__decap_6
X$936 VPWR VGND \$1460 \$1463 \$1470 VPWR VGND sky130_fd_sc_hd__xor2_1
X$938 VPWR VGND VPWR VGND sky130_fd_sc_hd__decap_4
X$940 VPWR COARSE_MUX[6] VGND \$1363 VPWR VGND sky130_fd_sc_hd__clkdlybuf4s50_1
X$943 VPWR FINE_MUX[0] VGND \$1260 VPWR VGND sky130_fd_sc_hd__clkdlybuf4s50_1
X$944 VPWR VPWR VGND VGND sky130_fd_sc_hd__decap_12
X$948 VPWR VPWR VGND VGND sky130_fd_sc_hd__decap_12
X$949 VPWR VPWR VGND VGND sky130_fd_sc_hd__decap_12
X$951 VPWR \$1576 VPWR VGND \$1573 \$1572 VGND sky130_fd_sc_hd__nand2_1
X$952 VPWR VGND VPWR VGND sky130_fd_sc_hd__decap_4
X$953 VPWR \$1440 VPWR VGND \$1439 \$894 VGND sky130_fd_sc_hd__nand2_1
X$957 VPWR \$1545 VPWR VGND \$1441 \$1440 VGND sky130_fd_sc_hd__nand2_1
X$958 VPWR VGND VPWR VGND sky130_fd_sc_hd__decap_4
X$960 VPWR VGND \$1253 \$1328 \$1485 VPWR VGND sky130_fd_sc_hd__xor2_1
X$961 VPWR VPWR VGND VGND sky130_fd_sc_hd__decap_6
X$963 VPWR VGND \$1488 \$1444 \$1621 VPWR VGND sky130_fd_sc_hd__xor2_1
X$967 VGND \$1601 \$1264 \$1334 \$1446 VPWR VPWR VGND sky130_fd_sc_hd__xnor3_1
X$971 VPWR VPWR VGND VGND sky130_fd_sc_hd__decap_12
X$972 VPWR VPWR VGND VGND sky130_fd_sc_hd__decap_8
X$973 VPWR VGND \$1339 \$1192 \$1514 VPWR VGND sky130_fd_sc_hd__xor2_1
X$975 VPWR VGND \$1519 \$1516 \$1521 VPWR VGND sky130_fd_sc_hd__xor2_1
X$979 VPWR \$1515 \$1452 \$1550 VPWR VGND \$1192 VGND sky130_fd_sc_hd__and3_1
X$980 VPWR VPWR VGND VGND sky130_fd_sc_hd__decap_12
X$981 VPWR VPWR VGND VGND sky130_fd_sc_hd__decap_6
X$982 VPWR \$1604 VGND \$1505 \$1664 \$1552 \$1535 VPWR VGND
+ sky130_fd_sc_hd__a211oi_1
X$985 VPWR VPWR VGND VGND sky130_fd_sc_hd__decap_12
X$989 VPWR VGND VPWR VGND sky130_fd_sc_hd__decap_3
X$990 VPWR VPWR \$1597 \$1348 VGND \$1295 VGND sky130_fd_sc_hd__xnor2_1
X$991 VPWR VPWR VGND VGND sky130_fd_sc_hd__decap_6
X$993 VPWR \$1503 VGND \$1352 VPWR \$1351 VGND sky130_fd_sc_hd__nor2_1
X$994 VPWR VPWR VGND VGND sky130_fd_sc_hd__decap_12
X$996 VPWR VGND \$1409 \$1223 \$1487 VPWR VGND sky130_fd_sc_hd__xor2_1
X$997 VPWR VPWR VGND VGND sky130_fd_sc_hd__decap_12
X$1001 VPWR VPWR VGND VGND sky130_fd_sc_hd__decap_12
X$1002 VPWR VPWR VGND VGND sky130_fd_sc_hd__decap_8
X$1005 VPWR VPWR VGND VGND sky130_fd_sc_hd__decap_12
X$1006 VPWR VPWR VGND VGND sky130_fd_sc_hd__decap_12
X$1010 VPWR VPWR VGND VGND sky130_fd_sc_hd__decap_12
X$1011 VPWR VPWR VGND VGND sky130_fd_sc_hd__decap_12
X$1012 VPWR VPWR VGND VGND sky130_fd_sc_hd__decap_12
X$1016 VPWR VPWR VGND VGND sky130_fd_sc_hd__decap_12
X$1017 VPWR VPWR VGND VGND sky130_fd_sc_hd__decap_12
X$1020 VPWR VPWR VGND VGND sky130_fd_sc_hd__decap_12
X$1021 VPWR VPWR VGND VGND sky130_fd_sc_hd__decap_12
X$1025 VPWR VPWR VGND VGND sky130_fd_sc_hd__decap_8
X$1026 VPWR VGND VPWR VGND sky130_fd_sc_hd__decap_3
X$1027 VPWR \$1461 VGND \$1472 VPWR \$1094 \$1462 VGND sky130_fd_sc_hd__a21boi_0
X$1028 VPWR VPWR \$1092 \$1461 VGND \$1462 VGND sky130_fd_sc_hd__xnor2_1
X$1029 VPWR COARSE_MUX[5] VGND \$1463 VPWR VGND sky130_fd_sc_hd__clkdlybuf4s50_1
X$1031 VPWR FINE_MUX[9] VGND \$2579 VPWR VGND sky130_fd_sc_hd__clkdlybuf4s50_1
X$1033 VPWR VPWR \$2577 \$2362 VGND \$2422 VGND sky130_fd_sc_hd__xnor2_1
X$1034 VPWR VPWR \$2584 \$2520 VGND \$2394 VGND sky130_fd_sc_hd__xnor2_1
X$1035 VPWR VPWR VGND VGND sky130_fd_sc_hd__decap_12
X$1037 VPWR VPWR \$2621 \$2588 VGND \$2549 VGND sky130_fd_sc_hd__xnor2_1
X$1039 VPWR VPWR VGND VGND sky130_fd_sc_hd__decap_12
X$1040 VPWR \$2457 VPWR \$2590 \$2623 VGND VGND sky130_fd_sc_hd__and2_0
X$1041 VPWR VPWR VGND VGND sky130_fd_sc_hd__decap_8
X$1042 VPWR VGND \$2553 \$2386 \$2533 VPWR VGND
+ sky130_fd_sc_hd__lpflow_isobufsrc_1
X$1043 VPWR VPWR \$2773 \$2402 VGND \$2553 VGND sky130_fd_sc_hd__xnor2_1
X$1044 VPWR VPWR VGND VGND sky130_fd_sc_hd__decap_12
X$1045 VPWR VPWR VGND VGND sky130_fd_sc_hd__decap_8
X$1046 VPWR \$2556 VGND \$2536 VPWR \$2613 VGND sky130_fd_sc_hd__nor2_1
X$1047 VPWR VPWR VGND VGND sky130_fd_sc_hd__decap_12
X$1048 VPWR VPWR VGND VGND sky130_fd_sc_hd__decap_6
X$1050 VPWR \$2562 \$2557 VPWR VGND \$2470 VGND sky130_fd_sc_hd__nand2b_1
X$1053 VPWR VGND VPWR VGND sky130_fd_sc_hd__decap_3
X$1054 VPWR VGND \$2563 \$2561 \$2562 VPWR VGND sky130_fd_sc_hd__nor2b_1
X$1056 VPWR \$2111 VGND \$2564 \$2611 \$2563 VPWR \$2539 VGND
+ sky130_fd_sc_hd__nor4_1
X$1057 VPWR VPWR VGND VGND sky130_fd_sc_hd__decap_12
X$1058 VPWR VPWR VGND VGND sky130_fd_sc_hd__decap_12
X$1059 VPWR VPWR VGND VGND sky130_fd_sc_hd__decap_12
X$1060 VPWR VPWR VGND VGND sky130_fd_sc_hd__decap_12
X$1061 VPWR VPWR VGND VGND sky130_fd_sc_hd__decap_12
X$1062 VPWR VPWR VGND VGND sky130_fd_sc_hd__decap_8
X$1063 VPWR VGND VPWR VGND sky130_fd_sc_hd__decap_3
X$1065 VPWR VPWR VGND VGND sky130_fd_sc_hd__decap_12
X$1066 VPWR VPWR VGND VGND sky130_fd_sc_hd__decap_12
X$1067 VPWR VPWR VGND VGND sky130_fd_sc_hd__decap_12
X$1068 VPWR VPWR VGND VGND sky130_fd_sc_hd__decap_12
X$1069 VPWR VPWR VGND VGND sky130_fd_sc_hd__decap_12
X$1070 VPWR VPWR VGND VGND sky130_fd_sc_hd__decap_12
X$1071 VPWR VPWR VGND VGND sky130_fd_sc_hd__decap_12
X$1074 VPWR VPWR VGND VGND sky130_fd_sc_hd__decap_12
X$1075 VPWR VPWR VGND VGND sky130_fd_sc_hd__decap_12
X$1076 VPWR VPWR VGND VGND sky130_fd_sc_hd__decap_12
X$1077 VPWR VPWR VGND VGND sky130_fd_sc_hd__decap_12
X$1078 VPWR VPWR VGND VGND sky130_fd_sc_hd__decap_12
X$1079 VPWR VPWR VGND VGND sky130_fd_sc_hd__decap_12
X$1080 VPWR VPWR VGND VGND sky130_fd_sc_hd__decap_8
X$1082 VPWR VGND \$2591 VPWR \$2508 VGND sky130_fd_sc_hd__buf_2
X$1084 VPWR VPWR \$2511 \$2572 VGND \$2715 VGND sky130_fd_sc_hd__nand2_2
X$1085 VPWR \$2592 VGND OUT VPWR VGND sky130_fd_sc_hd__clkdlybuf4s50_1
X$1088 VPWR VPWR VGND VGND sky130_fd_sc_hd__decap_8
X$1089 VPWR VGND VPWR VGND sky130_fd_sc_hd__decap_3
X$1091 VPWR \$2653 VPWR VGND \$2579 \$2719 VGND sky130_fd_sc_hd__nand2_1
X$1092 VPWR VPWR VGND VGND sky130_fd_sc_hd__decap_6
X$1093 VPWR \$2623 VPWR VGND \$2577 \$2435 \$2621 \$2579 VGND
+ sky130_fd_sc_hd__o31a_1
X$1094 VPWR VPWR VGND VGND sky130_fd_sc_hd__decap_12
X$1095 VPWR VPWR VGND VGND sky130_fd_sc_hd__decap_12
X$1096 VPWR \$2551 VGND \$2623 VPWR \$2590 VGND sky130_fd_sc_hd__nor2_1
X$1098 VPWR \$2627 VGND \$2551 \$2457 VPWR \$2626 VGND sky130_fd_sc_hd__nor3b_1
X$1099 VPWR VGND VPWR VGND sky130_fd_sc_hd__decap_4
X$1101 VGND \$2676 \$2533 \$2386 \$2627 VPWR VPWR VGND sky130_fd_sc_hd__xnor3_1
X$1104 VPWR VPWR VGND VGND sky130_fd_sc_hd__decap_12
X$1106 VPWR VPWR VGND VGND sky130_fd_sc_hd__decap_8
X$1108 VPWR \$2557 VGND \$2630 \$2684 \$2556 VPWR VGND sky130_fd_sc_hd__maj3_1
X$1109 VPWR VGND VPWR VGND sky130_fd_sc_hd__decap_4
X$1111 VPWR VGND \$2557 \$2470 \$2631 VPWR VGND sky130_fd_sc_hd__xor2_1
X$1112 VPWR VGND VPWR VGND sky130_fd_sc_hd__decap_4
X$1113 VPWR VPWR \$2633 \$2561 VGND \$2562 VGND sky130_fd_sc_hd__xnor2_1
X$1114 VPWR VPWR VGND VGND sky130_fd_sc_hd__decap_12
X$1116 VPWR VPWR VGND VGND sky130_fd_sc_hd__decap_12
X$1117 VPWR VPWR VGND VGND sky130_fd_sc_hd__decap_8
X$1120 VPWR VPWR VGND VGND sky130_fd_sc_hd__decap_12
X$1122 VPWR VPWR VGND VGND sky130_fd_sc_hd__decap_12
X$1123 VPWR VPWR VGND VGND sky130_fd_sc_hd__decap_12
X$1124 VPWR VPWR VGND VGND sky130_fd_sc_hd__decap_12
X$1125 VPWR VPWR VGND VGND sky130_fd_sc_hd__decap_12
X$1127 VPWR VPWR VGND VGND sky130_fd_sc_hd__decap_12
X$1128 VPWR VPWR VGND VGND sky130_fd_sc_hd__decap_12
X$1131 VPWR VPWR VGND VGND sky130_fd_sc_hd__decap_12
X$1132 VPWR VPWR VGND VGND sky130_fd_sc_hd__decap_12
X$1134 VPWR VPWR VGND VGND sky130_fd_sc_hd__decap_12
X$1135 VPWR VPWR VGND VGND sky130_fd_sc_hd__decap_12
X$1136 VPWR VPWR VGND VGND sky130_fd_sc_hd__decap_12
X$1138 VPWR VPWR VGND VGND sky130_fd_sc_hd__decap_12
X$1139 VPWR VPWR VGND VGND sky130_fd_sc_hd__decap_12
X$1142 VPWR VPWR VGND VGND sky130_fd_sc_hd__decap_12
X$1143 VPWR VPWR VGND VGND sky130_fd_sc_hd__decap_12
X$1145 VPWR VPWR VGND VGND sky130_fd_sc_hd__decap_12
X$1146 VPWR VGND \$2506 VPWR \$2572 VGND sky130_fd_sc_hd__buf_2
X$1147 VPWR \$2510 VGND INJ_EDGE VPWR VGND sky130_fd_sc_hd__clkdlybuf4s50_1
X$1148 VPWR \$2591 VGND SS_BBPD[1] VPWR VGND sky130_fd_sc_hd__clkdlybuf4s50_1
X$1168 VPWR FINE_MUX[3] VGND \$1667 VPWR VGND sky130_fd_sc_hd__clkdlybuf4s50_1
X$1170 VPWR VGND VPWR VGND sky130_fd_sc_hd__decap_4
X$1172 VPWR VPWR \$1959 \$1834 VGND \$1794 \$1927 VGND sky130_fd_sc_hd__o21ai_0
X$1173 VPWR VPWR VGND VGND sky130_fd_sc_hd__decap_12
X$1175 VPWR \$1929 VGND \$1926 VPWR \$1927 VGND sky130_fd_sc_hd__nor2_1
X$1176 VPWR \$1836 \$1965 \$1881 VGND \$1929 VPWR VGND sky130_fd_sc_hd__mux2i_1
X$1178 VPWR VGND VPWR VGND sky130_fd_sc_hd__decap_4
X$1179 VGND \$2071 \$1838 \$1841 \$1589 VPWR VPWR VGND sky130_fd_sc_hd__xnor3_1
X$1180 VPWR VGND VPWR VGND sky130_fd_sc_hd__decap_4
X$1181 VPWR \$1993 VPWR VGND \$1977 \$1808 VGND sky130_fd_sc_hd__nand2_1
X$1182 VPWR VPWR VGND VGND sky130_fd_sc_hd__decap_12
X$1183 VPWR VPWR VGND VGND sky130_fd_sc_hd__decap_12
X$1184 VPWR VPWR VGND VGND sky130_fd_sc_hd__decap_12
X$1185 VPWR VPWR VGND VGND sky130_fd_sc_hd__decap_12
X$1186 VPWR VGND VPWR VGND sky130_fd_sc_hd__decap_4
X$1187 VPWR VGND \$1972 VPWR \$1973 \$1969 \$1970 VGND sky130_fd_sc_hd__a21oi_1
X$1189 VPWR VPWR VGND VGND sky130_fd_sc_hd__decap_12
X$1190 VPWR VPWR VGND VGND sky130_fd_sc_hd__decap_12
X$1191 VPWR VPWR VGND VGND sky130_fd_sc_hd__decap_12
X$1192 VPWR VPWR VGND VGND sky130_fd_sc_hd__decap_12
X$1193 VPWR VPWR VGND VGND sky130_fd_sc_hd__decap_12
X$1194 VPWR VPWR VGND VGND sky130_fd_sc_hd__decap_12
X$1195 VPWR VPWR VGND VGND sky130_fd_sc_hd__decap_12
X$1198 VPWR VPWR VGND VGND sky130_fd_sc_hd__decap_12
X$1199 VPWR VPWR VGND VGND sky130_fd_sc_hd__decap_12
X$1200 VPWR VPWR VGND VGND sky130_fd_sc_hd__decap_12
X$1201 VPWR VPWR VGND VGND sky130_fd_sc_hd__decap_12
X$1202 VPWR VPWR VGND VGND sky130_fd_sc_hd__decap_12
X$1203 VPWR VPWR VGND VGND sky130_fd_sc_hd__decap_12
X$1204 VPWR VPWR VGND VGND sky130_fd_sc_hd__decap_12
X$1207 VPWR VPWR VGND VGND sky130_fd_sc_hd__decap_12
X$1208 VPWR VPWR VGND VGND sky130_fd_sc_hd__decap_12
X$1209 VPWR VPWR VGND VGND sky130_fd_sc_hd__decap_12
X$1210 VPWR VPWR VGND VGND sky130_fd_sc_hd__decap_12
X$1211 VPWR VPWR VGND VGND sky130_fd_sc_hd__decap_12
X$1212 VPWR VPWR VGND VGND sky130_fd_sc_hd__decap_12
X$1213 VPWR VPWR VGND VGND sky130_fd_sc_hd__decap_12
X$1216 VPWR VGND VPWR VGND sky130_fd_sc_hd__decap_4
X$1218 VPWR COARSE_MUX[2] VGND \$1799 VPWR VGND sky130_fd_sc_hd__clkdlybuf4s50_1
X$1221 VPWR FINE_MUX[4] VGND \$1832 VPWR VGND sky130_fd_sc_hd__clkdlybuf4s50_1
X$1222 VPWR VPWR VGND VGND sky130_fd_sc_hd__decap_6
X$1224 VPWR \$2025 VPWR VGND \$1950 \$1794 VGND sky130_fd_sc_hd__nand2_1
X$1225 VPWR VPWR VGND VGND sky130_fd_sc_hd__decap_8
X$1226 VPWR VGND VPWR VGND sky130_fd_sc_hd__decap_3
X$1227 VPWR VPWR \$1985 \$1926 VGND \$1927 VGND sky130_fd_sc_hd__xnor2_1
X$1228 VPWR VPWR VGND VGND sky130_fd_sc_hd__decap_12
X$1229 VPWR VPWR VGND VGND sky130_fd_sc_hd__decap_12
X$1232 VPWR VPWR \$1991 \$1977 VGND \$1893 \$1993 VGND sky130_fd_sc_hd__o21ai_0
X$1233 VPWR \$1993 \$2049 VPWR \$1977 VGND \$1893 \$2142 VGND
+ sky130_fd_sc_hd__o211ai_1
X$1234 VPWR VPWR VGND VGND sky130_fd_sc_hd__decap_6
X$1236 VPWR VGND \$1810 \$1993 \$2046 VPWR VGND sky130_fd_sc_hd__xor2_1
X$1238 VPWR \$1996 VGND \$1810 VPWR \$1993 VGND sky130_fd_sc_hd__nor2_1
X$1239 VPWR VGND VPWR VGND sky130_fd_sc_hd__decap_3
X$1240 VPWR \$2000 VPWR \$1996 \$1896 VGND VGND sky130_fd_sc_hd__and2_0
X$1242 VPWR VGND VPWR VGND sky130_fd_sc_hd__decap_4
X$1243 VPWR \$2002 \$2059 VGND \$1901 \$2000 VPWR VGND sky130_fd_sc_hd__nor3_1
X$1244 VPWR \$1973 VPWR \$2000 \$1905 VGND VGND sky130_fd_sc_hd__and2_0
X$1245 VPWR VPWR VGND VGND sky130_fd_sc_hd__decap_12
X$1247 VPWR VPWR \$2088 \$1912 VGND \$1973 VGND sky130_fd_sc_hd__xnor2_1
X$1248 VPWR VGND VPWR VGND sky130_fd_sc_hd__decap_4
X$1249 VPWR VPWR \$2054 \$1969 VGND \$1817 VGND sky130_fd_sc_hd__xnor2_1
X$1251 VPWR VPWR VGND VGND sky130_fd_sc_hd__decap_12
X$1252 VPWR VPWR VGND VGND sky130_fd_sc_hd__decap_12
X$1253 VPWR VPWR VGND VGND sky130_fd_sc_hd__decap_6
X$1255 VPWR VPWR VGND VGND sky130_fd_sc_hd__decap_12
X$1257 VPWR VPWR VGND VGND sky130_fd_sc_hd__decap_12
X$1258 VPWR VPWR VGND VGND sky130_fd_sc_hd__decap_12
X$1259 VPWR VPWR VGND VGND sky130_fd_sc_hd__decap_12
X$1260 VPWR VPWR VGND VGND sky130_fd_sc_hd__decap_12
X$1262 VPWR VPWR VGND VGND sky130_fd_sc_hd__decap_12
X$1263 VPWR VPWR VGND VGND sky130_fd_sc_hd__decap_12
X$1266 VPWR VPWR VGND VGND sky130_fd_sc_hd__decap_12
X$1267 VPWR VPWR VGND VGND sky130_fd_sc_hd__decap_12
X$1269 VPWR VPWR VGND VGND sky130_fd_sc_hd__decap_12
X$1270 VPWR VPWR VGND VGND sky130_fd_sc_hd__decap_12
X$1271 VPWR VPWR VGND VGND sky130_fd_sc_hd__decap_12
X$1273 VPWR VPWR VGND VGND sky130_fd_sc_hd__decap_12
X$1274 VPWR VPWR VGND VGND sky130_fd_sc_hd__decap_12
X$1277 VPWR VPWR VGND VGND sky130_fd_sc_hd__decap_12
X$1278 VPWR VPWR VGND VGND sky130_fd_sc_hd__decap_12
X$1280 VPWR VPWR VGND VGND sky130_fd_sc_hd__decap_12
X$1281 VPWR VPWR VGND VGND sky130_fd_sc_hd__decap_12
X$1282 VPWR VPWR VGND VGND sky130_fd_sc_hd__decap_8
X$1302 VPWR FINE_MUX[7] VGND \$2327 VPWR VGND sky130_fd_sc_hd__clkdlybuf4s50_1
X$1304 VPWR VGND VPWR VGND sky130_fd_sc_hd__decap_3
X$1305 VPWR VGND \$2391 \$2330 \$2394 VPWR VGND sky130_fd_sc_hd__xor2_1
X$1306 VPWR \$2435 \$2265 VPWR VGND \$2394 VGND sky130_fd_sc_hd__nand2b_1
X$1307 VPWR VPWR VGND VGND sky130_fd_sc_hd__decap_8
X$1308 VPWR VGND VPWR VGND sky130_fd_sc_hd__decap_3
X$1309 VPWR \$2549 VPWR VGND \$2307 \$2366 VGND sky130_fd_sc_hd__nand2_1
X$1310 VPWR \$2398 VGND \$2366 VPWR \$2307 \$2400 \$2441 VGND
+ sky130_fd_sc_hd__a31oi_1
X$1312 VPWR VPWR VGND \$2441 \$2422 VGND sky130_fd_sc_hd__clkinv_1
X$1313 VPWR VPWR VGND VGND sky130_fd_sc_hd__decap_12
X$1314 VPWR VGND VPWR VGND sky130_fd_sc_hd__decap_4
X$1316 VPWR \$2456 VPWR \$2400 \$2449 VGND VGND sky130_fd_sc_hd__and2_0
X$1317 VPWR VPWR VGND VGND sky130_fd_sc_hd__decap_6
X$1318 VPWR \$2457 \$2402 \$2380 VPWR VGND \$2386 VGND sky130_fd_sc_hd__and3_1
X$1319 VPWR VPWR VGND VGND sky130_fd_sc_hd__decap_12
X$1320 VPWR VPWR VGND VGND sky130_fd_sc_hd__decap_6
X$1322 VPWR VPWR \$2613 \$2377 VGND \$2380 VGND sky130_fd_sc_hd__xnor2_1
X$1323 VPWR VPWR \$2630 \$2467 VGND \$2318 VGND sky130_fd_sc_hd__xnor2_1
X$1324 VPWR VPWR VGND VGND sky130_fd_sc_hd__decap_12
X$1325 VPWR VGND VPWR VGND sky130_fd_sc_hd__decap_4
X$1327 VPWR VGND VPWR VGND sky130_fd_sc_hd__decap_3
X$1328 VPWR VPWR \$2561 \$2469 VGND \$2411 VGND sky130_fd_sc_hd__xnor2_1
X$1329 VPWR VPWR VGND VGND sky130_fd_sc_hd__decap_12
X$1330 VPWR VPWR VGND VGND sky130_fd_sc_hd__decap_12
X$1331 VPWR VPWR VGND VGND sky130_fd_sc_hd__decap_12
X$1332 VPWR VPWR VGND VGND sky130_fd_sc_hd__decap_12
X$1333 VPWR VPWR VGND VGND sky130_fd_sc_hd__decap_12
X$1334 VPWR VPWR VGND VGND sky130_fd_sc_hd__decap_12
X$1335 VPWR VGND VPWR VGND sky130_fd_sc_hd__decap_3
X$1337 VPWR VPWR VGND VGND sky130_fd_sc_hd__decap_12
X$1338 VPWR VPWR VGND VGND sky130_fd_sc_hd__decap_12
X$1339 VPWR VPWR VGND VGND sky130_fd_sc_hd__decap_12
X$1340 VPWR VPWR VGND VGND sky130_fd_sc_hd__decap_12
X$1341 VPWR VPWR VGND VGND sky130_fd_sc_hd__decap_12
X$1342 VPWR VPWR VGND VGND sky130_fd_sc_hd__decap_12
X$1343 VPWR VPWR VGND VGND sky130_fd_sc_hd__decap_12
X$1346 VPWR VPWR VGND VGND sky130_fd_sc_hd__decap_12
X$1347 VPWR VPWR VGND VGND sky130_fd_sc_hd__decap_12
X$1348 VPWR VPWR VGND VGND sky130_fd_sc_hd__decap_12
X$1349 VPWR VPWR VGND VGND sky130_fd_sc_hd__decap_12
X$1350 VPWR VPWR VGND VGND sky130_fd_sc_hd__decap_12
X$1351 VPWR VPWR VGND VGND sky130_fd_sc_hd__decap_12
X$1352 VPWR VPWR VGND VGND sky130_fd_sc_hd__decap_12
X$1355 VPWR VGND VPWR VGND sky130_fd_sc_hd__decap_3
X$1356 VPWR VGND \$2510 VPWR REF VGND sky130_fd_sc_hd__buf_2
X$1357 VPWR VPWR VGND VGND sky130_fd_sc_hd__decap_6
X$1360 VPWR FINE_MUX[8] VGND \$2422 VPWR VGND sky130_fd_sc_hd__clkdlybuf4s50_1
X$1361 VPWR VGND VPWR VGND sky130_fd_sc_hd__decap_4
X$1363 VPWR \$2519 VGND \$2520 \$2391 \$2294 VPWR VGND sky130_fd_sc_hd__maj3_1
X$1364 VPWR VGND \$2519 \$2265 \$2523 VPWR VGND sky130_fd_sc_hd__xor2_1
X$1365 VPWR VPWR VGND VGND sky130_fd_sc_hd__decap_8
X$1366 VPWR \$2588 VPWR VGND \$2422 \$2398 VGND sky130_fd_sc_hd__nand2_1
X$1367 VPWR VPWR VGND VGND sky130_fd_sc_hd__decap_12
X$1368 VPWR VPWR VGND VGND sky130_fd_sc_hd__decap_12
X$1370 VPWR VPWR VGND VGND sky130_fd_sc_hd__decap_6
X$1372 VPWR \$2533 VGND \$2457 VPWR \$2456 VGND sky130_fd_sc_hd__nor2_1
X$1373 VPWR VPWR VGND VGND sky130_fd_sc_hd__decap_12
X$1376 VGND \$2537 \$2536 \$2377 \$2380 VPWR VPWR VGND sky130_fd_sc_hd__xnor3_1
X$1378 VPWR VPWR VGND VGND sky130_fd_sc_hd__decap_12
X$1379 VPWR VPWR VGND VGND sky130_fd_sc_hd__decap_12
X$1380 VPWR VGND VPWR VGND sky130_fd_sc_hd__decap_4
X$1382 VPWR VGND \$2539 \$2411 \$2469 VPWR VGND
+ sky130_fd_sc_hd__lpflow_isobufsrc_1
X$1383 VPWR VPWR VGND VGND sky130_fd_sc_hd__decap_12
X$1385 VPWR VPWR VGND VGND sky130_fd_sc_hd__decap_12
X$1386 VPWR VPWR VGND VGND sky130_fd_sc_hd__decap_8
X$1389 VPWR VPWR VGND VGND sky130_fd_sc_hd__decap_12
X$1391 VPWR VPWR VGND VGND sky130_fd_sc_hd__decap_12
X$1392 VPWR VPWR VGND VGND sky130_fd_sc_hd__decap_12
X$1393 VPWR VPWR VGND VGND sky130_fd_sc_hd__decap_12
X$1394 VPWR VPWR VGND VGND sky130_fd_sc_hd__decap_12
X$1396 VPWR VPWR VGND VGND sky130_fd_sc_hd__decap_12
X$1397 VPWR VPWR VGND VGND sky130_fd_sc_hd__decap_12
X$1400 VPWR VPWR VGND VGND sky130_fd_sc_hd__decap_12
X$1401 VPWR VPWR VGND VGND sky130_fd_sc_hd__decap_12
X$1403 VPWR VPWR VGND VGND sky130_fd_sc_hd__decap_12
X$1404 VPWR VPWR VGND VGND sky130_fd_sc_hd__decap_12
X$1405 VPWR VPWR VGND VGND sky130_fd_sc_hd__decap_12
X$1407 VPWR VPWR VGND VGND sky130_fd_sc_hd__decap_12
X$1408 VPWR VPWR VGND VGND sky130_fd_sc_hd__decap_12
X$1411 VPWR VPWR VGND VGND sky130_fd_sc_hd__decap_12
X$1412 VPWR VPWR VGND VGND sky130_fd_sc_hd__decap_12
X$1414 VPWR VPWR VGND VGND sky130_fd_sc_hd__decap_12
X$1415 VPWR VPWR VGND VGND sky130_fd_sc_hd__decap_8
X$1416 VPWR VGND \$2508 VPWR \$2511 VGND sky130_fd_sc_hd__buf_2
X$1417 VPWR VGND \$2505 VPWR \$2506 VGND sky130_fd_sc_hd__buf_2
X$1418 VPWR VGND VPWR VGND sky130_fd_sc_hd__decap_4
X$1438 VPWR FINE_MUX[12] VGND \$3053 VPWR VGND sky130_fd_sc_hd__clkdlybuf4s50_1
X$1440 VPWR VPWR VGND VGND sky130_fd_sc_hd__decap_8
X$1442 VPWR \$3093 VGND \$3030 \$3053 \$2904 VPWR VGND sky130_fd_sc_hd__maj3_1
X$1444 VPWR \$3097 VGND \$2996 \$2950 VPWR VGND
+ sky130_fd_sc_hd__lpflow_inputiso1p_1
X$1445 VPWR VPWR VGND VGND sky130_fd_sc_hd__decap_8
X$1448 VPWR VGND \$3099 \$3053 \$3097 VPWR VGND
+ sky130_fd_sc_hd__lpflow_isobufsrc_1
X$1449 VPWR VPWR VGND VGND sky130_fd_sc_hd__decap_12
X$1450 VPWR VPWR VGND VGND sky130_fd_sc_hd__decap_6
X$1452 VPWR VGND \$3001 \$2965 \$3113 VPWR VGND sky130_fd_sc_hd__xor2_1
X$1453 VPWR \$3056 VGND \$3113 \$3141 \$2879 VPWR VGND sky130_fd_sc_hd__or3_1
X$1454 VPWR VPWR VGND VGND sky130_fd_sc_hd__decap_8
X$1456 VPWR VPWR \$3062 \$3056 VGND \$2968 VGND sky130_fd_sc_hd__xnor2_1
X$1457 VPWR VGND \$2914 \$3005 \$3062 \$3058 VPWR \$2759 VGND
+ sky130_fd_sc_hd__nor4b_1
X$1458 VPWR VPWR VGND VGND sky130_fd_sc_hd__decap_6
X$1460 VGND \$3132 \$2914 \$2824 \$3064 VPWR VPWR VGND sky130_fd_sc_hd__xor3_1
X$1462 VPWR VPWR VGND VGND sky130_fd_sc_hd__decap_12
X$1463 VPWR VPWR VGND VGND sky130_fd_sc_hd__decap_12
X$1464 VPWR VPWR VGND VGND sky130_fd_sc_hd__decap_12
X$1465 VPWR VPWR VGND VGND sky130_fd_sc_hd__decap_12
X$1466 VPWR VPWR VGND VGND sky130_fd_sc_hd__decap_12
X$1467 VPWR VPWR VGND VGND sky130_fd_sc_hd__decap_12
X$1468 VPWR VPWR VGND VGND sky130_fd_sc_hd__decap_12
X$1471 VPWR VPWR VGND VGND sky130_fd_sc_hd__decap_12
X$1472 VPWR VPWR VGND VGND sky130_fd_sc_hd__decap_12
X$1473 VPWR VPWR VGND VGND sky130_fd_sc_hd__decap_6
X$1475 VPWR VGND \$3118 \$3157 \$3076 VPWR VGND
+ sky130_fd_sc_hd__lpflow_isobufsrc_1
X$1476 VPWR VPWR \$2976 \$3118 VGND \$3075 \$3115 VGND sky130_fd_sc_hd__o21ai_0
X$1477 VPWR VPWR VGND VGND sky130_fd_sc_hd__decap_12
X$1478 VPWR VPWR VGND VGND sky130_fd_sc_hd__decap_6
X$1480 VPWR \$2980 VPWR VGND \$3106 \$3194 VGND sky130_fd_sc_hd__nand2_1
X$1481 VPWR VPWR VGND VGND sky130_fd_sc_hd__decap_12
X$1482 VPWR VPWR VGND VGND sky130_fd_sc_hd__decap_8
X$1483 VPWR VGND VPWR VGND sky130_fd_sc_hd__decap_3
X$1485 VPWR VPWR VGND VGND sky130_fd_sc_hd__decap_12
X$1486 VPWR VPWR VGND VGND sky130_fd_sc_hd__decap_12
X$1487 VPWR VPWR VGND VGND sky130_fd_sc_hd__decap_12
X$1488 VPWR VPWR VGND VGND sky130_fd_sc_hd__decap_12
X$1489 VPWR VPWR VGND VGND sky130_fd_sc_hd__decap_12
X$1490 VPWR VPWR VGND VGND sky130_fd_sc_hd__decap_12
X$1491 VPWR VPWR VGND VGND sky130_fd_sc_hd__decap_12
X$1494 VPWR VPWR VGND VGND sky130_fd_sc_hd__decap_12
X$1498 VPWR VPWR VGND VGND sky130_fd_sc_hd__decap_12
X$1500 VPWR VPWR VGND VGND sky130_fd_sc_hd__decap_12
X$1501 VPWR VGND \$2996 \$3053 \$3344 VPWR VGND sky130_fd_sc_hd__xor2_1
X$1502 VPWR VPWR VGND VGND sky130_fd_sc_hd__decap_8
X$1503 VPWR VGND VPWR VGND sky130_fd_sc_hd__decap_3
X$1504 VPWR \$3102 VPWR VGND \$3099 \$2958 \$3138 VGND sky130_fd_sc_hd__nand3_1
X$1505 VPWR VGND \$2958 VPWR \$3138 \$3137 \$3099 VGND sky130_fd_sc_hd__a21oi_1
X$1506 VPWR \$3389 VPWR VGND \$3138 \$2958 VGND sky130_fd_sc_hd__nand2_1
X$1508 VPWR VPWR VGND VGND sky130_fd_sc_hd__decap_6
X$1509 VGND \$3394 \$3141 \$3001 \$2965 VPWR VPWR VGND sky130_fd_sc_hd__xnor3_1
X$1510 VPWR VPWR \$3195 \$3044 VGND \$2879 VGND sky130_fd_sc_hd__xnor2_1
X$1513 VPWR VPWR VGND VGND sky130_fd_sc_hd__decap_6
X$1514 VPWR \$3143 VGND \$3056 \$2968 \$3058 VPWR VGND sky130_fd_sc_hd__maj3_1
X$1517 VPWR \$3206 VGND \$3143 VPWR \$3005 VGND sky130_fd_sc_hd__nor2_1
X$1518 VPWR VPWR VGND VGND sky130_fd_sc_hd__decap_6
X$1520 VPWR \$3144 \$2759 \$3064 VPWR VGND \$3129 VGND sky130_fd_sc_hd__and3_1
X$1521 VPWR VPWR VGND VGND sky130_fd_sc_hd__decap_12
X$1522 VPWR VGND VPWR VGND sky130_fd_sc_hd__decap_3
X$1523 VPWR \$2921 VPWR VGND \$3214 \$3132 VGND sky130_fd_sc_hd__nand2_1
X$1524 VPWR VPWR VGND VGND sky130_fd_sc_hd__decap_8
X$1526 VPWR VGND \$3041 VPWR \$3221 \$3067 \$2977 VGND sky130_fd_sc_hd__a21oi_1
X$1527 VPWR VPWR \$3150 \$3224 VGND \$3041 VGND sky130_fd_sc_hd__xnor2_1
X$1528 VPWR VPWR VGND VGND sky130_fd_sc_hd__decap_6
X$1530 VPWR VPWR \$3068 \$3319 VGND \$3150 \$3067 VGND sky130_fd_sc_hd__o21ai_0
X$1532 VPWR VPWR \$3155 \$3227 VGND \$3068 \$3069 VGND sky130_fd_sc_hd__o21ai_0
X$1534 VPWR \$3229 \$3069 VPWR \$3477 VGND \$3068 \$3251 VGND
+ sky130_fd_sc_hd__o211ai_1
X$1535 VPWR VPWR VGND VGND sky130_fd_sc_hd__decap_12
X$1538 VPWR VPWR \$3155 \$3075 \$3071 \$3218 \$3219 \$3253 VGND VGND
+ sky130_fd_sc_hd__o2111ai_1
X$1539 VPWR VGND VPWR VGND sky130_fd_sc_hd__decap_3
X$1540 VPWR VPWR \$3156 \$3334 VGND \$3256 VGND sky130_fd_sc_hd__xnor2_1
X$1541 VPWR VGND VPWR VGND sky130_fd_sc_hd__decap_4
X$1542 VPWR \$3071 VPWR VGND \$3156 \$3072 VGND sky130_fd_sc_hd__nand2_1
X$1544 VPWR VGND \$3072 \$3156 \$3157 VPWR VGND sky130_fd_sc_hd__xor2_1
X$1545 VPWR VPWR VGND VGND sky130_fd_sc_hd__decap_12
X$1547 VPWR VGND VPWR VGND sky130_fd_sc_hd__decap_4
X$1548 VPWR \$3074 VGND \$3261 VPWR \$3208 VGND sky130_fd_sc_hd__nor2_1
X$1549 VPWR \$3157 \$3115 VPWR \$3074 VGND \$3075 \$3314 VGND
+ sky130_fd_sc_hd__o211ai_1
X$1550 VPWR VPWR \$3106 \$3076 VGND \$3157 VGND sky130_fd_sc_hd__xnor2_1
X$1552 VPWR VPWR VGND VGND sky130_fd_sc_hd__decap_8
X$1554 VPWR \$3194 VGND \$3160 \$3203 \$3107 VPWR VGND sky130_fd_sc_hd__maj3_1
X$1556 VPWR VGND \$3194 \$3106 \$3185 VPWR VGND sky130_fd_sc_hd__xor2_1
X$1557 VPWR VGND VPWR VGND sky130_fd_sc_hd__decap_3
X$1558 VPWR VPWR \$3081 \$3164 VGND \$3183 VGND sky130_fd_sc_hd__xnor2_1
X$1560 VGND \$2782 \$3171 TICK \$3181 VPWR VPWR VGND sky130_fd_sc_hd__dfrtp_1
X$1562 VPWR \$2928 VGND \$3180 \$3178 \$3171 VPWR VGND sky130_fd_sc_hd__maj3_1
X$1563 VPWR VPWR \$3373 \$3081 VGND \$3270 VGND sky130_fd_sc_hd__xnor2_1
X$1564 VPWR VPWR VGND VGND sky130_fd_sc_hd__decap_12
X$1567 VPWR VPWR VGND VGND sky130_fd_sc_hd__decap_12
X$1568 VPWR VPWR VGND VGND sky130_fd_sc_hd__decap_12
X$1570 VPWR VPWR VGND VGND sky130_fd_sc_hd__decap_12
X$1571 VPWR VPWR VGND VGND sky130_fd_sc_hd__decap_12
X$1572 VPWR VPWR VGND VGND sky130_fd_sc_hd__decap_8
X$1592 VPWR FINE_MUX[13] VGND \$3342 VPWR VGND sky130_fd_sc_hd__clkdlybuf4s50_1
X$1594 VPWR VPWR VGND VGND sky130_fd_sc_hd__decap_8
X$1596 VPWR VGND \$3093 VPWR \$2584 \$3463 \$3376 VGND sky130_fd_sc_hd__a21oi_1
X$1597 VPWR VGND \$3093 \$2584 \$3343 VPWR VGND sky130_fd_sc_hd__xor2_1
X$1598 VPWR VGND \$3376 \$3343 \$3345 VPWR VGND sky130_fd_sc_hd__nor2b_1
X$1600 VPWR VGND \$3344 \$3342 \$3543 VPWR VGND sky130_fd_sc_hd__xor2_1
X$1602 VPWR \$3348 VGND \$3231 VPWR \$3345 VGND sky130_fd_sc_hd__nor2_1
X$1603 VPWR VGND VPWR VGND sky130_fd_sc_hd__decap_4
X$1605 VPWR \$3466 VPWR VGND \$3348 \$3389 VGND sky130_fd_sc_hd__nand2_1
X$1606 VPWR VPWR VGND VGND sky130_fd_sc_hd__decap_12
X$1607 VPWR VPWR VGND VGND sky130_fd_sc_hd__decap_8
X$1609 VPWR VPWR \$3476 \$3394 VGND \$3401 \$3195 VGND sky130_fd_sc_hd__o21ai_0
X$1610 VPWR VPWR VGND VGND sky130_fd_sc_hd__decap_12
X$1611 VPWR VPWR VGND VGND sky130_fd_sc_hd__decap_12
X$1612 VPWR VPWR VGND VGND sky130_fd_sc_hd__decap_8
X$1614 VPWR \$3409 \$3129 \$3411 VPWR VGND \$3496 VGND sky130_fd_sc_hd__and3_1
X$1615 VPWR VPWR VGND VGND sky130_fd_sc_hd__decap_8
X$1618 VPWR VPWR VGND VGND sky130_fd_sc_hd__decap_12
X$1619 VPWR VPWR VGND VGND sky130_fd_sc_hd__decap_12
X$1620 VPWR VPWR VGND VGND sky130_fd_sc_hd__decap_12
X$1621 VPWR VPWR VGND VGND sky130_fd_sc_hd__decap_12
X$1622 VPWR VPWR VGND VGND sky130_fd_sc_hd__decap_12
X$1623 VPWR VGND VPWR VGND sky130_fd_sc_hd__decap_4
X$1624 VPWR \$3219 VPWR VGND \$3154 \$3417 \$3442 VGND sky130_fd_sc_hd__nand3_1
X$1625 VPWR VPWR VGND VGND sky130_fd_sc_hd__decap_12
X$1626 VPWR VGND VPWR VGND sky130_fd_sc_hd__decap_4
X$1629 VPWR VPWR VGND VGND sky130_fd_sc_hd__decap_12
X$1630 VPWR VPWR VGND VGND sky130_fd_sc_hd__decap_12
X$1631 VPWR VPWR VGND VGND sky130_fd_sc_hd__decap_12
X$1632 VPWR VPWR VGND VGND sky130_fd_sc_hd__decap_12
X$1633 VPWR VPWR VGND VGND sky130_fd_sc_hd__decap_12
X$1634 VPWR VPWR VGND VGND sky130_fd_sc_hd__decap_6
X$1636 VPWR \$3183 VGND \$3392 VPWR \$3366 VGND sky130_fd_sc_hd__nor2_1
X$1637 VPWR VPWR VGND VGND sky130_fd_sc_hd__decap_12
X$1638 VPWR VGND VPWR VGND sky130_fd_sc_hd__decap_3
X$1640 VPWR VPWR VGND VGND sky130_fd_sc_hd__decap_12
X$1641 VPWR VPWR VGND VGND sky130_fd_sc_hd__decap_6
X$1643 VPWR VPWR \$3374 \$3635 VGND \$3379 VGND sky130_fd_sc_hd__xnor2_1
X$1644 VPWR VPWR VGND VGND sky130_fd_sc_hd__decap_12
X$1645 VPWR VPWR VGND VGND sky130_fd_sc_hd__decap_12
X$1646 VPWR VPWR VGND VGND sky130_fd_sc_hd__decap_12
X$1647 VPWR VPWR VGND VGND sky130_fd_sc_hd__decap_12
X$1648 VPWR VPWR VGND VGND sky130_fd_sc_hd__decap_8
X$1649 VPWR VGND VPWR VGND sky130_fd_sc_hd__decap_3
X$1651 VPWR VPWR VGND VGND sky130_fd_sc_hd__decap_12
X$1655 VPWR VPWR VGND VGND sky130_fd_sc_hd__decap_12
X$1657 VPWR VPWR VGND VGND sky130_fd_sc_hd__decap_8
X$1658 VPWR VGND VPWR VGND sky130_fd_sc_hd__decap_3
X$1659 VPWR VPWR \$3540 \$2523 VGND \$3463 VGND sky130_fd_sc_hd__xnor2_1
X$1660 VPWR \$3345 VPWR VGND \$3342 \$3382 VGND sky130_fd_sc_hd__nand2_1
X$1661 VPWR VPWR VGND VGND sky130_fd_sc_hd__decap_12
X$1662 VPWR VPWR VGND VGND sky130_fd_sc_hd__decap_12
X$1664 VPWR VPWR VGND VGND sky130_fd_sc_hd__decap_12
X$1665 VPWR \$3655 VPWR \$3394 \$3401 VGND VGND sky130_fd_sc_hd__and2_0
X$1666 VPWR \$3430 VGND \$3401 VPWR \$3394 VGND sky130_fd_sc_hd__nor2_1
X$1667 VPWR VGND VPWR VGND sky130_fd_sc_hd__decap_3
X$1668 VPWR \$3431 \$3429 VPWR VGND \$3195 VGND sky130_fd_sc_hd__nand2b_1
X$1671 VPWR \$3058 \$3430 VPWR VGND \$3195 VGND sky130_fd_sc_hd__nand2b_1
X$1673 VPWR \$3493 \$3476 \$3409 VPWR VGND \$3058 VGND sky130_fd_sc_hd__and3_1
X$1675 VPWR VGND VPWR VGND sky130_fd_sc_hd__decap_4
X$1676 VPWR VGND \$3144 \$3299 \$3431 VPWR VGND sky130_fd_sc_hd__nor2b_1
X$1677 VPWR VPWR \$3496 \$3299 VGND \$3431 VGND sky130_fd_sc_hd__xnor2_1
X$1678 VPWR VPWR \$3435 \$3129 VGND \$3562 VGND sky130_fd_sc_hd__xnor2_1
X$1679 VPWR VPWR VGND VGND sky130_fd_sc_hd__decap_6
X$1681 VPWR VGND \$3435 VPWR \$3497 \$3436 \$3411 VGND sky130_fd_sc_hd__a21oi_1
X$1682 VPWR \$3247 VPWR VGND \$3497 \$3435 VGND sky130_fd_sc_hd__nand2_1
X$1684 VPWR VPWR \$3501 \$3241 VGND \$3436 VGND sky130_fd_sc_hd__xnor2_1
X$1686 VPWR VPWR VGND VGND sky130_fd_sc_hd__decap_12
X$1687 VPWR VPWR \$3438 \$3683 VGND \$3502 VGND sky130_fd_sc_hd__xnor2_1
X$1688 VPWR VGND VPWR VGND sky130_fd_sc_hd__decap_4
X$1689 VPWR \$3477 VGND \$3438 VPWR \$3503 VGND sky130_fd_sc_hd__nor2_1
X$1692 VPWR VPWR VGND VGND sky130_fd_sc_hd__decap_8
X$1694 VPWR \$3355 VPWR VGND \$3439 \$3507 VGND sky130_fd_sc_hd__nand2_1
X$1697 VPWR VPWR \$3442 \$3441 VGND \$3439 VGND sky130_fd_sc_hd__xnor2_1
X$1698 VPWR VGND VPWR VGND sky130_fd_sc_hd__decap_4
X$1700 VPWR \$3257 VGND \$3417 \$3442 \$3589 VPWR VGND sky130_fd_sc_hd__maj3_1
X$1701 VPWR VPWR VGND VGND sky130_fd_sc_hd__decap_12
X$1702 VPWR VPWR \$3696 \$3513 VGND \$3615 \$3471 VGND sky130_fd_sc_hd__o21ai_0
X$1703 VPWR VPWR VGND VGND sky130_fd_sc_hd__decap_12
X$1705 VPWR VPWR VGND VGND sky130_fd_sc_hd__decap_6
X$1706 VPWR \$3208 VPWR VGND \$3515 \$3574 \$3618 VGND sky130_fd_sc_hd__nand3_1
X$1707 VPWR VPWR VGND VGND sky130_fd_sc_hd__decap_6
X$1708 VPWR \$3313 VPWR VGND \$3571 \$3444 VGND sky130_fd_sc_hd__nand2_1
X$1709 VPWR VGND VPWR VGND sky130_fd_sc_hd__decap_4
X$1712 VPWR VGND VPWR VGND sky130_fd_sc_hd__decap_4
X$1714 VPWR \$3311 VPWR VGND \$3519 \$3444 VGND sky130_fd_sc_hd__nand2_1
X$1715 VPWR \$3519 VGND \$3447 VPWR \$3445 VGND sky130_fd_sc_hd__nor2_1
X$1716 VPWR VPWR VGND VGND sky130_fd_sc_hd__decap_6
X$1718 VPWR \$3107 VGND \$3392 VPWR \$3523 VGND sky130_fd_sc_hd__nor2_1
X$1720 VPWR \$3523 \$3392 \$3452 VPWR VGND \$3366 VGND sky130_fd_sc_hd__and3_1
X$1721 VPWR \$3525 VGND \$3452 \$3183 \$3107 VPWR VGND sky130_fd_sc_hd__or3_1
X$1722 VPWR VGND VPWR VGND sky130_fd_sc_hd__decap_4
X$1723 VGND \$2782 \$3547 TICK \$3549 VPWR VPWR VGND sky130_fd_sc_hd__dfrtp_1
X$1724 VPWR VGND VPWR VGND sky130_fd_sc_hd__decap_4
X$1727 VPWR \$3271 VGND \$3525 \$3379 \$3528 VPWR VGND sky130_fd_sc_hd__maj3_1
X$1728 VPWR VPWR VGND VGND sky130_fd_sc_hd__decap_12
X$1729 VPWR VGND VPWR VGND sky130_fd_sc_hd__decap_4
X$1732 VPWR VPWR VGND VGND sky130_fd_sc_hd__decap_12
X$1733 VPWR VPWR VGND VGND sky130_fd_sc_hd__decap_12
X$1735 VPWR VPWR VGND VGND sky130_fd_sc_hd__decap_12
X$1736 VPWR VPWR VGND VGND sky130_fd_sc_hd__decap_12
X$1737 VPWR VPWR VGND VGND sky130_fd_sc_hd__decap_8
X$1757 VPWR VGND VPWR VGND sky130_fd_sc_hd__decap_4
X$1760 VPWR VPWR \$1833 \$1564 VGND \$1667 VGND sky130_fd_sc_hd__xnor2_1
X$1761 VPWR \$1834 VPWR \$1832 \$1833 VGND VGND sky130_fd_sc_hd__and2_0
X$1762 VPWR VGND VPWR VGND sky130_fd_sc_hd__decap_4
X$1763 VPWR \$1875 VPWR VGND \$1651 \$1793 \$1833 VGND sky130_fd_sc_hd__nand3_1
X$1764 VPWR VPWR VGND VGND sky130_fd_sc_hd__decap_8
X$1766 VPWR VGND \$894 \$1654 \$1881 VPWR VGND sky130_fd_sc_hd__xor2_1
X$1768 VPWR VPWR VGND VGND sky130_fd_sc_hd__decap_12
X$1769 VPWR VPWR VGND VGND sky130_fd_sc_hd__decap_12
X$1771 VGND \$1893 \$1808 \$1621 \$1735 VPWR VPWR VGND sky130_fd_sc_hd__mux2_1
X$1772 VPWR VPWR VGND VGND sky130_fd_sc_hd__decap_12
X$1774 VPWR VGND \$1846 \$1814 \$1896 VPWR VGND sky130_fd_sc_hd__xor2_1
X$1775 VPWR \$1849 VPWR VGND \$1814 \$1846 VGND sky130_fd_sc_hd__nand2_1
X$1776 VGND \$1901 \$1769 \$1849 \$1823 VPWR VPWR VGND sky130_fd_sc_hd__xnor3_1
X$1777 VPWR VPWR VGND VGND sky130_fd_sc_hd__decap_8
X$1780 VPWR VPWR VGND VGND sky130_fd_sc_hd__decap_12
X$1781 VPWR VPWR VGND VGND sky130_fd_sc_hd__decap_12
X$1782 VPWR VPWR VGND VGND sky130_fd_sc_hd__decap_12
X$1783 VPWR VPWR VGND VGND sky130_fd_sc_hd__decap_12
X$1784 VPWR VPWR VGND VGND sky130_fd_sc_hd__decap_12
X$1785 VPWR VPWR VGND VGND sky130_fd_sc_hd__decap_12
X$1786 VPWR VPWR VGND VGND sky130_fd_sc_hd__decap_12
X$1789 VPWR VPWR VGND VGND sky130_fd_sc_hd__decap_12
X$1790 VPWR VPWR VGND VGND sky130_fd_sc_hd__decap_12
X$1791 VPWR VPWR VGND VGND sky130_fd_sc_hd__decap_12
X$1792 VPWR VPWR VGND VGND sky130_fd_sc_hd__decap_12
X$1793 VPWR VPWR VGND VGND sky130_fd_sc_hd__decap_12
X$1794 VPWR VPWR VGND VGND sky130_fd_sc_hd__decap_12
X$1795 VPWR VPWR VGND VGND sky130_fd_sc_hd__decap_12
X$1798 VPWR VPWR VGND VGND sky130_fd_sc_hd__decap_12
X$1799 VPWR VPWR VGND VGND sky130_fd_sc_hd__decap_12
X$1800 VPWR VPWR VGND VGND sky130_fd_sc_hd__decap_12
X$1801 VPWR VPWR VGND VGND sky130_fd_sc_hd__decap_12
X$1802 VPWR VPWR VGND VGND sky130_fd_sc_hd__decap_12
X$1803 VPWR VPWR VGND VGND sky130_fd_sc_hd__decap_12
X$1804 VPWR VPWR VGND VGND sky130_fd_sc_hd__decap_8
X$1805 VPWR \$1641 VPWR \$1785 \$1472 \$1784 \$1799 VGND VGND
+ sky130_fd_sc_hd__nand4_1
X$1807 VPWR \$1888 VGND \$1799 \$1784 \$1785 VPWR VGND sky130_fd_sc_hd__maj3_1
X$1808 VPWR VGND VPWR VGND sky130_fd_sc_hd__decap_4
X$1812 VGND \$1950 \$1564 \$1832 \$1667 VPWR VPWR VGND sky130_fd_sc_hd__xnor3_1
X$1814 VPWR \$1927 VPWR VGND \$1834 \$1793 VGND sky130_fd_sc_hd__nand2_1
X$1815 VPWR VPWR VGND VGND sky130_fd_sc_hd__decap_6
X$1817 VPWR VPWR \$1838 \$1836 VGND \$1875 \$1832 VGND sky130_fd_sc_hd__o21ai_0
X$1818 VPWR VPWR VGND VGND sky130_fd_sc_hd__decap_12
X$1819 VPWR VPWR VGND VGND sky130_fd_sc_hd__decap_8
X$1822 VPWR VGND \$1844 \$1841 \$1589 VPWR VGND sky130_fd_sc_hd__nor2b_1
X$1823 VPWR \$1977 VGND \$1844 \$1838 VPWR \$1735 VGND sky130_fd_sc_hd__nor3b_1
X$1824 VPWR VPWR VGND VGND sky130_fd_sc_hd__decap_12
X$1825 VPWR VPWR VGND VGND sky130_fd_sc_hd__decap_8
X$1827 VPWR VPWR VGND VGND sky130_fd_sc_hd__decap_12
X$1829 VPWR VPWR VGND VGND sky130_fd_sc_hd__decap_6
X$1830 VPWR VGND \$1769 \$1823 \$1905 VPWR VGND sky130_fd_sc_hd__xor2_1
X$1831 VPWR VPWR VGND VGND sky130_fd_sc_hd__decap_8
X$1833 VPWR \$1970 VGND \$1829 VPWR \$1851 VGND sky130_fd_sc_hd__nor2_1
X$1834 VPWR VGND \$1829 \$1851 \$1912 VPWR VGND sky130_fd_sc_hd__xor2_1
X$1835 VPWR \$1972 VPWR VGND \$1851 \$1829 VGND sky130_fd_sc_hd__nand2_1
X$1836 VPWR VPWR VGND VGND sky130_fd_sc_hd__decap_12
X$1838 VPWR VPWR VGND VGND sky130_fd_sc_hd__decap_12
X$1839 VPWR VPWR VGND VGND sky130_fd_sc_hd__decap_12
X$1842 VPWR VPWR VGND VGND sky130_fd_sc_hd__decap_12
X$1844 VPWR VPWR VGND VGND sky130_fd_sc_hd__decap_12
X$1845 VPWR VPWR VGND VGND sky130_fd_sc_hd__decap_12
X$1846 VPWR VPWR VGND VGND sky130_fd_sc_hd__decap_12
X$1847 VPWR VPWR VGND VGND sky130_fd_sc_hd__decap_12
X$1849 VPWR VPWR VGND VGND sky130_fd_sc_hd__decap_12
X$1850 VPWR VPWR VGND VGND sky130_fd_sc_hd__decap_12
X$1853 VPWR VPWR VGND VGND sky130_fd_sc_hd__decap_12
X$1854 VPWR VPWR VGND VGND sky130_fd_sc_hd__decap_12
X$1856 VPWR VPWR VGND VGND sky130_fd_sc_hd__decap_12
X$1857 VPWR VPWR VGND VGND sky130_fd_sc_hd__decap_12
X$1858 VPWR VPWR VGND VGND sky130_fd_sc_hd__decap_12
X$1860 VPWR VPWR VGND VGND sky130_fd_sc_hd__decap_12
X$1861 VPWR VPWR VGND VGND sky130_fd_sc_hd__decap_12
X$1864 VPWR VPWR VGND VGND sky130_fd_sc_hd__decap_12
X$1865 VPWR VPWR VGND VGND sky130_fd_sc_hd__decap_12
X$1867 VPWR VPWR VGND VGND sky130_fd_sc_hd__decap_12
X$1868 VPWR VPWR VGND VGND sky130_fd_sc_hd__decap_12
X$1869 VPWR COARSE_MUX[0] VGND \$1784 VPWR VGND sky130_fd_sc_hd__clkdlybuf4s50_1
X$1889 VPWR VGND VPWR VGND sky130_fd_sc_hd__decap_4
X$1892 VPWR VGND \$2263 \$2327 \$2362 VPWR VGND sky130_fd_sc_hd__xor2_1
X$1893 VPWR VPWR VGND \$2294 \$2330 VGND sky130_fd_sc_hd__clkinv_1
X$1894 VPWR \$2265 VPWR \$2327 \$2333 \$2263 \$2294 VGND VGND
+ sky130_fd_sc_hd__nand4_1
X$1895 VPWR VPWR VGND VGND sky130_fd_sc_hd__decap_12
X$1896 VPWR \$2337 VPWR VGND \$2327 \$2304 VGND sky130_fd_sc_hd__nand2_1
X$1897 VPWR VPWR \$2366 VGND \$2136 \$2193 \$2266 \$2333 VGND
+ sky130_fd_sc_hd__a211o_1
X$1899 VPWR VPWR VGND VGND sky130_fd_sc_hd__decap_12
X$1900 VPWR VGND VPWR VGND sky130_fd_sc_hd__decap_3
X$1901 VPWR VPWR \$2449 \$2271 VGND \$2337 VGND sky130_fd_sc_hd__xnor2_1
X$1903 VPWR VGND \$2251 \$2313 \$2386 VPWR VGND sky130_fd_sc_hd__xor2_1
X$1904 VPWR VPWR VGND VGND sky130_fd_sc_hd__decap_12
X$1905 VPWR VPWR VGND VGND sky130_fd_sc_hd__decap_6
X$1906 VPWR \$2381 \$2339 VPWR VGND \$2406 VGND sky130_fd_sc_hd__nand2b_1
X$1907 VPWR VPWR VGND VGND sky130_fd_sc_hd__decap_8
X$1908 VPWR \$2376 VPWR VGND \$2318 \$2377 \$2380 VGND sky130_fd_sc_hd__nand3_1
X$1909 VPWR VPWR VGND VGND sky130_fd_sc_hd__decap_8
X$1910 VPWR VGND VPWR VGND sky130_fd_sc_hd__decap_3
X$1911 VPWR \$2469 VGND \$2373 \$2375 \$2376 VPWR VGND sky130_fd_sc_hd__maj3_1
X$1913 VPWR VPWR VGND VGND sky130_fd_sc_hd__decap_12
X$1914 VPWR VPWR VGND VGND sky130_fd_sc_hd__decap_12
X$1915 VPWR VPWR VGND VGND sky130_fd_sc_hd__decap_12
X$1916 VPWR VPWR VGND VGND sky130_fd_sc_hd__decap_12
X$1917 VPWR VPWR VGND VGND sky130_fd_sc_hd__decap_12
X$1918 VPWR VPWR VGND VGND sky130_fd_sc_hd__decap_12
X$1919 VPWR VPWR VGND VGND sky130_fd_sc_hd__decap_12
X$1922 VPWR VPWR VGND VGND sky130_fd_sc_hd__decap_12
X$1923 VPWR VPWR VGND VGND sky130_fd_sc_hd__decap_12
X$1924 VPWR VPWR VGND VGND sky130_fd_sc_hd__decap_12
X$1925 VPWR VPWR VGND VGND sky130_fd_sc_hd__decap_12
X$1926 VPWR VPWR VGND VGND sky130_fd_sc_hd__decap_12
X$1927 VPWR VPWR VGND VGND sky130_fd_sc_hd__decap_12
X$1928 VPWR VPWR VGND VGND sky130_fd_sc_hd__decap_12
X$1931 VPWR VPWR VGND VGND sky130_fd_sc_hd__decap_12
X$1932 VPWR VPWR VGND VGND sky130_fd_sc_hd__decap_12
X$1933 VPWR VPWR VGND VGND sky130_fd_sc_hd__decap_12
X$1934 VPWR VPWR VGND VGND sky130_fd_sc_hd__decap_12
X$1935 VPWR VPWR VGND VGND sky130_fd_sc_hd__decap_12
X$1936 VPWR VPWR VGND VGND sky130_fd_sc_hd__decap_12
X$1937 VPWR VPWR VGND VGND sky130_fd_sc_hd__decap_12
X$1940 VPWR VPWR VGND VGND sky130_fd_sc_hd__decap_12
X$1944 VPWR VGND VPWR VGND sky130_fd_sc_hd__decap_4
X$1945 VPWR \$2391 VGND \$2263 \$2422 \$2327 VPWR VGND sky130_fd_sc_hd__maj3_1
X$1948 VPWR \$2362 \$2265 \$2398 VPWR VGND \$2294 VGND sky130_fd_sc_hd__and3_1
X$1949 VPWR VPWR VGND VGND sky130_fd_sc_hd__decap_12
X$1950 VPWR VPWR VGND VGND sky130_fd_sc_hd__decap_12
X$1951 VPWR VPWR VGND VGND sky130_fd_sc_hd__decap_8
X$1952 VGND \$2590 \$2271 \$2400 \$2337 VPWR VPWR VGND sky130_fd_sc_hd__xnor3_1
X$1954 VPWR VPWR VGND VGND sky130_fd_sc_hd__decap_6
X$1955 VPWR \$2406 VPWR VGND \$2402 \$2386 \$2456 VGND sky130_fd_sc_hd__nand3_1
X$1956 VPWR VPWR VGND VGND sky130_fd_sc_hd__decap_6
X$1958 VPWR VGND VPWR VGND sky130_fd_sc_hd__decap_4
X$1959 VPWR VPWR \$2377 \$2339 VGND \$2406 VGND sky130_fd_sc_hd__xnor2_1
X$1961 VPWR VGND VPWR VGND sky130_fd_sc_hd__decap_3
X$1962 VPWR \$2377 VGND \$2381 VPWR \$2467 \$2380 VGND sky130_fd_sc_hd__a21boi_0
X$1963 VPWR \$2375 \$2318 VPWR VGND \$2381 VGND sky130_fd_sc_hd__nand2b_1
X$1964 VPWR VGND VPWR VGND sky130_fd_sc_hd__decap_4
X$1966 VGND \$2470 \$2373 \$2375 \$2376 VPWR VPWR VGND sky130_fd_sc_hd__xor3_1
X$1967 VPWR VPWR VGND VGND sky130_fd_sc_hd__decap_12
X$1969 VPWR VPWR VGND VGND sky130_fd_sc_hd__decap_12
X$1970 VPWR VPWR VGND VGND sky130_fd_sc_hd__decap_12
X$1972 VPWR VPWR VGND VGND sky130_fd_sc_hd__decap_12
X$1974 VPWR VPWR VGND VGND sky130_fd_sc_hd__decap_12
X$1975 VPWR VPWR VGND VGND sky130_fd_sc_hd__decap_12
X$1976 VPWR VPWR VGND VGND sky130_fd_sc_hd__decap_12
X$1977 VPWR VPWR VGND VGND sky130_fd_sc_hd__decap_12
X$1979 VPWR VPWR VGND VGND sky130_fd_sc_hd__decap_12
X$1980 VPWR VPWR VGND VGND sky130_fd_sc_hd__decap_12
X$1983 VPWR VPWR VGND VGND sky130_fd_sc_hd__decap_12
X$1984 VPWR VPWR VGND VGND sky130_fd_sc_hd__decap_12
X$1986 VPWR VPWR VGND VGND sky130_fd_sc_hd__decap_12
X$1987 VPWR VPWR VGND VGND sky130_fd_sc_hd__decap_12
X$1988 VPWR VPWR VGND VGND sky130_fd_sc_hd__decap_12
X$1990 VPWR VPWR VGND VGND sky130_fd_sc_hd__decap_12
X$1991 VPWR VPWR VGND VGND sky130_fd_sc_hd__decap_12
X$1994 VPWR VPWR VGND VGND sky130_fd_sc_hd__decap_12
X$1995 VPWR VPWR VGND VGND sky130_fd_sc_hd__decap_12
X$1997 VPWR VPWR VGND VGND sky130_fd_sc_hd__decap_12
X$1998 VPWR VPWR VGND VGND sky130_fd_sc_hd__decap_12
X$1999 VPWR VPWR VGND VGND sky130_fd_sc_hd__decap_8
X$2019 VPWR VGND VPWR VGND sky130_fd_sc_hd__decap_4
X$2021 VPWR VPWR VGND \$2155 \$2191 VGND sky130_fd_sc_hd__clkinv_1
X$2022 VPWR \$1959 \$2227 VPWR \$2155 VGND \$2130 \$2103 VGND
+ sky130_fd_sc_hd__o211ai_1
X$2023 VPWR \$2135 VGND \$2130 \$1959 VPWR VGND
+ sky130_fd_sc_hd__lpflow_inputiso1p_1
X$2024 VPWR VPWR VGND VGND sky130_fd_sc_hd__decap_6
X$2025 VPWR VPWR VGND \$2168 \$2135 VGND sky130_fd_sc_hd__clkinv_1
X$2026 VPWR VGND \$1985 \$1984 \$2190 VPWR VGND sky130_fd_sc_hd__xor2_1
X$2027 VPWR \$2191 \$2136 VPWR VGND \$1985 \$2137 \$2135 VGND
+ sky130_fd_sc_hd__o31ai_1
X$2030 VPWR VPWR VGND VGND sky130_fd_sc_hd__decap_6
X$2031 VGND \$2271 \$2137 \$2035 \$2071 VPWR VPWR VGND sky130_fd_sc_hd__xnor3_1
X$2032 VPWR \$2247 VGND \$2142 VPWR \$2140 VGND sky130_fd_sc_hd__nor2_1
X$2033 VPWR VPWR VGND VGND sky130_fd_sc_hd__decap_12
X$2034 VPWR VGND VPWR VGND sky130_fd_sc_hd__decap_4
X$2036 VPWR VPWR \$2199 \$2143 VGND \$2182 VGND sky130_fd_sc_hd__xnor2_1
X$2037 VPWR VPWR VGND VGND sky130_fd_sc_hd__decap_8
X$2038 VPWR VGND VPWR VGND sky130_fd_sc_hd__decap_3
X$2039 VPWR \$2082 \$2316 VGND \$1973 \$2059 VPWR VGND sky130_fd_sc_hd__nor3_1
X$2040 VPWR \$2205 VPWR VGND \$2059 \$1973 \$2082 \$2085 VGND
+ sky130_fd_sc_hd__o31a_1
X$2041 VPWR VGND VPWR VGND sky130_fd_sc_hd__decap_4
X$2043 VPWR VPWR \$2204 \$2088 VGND \$2086 VGND sky130_fd_sc_hd__xnor2_1
X$2045 VPWR VPWR VGND VGND sky130_fd_sc_hd__decap_8
X$2047 VPWR \$2174 VPWR VGND \$2255 \$2172 VGND sky130_fd_sc_hd__nand2_1
X$2048 VPWR VPWR VGND VGND sky130_fd_sc_hd__decap_12
X$2049 VPWR VPWR VGND VGND sky130_fd_sc_hd__decap_12
X$2050 VPWR VPWR VGND VGND sky130_fd_sc_hd__decap_12
X$2051 VPWR VPWR VGND VGND sky130_fd_sc_hd__decap_12
X$2052 VPWR VPWR VGND VGND sky130_fd_sc_hd__decap_12
X$2053 VPWR VPWR VGND VGND sky130_fd_sc_hd__decap_12
X$2056 VPWR VPWR VGND VGND sky130_fd_sc_hd__decap_12
X$2057 VPWR VPWR VGND VGND sky130_fd_sc_hd__decap_12
X$2058 VPWR VPWR VGND VGND sky130_fd_sc_hd__decap_12
X$2059 VPWR VPWR VGND VGND sky130_fd_sc_hd__decap_12
X$2060 VPWR VPWR VGND VGND sky130_fd_sc_hd__decap_12
X$2061 VPWR VPWR VGND VGND sky130_fd_sc_hd__decap_12
X$2062 VPWR VPWR VGND VGND sky130_fd_sc_hd__decap_12
X$2065 VPWR VPWR VGND VGND sky130_fd_sc_hd__decap_12
X$2066 VPWR VPWR VGND VGND sky130_fd_sc_hd__decap_12
X$2067 VPWR VPWR VGND VGND sky130_fd_sc_hd__decap_12
X$2068 VPWR VPWR VGND VGND sky130_fd_sc_hd__decap_12
X$2069 VPWR VPWR VGND VGND sky130_fd_sc_hd__decap_12
X$2070 VPWR VPWR VGND VGND sky130_fd_sc_hd__decap_12
X$2071 VPWR VPWR VGND VGND sky130_fd_sc_hd__decap_12
X$2074 VPWR VPWR VGND VGND sky130_fd_sc_hd__decap_12
X$2078 VPWR VPWR VGND VGND sky130_fd_sc_hd__decap_12
X$2080 VPWR \$2330 VPWR VGND \$1984 \$2227 \$2189 VGND sky130_fd_sc_hd__nand3_1
X$2081 VPWR VPWR VGND VGND sky130_fd_sc_hd__decap_8
X$2083 VPWR \$2189 VPWR VGND \$2191 \$2168 VGND sky130_fd_sc_hd__nand2_1
X$2084 VPWR \$2193 VPWR VGND \$2190 \$2168 \$2191 VGND sky130_fd_sc_hd__nand3_1
X$2085 VPWR VPWR VGND VGND sky130_fd_sc_hd__decap_12
X$2086 VPWR VPWR VGND VGND sky130_fd_sc_hd__decap_12
X$2088 VPWR \$2137 \$2142 VGND \$2244 \$2140 VPWR VGND sky130_fd_sc_hd__nor3_1
X$2090 VPWR VPWR \$2251 \$2247 VGND \$1991 VGND sky130_fd_sc_hd__xnor2_1
X$2091 VPWR VPWR VGND VGND sky130_fd_sc_hd__decap_12
X$2092 VPWR VGND VPWR VGND sky130_fd_sc_hd__decap_3
X$2094 VPWR VPWR \$2201 \$2076 VGND \$2049 VGND sky130_fd_sc_hd__xnor2_1
X$2095 VPWR VPWR VGND VGND sky130_fd_sc_hd__decap_12
X$2097 VPWR VPWR VGND VGND sky130_fd_sc_hd__decap_12
X$2099 VPWR VGND \$2255 \$2205 \$2204 \$2276 VPWR \$2087 VGND
+ sky130_fd_sc_hd__nor4b_1
X$2100 VPWR VPWR VGND VGND sky130_fd_sc_hd__decap_8
X$2102 VPWR VGND \$2172 \$2255 \$2411 VPWR VGND sky130_fd_sc_hd__xor2_1
X$2104 VPWR VPWR VGND VGND sky130_fd_sc_hd__decap_12
X$2105 VPWR VPWR VGND VGND sky130_fd_sc_hd__decap_12
X$2106 VPWR VPWR VGND VGND sky130_fd_sc_hd__decap_6
X$2108 VPWR VPWR VGND VGND sky130_fd_sc_hd__decap_12
X$2110 VPWR VPWR VGND VGND sky130_fd_sc_hd__decap_12
X$2111 VPWR VPWR VGND VGND sky130_fd_sc_hd__decap_12
X$2112 VPWR VPWR VGND VGND sky130_fd_sc_hd__decap_12
X$2113 VPWR VPWR VGND VGND sky130_fd_sc_hd__decap_12
X$2115 VPWR VPWR VGND VGND sky130_fd_sc_hd__decap_12
X$2116 VPWR VPWR VGND VGND sky130_fd_sc_hd__decap_12
X$2119 VPWR VPWR VGND VGND sky130_fd_sc_hd__decap_12
X$2120 VPWR VPWR VGND VGND sky130_fd_sc_hd__decap_12
X$2122 VPWR VPWR VGND VGND sky130_fd_sc_hd__decap_12
X$2123 VPWR VPWR VGND VGND sky130_fd_sc_hd__decap_12
X$2124 VPWR VPWR VGND VGND sky130_fd_sc_hd__decap_12
X$2126 VPWR VPWR VGND VGND sky130_fd_sc_hd__decap_12
X$2127 VPWR VPWR VGND VGND sky130_fd_sc_hd__decap_12
X$2130 VPWR VPWR VGND VGND sky130_fd_sc_hd__decap_12
X$2131 VPWR VPWR VGND VGND sky130_fd_sc_hd__decap_12
X$2133 VPWR VPWR VGND VGND sky130_fd_sc_hd__decap_12
X$2134 VPWR VPWR VGND VGND sky130_fd_sc_hd__decap_12
X$2135 VPWR VPWR VGND VGND sky130_fd_sc_hd__decap_8
X$2155 VPWR VGND VPWR VGND sky130_fd_sc_hd__decap_4
X$2158 VPWR \$1687 \$1667 VPWR VGND \$1564 VGND sky130_fd_sc_hd__nand2b_1
X$2159 VPWR VPWR VGND VGND sky130_fd_sc_hd__decap_8
X$2160 VPWR VGND VPWR VGND sky130_fd_sc_hd__decap_3
X$2161 VPWR \$1796 VGND \$1649 VPWR \$1687 VGND sky130_fd_sc_hd__nor2_1
X$2162 VPWR \$1437 \$1762 VGND \$1649 \$1687 VPWR VGND sky130_fd_sc_hd__nor3_1
X$2163 VPWR VPWR VGND VGND sky130_fd_sc_hd__decap_12
X$2166 VPWR VGND VPWR VGND sky130_fd_sc_hd__decap_4
X$2167 VPWR VPWR \$1661 \$894 VGND \$1654 VGND sky130_fd_sc_hd__xnor2_1
X$2168 VPWR VPWR \$1735 \$1589 \$1661 VGND \$1437 \$1576 \$1667 VGND
+ sky130_fd_sc_hd__o311ai_0
X$2169 VPWR VPWR VGND VGND sky130_fd_sc_hd__decap_12
X$2170 VPWR \$1693 VGND \$1735 \$1621 VPWR VGND
+ sky130_fd_sc_hd__lpflow_inputiso1p_1
X$2171 VPWR \$1672 VGND \$1693 VPWR \$1812 \$1592 VGND sky130_fd_sc_hd__a21boi_0
X$2172 VPWR \$1696 VPWR VGND \$1592 \$1672 VGND sky130_fd_sc_hd__nand2_1
X$2173 VPWR VGND VPWR VGND sky130_fd_sc_hd__decap_4
X$2175 VPWR VGND \$1680 \$1625 \$1846 VPWR VGND sky130_fd_sc_hd__xor2_1
X$2176 VPWR \$1823 VGND \$1696 \$1601 \$1625 VPWR VGND sky130_fd_sc_hd__or3_1
X$2177 VPWR VPWR VGND VGND sky130_fd_sc_hd__decap_8
X$2178 VPWR VGND VPWR VGND sky130_fd_sc_hd__decap_3
X$2179 VPWR VGND \$1627 \$1626 \$1769 VPWR VGND sky130_fd_sc_hd__xor2_1
X$2180 VPWR VPWR VGND VGND sky130_fd_sc_hd__decap_6
X$2182 VPWR VPWR VGND VGND sky130_fd_sc_hd__decap_8
X$2183 VPWR \$1822 VPWR VGND \$1700 \$1521 VGND sky130_fd_sc_hd__nand2_1
X$2184 VPWR \$1757 VPWR \$1521 \$1747 VGND \$1818 \$1666 \$1700 VGND
+ sky130_fd_sc_hd__a311oi_1
X$2185 VPWR \$1818 VGND \$1668 VPWR \$1607 VGND sky130_fd_sc_hd__nor2_1
X$2186 VPWR VPWR VGND VGND sky130_fd_sc_hd__decap_12
X$2187 VPWR VPWR VGND VGND sky130_fd_sc_hd__decap_12
X$2188 VPWR VPWR VGND VGND sky130_fd_sc_hd__decap_12
X$2189 VPWR VPWR VGND VGND sky130_fd_sc_hd__decap_12
X$2190 VPWR VPWR VGND VGND sky130_fd_sc_hd__decap_12
X$2191 VPWR VGND VPWR VGND sky130_fd_sc_hd__decap_4
X$2193 VPWR VPWR VGND VGND sky130_fd_sc_hd__decap_12
X$2194 VPWR VPWR VGND VGND sky130_fd_sc_hd__decap_12
X$2195 VPWR VPWR VGND VGND sky130_fd_sc_hd__decap_12
X$2196 VPWR VPWR VGND VGND sky130_fd_sc_hd__decap_12
X$2197 VPWR VPWR VGND VGND sky130_fd_sc_hd__decap_12
X$2198 VPWR VPWR VGND VGND sky130_fd_sc_hd__decap_12
X$2199 VPWR VPWR VGND VGND sky130_fd_sc_hd__decap_12
X$2202 VPWR VPWR VGND VGND sky130_fd_sc_hd__decap_12
X$2203 VPWR VPWR VGND VGND sky130_fd_sc_hd__decap_12
X$2204 VPWR VPWR VGND VGND sky130_fd_sc_hd__decap_12
X$2205 VPWR VPWR VGND VGND sky130_fd_sc_hd__decap_12
X$2206 VPWR VPWR VGND VGND sky130_fd_sc_hd__decap_12
X$2207 VPWR VPWR VGND VGND sky130_fd_sc_hd__decap_12
X$2208 VPWR VPWR VGND VGND sky130_fd_sc_hd__decap_8
X$2209 VPWR VGND \$1462 \$1472 \$1711 VPWR VGND
+ sky130_fd_sc_hd__lpflow_isobufsrc_1
X$2211 VPWR VGND \$1585 VPWR \$1641 \$1711 \$1888 VGND sky130_fd_sc_hd__a21oi_1
X$2213 VPWR COARSE_MUX[1] VGND \$1785 VPWR VGND sky130_fd_sc_hd__clkdlybuf4s50_1
X$2216 VPWR VPWR VGND VGND sky130_fd_sc_hd__decap_8
X$2217 VPWR VGND VPWR VGND sky130_fd_sc_hd__decap_3
X$2221 VPWR VPWR \$1794 \$1793 VGND \$1687 VGND sky130_fd_sc_hd__xnor2_1
X$2222 VPWR VGND VPWR VGND sky130_fd_sc_hd__decap_4
X$2224 VPWR VPWR \$1796 \$1651 \$1926 \$1762 VGND VGND sky130_fd_sc_hd__o21bai_1
X$2225 VPWR VGND VPWR VGND sky130_fd_sc_hd__decap_4
X$2226 VGND \$1836 \$894 \$1654 \$1762 VPWR VPWR VGND sky130_fd_sc_hd__xnor3_1
X$2227 VPWR VPWR VGND VGND sky130_fd_sc_hd__decap_12
X$2231 VPWR VPWR VGND VGND sky130_fd_sc_hd__decap_6
X$2233 VPWR VPWR \$1808 \$1621 VGND \$1592 VGND sky130_fd_sc_hd__xnor2_1
X$2235 VPWR VPWR \$1810 \$1812 VGND \$1601 VGND sky130_fd_sc_hd__xnor2_1
X$2237 VPWR \$1814 VGND \$1601 VPWR \$1693 VGND sky130_fd_sc_hd__nor2_1
X$2238 VPWR VPWR VGND VGND sky130_fd_sc_hd__decap_12
X$2242 VPWR VPWR VGND VGND sky130_fd_sc_hd__decap_8
X$2244 VPWR \$1851 VGND \$1769 \$1849 \$1823 VPWR VGND sky130_fd_sc_hd__maj3_1
X$2245 VPWR VGND VPWR VGND sky130_fd_sc_hd__decap_4
X$2247 VPWR VGND \$1521 \$1674 \$1829 VPWR VGND sky130_fd_sc_hd__xor2_1
X$2248 VPWR VGND VPWR VGND sky130_fd_sc_hd__decap_4
X$2249 VGND \$1817 \$1668 \$1607 \$1822 VPWR VPWR VGND sky130_fd_sc_hd__xnor3_1
X$2253 VPWR VPWR VGND VGND sky130_fd_sc_hd__decap_12
X$2254 VPWR VPWR VGND VGND sky130_fd_sc_hd__decap_6
X$2256 VPWR VPWR VGND VGND sky130_fd_sc_hd__decap_12
X$2260 VPWR VPWR VGND VGND sky130_fd_sc_hd__decap_12
X$2261 VPWR VPWR VGND VGND sky130_fd_sc_hd__decap_12
X$2262 VPWR VPWR VGND VGND sky130_fd_sc_hd__decap_12
X$2263 VPWR VPWR VGND VGND sky130_fd_sc_hd__decap_12
X$2267 VPWR VPWR VGND VGND sky130_fd_sc_hd__decap_12
X$2268 VPWR VPWR VGND VGND sky130_fd_sc_hd__decap_12
X$2271 VPWR VPWR VGND VGND sky130_fd_sc_hd__decap_12
X$2272 VPWR VPWR VGND VGND sky130_fd_sc_hd__decap_12
X$2276 VPWR VPWR VGND VGND sky130_fd_sc_hd__decap_12
X$2277 VPWR VPWR VGND VGND sky130_fd_sc_hd__decap_12
X$2278 VPWR VPWR VGND VGND sky130_fd_sc_hd__decap_12
X$2282 VPWR VPWR VGND VGND sky130_fd_sc_hd__decap_12
X$2283 VPWR VPWR VGND VGND sky130_fd_sc_hd__decap_12
X$2286 VPWR VPWR VGND VGND sky130_fd_sc_hd__decap_12
X$2287 VPWR VPWR VGND VGND sky130_fd_sc_hd__decap_12
X$2291 VPWR VGND VPWR VGND sky130_fd_sc_hd__decap_4
X$2293 VPWR COARSE_MUX[4] VGND \$1637 VPWR VGND sky130_fd_sc_hd__clkdlybuf4s50_1
X$2294 VGND \$1585 \$1799 \$1784 \$1785 VPWR VPWR VGND sky130_fd_sc_hd__xor3_1
X$2296 VPWR VGND VPWR VGND sky130_fd_sc_hd__decap_4
X$2299 VPWR VGND \$2577 \$2579 \$2692 VPWR VGND sky130_fd_sc_hd__xor2_1
X$2301 VPWR \$2520 VPWR VGND \$2653 \$2723 VGND sky130_fd_sc_hd__nand2_1
X$2302 VPWR VGND VPWR VGND sky130_fd_sc_hd__decap_4
X$2303 VPWR \$2697 VGND \$2435 VPWR \$2653 VGND sky130_fd_sc_hd__nor2_1
X$2304 VPWR VPWR VGND VGND sky130_fd_sc_hd__decap_12
X$2305 VPWR \$2695 VGND \$2736 \$2907 \$2622 \$2621 VPWR VGND
+ sky130_fd_sc_hd__a211oi_1
X$2308 VGND \$2835 \$2626 \$2623 \$2590 VPWR VPWR VGND sky130_fd_sc_hd__xor3_1
X$2309 VPWR VPWR VGND VGND sky130_fd_sc_hd__decap_6
X$2310 VPWR VPWR \$2628 \$2533 VGND \$2386 VGND sky130_fd_sc_hd__xnor2_1
X$2311 VPWR \$2536 VPWR VGND \$2402 \$2628 \$2627 VGND sky130_fd_sc_hd__nand3_1
X$2312 VPWR VPWR VGND VGND sky130_fd_sc_hd__decap_12
X$2314 VGND \$2759 \$2758 \$2630 \$2556 VPWR VPWR VGND sky130_fd_sc_hd__xor3_1
X$2315 VPWR VPWR VGND VGND sky130_fd_sc_hd__decap_6
X$2316 VPWR \$2632 VGND \$2687 \$2631 \$2707 VPWR VGND sky130_fd_sc_hd__maj3_1
X$2318 VPWR VGND VPWR VGND sky130_fd_sc_hd__decap_3
X$2319 VPWR VGND \$2611 \$2633 \$2632 VPWR VGND
+ sky130_fd_sc_hd__lpflow_isobufsrc_1
X$2320 VPWR VPWR VGND VGND sky130_fd_sc_hd__decap_12
X$2321 VPWR VPWR VGND VGND sky130_fd_sc_hd__decap_12
X$2322 VPWR VPWR VGND VGND sky130_fd_sc_hd__decap_12
X$2323 VPWR VPWR VGND VGND sky130_fd_sc_hd__decap_12
X$2324 VPWR VPWR VGND VGND sky130_fd_sc_hd__decap_12
X$2325 VPWR VPWR VGND VGND sky130_fd_sc_hd__decap_12
X$2326 VPWR VGND VPWR VGND sky130_fd_sc_hd__decap_4
X$2329 VPWR VPWR VGND VGND sky130_fd_sc_hd__decap_12
X$2330 VPWR VPWR VGND VGND sky130_fd_sc_hd__decap_12
X$2331 VPWR VPWR VGND VGND sky130_fd_sc_hd__decap_12
X$2332 VPWR VPWR VGND VGND sky130_fd_sc_hd__decap_12
X$2333 VPWR VPWR VGND VGND sky130_fd_sc_hd__decap_12
X$2334 VPWR VPWR VGND VGND sky130_fd_sc_hd__decap_12
X$2335 VPWR VPWR VGND VGND sky130_fd_sc_hd__decap_12
X$2338 VPWR VPWR VGND VGND sky130_fd_sc_hd__decap_12
X$2339 VPWR VPWR VGND VGND sky130_fd_sc_hd__decap_12
X$2340 VPWR VPWR VGND VGND sky130_fd_sc_hd__decap_12
X$2341 VPWR VPWR VGND VGND sky130_fd_sc_hd__decap_12
X$2342 VPWR VPWR VGND VGND sky130_fd_sc_hd__decap_12
X$2343 VPWR VPWR VGND VGND sky130_fd_sc_hd__decap_12
X$2344 VPWR VPWR VGND VGND sky130_fd_sc_hd__decap_8
X$2346 VPWR VGND \$2592 VPWR \$2715 VGND sky130_fd_sc_hd__buf_2
X$2348 VPWR VPWR \$2572 \$2511 VGND REF VGND sky130_fd_sc_hd__nand2_2
X$2349 VPWR \$2505 VGND SS_BBPD[0] VPWR VGND sky130_fd_sc_hd__clkdlybuf4s50_1
X$2352 VPWR VPWR VGND VGND sky130_fd_sc_hd__decap_6
X$2353 VPWR VPWR VGND \$2763 \$2692 VGND sky130_fd_sc_hd__clkinv_1
X$2354 VPWR VPWR VGND \$2719 \$2577 VGND sky130_fd_sc_hd__clkinv_1
X$2356 VPWR \$2723 VPWR VGND \$2728 \$2763 VGND sky130_fd_sc_hd__nand2_1
X$2357 VPWR \$2626 VPWR VGND \$2692 \$2435 \$2733 \$2728 VGND
+ sky130_fd_sc_hd__o31a_1
X$2358 VPWR \$2736 VGND \$2723 \$2435 VPWR VGND
+ sky130_fd_sc_hd__lpflow_inputiso1p_1
X$2360 VPWR VGND \$2621 VPWR \$2622 \$2695 \$2733 VGND sky130_fd_sc_hd__a21o_1
X$2361 VPWR \$2621 VGND \$2697 \$2736 VPWR \$2767 \$2908 VGND
+ sky130_fd_sc_hd__o211a_1
X$2362 VPWR \$2695 VGND \$2549 VPWR \$2622 VGND sky130_fd_sc_hd__nor2_1
X$2363 VPWR VPWR VGND VGND sky130_fd_sc_hd__decap_12
X$2365 VPWR VPWR VGND VGND sky130_fd_sc_hd__decap_8
X$2367 VPWR \$2810 VGND \$2628 \$2771 \$2627 VPWR VGND sky130_fd_sc_hd__maj3_1
X$2368 VPWR VPWR VGND VGND sky130_fd_sc_hd__decap_8
X$2371 VPWR VGND VPWR VGND sky130_fd_sc_hd__decap_3
X$2372 VPWR \$2758 VGND \$2774 \$2537 \$2706 VPWR VGND sky130_fd_sc_hd__maj3_1
X$2375 VPWR \$2684 VPWR \$2537 \$2774 VGND VGND sky130_fd_sc_hd__and2_0
X$2376 VPWR \$2823 VGND \$2821 VPWR \$2684 VGND sky130_fd_sc_hd__nor2_1
X$2377 VPWR VGND \$2630 \$2556 \$2705 VPWR VGND sky130_fd_sc_hd__xor2_1
X$2378 VPWR \$2707 VPWR VGND \$2705 \$2823 \$2706 VGND sky130_fd_sc_hd__nand3_1
X$2379 VGND \$2824 \$2687 \$2631 \$2707 VPWR VPWR VGND sky130_fd_sc_hd__xnor3_1
X$2380 VPWR VPWR \$2827 \$2632 VGND \$2633 VGND sky130_fd_sc_hd__xnor2_1
X$2382 VPWR VPWR VGND VGND sky130_fd_sc_hd__decap_12
X$2383 VPWR VPWR VGND VGND sky130_fd_sc_hd__decap_12
X$2384 VPWR VGND VPWR VGND sky130_fd_sc_hd__decap_4
X$2387 VPWR VPWR VGND VGND sky130_fd_sc_hd__decap_12
X$2389 VPWR VPWR VGND VGND sky130_fd_sc_hd__decap_12
X$2390 VPWR VPWR VGND VGND sky130_fd_sc_hd__decap_12
X$2391 VPWR VPWR VGND VGND sky130_fd_sc_hd__decap_12
X$2392 VPWR VPWR VGND VGND sky130_fd_sc_hd__decap_12
X$2394 VPWR VPWR VGND VGND sky130_fd_sc_hd__decap_12
X$2395 VPWR VPWR VGND VGND sky130_fd_sc_hd__decap_12
X$2398 VPWR VPWR VGND VGND sky130_fd_sc_hd__decap_12
X$2399 VPWR VPWR VGND VGND sky130_fd_sc_hd__decap_12
X$2401 VPWR VPWR VGND VGND sky130_fd_sc_hd__decap_12
X$2402 VPWR VPWR VGND VGND sky130_fd_sc_hd__decap_12
X$2403 VPWR VPWR VGND VGND sky130_fd_sc_hd__decap_12
X$2405 VPWR VPWR VGND VGND sky130_fd_sc_hd__decap_12
X$2406 VPWR VPWR VGND VGND sky130_fd_sc_hd__decap_12
X$2409 VPWR VPWR VGND VGND sky130_fd_sc_hd__decap_12
X$2410 VPWR VPWR VGND VGND sky130_fd_sc_hd__decap_12
X$2412 VPWR VPWR VGND VGND sky130_fd_sc_hd__decap_12
X$2413 VGND \$2782 \$2715 TICK \$2806 VPWR VPWR VGND sky130_fd_sc_hd__dfrtp_1
X$2433 VPWR VPWR VGND VGND sky130_fd_sc_hd__decap_12
X$2435 VPWR VPWR VGND VGND sky130_fd_sc_hd__decap_12
X$2436 VPWR VPWR VGND VGND sky130_fd_sc_hd__decap_12
X$2437 VPWR VPWR VGND VGND sky130_fd_sc_hd__decap_6
X$2439 VPWR VPWR VGND VGND sky130_fd_sc_hd__decap_12
X$2440 VPWR VPWR VGND VGND sky130_fd_sc_hd__decap_12
X$2441 VPWR VPWR VGND VGND sky130_fd_sc_hd__decap_12
X$2442 VPWR VPWR VGND VGND sky130_fd_sc_hd__decap_6
X$2444 VPWR VPWR VGND VGND sky130_fd_sc_hd__decap_12
X$2445 VPWR VGND VPWR VGND sky130_fd_sc_hd__decap_4
X$2446 VPWR VPWR VGND VGND sky130_fd_sc_hd__decap_12
X$2447 VPWR VPWR VGND VGND sky130_fd_sc_hd__decap_6
X$2450 VPWR VPWR VGND VGND sky130_fd_sc_hd__decap_12
X$2451 VPWR VGND VPWR VGND sky130_fd_sc_hd__decap_4
X$2455 VPWR VPWR VGND VGND sky130_fd_sc_hd__decap_8
X$2457 VPWR VPWR VGND VGND sky130_fd_sc_hd__decap_6
X$2459 VPWR VPWR VGND VGND sky130_fd_sc_hd__decap_12
X$2460 VPWR VPWR VGND VGND sky130_fd_sc_hd__decap_12
X$2461 VPWR VGND VPWR VGND sky130_fd_sc_hd__decap_3
X$2463 VPWR VPWR VGND VGND sky130_fd_sc_hd__decap_12
X$2464 VPWR VPWR VGND VGND sky130_fd_sc_hd__decap_6
X$2466 VPWR \$76 VGND \$51 VPWR \$118 VGND sky130_fd_sc_hd__nor2_1
X$2467 VPWR VPWR VGND VGND sky130_fd_sc_hd__decap_12
X$2468 VPWR VGND VPWR VGND sky130_fd_sc_hd__decap_4
X$2470 VPWR \$69 VGND \$140 \$53 \$66 VPWR VGND sky130_fd_sc_hd__maj3_1
X$2471 VPWR VPWR VGND VGND sky130_fd_sc_hd__decap_6
X$2473 VPWR VPWR VGND VGND sky130_fd_sc_hd__decap_12
X$2474 VPWR VPWR VGND VGND sky130_fd_sc_hd__decap_6
X$2476 VPWR VGND VPWR VGND sky130_fd_sc_hd__decap_4
X$2480 VPWR VPWR VGND VGND sky130_fd_sc_hd__decap_12
X$2483 VPWR VPWR VGND VGND sky130_fd_sc_hd__decap_12
X$2484 VPWR VPWR VGND VGND sky130_fd_sc_hd__decap_12
X$2485 VPWR VPWR VGND VGND sky130_fd_sc_hd__decap_12
X$2486 VPWR VPWR VGND VGND sky130_fd_sc_hd__decap_12
X$2489 VPWR VPWR VGND VGND sky130_fd_sc_hd__decap_12
X$2490 VPWR VPWR VGND VGND sky130_fd_sc_hd__decap_12
X$2493 VPWR VPWR VGND VGND sky130_fd_sc_hd__decap_12
X$2496 VPWR VPWR VGND VGND sky130_fd_sc_hd__decap_12
X$2497 VPWR VPWR VGND VGND sky130_fd_sc_hd__decap_12
X$2498 VPWR VPWR VGND VGND sky130_fd_sc_hd__decap_12
X$2499 VPWR VPWR VGND VGND sky130_fd_sc_hd__decap_8
X$2503 VGND \$201 \$97 \$98 \$99 VPWR VPWR VGND sky130_fd_sc_hd__xnor3_1
X$2504 VPWR VPWR \$159 \$97 VGND \$99 VGND sky130_fd_sc_hd__xnor2_1
X$2507 VPWR VPWR VGND \$99 \$83 VGND sky130_fd_sc_hd__clkinv_1
X$2508 VPWR VGND VPWR VGND sky130_fd_sc_hd__decap_3
X$2509 VGND \$97 \$161 \$105 \$103 VPWR VPWR VGND sky130_fd_sc_hd__xnor3_1
X$2512 VPWR VPWR VGND \$162 \$103 VGND sky130_fd_sc_hd__clkinv_1
X$2514 VGND \$161 \$106 \$89 \$108 VPWR VPWR VGND sky130_fd_sc_hd__xor3_1
X$2515 VPWR \$246 VPWR \$108 \$106 VGND VGND sky130_fd_sc_hd__and2_0
X$2518 VPWR \$226 VPWR VGND \$108 \$106 VGND sky130_fd_sc_hd__nand2_1
X$2520 VGND \$106 \$110 \$84 \$77 VPWR VPWR VGND sky130_fd_sc_hd__xor3_1
X$2523 VPWR VGND VPWR VGND sky130_fd_sc_hd__decap_4
X$2524 VGND \$164 \$221 \$114 \$76 VPWR VPWR VGND sky130_fd_sc_hd__xnor3_1
X$2527 VPWR VPWR \$170 \$114 VGND \$76 VGND sky130_fd_sc_hd__xnor2_1
X$2529 VGND \$110 \$116 \$51 \$118 VPWR VPWR VGND sky130_fd_sc_hd__xnor3_1
X$2530 VPWR VPWR VGND VGND sky130_fd_sc_hd__decap_12
X$2534 VGND \$114 \$140 \$53 \$121 VPWR VPWR VGND sky130_fd_sc_hd__xnor3_1
X$2535 VPWR VPWR VGND \$121 \$66 VGND sky130_fd_sc_hd__clkinv_1
X$2538 VPWR VGND VPWR VGND sky130_fd_sc_hd__decap_4
X$2539 VGND \$140 \$134 \$64 \$125 VPWR VPWR VGND sky130_fd_sc_hd__xor3_1
X$2543 VGND \$134 \$262 \$132 \$126 VPWR VPWR VGND sky130_fd_sc_hd__xnor3_1
X$2544 VPWR VPWR VGND \$132 \$59 VGND sky130_fd_sc_hd__clkinv_1
X$2545 VPWR VPWR VGND \$126 \$62 VGND sky130_fd_sc_hd__clkinv_1
X$2556 VPWR VPWR VGND VGND sky130_fd_sc_hd__decap_12
X$2558 VPWR VPWR VGND VGND sky130_fd_sc_hd__decap_12
X$2559 VPWR VPWR VGND VGND sky130_fd_sc_hd__decap_12
X$2560 VPWR VPWR VGND VGND sky130_fd_sc_hd__decap_6
X$2562 VPWR VPWR VGND VGND sky130_fd_sc_hd__decap_12
X$2563 VPWR VPWR VGND VGND sky130_fd_sc_hd__decap_12
X$2564 VPWR VPWR VGND VGND sky130_fd_sc_hd__decap_12
X$2565 VPWR VGND VPWR VGND sky130_fd_sc_hd__decap_4
X$2566 VPWR \$3833 \$4193 \$4194 VGND \$4162 VPWR VGND sky130_fd_sc_hd__mux2i_1
X$2567 VPWR VPWR \$4172 \$3865 VGND \$4100 VGND sky130_fd_sc_hd__xnor2_1
X$2568 VPWR VPWR VGND VGND sky130_fd_sc_hd__decap_6
X$2570 VPWR \$4172 VPWR \$4109 \$4261 \$4129 \$4194 VGND VGND
+ sky130_fd_sc_hd__nand4_1
X$2571 VPWR VPWR VGND VGND sky130_fd_sc_hd__decap_12
X$2572 VPWR VPWR VGND VGND sky130_fd_sc_hd__decap_6
X$2574 VGND \$3927 \$4268 \$4132 \$4181 \$4180 \$4271 VPWR VPWR VGND
+ sky130_fd_sc_hd__o41a_1
X$2575 VPWR VPWR VGND VGND sky130_fd_sc_hd__decap_12
X$2576 VPWR VPWR VGND VGND sky130_fd_sc_hd__decap_12
X$2577 VPWR VGND \$4187 VPWR \$4188 \$4210 \$4209 VGND sky130_fd_sc_hd__a21oi_1
X$2578 VPWR \$4209 \$4187 \$4184 VPWR VGND \$4188 VGND sky130_fd_sc_hd__and3_1
X$2580 VPWR \$4185 \$4120 VPWR \$4287 VGND \$4212 \$4183 VGND
+ sky130_fd_sc_hd__o211ai_1
X$2581 VPWR VGND \$4292 \$4185 \$4216 VPWR VGND sky130_fd_sc_hd__xor2_1
X$2582 VPWR \$4060 VGND \$4216 \$4217 VPWR VGND
+ sky130_fd_sc_hd__lpflow_inputiso1p_1
X$2583 VPWR VGND \$4217 \$4216 \$4218 VPWR VGND sky130_fd_sc_hd__xor2_1
X$2584 VPWR VPWR VGND VGND sky130_fd_sc_hd__decap_8
X$2586 VPWR VGND \$4395 \$4218 \$4113 VPWR VGND sky130_fd_sc_hd__xor2_1
X$2588 VPWR VPWR VGND VGND sky130_fd_sc_hd__decap_8
X$2589 VPWR VGND \$4112 \$4113 \$4222 VPWR VGND sky130_fd_sc_hd__xor2_1
X$2590 VPWR VPWR VGND VGND sky130_fd_sc_hd__decap_6
X$2592 VPWR \$4064 VPWR VGND \$4323 \$4222 \$4221 VGND sky130_fd_sc_hd__nand3_1
X$2593 VPWR VGND \$4380 \$4222 \$4065 VPWR VGND sky130_fd_sc_hd__xor2_1
X$2594 VPWR VGND VPWR VGND sky130_fd_sc_hd__decap_3
X$2595 VPWR VPWR \$4143 \$4104 VGND \$4065 VGND sky130_fd_sc_hd__xnor2_1
X$2596 VPWR VPWR VGND VGND sky130_fd_sc_hd__decap_6
X$2598 VGND \$4276 \$4227 \$4161 \$4143 VPWR VPWR VGND sky130_fd_sc_hd__xnor3_1
X$2600 VPWR VPWR \$4229 \$4160 VGND \$4276 VGND sky130_fd_sc_hd__xnor2_1
X$2602 VPWR VGND \$4230 \$4229 \$4156 VPWR VGND sky130_fd_sc_hd__xor2_1
X$2604 VGND \$2782 \$4157 TICK \$4158 VPWR VPWR VGND sky130_fd_sc_hd__dfrtp_1
X$2605 VPWR VPWR VGND VGND sky130_fd_sc_hd__decap_12
X$2607 VPWR \$4154 VGND \$4243 \$4242 \$4233 VPWR VGND sky130_fd_sc_hd__maj3_1
X$2608 VPWR VPWR VGND VGND sky130_fd_sc_hd__decap_12
X$2609 VPWR VPWR VGND VGND sky130_fd_sc_hd__decap_12
X$2610 VPWR VPWR VGND VGND sky130_fd_sc_hd__decap_12
X$2611 VPWR VPWR VGND VGND sky130_fd_sc_hd__decap_8
X$2613 VPWR VPWR VGND VGND sky130_fd_sc_hd__decap_12
X$2617 VPWR VPWR VGND VGND sky130_fd_sc_hd__decap_12
X$2619 VPWR VPWR VGND VGND sky130_fd_sc_hd__decap_12
X$2620 VPWR VPWR VGND VGND sky130_fd_sc_hd__decap_12
X$2621 VPWR VPWR VGND VGND sky130_fd_sc_hd__decap_12
X$2622 VPWR VPWR VGND VGND sky130_fd_sc_hd__decap_12
X$2624 VPWR VPWR VGND VGND sky130_fd_sc_hd__decap_12
X$2625 VPWR VPWR VGND VGND sky130_fd_sc_hd__decap_12
X$2628 VPWR VPWR VGND VGND sky130_fd_sc_hd__decap_12
X$2630 VPWR VPWR VGND VGND sky130_fd_sc_hd__decap_8
X$2632 VPWR VPWR \$4309 \$4351 VGND \$4172 \$4261 VGND sky130_fd_sc_hd__o21ai_0
X$2633 VPWR VGND \$4193 \$4354 \$4407 VPWR VGND sky130_fd_sc_hd__xor2_1
X$2634 VPWR VPWR VGND VGND sky130_fd_sc_hd__decap_8
X$2636 VPWR \$4180 VGND \$4193 \$4309 VPWR VGND
+ sky130_fd_sc_hd__lpflow_inputiso1p_1
X$2637 VPWR \$4364 VGND \$4309 VPWR \$4311 VGND sky130_fd_sc_hd__nor2_1
X$2638 VPWR VPWR VGND VGND sky130_fd_sc_hd__decap_12
X$2640 VPWR \$3970 VPWR \$4187 \$4188 \$4371 VGND \$4372 VGND
+ sky130_fd_sc_hd__a31o_1
X$2641 VPWR \$4034 VPWR \$4548 \$4187 \$4188 VGND \$4379 VGND
+ sky130_fd_sc_hd__a31o_1
X$2642 VPWR VPWR VGND VGND sky130_fd_sc_hd__decap_8
X$2646 VPWR \$4287 VGND \$4210 \$4184 VPWR VGND
+ sky130_fd_sc_hd__lpflow_inputiso1p_1
X$2647 VPWR VPWR VGND VGND sky130_fd_sc_hd__decap_12
X$2649 VPWR VPWR VGND VGND sky130_fd_sc_hd__decap_12
X$2650 VPWR VGND VPWR VGND sky130_fd_sc_hd__decap_4
X$2651 VPWR VPWR \$4061 \$4218 \$4317 VGND \$4394 \$4315 \$4318 VGND
+ sky130_fd_sc_hd__o311ai_0
X$2652 VPWR VGND VPWR VGND sky130_fd_sc_hd__decap_4
X$2654 VPWR \$4322 \$4317 VPWR VGND \$4394 \$4112 \$4389 VGND
+ sky130_fd_sc_hd__o31ai_1
X$2655 VPWR VPWR VGND VGND sky130_fd_sc_hd__decap_12
X$2657 VPWR VPWR VGND VGND sky130_fd_sc_hd__decap_6
X$2658 VPWR \$4380 VPWR VGND \$4221 \$4323 VGND sky130_fd_sc_hd__nand2_1
X$2659 VPWR VPWR VGND VGND sky130_fd_sc_hd__decap_12
X$2661 VPWR VPWR VGND VGND sky130_fd_sc_hd__decap_6
X$2662 VPWR \$4367 VGND \$4227 \$4161 \$4143 VPWR VGND sky130_fd_sc_hd__maj3_1
X$2664 VPWR VPWR VGND VGND sky130_fd_sc_hd__decap_12
X$2665 VPWR VPWR VGND VGND sky130_fd_sc_hd__decap_12
X$2666 VPWR VPWR VGND VGND sky130_fd_sc_hd__decap_8
X$2667 VPWR VGND VPWR VGND sky130_fd_sc_hd__decap_3
X$2668 VPWR VPWR \$4357 \$4156 VGND \$4157 VGND sky130_fd_sc_hd__xnor2_1
X$2670 VPWR VGND VPWR VGND sky130_fd_sc_hd__decap_4
X$2672 VGND \$2782 \$4233 TICK \$4353 VPWR VPWR VGND sky130_fd_sc_hd__dfrtp_1
X$2673 VPWR VGND VPWR VGND sky130_fd_sc_hd__decap_4
X$2675 VPWR VPWR VGND VGND sky130_fd_sc_hd__decap_12
X$2677 VPWR \$4440 VGND \$4335 VPWR \$4334 VGND sky130_fd_sc_hd__nor2_1
X$2679 VPWR VGND \$4333 \$4334 \$4340 VPWR VGND sky130_fd_sc_hd__xor2_1
X$2680 VGND \$2782 \$4332 TICK \$4340 VPWR VPWR VGND sky130_fd_sc_hd__dfrtp_1
X$2681 VPWR VPWR VGND VGND sky130_fd_sc_hd__decap_12
X$2702 VPWR VPWR VGND VGND sky130_fd_sc_hd__decap_12
X$2704 VPWR VPWR VGND VGND sky130_fd_sc_hd__decap_12
X$2705 VPWR VPWR VGND VGND sky130_fd_sc_hd__decap_12
X$2706 VPWR VPWR VGND VGND sky130_fd_sc_hd__decap_6
X$2708 VPWR VPWR VGND VGND sky130_fd_sc_hd__decap_12
X$2709 VPWR VPWR VGND VGND sky130_fd_sc_hd__decap_12
X$2710 VPWR VPWR VGND VGND sky130_fd_sc_hd__decap_12
X$2711 VPWR VPWR VGND VGND sky130_fd_sc_hd__decap_6
X$2712 VPWR \$799 VGND \$280 VPWR \$469 VGND sky130_fd_sc_hd__nor2_1
X$2713 VPWR VPWR VGND VGND sky130_fd_sc_hd__decap_12
X$2714 VPWR VPWR VGND VGND sky130_fd_sc_hd__decap_8
X$2715 VPWR VPWR VGND \$469 \$632 VGND sky130_fd_sc_hd__clkinv_1
X$2717 VPWR VGND \$428 \$633 \$807 VPWR VGND sky130_fd_sc_hd__xor2_1
X$2718 VPWR VPWR VGND VGND sky130_fd_sc_hd__decap_8
X$2721 VPWR VPWR VGND VGND sky130_fd_sc_hd__decap_12
X$2722 VPWR VPWR VGND VGND sky130_fd_sc_hd__decap_12
X$2723 VPWR \$818 VGND \$719 \$639 \$820 VPWR VGND sky130_fd_sc_hd__maj3_1
X$2724 VPWR VGND VPWR VGND sky130_fd_sc_hd__decap_4
X$2725 VPWR \$823 VPWR \$820 \$639 VGND VGND sky130_fd_sc_hd__and2_0
X$2726 VPWR VPWR VGND VGND sky130_fd_sc_hd__decap_8
X$2728 VPWR \$735 VGND \$399 VPWR \$640 VGND sky130_fd_sc_hd__nor2_1
X$2729 VGND \$640 \$644 \$645 \$757 VPWR VPWR VGND sky130_fd_sc_hd__xor3_1
X$2730 VPWR VPWR VGND VGND sky130_fd_sc_hd__decap_12
X$2733 VPWR VPWR VGND VGND sky130_fd_sc_hd__decap_12
X$2734 VPWR VGND VPWR VGND sky130_fd_sc_hd__decap_3
X$2735 VPWR VGND \$762 \$847 \$844 VPWR VGND sky130_fd_sc_hd__xor2_1
X$2736 VPWR VPWR VGND VGND sky130_fd_sc_hd__decap_8
X$2737 VGND \$847 \$648 \$764 \$732 VPWR VPWR VGND sky130_fd_sc_hd__xor3_1
X$2738 VPWR VPWR VGND VGND sky130_fd_sc_hd__decap_8
X$2740 VPWR VPWR \$732 \$768 VGND \$651 VGND sky130_fd_sc_hd__xnor2_1
X$2741 VPWR VPWR VGND VGND sky130_fd_sc_hd__decap_12
X$2742 VPWR VPWR VGND VGND sky130_fd_sc_hd__decap_8
X$2744 VPWR VGND VPWR VGND sky130_fd_sc_hd__decap_4
X$2745 VPWR \$658 \$828 \$721 \$603 \$604 VGND VPWR VGND
+ sky130_fd_sc_hd__nand4b_1
X$2747 VPWR \$721 VGND \$53 \$661 VPWR VGND sky130_fd_sc_hd__lpflow_inputiso1p_1
X$2748 VPWR \$657 VGND \$661 VPWR \$53 VGND sky130_fd_sc_hd__nor2_1
X$2749 VPWR VPWR VGND VGND sky130_fd_sc_hd__decap_6
X$2751 VPWR \$810 \$661 \$776 VGND \$808 VPWR VGND sky130_fd_sc_hd__mux2i_1
X$2753 VPWR \$663 VGND \$668 VPWR \$781 \$776 \$121 VGND
+ sky130_fd_sc_hd__a31oi_1
X$2754 VPWR VPWR VGND VGND sky130_fd_sc_hd__decap_12
X$2755 VPWR VPWR VGND VGND sky130_fd_sc_hd__decap_6
X$2757 VPWR \$916 VPWR VGND \$465 \$362 VGND sky130_fd_sc_hd__nand2_1
X$2758 VPWR VGND \$362 VPWR \$465 \$780 \$668 VGND sky130_fd_sc_hd__a21oi_1
X$2759 VPWR VPWR VGND VGND sky130_fd_sc_hd__decap_12
X$2761 VPWR VPWR \$668 \$670 VGND \$669 \$785 VGND sky130_fd_sc_hd__o21ai_0
X$2763 VPWR \$785 VGND \$784 \$478 \$669 VPWR \$670 VGND sky130_fd_sc_hd__nor4_1
X$2764 VPWR VPWR VGND VGND sky130_fd_sc_hd__decap_8
X$2767 VPWR VPWR VGND VGND sky130_fd_sc_hd__decap_12
X$2769 VPWR VPWR VGND VGND sky130_fd_sc_hd__decap_12
X$2770 VPWR VPWR VGND VGND sky130_fd_sc_hd__decap_12
X$2771 VPWR VPWR VGND VGND sky130_fd_sc_hd__decap_12
X$2772 VPWR VPWR VGND VGND sky130_fd_sc_hd__decap_12
X$2774 VPWR VPWR VGND VGND sky130_fd_sc_hd__decap_12
X$2775 VPWR VPWR VGND VGND sky130_fd_sc_hd__decap_8
X$2777 VPWR VGND \$742 VPWR \$71 \$892 \$799 VGND sky130_fd_sc_hd__a21oi_1
X$2779 VPWR \$742 VPWR VGND \$469 \$280 VGND sky130_fd_sc_hd__nand2_1
X$2780 VPWR VPWR VGND VGND sky130_fd_sc_hd__decap_8
X$2783 VPWR \$900 VGND \$472 \$537 VPWR VGND
+ sky130_fd_sc_hd__lpflow_inputiso1p_1
X$2784 VGND \$979 \$428 \$633 \$702 VPWR VPWR VGND sky130_fd_sc_hd__xnor3_1
X$2785 VPWR VPWR VGND VGND sky130_fd_sc_hd__decap_12
X$2786 VPWR VGND VPWR VGND sky130_fd_sc_hd__decap_4
X$2787 VPWR VPWR \$914 \$716 VGND \$749 VGND sky130_fd_sc_hd__xnor2_1
X$2789 VPWR VPWR VGND VGND sky130_fd_sc_hd__decap_8
X$2791 VGND \$749 \$639 \$399 \$640 VPWR VPWR VGND sky130_fd_sc_hd__xnor3_1
X$2793 VPWR VGND \$399 \$640 \$820 VPWR VGND sky130_fd_sc_hd__xor2_1
X$2795 VPWR \$986 VGND \$399 \$644 \$755 VPWR VGND sky130_fd_sc_hd__maj3_1
X$2797 VPWR VGND VPWR VGND sky130_fd_sc_hd__decap_3
X$2798 VPWR \$933 VGND \$644 VPWR \$755 VGND sky130_fd_sc_hd__nor2_1
X$2799 VPWR VPWR \$755 \$645 VGND \$757 VGND sky130_fd_sc_hd__xnor2_1
X$2801 VPWR \$757 \$860 \$1073 VPWR VGND \$645 VGND sky130_fd_sc_hd__and3_1
X$2802 VPWR \$844 VPWR \$935 \$757 \$645 VGND \$759 VGND
+ sky130_fd_sc_hd__a22oi_1
X$2804 VGND \$757 \$759 \$762 \$847 VPWR VPWR VGND sky130_fd_sc_hd__xor3_1
X$2807 VPWR \$952 VPWR VGND \$847 \$762 \$846 \$866 VGND sky130_fd_sc_hd__o31a_1
X$2808 VPWR VPWR VGND VGND sky130_fd_sc_hd__decap_12
X$2809 VPWR \$957 VPWR VGND \$732 \$764 VGND sky130_fd_sc_hd__nand2_1
X$2811 VPWR \$956 VGND \$648 \$764 \$732 VPWR VGND sky130_fd_sc_hd__maj3_1
X$2812 VPWR \$868 VGND \$732 \$764 VPWR VGND
+ sky130_fd_sc_hd__lpflow_inputiso1p_1
X$2815 VPWR \$969 VPWR \$651 \$768 VGND VGND sky130_fd_sc_hd__and2_0
X$2816 VPWR \$870 \$835 VPWR \$969 VGND \$834 \$770 VGND
+ sky130_fd_sc_hd__o211ai_1
X$2817 VPWR VGND \$724 \$828 VPWR \$772 \$834 \$501 VGND sky130_fd_sc_hd__a22o_1
X$2818 VPWR \$724 VPWR \$772 \$770 \$501 \$828 VGND VGND
+ sky130_fd_sc_hd__nand4_1
X$2819 VPWR VPWR VGND VGND sky130_fd_sc_hd__decap_8
X$2821 VPWR \$721 VGND \$604 VPWR \$603 \$946 \$658 VGND
+ sky130_fd_sc_hd__a31oi_1
X$2822 VPWR VPWR VGND VGND sky130_fd_sc_hd__decap_12
X$2824 VPWR VPWR VGND VGND sky130_fd_sc_hd__decap_12
X$2825 VPWR VPWR VGND VGND sky130_fd_sc_hd__decap_8
X$2829 VPWR \$686 VPWR \$808 VGND \$877 \$64 VGND sky130_fd_sc_hd__o21a_1
X$2831 VPWR \$686 \$877 VPWR \$780 VGND \$879 \$64 VGND
+ sky130_fd_sc_hd__o211ai_1
X$2834 VPWR \$781 VPWR \$181 \$879 \$916 \$906 VGND VGND
+ sky130_fd_sc_hd__nand4_1
X$2835 VPWR VPWR VGND VGND sky130_fd_sc_hd__decap_6
X$2836 VPWR \$906 VPWR VGND \$371 \$883 VGND sky130_fd_sc_hd__nand2_1
X$2837 VPWR \$781 VGND \$889 \$784 VPWR VGND
+ sky130_fd_sc_hd__lpflow_inputiso1p_1
X$2838 VPWR VGND VPWR VGND sky130_fd_sc_hd__decap_4
X$2839 VPWR \$889 VGND VPWR \$478 \$785 \$670 \$669 VGND sky130_fd_sc_hd__o22a_1
X$2840 VPWR VPWR \$883 \$669 VGND \$670 VGND sky130_fd_sc_hd__xnor2_1
X$2861 VPWR VPWR VGND VGND sky130_fd_sc_hd__decap_12
X$2863 VPWR VPWR VGND VGND sky130_fd_sc_hd__decap_12
X$2864 VPWR VPWR VGND VGND sky130_fd_sc_hd__decap_12
X$2865 VPWR VPWR VGND VGND sky130_fd_sc_hd__decap_6
X$2867 VPWR VPWR VGND VGND sky130_fd_sc_hd__decap_12
X$2868 VPWR VPWR VGND VGND sky130_fd_sc_hd__decap_12
X$2869 VPWR VPWR VGND VGND sky130_fd_sc_hd__decap_12
X$2870 VPWR VGND VPWR VGND sky130_fd_sc_hd__decap_4
X$2872 VPWR \$1098 VPWR VGND \$1059 \$684 VGND sky130_fd_sc_hd__nand2_1
X$2873 VPWR \$807 \$1444 \$979 VGND \$1098 VPWR VGND sky130_fd_sc_hd__mux2i_1
X$2874 VPWR VPWR VGND VGND sky130_fd_sc_hd__decap_12
X$2875 VPWR VGND VPWR VGND sky130_fd_sc_hd__decap_4
X$2877 VPWR VPWR \$1336 \$1032 VGND \$912 VGND sky130_fd_sc_hd__xnor2_1
X$2878 VPWR VPWR VGND VGND sky130_fd_sc_hd__decap_8
X$2881 VPWR \$1187 VGND \$1032 \$1035 \$914 VPWR VGND sky130_fd_sc_hd__maj3_1
X$2882 VPWR VPWR VGND VGND sky130_fd_sc_hd__decap_8
X$2884 VPWR \$984 VGND \$1045 VPWR \$1109 \$1040 VGND sky130_fd_sc_hd__a21boi_0
X$2885 VPWR \$1284 VPWR VGND \$1040 \$984 VGND sky130_fd_sc_hd__nand2_1
X$2886 VPWR VPWR VGND VGND sky130_fd_sc_hd__decap_12
X$2888 VPWR VGND \$1069 \$1199 \$1114 VPWR VGND sky130_fd_sc_hd__xor2_1
X$2889 VPWR \$1117 VPWR VGND \$1069 \$985 \$823 VGND sky130_fd_sc_hd__nand3_1
X$2891 VPWR \$735 \$990 \$1122 VPWR VGND \$934 VGND sky130_fd_sc_hd__and3_1
X$2892 VPWR VGND VPWR VGND sky130_fd_sc_hd__decap_3
X$2893 VPWR \$1123 VPWR VGND \$990 \$934 \$933 VGND sky130_fd_sc_hd__nand3_1
X$2894 VPWR VGND VPWR VGND sky130_fd_sc_hd__decap_4
X$2896 VPWR VGND \$1072 \$1073 \$1069 VPWR VGND sky130_fd_sc_hd__xor2_1
X$2897 VPWR VPWR \$1072 \$990 VGND \$1126 VGND sky130_fd_sc_hd__xnor2_1
X$2899 VPWR VGND \$1128 \$990 \$1126 VPWR VGND sky130_fd_sc_hd__nor2b_1
X$2900 VPWR VPWR VGND VGND sky130_fd_sc_hd__decap_8
X$2901 VPWR \$1131 VGND \$952 VPWR \$1075 VGND sky130_fd_sc_hd__nor2_1
X$2902 VPWR VGND \$952 \$1075 \$990 VPWR VGND sky130_fd_sc_hd__xor2_1
X$2903 VPWR VGND \$1412 \$1129 \$1075 \$846 VPWR \$863 VGND
+ sky130_fd_sc_hd__nor4b_1
X$2904 VPWR VPWR VGND VGND sky130_fd_sc_hd__decap_12
X$2905 VPWR VGND VPWR VGND sky130_fd_sc_hd__decap_4
X$2906 VPWR \$1124 VGND \$835 VPWR \$868 VGND sky130_fd_sc_hd__nor2_1
X$2907 VPWR VGND VPWR VGND sky130_fd_sc_hd__decap_4
X$2908 VPWR \$868 VGND \$835 \$1118 \$870 \$1078 VPWR VGND
+ sky130_fd_sc_hd__a211oi_1
X$2909 VPWR VPWR VGND VGND sky130_fd_sc_hd__decap_8
X$2910 VPWR VPWR \$1115 \$1190 VGND \$1153 VGND sky130_fd_sc_hd__xnor2_1
X$2911 VPWR VPWR \$1078 \$1053 VGND \$770 VGND sky130_fd_sc_hd__xnor2_1
X$2912 VPWR VGND VPWR VGND sky130_fd_sc_hd__decap_4
X$2914 VPWR VPWR VGND VGND sky130_fd_sc_hd__decap_12
X$2915 VPWR VGND \$998 VPWR \$658 \$1113 \$1031 VGND sky130_fd_sc_hd__a21oi_1
X$2917 VPWR VGND \$1083 \$1030 \$1031 VPWR VGND sky130_fd_sc_hd__xor2_1
X$2918 VPWR VPWR VGND VGND sky130_fd_sc_hd__decap_8
X$2920 VPWR VPWR \$1083 \$1085 VGND \$929 VGND sky130_fd_sc_hd__xnor2_1
X$2921 VPWR VPWR \$1085 \$560 VGND \$478 \$918 VGND sky130_fd_sc_hd__o21ai_0
X$2922 VPWR VPWR VGND VGND sky130_fd_sc_hd__decap_8
X$2923 VPWR VGND VPWR VGND sky130_fd_sc_hd__decap_3
X$2924 VPWR VPWR \$1101 \$1174 VGND \$1089 \$879 VGND sky130_fd_sc_hd__o21ai_0
X$2925 VPWR VGND VPWR VGND sky130_fd_sc_hd__decap_3
X$2926 VPWR \$560 VGND \$780 \$1089 \$901 \$1004 VPWR VGND
+ sky130_fd_sc_hd__a211oi_1
X$2927 VPWR VPWR VGND VGND sky130_fd_sc_hd__decap_12
X$2928 VPWR VGND VPWR VGND sky130_fd_sc_hd__decap_4
X$2930 VPWR \$1094 \$478 VGND \$1092 \$1091 VPWR VGND sky130_fd_sc_hd__nor3_1
X$2931 VPWR \$1091 VPWR VGND \$264 \$271 VGND sky130_fd_sc_hd__nand2_1
X$2932 VPWR VPWR VGND VGND sky130_fd_sc_hd__decap_6
X$2935 VPWR VPWR VGND VGND sky130_fd_sc_hd__decap_12
X$2937 VPWR VPWR VGND VGND sky130_fd_sc_hd__decap_12
X$2938 VPWR VPWR VGND VGND sky130_fd_sc_hd__decap_12
X$2939 VPWR VPWR VGND VGND sky130_fd_sc_hd__decap_12
X$2940 VPWR VPWR VGND VGND sky130_fd_sc_hd__decap_12
X$2942 VPWR VPWR VGND VGND sky130_fd_sc_hd__decap_12
X$2943 VPWR VPWR VGND VGND sky130_fd_sc_hd__decap_6
X$2944 VPWR VPWR \$1389 \$684 VGND \$1059 VGND sky130_fd_sc_hd__xnor2_1
X$2946 VPWR VPWR VGND VGND sky130_fd_sc_hd__decap_12
X$2948 VPWR VGND VPWR VGND sky130_fd_sc_hd__decap_3
X$2949 VGND \$1264 \$1027 \$1032 \$912 VPWR VPWR VGND sky130_fd_sc_hd__xnor3_1
X$2950 VPWR VGND VPWR VGND sky130_fd_sc_hd__decap_3
X$2951 VPWR \$1210 VGND \$1032 VPWR \$912 VGND sky130_fd_sc_hd__nor2_1
X$2952 VPWR \$1272 VPWR VGND \$1210 \$984 VGND sky130_fd_sc_hd__nand2_1
X$2953 VPWR VGND \$1187 \$984 \$1337 VPWR VGND sky130_fd_sc_hd__xor2_1
X$2954 VPWR VPWR VGND VGND sky130_fd_sc_hd__decap_8
X$2956 VPWR VGND VPWR VGND sky130_fd_sc_hd__decap_3
X$2957 VPWR VGND \$1109 \$1114 \$1192 VPWR VGND sky130_fd_sc_hd__xor2_1
X$2958 VPWR \$1287 VGND \$1114 VPWR \$1284 VGND sky130_fd_sc_hd__nor2_1
X$2959 VPWR \$1195 VGND \$1114 VPWR \$1045 VGND sky130_fd_sc_hd__nor2_1
X$2960 VPWR VPWR VGND VGND sky130_fd_sc_hd__decap_12
X$2963 VPWR VGND \$985 VPWR \$823 \$1199 \$1047 VGND sky130_fd_sc_hd__a21oi_1
X$2964 VPWR VPWR VGND VGND sky130_fd_sc_hd__decap_12
X$2966 VPWR VPWR VGND VGND sky130_fd_sc_hd__decap_12
X$2967 VPWR VGND VPWR VGND sky130_fd_sc_hd__decap_4
X$2968 VPWR \$1073 \$1143 \$1300 VPWR VGND \$1072 VGND sky130_fd_sc_hd__and3_1
X$2969 VPWR \$1128 VGND \$1143 \$1303 \$1073 \$1072 VPWR VGND
+ sky130_fd_sc_hd__a211oi_1
X$2970 VPWR VPWR VGND VGND sky130_fd_sc_hd__decap_8
X$2972 VPWR VPWR \$1143 \$1129 VGND \$1131 VGND sky130_fd_sc_hd__xnor2_1
X$2974 VPWR VPWR VGND VGND sky130_fd_sc_hd__decap_12
X$2976 VPWR \$1129 \$1226 VGND \$1075 \$866 VPWR VGND sky130_fd_sc_hd__nor3_1
X$2977 VPWR VPWR VGND VGND sky130_fd_sc_hd__decap_6
X$2979 VPWR VPWR \$1075 \$1197 VGND \$1124 VGND sky130_fd_sc_hd__xnor2_1
X$2981 VPWR VGND \$1078 \$870 \$1197 VPWR VGND sky130_fd_sc_hd__xor2_1
X$2983 VPWR VGND VPWR VGND sky130_fd_sc_hd__decap_3
X$2984 VPWR \$1310 VGND \$1078 VPWR \$870 VGND sky130_fd_sc_hd__nor2_1
X$2985 VPWR VGND VPWR VGND sky130_fd_sc_hd__decap_3
X$2986 VPWR \$1190 VGND \$1053 \$770 \$870 VPWR VGND sky130_fd_sc_hd__maj3_1
X$2987 VPWR VGND VPWR VGND sky130_fd_sc_hd__decap_4
X$2988 VPWR \$1297 VGND \$1053 VPWR \$770 VGND sky130_fd_sc_hd__nor2_1
X$2990 VPWR VGND \$1153 VPWR \$1297 \$1233 \$1049 VGND sky130_fd_sc_hd__a21oi_1
X$2992 VPWR \$1153 VGND \$1113 \$1049 VPWR \$1034 VGND sky130_fd_sc_hd__nor3b_1
X$2993 VPWR VPWR VGND VGND sky130_fd_sc_hd__decap_6
X$2996 VPWR VPWR \$1282 \$1030 VGND \$1083 \$1034 VGND sky130_fd_sc_hd__o21ai_0
X$2997 VPWR VGND \$1277 VPWR \$1034 \$1379 \$1237 VGND sky130_fd_sc_hd__a21oi_1
X$2998 VPWR VPWR VGND VGND sky130_fd_sc_hd__decap_8
X$3000 VPWR \$1276 VPWR VGND \$1268 \$776 VGND sky130_fd_sc_hd__nand2_1
X$3001 VPWR \$1382 VGND \$1238 VPWR \$560 VGND sky130_fd_sc_hd__nor2_1
X$3002 VPWR \$1238 VPWR VGND \$64 \$478 VGND sky130_fd_sc_hd__nand2_1
X$3004 VPWR VPWR VGND VGND sky130_fd_sc_hd__decap_6
X$3005 VPWR \$1101 VGND \$1239 VPWR \$64 \$690 \$1378 VGND
+ sky130_fd_sc_hd__a31oi_1
X$3006 VPWR VGND VPWR VGND sky130_fd_sc_hd__decap_3
X$3008 VPWR \$1174 VPWR \$560 \$780 VGND VGND sky130_fd_sc_hd__and2_0
X$3009 VPWR VPWR VGND VGND sky130_fd_sc_hd__decap_12
X$3010 VPWR VPWR VGND VGND sky130_fd_sc_hd__decap_6
X$3012 VPWR \$1166 VPWR \$785 VGND \$1094 \$1092 VGND sky130_fd_sc_hd__o21a_1
X$3013 VPWR VPWR \$670 \$1166 VGND \$1092 VGND sky130_fd_sc_hd__xnor2_1
X$3014 VPWR VPWR VGND \$1243 \$264 VGND sky130_fd_sc_hd__clkinv_1
X$3035 VPWR VPWR VGND VGND sky130_fd_sc_hd__decap_12
X$3037 VPWR VPWR VGND VGND sky130_fd_sc_hd__decap_12
X$3038 VPWR VPWR VGND VGND sky130_fd_sc_hd__decap_12
X$3039 VPWR VPWR VGND VGND sky130_fd_sc_hd__decap_6
X$3041 VPWR VPWR VGND VGND sky130_fd_sc_hd__decap_12
X$3042 VPWR VPWR VGND VGND sky130_fd_sc_hd__decap_12
X$3043 VPWR VPWR VGND VGND sky130_fd_sc_hd__decap_8
X$3045 VPWR VGND \$472 \$892 \$894 VPWR VGND sky130_fd_sc_hd__xor2_1
X$3046 VPWR VPWR \$977 \$280 VGND \$469 VGND sky130_fd_sc_hd__xnor2_1
X$3047 VPWR VPWR VGND VGND sky130_fd_sc_hd__decap_12
X$3049 VPWR \$853 VGND \$900 VPWR \$280 VGND sky130_fd_sc_hd__nor2_1
X$3051 VPWR \$907 VPWR VGND \$807 \$853 VGND sky130_fd_sc_hd__nand2_1
X$3052 VPWR VPWR VGND VGND sky130_fd_sc_hd__decap_12
X$3053 VPWR VGND VPWR VGND sky130_fd_sc_hd__decap_4
X$3056 VGND \$912 \$855 \$716 \$749 VPWR VPWR VGND sky130_fd_sc_hd__xnor3_1
X$3057 VPWR \$920 VGND \$716 VPWR \$749 VGND sky130_fd_sc_hd__nor2_1
X$3058 VPWR VPWR VGND VGND sky130_fd_sc_hd__decap_12
X$3059 VPWR VPWR VGND VGND sky130_fd_sc_hd__decap_12
X$3060 VPWR VPWR VGND VGND sky130_fd_sc_hd__decap_12
X$3061 VPWR VPWR VGND VGND sky130_fd_sc_hd__decap_12
X$3062 VPWR VPWR VGND VGND sky130_fd_sc_hd__decap_6
X$3063 VPWR VPWR \$934 \$935 VGND \$860 VGND sky130_fd_sc_hd__xnor2_1
X$3064 VPWR VGND VPWR VGND sky130_fd_sc_hd__decap_3
X$3066 VPWR \$1126 VPWR VGND \$860 \$759 \$844 VGND sky130_fd_sc_hd__nand3_1
X$3067 VPWR VPWR VGND VGND sky130_fd_sc_hd__decap_12
X$3069 VPWR \$863 VGND \$762 VPWR \$847 VGND sky130_fd_sc_hd__nor2_1
X$3070 VPWR VPWR \$860 \$846 VGND \$863 VGND sky130_fd_sc_hd__xnor2_1
X$3071 VPWR VPWR VGND VGND sky130_fd_sc_hd__decap_8
X$3072 VPWR VPWR \$846 \$956 VGND \$835 VGND sky130_fd_sc_hd__xnor2_1
X$3073 VPWR VPWR VGND \$648 \$866 \$868 \$957 \$835 VGND
+ sky130_fd_sc_hd__nand4bb_1
X$3074 VPWR VPWR VGND VGND sky130_fd_sc_hd__decap_12
X$3076 VPWR \$724 VPWR \$651 \$870 \$768 \$828 VGND VGND
+ sky130_fd_sc_hd__nand4_1
X$3077 VPWR VPWR VGND VGND sky130_fd_sc_hd__decap_12
X$3078 VPWR VGND VPWR VGND sky130_fd_sc_hd__decap_4
X$3080 VPWR VPWR VGND VGND sky130_fd_sc_hd__decap_12
X$3081 VPWR VPWR VGND VGND sky130_fd_sc_hd__decap_12
X$3082 VPWR VGND VPWR VGND sky130_fd_sc_hd__decap_4
X$3084 VPWR \$942 VPWR \$808 \$776 VGND VGND sky130_fd_sc_hd__and2_0
X$3085 VPWR VPWR \$555 \$929 VGND \$560 VGND sky130_fd_sc_hd__xnor2_1
X$3086 VPWR VGND VPWR VGND sky130_fd_sc_hd__decap_4
X$3088 VPWR VPWR \$998 \$477 VGND \$877 VGND sky130_fd_sc_hd__xnor2_1
X$3089 VPWR \$918 \$477 VPWR VGND \$877 VGND sky130_fd_sc_hd__nand2b_1
X$3090 VPWR VPWR VGND VGND sky130_fd_sc_hd__decap_12
X$3091 VPWR \$889 VPWR \$901 \$784 \$883 \$371 VGND VGND
+ sky130_fd_sc_hd__o22ai_1
X$3092 VPWR \$371 \$1004 \$883 VGND \$889 \$784 VPWR VGND sky130_fd_sc_hd__or4_1
X$3093 VPWR VGND VPWR VGND sky130_fd_sc_hd__decap_4
X$3095 VPWR VPWR VGND VGND sky130_fd_sc_hd__decap_12
X$3099 VPWR VPWR VGND VGND sky130_fd_sc_hd__decap_12
X$3101 VPWR VPWR VGND VGND sky130_fd_sc_hd__decap_12
X$3102 VPWR VPWR VGND VGND sky130_fd_sc_hd__decap_12
X$3103 VPWR VPWR VGND VGND sky130_fd_sc_hd__decap_12
X$3104 VPWR VPWR VGND VGND sky130_fd_sc_hd__decap_12
X$3106 VPWR VPWR VGND VGND sky130_fd_sc_hd__decap_12
X$3107 VPWR VPWR VGND VGND sky130_fd_sc_hd__decap_6
X$3108 VPWR VGND \$977 \$71 \$1437 VPWR VGND sky130_fd_sc_hd__xor2_1
X$3110 VPWR \$1059 VGND \$977 \$472 VPWR \$71 VGND sky130_fd_sc_hd__nor3b_1
X$3111 VPWR VGND VPWR VGND sky130_fd_sc_hd__decap_3
X$3112 VPWR \$71 \$900 VPWR VGND \$979 \$1027 \$977 VGND
+ sky130_fd_sc_hd__o31ai_1
X$3114 VPWR VPWR VGND VGND sky130_fd_sc_hd__decap_8
X$3115 VPWR VGND VPWR VGND sky130_fd_sc_hd__decap_3
X$3116 VPWR \$1032 VPWR VGND \$632 \$907 VGND sky130_fd_sc_hd__nand2_1
X$3117 VPWR VPWR VGND VGND sky130_fd_sc_hd__decap_12
X$3118 VPWR VGND VPWR VGND sky130_fd_sc_hd__decap_3
X$3119 VPWR VPWR VGND \$1035 \$855 VGND sky130_fd_sc_hd__clkinv_1
X$3120 VPWR VGND VPWR VGND sky130_fd_sc_hd__decap_3
X$3121 VPWR \$1040 VGND \$1035 VPWR \$914 VGND sky130_fd_sc_hd__nor2_1
X$3122 VPWR VPWR VGND VGND sky130_fd_sc_hd__decap_12
X$3124 VPWR \$1045 VPWR VGND \$920 \$985 VGND sky130_fd_sc_hd__nand2_1
X$3125 VPWR VGND \$818 \$985 \$984 VPWR VGND sky130_fd_sc_hd__xor2_1
X$3126 VPWR VPWR VGND VGND sky130_fd_sc_hd__decap_8
X$3130 VPWR VGND \$1047 \$934 \$986 VPWR VGND
+ sky130_fd_sc_hd__lpflow_isobufsrc_1
X$3131 VPWR VPWR \$985 \$986 VGND \$934 VGND sky130_fd_sc_hd__xnor2_1
X$3133 VPWR VPWR VGND VGND sky130_fd_sc_hd__decap_12
X$3134 VPWR VPWR VGND VGND sky130_fd_sc_hd__decap_12
X$3135 VPWR VPWR VGND VGND sky130_fd_sc_hd__decap_12
X$3136 VPWR VPWR VGND VGND sky130_fd_sc_hd__decap_12
X$3138 VPWR VPWR VGND VGND sky130_fd_sc_hd__decap_12
X$3139 VPWR VPWR VGND VGND sky130_fd_sc_hd__decap_8
X$3140 VPWR VGND VPWR VGND sky130_fd_sc_hd__decap_3
X$3142 VPWR VPWR VGND VGND sky130_fd_sc_hd__decap_12
X$3143 VPWR VPWR VGND VGND sky130_fd_sc_hd__decap_12
X$3145 VPWR VPWR VGND VGND sky130_fd_sc_hd__decap_12
X$3146 VPWR VGND VPWR VGND sky130_fd_sc_hd__decap_4
X$3147 VPWR \$1049 VGND \$996 VPWR \$828 VGND sky130_fd_sc_hd__nor2_1
X$3148 VPWR VPWR \$1053 \$996 VGND \$946 VGND sky130_fd_sc_hd__xnor2_1
X$3149 VPWR VPWR VGND VGND sky130_fd_sc_hd__decap_6
X$3152 VPWR \$1034 VPWR VGND \$1031 \$998 \$658 VGND sky130_fd_sc_hd__nand3_1
X$3153 VPWR VPWR \$996 \$998 VGND \$942 VGND sky130_fd_sc_hd__xnor2_1
X$3154 VPWR \$1030 VPWR VGND \$942 \$998 VGND sky130_fd_sc_hd__nand2_1
X$3155 VPWR VPWR VGND VGND sky130_fd_sc_hd__decap_12
X$3158 VPWR VPWR VGND VGND sky130_fd_sc_hd__decap_12
X$3159 VPWR VGND VPWR VGND sky130_fd_sc_hd__decap_4
X$3162 VPWR VGND \$1004 VPWR \$901 \$1012 \$918 VGND sky130_fd_sc_hd__a21oi_1
X$3163 VPWR \$929 VPWR VGND \$901 \$1004 VGND sky130_fd_sc_hd__nand2_1
X$3164 VPWR VPWR VGND VGND sky130_fd_sc_hd__decap_12
X$3165 VPWR VPWR VGND VGND sky130_fd_sc_hd__decap_12
X$3166 VPWR VPWR VGND VGND sky130_fd_sc_hd__decap_8
X$3186 VPWR VPWR VGND VGND sky130_fd_sc_hd__decap_12
X$3188 VPWR VPWR VGND VGND sky130_fd_sc_hd__decap_12
X$3189 VPWR VPWR VGND VGND sky130_fd_sc_hd__decap_12
X$3190 VPWR VPWR VGND VGND sky130_fd_sc_hd__decap_6
X$3192 VPWR VPWR VGND VGND sky130_fd_sc_hd__decap_12
X$3193 VPWR VPWR VGND VGND sky130_fd_sc_hd__decap_12
X$3194 VPWR VPWR VGND VGND sky130_fd_sc_hd__decap_12
X$3195 VPWR VPWR VGND VGND sky130_fd_sc_hd__decap_12
X$3196 VPWR VPWR VGND VGND sky130_fd_sc_hd__decap_12
X$3197 VPWR VPWR VGND VGND sky130_fd_sc_hd__decap_6
X$3199 VGND \$280 \$201 \$288 \$203 VPWR VPWR VGND sky130_fd_sc_hd__xnor3_1
X$3202 VPWR VPWR VGND \$203 \$207 VGND sky130_fd_sc_hd__clkinv_1
X$3203 VPWR VPWR VGND VGND sky130_fd_sc_hd__decap_12
X$3205 VPWR \$425 VGND \$211 \$238 \$298 VPWR VGND sky130_fd_sc_hd__maj3_1
X$3206 VPWR \$298 VGND \$97 VPWR \$99 VGND sky130_fd_sc_hd__nor2_1
X$3207 VPWR VGND VPWR VGND sky130_fd_sc_hd__decap_3
X$3208 VPWR VPWR VGND \$302 \$159 VGND sky130_fd_sc_hd__clkinv_1
X$3209 VPWR \$239 VPWR VGND \$218 \$215 VGND sky130_fd_sc_hd__nand2_1
X$3210 VPWR \$218 VGND \$99 \$97 VPWR VGND sky130_fd_sc_hd__lpflow_inputiso1p_1
X$3211 VPWR VPWR VGND VGND sky130_fd_sc_hd__decap_12
X$3213 VPWR \$242 VPWR VGND \$103 \$161 VGND sky130_fd_sc_hd__nand2_1
X$3214 VPWR VPWR \$244 \$161 VGND \$162 VGND sky130_fd_sc_hd__xnor2_1
X$3215 VPWR VGND \$408 VPWR \$161 \$645 \$162 VGND sky130_fd_sc_hd__a21oi_1
X$3216 VPWR VPWR VGND VGND sky130_fd_sc_hd__decap_12
X$3220 VGND \$211 \$164 \$325 \$165 VPWR VPWR VGND sky130_fd_sc_hd__xnor3_1
X$3221 VPWR VGND \$226 VPWR \$165 \$329 \$164 VGND sky130_fd_sc_hd__a21oi_1
X$3222 VPWR VPWR VGND VGND sky130_fd_sc_hd__decap_6
X$3223 VPWR \$165 VPWR VGND \$84 \$167 VGND sky130_fd_sc_hd__nand2_1
X$3225 VPWR VGND \$110 \$77 \$167 VPWR VGND sky130_fd_sc_hd__xor2_1
X$3226 VPWR VGND VPWR VGND sky130_fd_sc_hd__decap_3
X$3227 VPWR \$77 \$170 \$349 VPWR VGND \$110 VGND sky130_fd_sc_hd__and3_1
X$3228 VPWR \$110 VGND \$174 VPWR \$221 \$77 VGND sky130_fd_sc_hd__a21boi_0
X$3229 VPWR VPWR VGND VGND sky130_fd_sc_hd__decap_8
X$3231 VPWR \$316 VPWR VGND \$250 \$170 VGND sky130_fd_sc_hd__nand2_1
X$3232 VPWR \$314 VGND \$176 \$174 \$76 VPWR VGND sky130_fd_sc_hd__maj3_1
X$3234 VPWR VPWR \$250 \$51 VGND \$118 VGND sky130_fd_sc_hd__xnor2_1
X$3236 VPWR VPWR VGND VGND sky130_fd_sc_hd__decap_8
X$3237 VPWR VGND VPWR VGND sky130_fd_sc_hd__decap_3
X$3238 VPWR VPWR \$176 \$255 VGND \$53 VGND sky130_fd_sc_hd__xnor2_1
X$3239 VPWR VPWR VGND VGND sky130_fd_sc_hd__decap_6
X$3240 VPWR VPWR \$253 \$69 VGND \$258 VGND sky130_fd_sc_hd__xnor2_1
X$3241 VPWR VPWR \$255 \$140 VGND \$121 VGND sky130_fd_sc_hd__xnor2_1
X$3242 VPWR VPWR VGND VGND sky130_fd_sc_hd__decap_6
X$3243 VPWR VPWR \$259 \$181 VGND \$64 VGND sky130_fd_sc_hd__xnor2_1
X$3244 VPWR VPWR VGND VGND sky130_fd_sc_hd__decap_6
X$3245 VPWR VGND \$134 \$125 \$181 VPWR VGND sky130_fd_sc_hd__xor2_1
X$3246 VPWR VGND VPWR VGND sky130_fd_sc_hd__decap_4
X$3250 VPWR \$669 VGND \$456 \$126 \$187 VPWR VGND sky130_fd_sc_hd__maj3_1
X$3251 VPWR VPWR VGND \$187 \$188 VGND sky130_fd_sc_hd__clkinv_1
X$3255 VPWR VPWR VGND VGND sky130_fd_sc_hd__decap_12
X$3257 VPWR VPWR VGND VGND sky130_fd_sc_hd__decap_12
X$3258 VPWR VPWR VGND VGND sky130_fd_sc_hd__decap_12
X$3259 VPWR VPWR VGND VGND sky130_fd_sc_hd__decap_12
X$3260 VPWR VPWR VGND VGND sky130_fd_sc_hd__decap_12
X$3262 VPWR VPWR VGND VGND sky130_fd_sc_hd__decap_12
X$3263 VPWR VPWR VGND VGND sky130_fd_sc_hd__decap_12
X$3266 VPWR VPWR VGND VGND sky130_fd_sc_hd__decap_12
X$3268 VPWR VPWR VGND VGND sky130_fd_sc_hd__decap_12
X$3269 VPWR VPWR VGND VGND sky130_fd_sc_hd__decap_8
X$3271 VPWR \$379 VGND \$201 VPWR \$203 VGND sky130_fd_sc_hd__nor2_1
X$3272 VPWR VPWR \$335 \$201 VGND \$203 VGND sky130_fd_sc_hd__xnor2_1
X$3273 VPWR VPWR VGND VGND sky130_fd_sc_hd__decap_6
X$3275 VGND \$386 \$239 \$211 \$238 VPWR VPWR VGND sky130_fd_sc_hd__xor3_1
X$3277 VPWR VPWR VGND VGND sky130_fd_sc_hd__decap_8
X$3279 VPWR \$215 VPWR VGND \$98 \$302 VGND sky130_fd_sc_hd__nand2_1
X$3280 VPWR VGND VPWR VGND sky130_fd_sc_hd__decap_3
X$3282 VPWR VPWR VGND VGND sky130_fd_sc_hd__decap_8
X$3284 VPWR \$238 VPWR VGND \$242 \$240 VGND sky130_fd_sc_hd__nand2_1
X$3286 VPWR VGND VPWR VGND sky130_fd_sc_hd__decap_4
X$3288 VPWR \$240 VPWR VGND \$105 \$244 VGND sky130_fd_sc_hd__nand2_1
X$3289 VPWR VPWR VGND VGND sky130_fd_sc_hd__decap_12
X$3290 VPWR VPWR VGND VGND sky130_fd_sc_hd__decap_8
X$3292 VPWR VPWR \$413 \$106 VGND \$108 VGND sky130_fd_sc_hd__xnor2_1
X$3294 VPWR \$325 VGND \$343 VPWR \$246 VGND sky130_fd_sc_hd__nor2_1
X$3295 VPWR VPWR VGND VGND sky130_fd_sc_hd__decap_12
X$3297 VPWR VPWR VGND VGND sky130_fd_sc_hd__decap_12
X$3298 VPWR VPWR VGND VGND sky130_fd_sc_hd__decap_8
X$3301 VPWR VPWR VGND VGND sky130_fd_sc_hd__decap_6
X$3302 VPWR \$522 VPWR VGND \$350 \$170 \$110 VGND sky130_fd_sc_hd__nand3_1
X$3303 VPWR VPWR VGND VGND sky130_fd_sc_hd__decap_12
X$3306 VPWR \$768 VPWR VGND \$316 \$253 \$315 \$116 VGND sky130_fd_sc_hd__o31a_1
X$3307 VPWR \$174 VPWR VGND \$116 \$250 VGND sky130_fd_sc_hd__nand2_1
X$3308 VPWR VPWR VGND VGND sky130_fd_sc_hd__decap_12
X$3310 VPWR \$445 VGND \$176 \$253 \$252 VPWR VGND sky130_fd_sc_hd__or3_1
X$3311 VPWR VGND VPWR VGND sky130_fd_sc_hd__decap_4
X$3313 VPWR \$53 \$258 \$355 VPWR VGND \$255 VGND sky130_fd_sc_hd__and3_1
X$3314 VPWR \$552 VPWR VGND \$255 \$258 VGND sky130_fd_sc_hd__nand2_1
X$3315 VPWR VPWR VGND VGND sky130_fd_sc_hd__decap_12
X$3316 VPWR VGND VPWR VGND sky130_fd_sc_hd__decap_4
X$3317 VPWR \$663 VGND \$358 VPWR \$259 VGND sky130_fd_sc_hd__nor2_1
X$3320 VPWR VGND VPWR VGND sky130_fd_sc_hd__decap_4
X$3321 VPWR \$357 VPWR VGND \$64 \$181 VGND sky130_fd_sc_hd__nand2_1
X$3322 VPWR VPWR VGND VGND sky130_fd_sc_hd__decap_12
X$3324 VPWR \$363 VPWR VGND \$125 \$134 VGND sky130_fd_sc_hd__nand2_1
X$3325 VPWR VPWR VGND VGND sky130_fd_sc_hd__decap_6
X$3327 VPWR VPWR \$364 \$262 VGND \$126 VGND sky130_fd_sc_hd__xnor2_1
X$3328 VGND \$262 \$271 \$188 \$264 VPWR VPWR VGND sky130_fd_sc_hd__xnor3_1
X$3349 VPWR VPWR VGND VGND sky130_fd_sc_hd__decap_12
X$3351 VPWR VPWR VGND VGND sky130_fd_sc_hd__decap_12
X$3352 VPWR VPWR VGND VGND sky130_fd_sc_hd__decap_12
X$3353 VPWR VPWR VGND VGND sky130_fd_sc_hd__decap_6
X$3355 VPWR VPWR VGND VGND sky130_fd_sc_hd__decap_12
X$3356 VPWR VPWR VGND VGND sky130_fd_sc_hd__decap_12
X$3357 VPWR VPWR VGND VGND sky130_fd_sc_hd__decap_12
X$3358 VPWR VPWR VGND VGND sky130_fd_sc_hd__decap_8
X$3360 VGND \$684 \$575 \$536 \$537 VPWR VPWR VGND sky130_fd_sc_hd__xnor3_1
X$3362 VPWR \$696 VPWR \$537 \$536 VGND VGND sky130_fd_sc_hd__and2_0
X$3364 VPWR \$704 VGND \$536 VPWR \$537 VGND sky130_fd_sc_hd__nor2_1
X$3365 VPWR VPWR VGND VGND sky130_fd_sc_hd__decap_8
X$3366 VPWR VGND VPWR VGND sky130_fd_sc_hd__decap_3
X$3368 VPWR \$855 VPWR VGND \$335 \$537 \$589 \$288 VGND sky130_fd_sc_hd__o31a_1
X$3369 VPWR \$589 \$386 VPWR VGND \$428 VGND sky130_fd_sc_hd__nand2b_1
X$3370 VGND \$537 \$425 \$426 \$542 VPWR VPWR VGND sky130_fd_sc_hd__xnor3_1
X$3371 VPWR VPWR VGND VGND sky130_fd_sc_hd__decap_12
X$3372 VPWR VPWR VGND VGND sky130_fd_sc_hd__decap_12
X$3373 VPWR VPWR VGND VGND sky130_fd_sc_hd__decap_12
X$3374 VPWR VGND VPWR VGND sky130_fd_sc_hd__decap_4
X$3376 VPWR VGND \$437 \$342 \$426 VPWR VGND sky130_fd_sc_hd__xor2_1
X$3378 VPWR \$440 VPWR \$759 VGND \$89 \$606 VGND sky130_fd_sc_hd__o21a_1
X$3380 VPWR VPWR \$407 \$440 VGND \$614 VGND sky130_fd_sc_hd__xnor2_1
X$3381 VPWR VPWR VGND VGND sky130_fd_sc_hd__decap_12
X$3382 VPWR VPWR VGND VGND sky130_fd_sc_hd__decap_12
X$3383 VPWR VPWR VGND VGND sky130_fd_sc_hd__decap_8
X$3384 VPWR VPWR \$648 \$443 VGND \$619 \$84 VGND sky130_fd_sc_hd__o21ai_0
X$3385 VPWR VPWR VGND VGND sky130_fd_sc_hd__decap_12
X$3386 VPWR VPWR VGND VGND sky130_fd_sc_hd__decap_12
X$3387 VPWR VPWR VGND VGND sky130_fd_sc_hd__decap_8
X$3389 VPWR VPWR \$772 \$604 VGND \$548 VGND sky130_fd_sc_hd__xnor2_1
X$3392 VPWR VPWR VGND VGND sky130_fd_sc_hd__decap_8
X$3394 VPWR VGND \$549 \$551 \$604 VPWR VGND sky130_fd_sc_hd__xor2_1
X$3395 VGND \$658 \$552 \$252 \$549 \$661 \$53 VPWR VPWR VGND
+ sky130_fd_sc_hd__o311a_1
X$3396 VPWR VPWR VGND VGND sky130_fd_sc_hd__decap_8
X$3398 VPWR VPWR \$252 \$592 VGND \$555 VGND sky130_fd_sc_hd__xnor2_1
X$3399 VPWR \$689 VPWR VGND \$481 \$555 VGND sky130_fd_sc_hd__nand2_1
X$3400 VPWR VPWR VGND VGND sky130_fd_sc_hd__decap_8
X$3401 VPWR VGND VPWR VGND sky130_fd_sc_hd__decap_3
X$3402 VPWR VPWR \$448 \$583 \$686 \$181 VGND VGND sky130_fd_sc_hd__o21bai_1
X$3403 VPWR \$580 VGND \$478 VPWR \$560 VGND sky130_fd_sc_hd__nor2_1
X$3404 VPWR VPWR \$448 \$362 VGND \$465 VGND sky130_fd_sc_hd__xnor2_1
X$3405 VPWR VPWR VGND VGND sky130_fd_sc_hd__decap_8
X$3407 VPWR \$362 VPWR \$125 \$560 \$371 \$459 VGND VGND
+ sky130_fd_sc_hd__nand4_1
X$3409 VPWR VPWR VGND VGND sky130_fd_sc_hd__decap_12
X$3413 VPWR VPWR VGND VGND sky130_fd_sc_hd__decap_12
X$3417 VPWR VPWR VGND VGND sky130_fd_sc_hd__decap_12
X$3418 VPWR VPWR VGND VGND sky130_fd_sc_hd__decap_12
X$3419 VPWR VPWR VGND VGND sky130_fd_sc_hd__decap_12
X$3420 VPWR VPWR VGND VGND sky130_fd_sc_hd__decap_12
X$3424 VPWR VPWR VGND VGND sky130_fd_sc_hd__decap_12
X$3425 VPWR VPWR VGND VGND sky130_fd_sc_hd__decap_12
X$3428 VPWR VPWR VGND VGND sky130_fd_sc_hd__decap_12
X$3432 VPWR VPWR VGND VGND sky130_fd_sc_hd__decap_12
X$3434 VPWR \$575 \$702 VGND \$696 \$704 VPWR VGND sky130_fd_sc_hd__nor3_1
X$3435 VPWR VPWR VGND VGND sky130_fd_sc_hd__decap_8
X$3436 VPWR VGND \$634 VPWR \$542 \$633 \$704 VGND sky130_fd_sc_hd__a21oi_1
X$3438 VPWR \$207 \$589 VPWR VGND \$537 \$716 \$201 VGND
+ sky130_fd_sc_hd__o31ai_1
X$3439 VPWR \$719 VPWR VGND \$201 \$537 \$589 \$207 VGND sky130_fd_sc_hd__o31a_1
X$3443 VPWR VPWR VGND VGND sky130_fd_sc_hd__decap_12
X$3444 VPWR VPWR VGND VGND sky130_fd_sc_hd__decap_12
X$3445 VPWR VGND VPWR VGND sky130_fd_sc_hd__decap_4
X$3448 VPWR VPWR VGND VGND sky130_fd_sc_hd__decap_12
X$3452 VPWR VPWR VGND VGND sky130_fd_sc_hd__decap_12
X$3453 VPWR VPWR VGND VGND sky130_fd_sc_hd__decap_12
X$3454 VPWR VPWR VGND VGND sky130_fd_sc_hd__decap_12
X$3455 VPWR VPWR VGND VGND sky130_fd_sc_hd__decap_12
X$3459 VPWR VPWR VGND VGND sky130_fd_sc_hd__decap_12
X$3460 VPWR VPWR VGND VGND sky130_fd_sc_hd__decap_12
X$3463 VPWR VPWR VGND VGND sky130_fd_sc_hd__decap_12
X$3464 VPWR VPWR VGND VGND sky130_fd_sc_hd__decap_8
X$3468 VPWR VGND VPWR VGND sky130_fd_sc_hd__decap_3
X$3469 VGND \$651 \$501 \$604 \$548 VPWR VPWR VGND sky130_fd_sc_hd__xnor3_1
X$3470 VPWR VPWR VGND VGND sky130_fd_sc_hd__decap_6
X$3472 VPWR \$603 VPWR VGND \$604 \$724 \$657 \$658 VGND
+ sky130_fd_sc_hd__o2bb2ai_1
X$3473 VPWR VPWR VGND VGND sky130_fd_sc_hd__decap_12
X$3477 VPWR VPWR VGND VGND sky130_fd_sc_hd__decap_6
X$3479 VPWR \$810 VGND \$663 VPWR \$66 VGND sky130_fd_sc_hd__nor2_1
X$3480 VPWR VPWR \$549 \$690 VGND \$689 VGND sky130_fd_sc_hd__xnor2_1
X$3483 VPWR VPWR VGND VGND sky130_fd_sc_hd__decap_12
X$3484 VPWR VPWR VGND VGND sky130_fd_sc_hd__decap_12
X$3488 VPWR VPWR VGND VGND sky130_fd_sc_hd__decap_12
X$3489 VPWR VPWR VGND VGND sky130_fd_sc_hd__decap_6
X$3491 VPWR VGND \$669 \$670 \$362 VPWR VGND sky130_fd_sc_hd__xor2_1
X$3492 VPWR VPWR VGND VGND sky130_fd_sc_hd__decap_6
X$3494 VPWR VPWR VGND VGND sky130_fd_sc_hd__decap_12
X$3496 VPWR VPWR VGND VGND sky130_fd_sc_hd__decap_12
X$3497 VPWR VPWR VGND VGND sky130_fd_sc_hd__decap_12
X$3498 VPWR VPWR VGND VGND sky130_fd_sc_hd__decap_6
X$3500 VPWR VPWR VGND VGND sky130_fd_sc_hd__decap_12
X$3501 VPWR VPWR VGND VGND sky130_fd_sc_hd__decap_12
X$3502 VPWR VGND VPWR VGND sky130_fd_sc_hd__decap_3
X$3503 VGND \$1253 \$684 \$1059 \$1260 VPWR VPWR VGND sky130_fd_sc_hd__xnor3_1
X$3504 VPWR VPWR VGND VGND sky130_fd_sc_hd__decap_12
X$3505 VPWR VPWR VGND VGND sky130_fd_sc_hd__decap_12
X$3506 VPWR VPWR VGND VGND sky130_fd_sc_hd__decap_12
X$3507 VPWR VGND VPWR VGND sky130_fd_sc_hd__decap_4
X$3509 VPWR VPWR VGND VGND sky130_fd_sc_hd__decap_12
X$3510 VPWR VPWR VGND VGND sky130_fd_sc_hd__decap_12
X$3512 VPWR VGND \$1344 \$1195 \$1421 VPWR VGND sky130_fd_sc_hd__xor2_1
X$3513 VPWR VPWR VGND VGND sky130_fd_sc_hd__decap_12
X$3515 VPWR VPWR VGND \$1427 \$1117 VGND sky130_fd_sc_hd__clkinv_1
X$3516 VPWR \$1533 VGND \$1122 \$1215 VPWR VGND
+ sky130_fd_sc_hd__lpflow_inputiso1p_1
X$3517 VPWR \$1295 VPWR VGND \$1122 \$1215 VGND sky130_fd_sc_hd__nand2_1
X$3518 VPWR VPWR VGND VGND sky130_fd_sc_hd__decap_8
X$3519 VPWR VPWR \$1215 \$1221 VGND \$1123 VGND sky130_fd_sc_hd__xnor2_1
X$3520 VPWR VPWR VGND VGND sky130_fd_sc_hd__decap_8
X$3522 VPWR \$1223 \$1221 VGND \$1300 \$1303 VPWR VGND sky130_fd_sc_hd__nor3_1
X$3524 VPWR VGND VPWR VGND sky130_fd_sc_hd__decap_4
X$3526 VPWR VGND \$1223 \$1128 \$1129 VPWR VGND
+ sky130_fd_sc_hd__lpflow_isobufsrc_1
X$3527 VPWR VPWR VGND VGND sky130_fd_sc_hd__decap_12
X$3528 VPWR VPWR VGND VGND sky130_fd_sc_hd__decap_8
X$3529 VPWR VGND \$1358 \$1226 \$1357 VPWR VGND sky130_fd_sc_hd__xor2_1
X$3530 VPWR VPWR \$1394 \$1454 \$1317 \$1227 \$1359 \$1228 VGND VGND
+ sky130_fd_sc_hd__o2111ai_1
X$3531 VPWR VPWR VGND VGND sky130_fd_sc_hd__decap_8
X$3532 VPWR VGND VPWR VGND sky130_fd_sc_hd__decap_3
X$3533 VPWR VPWR \$1129 \$1115 VGND \$1118 VGND sky130_fd_sc_hd__xnor2_1
X$3534 VPWR \$1310 VPWR \$1228 \$1115 \$1118 VGND \$1153 VGND
+ sky130_fd_sc_hd__a22oi_1
X$3535 VPWR VPWR VGND VGND sky130_fd_sc_hd__decap_12
X$3536 VPWR VGND VPWR VGND sky130_fd_sc_hd__decap_4
X$3539 VPWR VGND VPWR VGND sky130_fd_sc_hd__decap_4
X$3540 VPWR \$1391 VGND \$1234 VPWR \$1233 VGND sky130_fd_sc_hd__nor2_1
X$3541 VPWR VPWR VGND VGND sky130_fd_sc_hd__decap_8
X$3542 VPWR VGND VPWR VGND sky130_fd_sc_hd__decap_3
X$3543 VPWR VGND \$1237 \$1282 \$1234 VPWR VGND sky130_fd_sc_hd__xor2_1
X$3544 VPWR VGND VPWR VGND sky130_fd_sc_hd__decap_3
X$3545 VPWR \$1277 VGND \$1083 \$1276 VPWR VGND
+ sky130_fd_sc_hd__lpflow_inputiso1p_1
X$3546 VPWR VPWR VGND VGND sky130_fd_sc_hd__decap_12
X$3548 VPWR \$1268 VPWR VGND \$1239 \$1101 VGND sky130_fd_sc_hd__nand2_1
X$3549 VPWR VGND VPWR VGND sky130_fd_sc_hd__decap_3
X$3550 VPWR \$1239 VGND \$780 \$879 VPWR VGND
+ sky130_fd_sc_hd__lpflow_inputiso1p_1
X$3551 VPWR VGND \$1012 \$1174 \$1237 VPWR VGND sky130_fd_sc_hd__xor2_1
X$3552 VPWR VPWR VGND VGND sky130_fd_sc_hd__decap_12
X$3553 VPWR VPWR VGND VGND sky130_fd_sc_hd__decap_8
X$3556 VPWR \$1166 VGND \$1470 \$1243 \$1364 VPWR VGND sky130_fd_sc_hd__maj3_1
X$3557 VPWR VGND VPWR VGND sky130_fd_sc_hd__decap_4
X$3561 VPWR VPWR VGND VGND sky130_fd_sc_hd__decap_12
X$3563 VPWR VPWR VGND VGND sky130_fd_sc_hd__decap_12
X$3564 VPWR VPWR VGND VGND sky130_fd_sc_hd__decap_12
X$3565 VPWR VPWR VGND VGND sky130_fd_sc_hd__decap_12
X$3566 VPWR VPWR VGND VGND sky130_fd_sc_hd__decap_12
X$3568 VPWR VPWR VGND VGND sky130_fd_sc_hd__decap_12
X$3569 VPWR VPWR VGND VGND sky130_fd_sc_hd__decap_8
X$3571 VPWR \$1330 VPWR VGND \$1260 \$1389 VGND sky130_fd_sc_hd__nand2_1
X$3573 VPWR VPWR VGND VGND sky130_fd_sc_hd__decap_12
X$3576 VPWR VPWR VGND \$1401 \$1334 VGND sky130_fd_sc_hd__clkinv_1
X$3578 VPWR \$1404 VGND \$1027 \$1336 \$1401 VPWR VGND sky130_fd_sc_hd__maj3_1
X$3579 VPWR \$1408 VGND \$1336 \$1027 VPWR VGND
+ sky130_fd_sc_hd__lpflow_inputiso1p_1
X$3580 VPWR VPWR VGND VGND sky130_fd_sc_hd__decap_8
X$3582 VPWR VPWR \$1339 \$1408 VGND \$1337 \$1272 VGND sky130_fd_sc_hd__o21ai_0
X$3583 VPWR VGND VPWR VGND sky130_fd_sc_hd__decap_4
X$3584 VPWR VGND \$1425 \$1192 \$1272 VPWR VGND sky130_fd_sc_hd__nor2b_1
X$3586 VPWR VPWR VGND VGND sky130_fd_sc_hd__decap_12
X$3588 VPWR \$1535 VGND \$1421 \$1425 \$1287 VPWR VGND sky130_fd_sc_hd__maj3_1
X$3589 VPWR VPWR VGND VGND sky130_fd_sc_hd__decap_8
X$3592 VGND \$1344 \$1215 \$1122 \$1117 VPWR VPWR VGND sky130_fd_sc_hd__xnor3_1
X$3594 VPWR VPWR VGND VGND sky130_fd_sc_hd__decap_6
X$3596 VPWR \$1351 \$1221 VPWR VGND \$1123 VGND sky130_fd_sc_hd__nand2b_1
X$3597 VPWR VPWR VGND VGND sky130_fd_sc_hd__decap_8
X$3598 VPWR VGND VPWR VGND sky130_fd_sc_hd__decap_3
X$3599 VPWR VPWR \$1352 \$1487 VGND \$1300 VGND sky130_fd_sc_hd__xnor2_1
X$3600 VPWR VPWR VGND VGND sky130_fd_sc_hd__decap_12
X$3602 VPWR VGND VPWR VGND sky130_fd_sc_hd__decap_4
X$3604 VPWR VGND \$1357 \$1412 \$1409 VPWR VGND sky130_fd_sc_hd__xor2_1
X$3605 VPWR \$1317 VPWR VGND \$1412 \$1357 VGND sky130_fd_sc_hd__nand2_1
X$3606 VPWR \$1227 VPWR VGND \$1226 \$1358 VGND sky130_fd_sc_hd__nand2_1
X$3607 VPWR VGND \$1228 \$1359 \$1358 VPWR VGND sky130_fd_sc_hd__xor2_1
X$3609 VPWR VPWR VGND VGND sky130_fd_sc_hd__decap_12
X$3610 VPWR VPWR VGND VGND sky130_fd_sc_hd__decap_12
X$3612 VPWR VPWR VGND VGND sky130_fd_sc_hd__decap_12
X$3613 VPWR VGND VPWR VGND sky130_fd_sc_hd__decap_4
X$3615 VPWR VPWR \$1359 \$1234 VGND \$1233 VGND sky130_fd_sc_hd__xnor2_1
X$3616 VPWR VGND VPWR VGND sky130_fd_sc_hd__decap_3
X$3617 VPWR \$1382 \$1394 VGND \$1379 \$1391 VPWR VGND sky130_fd_sc_hd__nor3_1
X$3618 VPWR VPWR VGND VGND sky130_fd_sc_hd__decap_12
X$3620 VPWR VPWR VGND VGND sky130_fd_sc_hd__decap_12
X$3621 VPWR VPWR VGND VGND sky130_fd_sc_hd__decap_6
X$3623 VPWR VPWR VGND VGND sky130_fd_sc_hd__decap_12
X$3624 VPWR VGND VPWR VGND sky130_fd_sc_hd__decap_3
X$3626 VPWR \$1089 \$1378 VGND \$1174 \$64 VPWR VGND sky130_fd_sc_hd__nor3_1
X$3627 VPWR VPWR VGND VGND sky130_fd_sc_hd__decap_12
X$3629 VGND \$271 \$1460 \$1363 \$1463 VPWR VPWR VGND sky130_fd_sc_hd__xnor3_1
X$3630 VPWR VPWR VGND \$1364 \$1363 VGND sky130_fd_sc_hd__clkinv_1
X$3631 VPWR VGND VPWR VGND sky130_fd_sc_hd__decap_3
X$3651 VPWR VPWR VGND VGND sky130_fd_sc_hd__decap_12
X$3653 VPWR VPWR VGND VGND sky130_fd_sc_hd__decap_12
X$3654 VPWR VPWR VGND VGND sky130_fd_sc_hd__decap_12
X$3655 VPWR VPWR VGND VGND sky130_fd_sc_hd__decap_6
X$3657 VPWR VPWR VGND VGND sky130_fd_sc_hd__decap_12
X$3658 VPWR VPWR VGND VGND sky130_fd_sc_hd__decap_12
X$3659 VPWR VPWR VGND VGND sky130_fd_sc_hd__decap_12
X$3660 VPWR VPWR VGND VGND sky130_fd_sc_hd__decap_12
X$3661 VPWR VPWR VGND VGND sky130_fd_sc_hd__decap_12
X$3662 VPWR VPWR VGND VGND sky130_fd_sc_hd__decap_8
X$3664 VPWR VGND \$333 VPWR \$288 \$379 \$473 VGND sky130_fd_sc_hd__a21o_1
X$3665 VPWR VGND VPWR VGND sky130_fd_sc_hd__decap_4
X$3666 VPWR VPWR VGND \$333 \$335 VGND sky130_fd_sc_hd__clkinv_1
X$3669 VPWR VPWR VGND VGND sky130_fd_sc_hd__decap_12
X$3670 VPWR VPWR VGND VGND sky130_fd_sc_hd__decap_12
X$3672 VPWR VPWR \$427 \$211 VGND \$238 VGND sky130_fd_sc_hd__xnor2_1
X$3673 VPWR VPWR VGND VGND sky130_fd_sc_hd__decap_8
X$3675 VPWR \$83 \$429 VPWR VGND \$337 \$399 \$97 VGND sky130_fd_sc_hd__o31ai_1
X$3676 VPWR \$337 VPWR \$496 \$218 \$341 \$240 VGND VGND
+ sky130_fd_sc_hd__o22ai_1
X$3677 VPWR VGND VPWR VGND sky130_fd_sc_hd__decap_4
X$3679 VPWR \$504 VGND \$341 VPWR \$242 VGND sky130_fd_sc_hd__nor2_1
X$3681 VPWR \$431 VPWR VGND \$342 \$211 \$244 VGND sky130_fd_sc_hd__nand3_1
X$3682 VPWR \$408 VGND \$407 VPWR \$341 VGND sky130_fd_sc_hd__nor2_1
X$3683 VPWR \$341 VPWR VGND \$211 \$342 VGND sky130_fd_sc_hd__nand2_1
X$3684 VPWR VPWR VGND VGND sky130_fd_sc_hd__decap_12
X$3686 VPWR VGND \$343 \$89 \$413 VPWR VGND sky130_fd_sc_hd__lpflow_isobufsrc_1
X$3687 VPWR VGND VPWR VGND sky130_fd_sc_hd__decap_4
X$3689 VPWR VPWR \$342 \$329 VGND \$344 VGND sky130_fd_sc_hd__xnor2_1
X$3690 VPWR VPWR \$436 \$164 VGND \$165 VGND sky130_fd_sc_hd__xnor2_1
X$3691 VPWR VPWR VGND VGND sky130_fd_sc_hd__decap_8
X$3693 VPWR \$348 \$344 VPWR VGND \$164 \$526 \$165 VGND
+ sky130_fd_sc_hd__o31ai_1
X$3694 VPWR \$348 VPWR VGND \$349 \$350 VGND sky130_fd_sc_hd__nand2_1
X$3695 VPWR VPWR \$344 \$350 VGND \$349 VGND sky130_fd_sc_hd__xnor2_1
X$3696 VPWR VPWR VGND VGND sky130_fd_sc_hd__decap_12
X$3697 VPWR VGND VPWR VGND sky130_fd_sc_hd__decap_3
X$3698 VPWR VGND \$253 \$314 \$350 VPWR VGND sky130_fd_sc_hd__xor2_1
X$3699 VPWR \$510 VGND \$253 VPWR \$314 VGND sky130_fd_sc_hd__nor2_1
X$3700 VPWR VPWR VGND VGND sky130_fd_sc_hd__decap_8
X$3701 VPWR VGND VPWR VGND sky130_fd_sc_hd__decap_3
X$3703 VPWR VPWR VGND VGND sky130_fd_sc_hd__decap_8
X$3704 VPWR VGND \$252 \$355 \$315 VPWR VGND sky130_fd_sc_hd__xor2_1
X$3705 VPWR VPWR VGND VGND sky130_fd_sc_hd__decap_12
X$3706 VPWR VPWR VGND VGND sky130_fd_sc_hd__decap_8
X$3707 VPWR \$358 \$481 VGND \$259 \$121 VPWR VGND sky130_fd_sc_hd__nor3_1
X$3708 VPWR \$359 \$258 \$358 VGND \$357 VPWR VGND sky130_fd_sc_hd__mux2i_1
X$3709 VPWR VPWR VGND VGND sky130_fd_sc_hd__decap_8
X$3710 VGND \$358 \$362 \$363 \$371 VPWR VPWR VGND sky130_fd_sc_hd__xnor3_1
X$3711 VPWR VPWR \$359 \$362 VGND \$371 VGND sky130_fd_sc_hd__xnor2_1
X$3713 VPWR \$465 VGND \$364 VPWR \$132 VGND sky130_fd_sc_hd__nor2_1
X$3715 VPWR \$459 VPWR VGND \$132 \$364 VGND sky130_fd_sc_hd__nand2_1
X$3719 VPWR VPWR VGND VGND sky130_fd_sc_hd__decap_12
X$3721 VPWR VPWR VGND VGND sky130_fd_sc_hd__decap_12
X$3722 VPWR VPWR VGND VGND sky130_fd_sc_hd__decap_12
X$3723 VPWR VPWR VGND VGND sky130_fd_sc_hd__decap_12
X$3724 VPWR VPWR VGND VGND sky130_fd_sc_hd__decap_12
X$3726 VPWR VPWR VGND VGND sky130_fd_sc_hd__decap_12
X$3727 VPWR VPWR VGND VGND sky130_fd_sc_hd__decap_12
X$3730 VPWR VPWR VGND VGND sky130_fd_sc_hd__decap_12
X$3733 VPWR \$575 VPWR VGND \$469 \$280 \$472 \$420 VGND sky130_fd_sc_hd__o31a_1
X$3734 VPWR VPWR \$472 \$473 VGND \$386 VGND sky130_fd_sc_hd__xnor2_1
X$3736 VPWR \$420 VPWR VGND \$386 \$333 \$288 VGND sky130_fd_sc_hd__nand3_1
X$3737 VPWR \$536 VPWR VGND \$379 \$386 VGND sky130_fd_sc_hd__nand2_1
X$3738 VPWR VPWR VGND VGND sky130_fd_sc_hd__decap_12
X$3739 VPWR VPWR VGND VGND sky130_fd_sc_hd__decap_12
X$3742 VPWR VGND \$425 \$426 \$634 VPWR VGND sky130_fd_sc_hd__xor2_1
X$3744 VPWR \$542 VGND \$427 VPWR \$215 VGND sky130_fd_sc_hd__nor2_1
X$3745 VPWR \$337 \$426 VPWR VGND \$427 VGND sky130_fd_sc_hd__nand2b_1
X$3746 VPWR \$639 VPWR VGND \$159 \$337 \$428 \$98 VGND sky130_fd_sc_hd__o31a_1
X$3748 VPWR VGND \$429 \$496 \$428 VPWR VGND sky130_fd_sc_hd__xor2_1
X$3749 VPWR VPWR VGND VGND sky130_fd_sc_hd__decap_6
X$3751 VPWR VPWR \$644 \$431 VGND \$429 \$105 VGND sky130_fd_sc_hd__o21ai_0
X$3752 VPWR VGND \$504 \$407 \$429 VPWR VGND sky130_fd_sc_hd__xor2_1
X$3753 VPWR VPWR VGND VGND sky130_fd_sc_hd__decap_12
X$3755 VPWR \$606 VPWR VGND \$342 \$544 VGND sky130_fd_sc_hd__nand2_1
X$3756 VPWR VGND \$437 \$343 \$436 VPWR VGND sky130_fd_sc_hd__lpflow_isobufsrc_1
X$3757 VPWR \$342 VPWR \$614 \$617 \$246 VGND \$437 VGND
+ sky130_fd_sc_hd__a22oi_1
X$3758 VPWR \$544 VGND \$436 VPWR \$413 VGND sky130_fd_sc_hd__nor2_1
X$3759 VPWR VGND VPWR VGND sky130_fd_sc_hd__decap_3
X$3761 VPWR \$617 VGND \$344 VPWR \$436 VGND sky130_fd_sc_hd__nor2_1
X$3763 VPWR \$441 VGND \$436 \$344 \$440 \$762 \$108 VPWR VGND
+ sky130_fd_sc_hd__o41ai_1
X$3765 VPWR VPWR \$441 \$167 VGND \$84 VGND sky130_fd_sc_hd__xnor2_1
X$3767 VPWR VGND \$443 \$526 \$440 VPWR VGND sky130_fd_sc_hd__xor2_1
X$3769 VPWR \$619 \$164 VPWR VGND \$167 \$350 VGND sky130_fd_sc_hd__nand3b_1
X$3770 VPWR VPWR \$764 \$522 VGND \$443 \$77 VGND sky130_fd_sc_hd__o21ai_0
X$3771 VPWR VPWR VGND VGND sky130_fd_sc_hd__decap_8
X$3774 VPWR VGND \$315 \$510 \$443 VPWR VGND sky130_fd_sc_hd__xor2_1
X$3775 VPWR VPWR VGND VGND sky130_fd_sc_hd__decap_6
X$3777 VPWR \$548 VPWR VGND \$118 \$445 VGND sky130_fd_sc_hd__nand2_1
X$3778 VPWR \$445 VPWR \$501 VGND \$51 \$118 VGND sky130_fd_sc_hd__o21a_1
X$3780 VPWR \$603 VPWR \$118 \$445 VGND VGND sky130_fd_sc_hd__and2_0
X$3781 VPWR VPWR VGND VGND sky130_fd_sc_hd__decap_6
X$3783 VPWR VGND \$551 \$355 \$252 VPWR VGND sky130_fd_sc_hd__lpflow_isobufsrc_1
X$3784 VPWR VPWR VGND VGND sky130_fd_sc_hd__decap_12
X$3785 VPWR VPWR VGND VGND sky130_fd_sc_hd__decap_6
X$3786 VPWR VPWR \$357 \$448 \$592 \$481 VGND VGND sky130_fd_sc_hd__o21bai_1
X$3788 VPWR VPWR VGND VGND sky130_fd_sc_hd__decap_8
X$3789 VPWR VGND VPWR VGND sky130_fd_sc_hd__decap_3
X$3790 VPWR VPWR \$583 \$125 VGND \$134 \$478 VGND sky130_fd_sc_hd__o21ai_0
X$3792 VPWR VGND \$448 VPWR \$363 \$477 \$580 VGND sky130_fd_sc_hd__a21oi_1
X$3793 VPWR VPWR VGND VGND sky130_fd_sc_hd__decap_12
X$3794 VPWR VGND VPWR VGND sky130_fd_sc_hd__decap_4
X$3796 VPWR \$371 VGND \$132 \$364 VPWR VGND
+ sky130_fd_sc_hd__lpflow_inputiso1p_1
X$3797 VPWR VPWR \$456 \$271 VGND \$264 VGND sky130_fd_sc_hd__xnor2_1
X$3817 VPWR VPWR VGND VGND sky130_fd_sc_hd__decap_12
X$3819 VPWR VPWR VGND VGND sky130_fd_sc_hd__decap_12
X$3820 VPWR VPWR VGND VGND sky130_fd_sc_hd__decap_12
X$3821 VPWR VPWR VGND VGND sky130_fd_sc_hd__decap_6
X$3823 VPWR VGND VPWR VGND sky130_fd_sc_hd__decap_4
X$3824 VPWR \$3281 \$3102 VPWR VGND \$3137 VGND sky130_fd_sc_hd__nand2b_1
X$3825 VPWR VPWR VGND VGND sky130_fd_sc_hd__decap_12
X$3826 VPWR VPWR VGND VGND sky130_fd_sc_hd__decap_6
X$3827 VPWR \$3192 VGND \$3141 VPWR \$3113 VGND sky130_fd_sc_hd__nor2_1
X$3828 VPWR VPWR VGND VGND sky130_fd_sc_hd__decap_8
X$3830 VGND \$3299 \$3056 \$2968 \$3058 VPWR VPWR VGND sky130_fd_sc_hd__xnor3_1
X$3832 VPWR VGND \$3143 \$3005 \$3129 VPWR VGND sky130_fd_sc_hd__xor2_1
X$3833 VPWR VGND \$3129 VPWR \$3144 \$3239 \$3206 VGND sky130_fd_sc_hd__a21oi_1
X$3834 VPWR VGND \$2759 \$3239 \$3241 VPWR VGND sky130_fd_sc_hd__xor2_1
X$3835 VPWR VPWR VGND VGND sky130_fd_sc_hd__decap_8
X$3839 VPWR VPWR \$3245 \$3132 VGND \$3214 VGND sky130_fd_sc_hd__xnor2_1
X$3841 VPWR \$2921 \$3245 VPWR VGND \$3241 \$3224 \$3247 VGND
+ sky130_fd_sc_hd__o31ai_1
X$3842 VPWR \$3245 \$3221 VGND \$3241 \$3247 VPWR VGND sky130_fd_sc_hd__nor3_1
X$3843 VPWR VPWR VGND VGND sky130_fd_sc_hd__decap_8
X$3844 VPWR \$3319 VGND \$3354 \$3248 VPWR VGND
+ sky130_fd_sc_hd__lpflow_inputiso1p_1
X$3846 VPWR VGND \$3150 \$3319 \$3251 VPWR VGND sky130_fd_sc_hd__xor2_1
X$3847 VPWR \$3150 \$3227 VGND \$3152 \$3151 VPWR VGND sky130_fd_sc_hd__nor3_1
X$3848 VPWR VPWR \$3328 \$3251 \$3253 \$3227 VGND VGND sky130_fd_sc_hd__o21bai_1
X$3849 VPWR VGND \$3152 \$3151 \$3154 VPWR VGND sky130_fd_sc_hd__xor2_1
X$3850 VPWR VPWR VGND VGND sky130_fd_sc_hd__decap_6
X$3852 VPWR VGND \$3253 \$3219 \$3256 VPWR VGND sky130_fd_sc_hd__xor2_1
X$3853 VPWR \$3218 VPWR VGND \$3256 \$3154 \$3359 VGND sky130_fd_sc_hd__nand3_1
X$3855 VPWR VGND \$3154 \$3257 \$3332 VPWR VGND sky130_fd_sc_hd__xor2_1
X$3858 VPWR \$3072 VGND \$3259 \$3332 \$3331 VPWR VGND sky130_fd_sc_hd__maj3_1
X$3859 VPWR VPWR VGND VGND sky130_fd_sc_hd__decap_8
X$3861 VPWR VGND \$3259 \$3260 \$3261 VPWR VGND sky130_fd_sc_hd__xor2_1
X$3863 VPWR \$3076 VGND \$3261 \$3208 \$3313 VPWR VGND sky130_fd_sc_hd__maj3_1
X$3864 VPWR VGND \$3314 \$3263 \$3313 VPWR VGND sky130_fd_sc_hd__nor2b_1
X$3865 VPWR VGND VPWR VGND sky130_fd_sc_hd__decap_4
X$3867 VGND \$3164 \$3160 \$3311 \$3107 VPWR VPWR VGND sky130_fd_sc_hd__xnor3_1
X$3868 VPWR VGND VPWR VGND sky130_fd_sc_hd__decap_3
X$3869 VPWR \$2925 VPWR VGND \$3185 \$3164 \$3183 VGND sky130_fd_sc_hd__nand3_1
X$3870 VPWR VGND \$3185 \$3292 \$3180 VPWR VGND sky130_fd_sc_hd__xor2_1
X$3871 VPWR VPWR VGND VGND sky130_fd_sc_hd__decap_8
X$3874 VGND \$3181 \$3180 \$3178 \$3171 VPWR VPWR VGND sky130_fd_sc_hd__xor3_1
X$3876 VGND \$2782 \$3270 TICK \$3276 VPWR VPWR VGND sky130_fd_sc_hd__dfrtp_1
X$3877 VPWR VPWR VGND VGND sky130_fd_sc_hd__decap_12
X$3878 VPWR VPWR VGND VGND sky130_fd_sc_hd__decap_12
X$3879 VPWR VPWR VGND VGND sky130_fd_sc_hd__decap_12
X$3880 VPWR VPWR VGND VGND sky130_fd_sc_hd__decap_8
X$3882 VPWR VPWR VGND VGND sky130_fd_sc_hd__decap_12
X$3886 VPWR VPWR VGND VGND sky130_fd_sc_hd__decap_12
X$3890 VPWR VPWR VGND VGND sky130_fd_sc_hd__decap_12
X$3891 VPWR VGND VPWR VGND sky130_fd_sc_hd__decap_3
X$3892 VPWR \$3231 VPWR VGND \$3343 \$2523 VGND sky130_fd_sc_hd__nand2_1
X$3893 VPWR VPWR VGND \$3382 \$3344 VGND sky130_fd_sc_hd__clkinv_1
X$3894 VPWR VPWR VGND VGND sky130_fd_sc_hd__decap_8
X$3896 VPWR \$3342 \$3281 VPWR VGND \$3231 \$3141 \$3344 VGND
+ sky130_fd_sc_hd__o31ai_1
X$3897 VPWR \$3395 VPWR VGND \$3348 \$3137 \$3102 VGND sky130_fd_sc_hd__or3b_1
X$3901 VPWR VPWR VGND VGND sky130_fd_sc_hd__decap_12
X$3902 VPWR VPWR VGND VGND sky130_fd_sc_hd__decap_12
X$3903 VPWR VPWR VGND VGND sky130_fd_sc_hd__decap_6
X$3905 VPWR VPWR VGND VGND sky130_fd_sc_hd__decap_12
X$3909 VPWR VPWR VGND VGND sky130_fd_sc_hd__decap_12
X$3910 VPWR VPWR VGND VGND sky130_fd_sc_hd__decap_12
X$3911 VPWR VGND VPWR VGND sky130_fd_sc_hd__decap_4
X$3912 VPWR VGND \$3214 \$3411 \$3241 VPWR VGND
+ sky130_fd_sc_hd__lpflow_isobufsrc_1
X$3913 VPWR VPWR VGND VGND sky130_fd_sc_hd__decap_8
X$3918 VPWR \$3246 VGND \$3241 VPWR \$3247 VGND sky130_fd_sc_hd__nor2_1
X$3919 VPWR VGND \$3245 \$3246 \$3354 VPWR VGND sky130_fd_sc_hd__xor2_1
X$3920 VPWR VPWR VGND VGND sky130_fd_sc_hd__decap_6
X$3922 VPWR VPWR \$3151 \$3248 VGND \$3354 VGND sky130_fd_sc_hd__xnor2_1
X$3923 VPWR VPWR VGND VGND sky130_fd_sc_hd__decap_6
X$3927 VPWR \$3229 VGND \$3151 VPWR \$3355 VGND sky130_fd_sc_hd__nor2_1
X$3928 VPWR \$3328 VGND \$3152 VPWR \$3151 VGND sky130_fd_sc_hd__nor2_1
X$3929 VPWR VPWR VGND VGND sky130_fd_sc_hd__decap_12
X$3933 VPWR VPWR VGND VGND sky130_fd_sc_hd__decap_8
X$3935 VPWR \$3334 VPWR VGND \$3359 \$3154 VGND sky130_fd_sc_hd__nand2_1
X$3936 VGND \$3260 \$3154 \$3257 \$3331 VPWR VPWR VGND sky130_fd_sc_hd__xnor3_1
X$3938 VGND \$3263 \$3259 \$3260 \$3208 VPWR VPWR VGND sky130_fd_sc_hd__xor3_1
X$3942 VPWR VPWR VGND VGND sky130_fd_sc_hd__decap_6
X$3943 VPWR VPWR \$3160 \$3263 VGND \$3313 VGND sky130_fd_sc_hd__xnor2_1
X$3946 VPWR VPWR VGND VGND sky130_fd_sc_hd__decap_8
X$3948 VPWR VPWR VGND \$3203 \$3311 VGND sky130_fd_sc_hd__clkinv_1
X$3952 VPWR VPWR VGND VGND sky130_fd_sc_hd__decap_12
X$3953 VPWR \$3292 VPWR VGND \$3183 \$3164 VGND sky130_fd_sc_hd__nand2_1
X$3954 VPWR VPWR VGND VGND sky130_fd_sc_hd__decap_12
X$3955 VPWR VPWR VGND VGND sky130_fd_sc_hd__decap_12
X$3956 VPWR VPWR VGND VGND sky130_fd_sc_hd__decap_8
X$3960 VPWR \$3178 VGND \$3271 \$3081 \$3270 VPWR VGND sky130_fd_sc_hd__maj3_1
X$3961 VPWR VPWR \$3276 \$3271 VGND \$3373 VGND sky130_fd_sc_hd__xnor2_1
X$3962 VPWR VPWR VGND VGND sky130_fd_sc_hd__decap_8
X$3965 VPWR VPWR VGND VGND sky130_fd_sc_hd__decap_12
X$3966 VPWR VPWR VGND VGND sky130_fd_sc_hd__decap_12
X$3970 VPWR VPWR VGND VGND sky130_fd_sc_hd__decap_12
X$3971 VPWR VPWR VGND VGND sky130_fd_sc_hd__decap_12
X$3972 VPWR VPWR VGND VGND sky130_fd_sc_hd__decap_8
X$3974 VPWR VPWR VGND VGND sky130_fd_sc_hd__decap_12
X$3976 VPWR VPWR VGND VGND sky130_fd_sc_hd__decap_12
X$3977 VPWR \$2904 \$2950 VPWR VGND \$2906 \$2911 \$2864 VGND
+ sky130_fd_sc_hd__o31ai_1
X$3978 VPWR VPWR VGND VGND sky130_fd_sc_hd__decap_6
X$3980 VPWR \$2906 VGND \$2908 \$2907 VPWR VGND
+ sky130_fd_sc_hd__lpflow_inputiso1p_1
X$3982 VPWR \$2958 VGND \$2908 \$2907 \$2999 VPWR VGND sky130_fd_sc_hd__or3_1
X$3983 VPWR VPWR VGND VGND sky130_fd_sc_hd__decap_6
X$3984 VPWR VPWR \$2965 \$2835 VGND \$2911 VGND sky130_fd_sc_hd__xnor2_1
X$3985 VPWR VPWR VGND VGND sky130_fd_sc_hd__decap_8
X$3987 VPWR \$2912 VPWR VGND \$3003 \$2676 VGND sky130_fd_sc_hd__nand2_1
X$3988 VPWR VPWR VGND VGND sky130_fd_sc_hd__decap_6
X$3990 VPWR VPWR \$2968 \$2836 VGND \$2912 VGND sky130_fd_sc_hd__xnor2_1
X$3991 VPWR VPWR VGND VGND sky130_fd_sc_hd__decap_12
X$3992 VPWR VPWR VGND VGND sky130_fd_sc_hd__decap_12
X$3993 VPWR VPWR VGND VGND sky130_fd_sc_hd__decap_12
X$3995 VPWR \$2896 VPWR VGND \$2824 \$2914 VGND sky130_fd_sc_hd__nand2_1
X$3997 VPWR \$2917 VPWR VGND \$2827 \$2914 \$2824 VGND sky130_fd_sc_hd__nand3_1
X$3999 VPWR VPWR \$2917 \$2977 \$2564 \$2982 \$2921 \$2919 VGND VGND
+ sky130_fd_sc_hd__o2111ai_1
X$4000 VPWR \$2982 VPWR VGND \$3009 \$2827 VGND sky130_fd_sc_hd__nand2_1
X$4001 VPWR VPWR VGND VGND sky130_fd_sc_hd__decap_12
X$4002 VPWR VPWR VGND VGND sky130_fd_sc_hd__decap_12
X$4003 VPWR VPWR VGND VGND sky130_fd_sc_hd__decap_12
X$4004 VPWR VPWR VGND VGND sky130_fd_sc_hd__decap_12
X$4005 VPWR VPWR VGND VGND sky130_fd_sc_hd__decap_12
X$4006 VPWR VPWR VGND VGND sky130_fd_sc_hd__decap_8
X$4009 VPWR VPWR VGND VGND sky130_fd_sc_hd__decap_12
X$4010 VPWR VPWR VGND VGND sky130_fd_sc_hd__decap_12
X$4011 VPWR VPWR VGND VGND sky130_fd_sc_hd__decap_12
X$4012 VPWR VPWR VGND VGND sky130_fd_sc_hd__decap_12
X$4013 VPWR VPWR VGND VGND sky130_fd_sc_hd__decap_12
X$4014 VPWR VGND VPWR VGND sky130_fd_sc_hd__decap_4
X$4015 VPWR VGND VPWR \$2926 \$2976 \$2925 \$2980 \$2927 VGND
+ sky130_fd_sc_hd__and4_1
X$4016 VPWR VGND VPWR VGND sky130_fd_sc_hd__decap_4
X$4017 VPWR VGND \$2928 \$3026 \$2972 VPWR VGND sky130_fd_sc_hd__xor2_1
X$4018 VPWR VGND VPWR VGND sky130_fd_sc_hd__decap_3
X$4021 VPWR VPWR \$2969 \$2926 VGND \$2928 \$2930 VGND sky130_fd_sc_hd__o21ai_0
X$4022 VPWR VPWR VGND VGND sky130_fd_sc_hd__decap_6
X$4024 VPWR VPWR \$2951 \$2855 \$2887 \$2930 \$2926 \$2928 VGND VGND
+ sky130_fd_sc_hd__o2111ai_1
X$4026 VGND \$2782 \$2951 TICK \$2885 VPWR VPWR VGND sky130_fd_sc_hd__dfrtp_1
X$4027 VPWR VPWR VGND VGND sky130_fd_sc_hd__decap_12
X$4028 VPWR VPWR VGND VGND sky130_fd_sc_hd__decap_6
X$4029 VPWR \$2855 \$2786 VGND \$2809 \$2881 VPWR VGND sky130_fd_sc_hd__nor3_1
X$4030 VPWR VPWR VGND VGND sky130_fd_sc_hd__decap_12
X$4031 VPWR VPWR VGND VGND sky130_fd_sc_hd__decap_8
X$4034 VPWR VPWR VGND VGND sky130_fd_sc_hd__decap_12
X$4038 VPWR FINE_MUX[11] VGND \$2904 VPWR VGND sky130_fd_sc_hd__clkdlybuf4s50_1
X$4039 VPWR VPWR VGND VGND sky130_fd_sc_hd__decap_6
X$4043 VPWR VPWR VGND \$3030 \$2864 VGND sky130_fd_sc_hd__clkinv_1
X$4044 VPWR VGND \$2864 \$2904 \$2996 VPWR VGND sky130_fd_sc_hd__xor2_1
X$4045 VPWR \$2523 VPWR \$2904 \$2999 \$3030 \$2584 VGND VGND
+ sky130_fd_sc_hd__nand4_1
X$4046 VPWR \$2950 VPWR VGND \$2584 \$2523 VGND sky130_fd_sc_hd__nand2_1
X$4047 VPWR VGND VPWR VGND sky130_fd_sc_hd__decap_4
X$4049 VPWR VPWR \$3001 \$2906 VGND \$3097 \$3053 VGND sky130_fd_sc_hd__o21ai_0
X$4050 VPWR VPWR \$3138 \$2908 VGND \$2907 \$2999 VGND sky130_fd_sc_hd__o21ai_0
X$4051 VPWR VPWR VGND VGND sky130_fd_sc_hd__decap_12
X$4054 VPWR VPWR VGND VGND sky130_fd_sc_hd__decap_8
X$4056 VPWR VGND \$3003 \$2965 \$3001 VPWR VGND
+ sky130_fd_sc_hd__lpflow_isobufsrc_1
X$4057 VPWR \$3044 VGND \$3192 VPWR \$3003 VGND sky130_fd_sc_hd__nor2_1
X$4058 VPWR VPWR VGND VGND sky130_fd_sc_hd__decap_8
X$4061 VPWR VPWR VGND VGND sky130_fd_sc_hd__decap_8
X$4063 VPWR \$3005 \$3049 VGND \$3056 \$2968 VPWR VGND sky130_fd_sc_hd__nor3_1
X$4066 VPWR VPWR VGND VGND sky130_fd_sc_hd__decap_12
X$4067 VPWR VPWR VGND VGND sky130_fd_sc_hd__decap_8
X$4069 VPWR \$3047 VGND \$2914 VPWR \$2824 VGND sky130_fd_sc_hd__nor2_1
X$4070 VPWR \$3009 VPWR VGND \$2896 \$3064 \$3047 VGND sky130_fd_sc_hd__and3b_1
X$4071 VPWR VPWR VGND VGND sky130_fd_sc_hd__decap_8
X$4075 VPWR \$2919 \$3041 \$2827 VGND \$3009 VPWR VGND sky130_fd_sc_hd__mux2i_1
X$4076 VPWR VPWR VGND VGND sky130_fd_sc_hd__decap_12
X$4077 VPWR VPWR VGND VGND sky130_fd_sc_hd__decap_8
X$4078 VPWR VGND VPWR VGND sky130_fd_sc_hd__decap_3
X$4080 VPWR VPWR VGND VGND sky130_fd_sc_hd__decap_12
X$4083 VPWR VPWR VGND VGND sky130_fd_sc_hd__decap_12
X$4084 VPWR VPWR VGND VGND sky130_fd_sc_hd__decap_12
X$4085 VPWR VPWR VGND VGND sky130_fd_sc_hd__decap_12
X$4086 VPWR VPWR VGND VGND sky130_fd_sc_hd__decap_12
X$4089 VPWR VPWR VGND VGND sky130_fd_sc_hd__decap_12
X$4090 VPWR VPWR VGND VGND sky130_fd_sc_hd__decap_12
X$4093 VPWR VPWR VGND VGND sky130_fd_sc_hd__decap_12
X$4094 VPWR VPWR VGND VGND sky130_fd_sc_hd__decap_8
X$4097 VPWR \$2930 VPWR \$2976 \$2925 \$2980 VGND \$2927 VGND
+ sky130_fd_sc_hd__a31o_1
X$4099 VPWR VGND \$3026 \$2930 \$2926 VPWR VGND sky130_fd_sc_hd__nor2b_1
X$4100 VPWR VPWR VGND VGND sky130_fd_sc_hd__decap_12
X$4101 VPWR VPWR VGND VGND sky130_fd_sc_hd__decap_8
X$4105 VPWR \$2930 \$3021 VPWR \$2926 VGND \$2928 \$2887 VGND
+ sky130_fd_sc_hd__o211ai_1
X$4106 VPWR VPWR VGND VGND sky130_fd_sc_hd__decap_12
X$4107 VPWR VPWR VGND VGND sky130_fd_sc_hd__decap_8
X$4108 VPWR VGND VPWR VGND sky130_fd_sc_hd__decap_3
X$4110 VPWR VPWR VGND VGND sky130_fd_sc_hd__decap_12
X$4111 VPWR VPWR VGND VGND sky130_fd_sc_hd__decap_12
X$4114 VPWR VPWR VGND VGND sky130_fd_sc_hd__decap_12
X$4115 VPWR VPWR VGND VGND sky130_fd_sc_hd__decap_12
X$4116 VPWR VPWR VGND VGND sky130_fd_sc_hd__decap_8
X$4127 VPWR VPWR VGND VGND sky130_fd_sc_hd__decap_12
X$4129 VPWR VPWR VGND VGND sky130_fd_sc_hd__decap_12
X$4130 VPWR VPWR VGND VGND sky130_fd_sc_hd__decap_12
X$4131 VPWR VPWR VGND VGND sky130_fd_sc_hd__decap_6
X$4133 VPWR VPWR VGND VGND sky130_fd_sc_hd__decap_12
X$4134 VPWR \$4088 VGND \$3833 VPWR \$4004 VGND sky130_fd_sc_hd__nor2_1
X$4135 VPWR VPWR \$3958 \$3594 VGND \$3861 VGND sky130_fd_sc_hd__xnor2_1
X$4136 VPWR VPWR VGND VGND sky130_fd_sc_hd__decap_12
X$4137 VPWR VPWR VGND VGND sky130_fd_sc_hd__decap_6
X$4138 VPWR \$4100 VGND \$3833 VPWR \$4162 VGND sky130_fd_sc_hd__nor2_1
X$4139 VPWR VPWR \$4055 \$3913 VGND \$3962 \$3959 VGND sky130_fd_sc_hd__o21ai_0
X$4140 VPWR VPWR VGND VGND sky130_fd_sc_hd__decap_12
X$4141 VPWR VGND VPWR VGND sky130_fd_sc_hd__decap_4
X$4143 VPWR \$3852 VPWR \$3961 \$4055 \$4107 VGND \$4106 VGND
+ sky130_fd_sc_hd__a31o_1
X$4144 VPWR VPWR VGND \$4106 \$4109 VGND sky130_fd_sc_hd__clkinv_1
X$4145 VPWR VPWR VGND VGND sky130_fd_sc_hd__decap_8
X$4146 VPWR VGND VPWR VGND sky130_fd_sc_hd__decap_3
X$4148 VPWR VPWR VGND VGND sky130_fd_sc_hd__decap_12
X$4149 VPWR VPWR VGND VGND sky130_fd_sc_hd__decap_12
X$4150 VPWR VPWR VGND VGND sky130_fd_sc_hd__decap_12
X$4151 VPWR VPWR VGND VGND sky130_fd_sc_hd__decap_12
X$4153 VPWR VPWR VGND \$4038 \$4120 VGND sky130_fd_sc_hd__clkinv_1
X$4154 VPWR VPWR VGND VGND sky130_fd_sc_hd__decap_8
X$4156 VPWR \$4117 VPWR VGND \$4120 \$4060 VGND sky130_fd_sc_hd__nand2_1
X$4157 VPWR VPWR \$3976 \$4117 VGND \$3935 VGND sky130_fd_sc_hd__xnor2_1
X$4158 VPWR VPWR VGND VGND sky130_fd_sc_hd__decap_8
X$4159 VPWR \$3946 VGND \$4061 \$3976 VPWR VGND
+ sky130_fd_sc_hd__lpflow_inputiso1p_1
X$4162 VPWR \$3976 \$3949 VGND \$4112 \$4113 VPWR VGND sky130_fd_sc_hd__nor3_1
X$4163 VPWR VGND \$4175 \$3976 \$4062 VPWR VGND sky130_fd_sc_hd__xor2_1
X$4164 VPWR VPWR VGND VGND sky130_fd_sc_hd__decap_8
X$4166 VPWR \$3840 VGND \$4062 VPWR \$4064 VGND sky130_fd_sc_hd__nor2_1
X$4167 VPWR VGND VPWR VGND sky130_fd_sc_hd__decap_4
X$4169 VPWR VPWR \$4105 \$4065 VGND \$4104 \$4064 VGND sky130_fd_sc_hd__o21ai_0
X$4170 VPWR VPWR VGND VGND sky130_fd_sc_hd__decap_12
X$4171 VPWR VPWR VGND VGND sky130_fd_sc_hd__decap_6
X$4172 VPWR VPWR \$3827 \$4367 VGND \$3880 VGND sky130_fd_sc_hd__xnor2_1
X$4173 VPWR VPWR VGND VGND sky130_fd_sc_hd__decap_12
X$4175 VPWR \$4092 VGND \$3982 VPWR \$3826 VGND sky130_fd_sc_hd__nor2_1
X$4176 VPWR VPWR VGND VGND sky130_fd_sc_hd__decap_8
X$4177 VPWR VGND VPWR VGND sky130_fd_sc_hd__decap_3
X$4179 VPWR VPWR VGND VGND sky130_fd_sc_hd__decap_12
X$4180 VPWR VGND VPWR VGND sky130_fd_sc_hd__decap_4
X$4182 VPWR VPWR \$3897 \$3993 VGND \$3821 VGND sky130_fd_sc_hd__xnor2_1
X$4183 VPWR VGND VPWR VGND sky130_fd_sc_hd__decap_4
X$4185 VPWR VPWR \$4152 \$4072 VGND \$4073 VGND sky130_fd_sc_hd__xnor2_1
X$4186 VGND \$2782 \$4073 TICK \$4081 VPWR VPWR VGND sky130_fd_sc_hd__dfrtp_1
X$4187 VPWR VPWR VGND VGND sky130_fd_sc_hd__decap_12
X$4188 VPWR VPWR VGND VGND sky130_fd_sc_hd__decap_12
X$4189 VPWR VGND VPWR VGND sky130_fd_sc_hd__decap_4
X$4192 VPWR VPWR VGND VGND sky130_fd_sc_hd__decap_12
X$4196 VPWR VPWR VGND VGND sky130_fd_sc_hd__decap_12
X$4198 VPWR VPWR VGND VGND sky130_fd_sc_hd__decap_12
X$4199 VPWR VPWR VGND VGND sky130_fd_sc_hd__decap_12
X$4200 VPWR VPWR VGND VGND sky130_fd_sc_hd__decap_12
X$4201 VPWR VPWR VGND VGND sky130_fd_sc_hd__decap_12
X$4203 VPWR VGND VPWR VGND sky130_fd_sc_hd__decap_3
X$4204 VPWR VGND \$3833 \$4004 \$4194 VPWR VGND sky130_fd_sc_hd__xor2_1
X$4205 VPWR VPWR VGND VGND sky130_fd_sc_hd__decap_8
X$4207 VPWR \$3959 VGND \$4162 \$3833 \$3865 VPWR VGND sky130_fd_sc_hd__or3_1
X$4209 VPWR VPWR VGND \$4168 \$3958 VGND sky130_fd_sc_hd__clkinv_1
X$4210 VPWR \$4162 VPWR VGND \$4127 \$4168 VGND sky130_fd_sc_hd__nand2_1
X$4211 VPWR VGND VPWR VGND sky130_fd_sc_hd__decap_4
X$4212 VPWR VPWR \$4129 \$3958 VGND \$4127 VGND sky130_fd_sc_hd__xnor2_1
X$4215 VPWR \$4129 \$4172 \$4107 VPWR VGND \$4194 VGND sky130_fd_sc_hd__and3_1
X$4216 VPWR VGND VPWR VGND sky130_fd_sc_hd__decap_4
X$4218 VPWR VPWR VGND \$4131 \$4261 VGND sky130_fd_sc_hd__clkinv_1
X$4220 VPWR VGND \$3961 VPWR \$4055 \$4181 \$4131 VGND sky130_fd_sc_hd__a21oi_1
X$4221 VPWR \$4131 \$3961 \$4132 VPWR VGND \$4055 VGND sky130_fd_sc_hd__and3_1
X$4223 VPWR \$4181 VPWR \$4187 \$4132 \$4180 \$4177 VGND VGND
+ sky130_fd_sc_hd__o22ai_1
X$4224 VPWR \$4188 VPWR VGND \$3961 \$4055 \$4364 VGND sky130_fd_sc_hd__nand3_1
X$4225 VPWR VGND VPWR VGND sky130_fd_sc_hd__decap_4
X$4228 VGND \$4185 \$4034 \$3970 \$3967 VPWR VPWR VGND sky130_fd_sc_hd__xnor3_1
X$4229 VPWR VPWR VGND VGND sky130_fd_sc_hd__decap_8
X$4233 VPWR \$4183 \$4212 VPWR VGND \$4184 \$4292 \$4210 VGND
+ sky130_fd_sc_hd__o31ai_1
X$4234 VPWR VPWR VGND VGND sky130_fd_sc_hd__decap_12
X$4236 VPWR VPWR VGND VGND sky130_fd_sc_hd__decap_12
X$4237 VPWR VPWR VGND VGND sky130_fd_sc_hd__decap_12
X$4239 VPWR VPWR \$4175 \$4113 VGND \$4112 \$4061 VGND sky130_fd_sc_hd__o21ai_0
X$4240 VPWR VPWR VGND VGND sky130_fd_sc_hd__decap_12
X$4242 VPWR VPWR VGND VGND sky130_fd_sc_hd__decap_6
X$4243 VPWR \$4062 \$3618 VGND \$4104 \$4065 VPWR VGND sky130_fd_sc_hd__nor3_1
X$4244 VPWR VPWR \$3880 \$4105 VGND \$4062 VGND sky130_fd_sc_hd__xnor2_1
X$4245 VPWR VPWR VGND VGND sky130_fd_sc_hd__decap_6
X$4249 VPWR \$4144 VPWR VGND \$4143 \$4161 VGND sky130_fd_sc_hd__nand2_1
X$4250 VPWR \$3880 VGND \$4144 \$3832 \$4227 \$3834 VPWR VGND
+ sky130_fd_sc_hd__nor4bb_1
X$4252 VPWR \$3834 VGND \$4161 VPWR \$4143 VGND sky130_fd_sc_hd__nor2_1
X$4253 VPWR VPWR VGND VGND sky130_fd_sc_hd__decap_8
X$4255 VPWR VGND \$3826 \$4276 \$4160 VPWR VGND
+ sky130_fd_sc_hd__lpflow_isobufsrc_1
X$4256 VPWR VGND \$3982 \$4229 \$4230 VPWR VGND
+ sky130_fd_sc_hd__lpflow_isobufsrc_1
X$4257 VPWR VPWR VGND VGND sky130_fd_sc_hd__decap_8
X$4258 VPWR VPWR \$4158 \$4357 VGND \$4146 VGND sky130_fd_sc_hd__xnor2_1
X$4259 VPWR \$3821 VGND \$4156 \$4146 \$4157 VPWR VGND sky130_fd_sc_hd__maj3_1
X$4261 VPWR VPWR VGND VGND sky130_fd_sc_hd__decap_12
X$4263 VPWR \$4146 VGND \$4072 \$4154 \$4073 VPWR VGND sky130_fd_sc_hd__maj3_1
X$4264 VPWR VGND VPWR VGND sky130_fd_sc_hd__decap_4
X$4267 VPWR VPWR \$4081 \$4152 VGND \$4154 VGND sky130_fd_sc_hd__xnor2_1
X$4268 VPWR VPWR VGND VGND sky130_fd_sc_hd__decap_12
X$4270 VPWR VPWR VGND VGND sky130_fd_sc_hd__decap_12
X$4271 VPWR VPWR VGND VGND sky130_fd_sc_hd__decap_12
X$4272 VPWR VPWR VGND VGND sky130_fd_sc_hd__decap_12
X$4293 VPWR VPWR VGND VGND sky130_fd_sc_hd__decap_12
X$4295 VPWR VPWR VGND VGND sky130_fd_sc_hd__decap_12
X$4296 VPWR VPWR VGND VGND sky130_fd_sc_hd__decap_12
X$4297 VPWR VPWR VGND VGND sky130_fd_sc_hd__decap_6
X$4299 VPWR VPWR VGND VGND sky130_fd_sc_hd__decap_12
X$4300 VPWR VPWR VGND VGND sky130_fd_sc_hd__decap_12
X$4301 VPWR VPWR VGND VGND sky130_fd_sc_hd__decap_12
X$4302 VPWR VPWR VGND VGND sky130_fd_sc_hd__decap_12
X$4303 VPWR VPWR VGND VGND sky130_fd_sc_hd__decap_12
X$4305 VPWR \$4354 VPWR VGND \$4109 \$4129 VGND sky130_fd_sc_hd__nand2_1
X$4306 VPWR \$4351 VGND \$4193 VPWR \$4354 VGND sky130_fd_sc_hd__nor2_1
X$4307 VPWR VPWR \$4271 \$4129 VGND \$4109 VGND sky130_fd_sc_hd__xnor2_1
X$4308 VPWR VPWR VGND VGND sky130_fd_sc_hd__decap_8
X$4309 VPWR VGND VPWR VGND sky130_fd_sc_hd__decap_3
X$4311 VPWR \$4311 VGND \$4177 \$4193 VPWR VGND
+ sky130_fd_sc_hd__lpflow_inputiso1p_1
X$4313 VPWR VGND \$4309 \$4311 \$4413 VPWR VGND sky130_fd_sc_hd__xor2_1
X$4314 VPWR VPWR VGND VGND sky130_fd_sc_hd__decap_12
X$4315 VPWR VPWR VGND \$4372 \$4414 VGND sky130_fd_sc_hd__clkinv_1
X$4316 VPWR VPWR VGND VGND sky130_fd_sc_hd__decap_12
X$4317 VPWR VPWR VGND VGND sky130_fd_sc_hd__decap_12
X$4318 VPWR VGND VPWR VGND sky130_fd_sc_hd__decap_4
X$4319 VGND \$4317 \$4480 \$4287 \$4482 VPWR VPWR VGND sky130_fd_sc_hd__xnor3_1
X$4320 VPWR VGND VPWR VGND sky130_fd_sc_hd__decap_3
X$4321 VPWR \$4318 \$4317 VPWR VGND \$4394 \$4395 \$4315 VGND
+ sky130_fd_sc_hd__o31ai_1
X$4324 VPWR VPWR \$4320 \$4315 VGND \$4318 VGND sky130_fd_sc_hd__xnor2_1
X$4325 VPWR VPWR VGND \$4389 \$4320 VGND sky130_fd_sc_hd__clkinv_1
X$4326 VPWR VPWR VGND VGND sky130_fd_sc_hd__decap_6
X$4327 VPWR VPWR \$4468 \$4320 VGND \$4322 VGND sky130_fd_sc_hd__xnor2_1
X$4328 VPWR VPWR VGND VGND sky130_fd_sc_hd__decap_12
X$4329 VPWR VGND VPWR VGND sky130_fd_sc_hd__decap_4
X$4331 VPWR \$4104 VPWR VGND \$4423 \$4466 VGND sky130_fd_sc_hd__nand2_1
X$4332 VPWR VPWR VGND VGND sky130_fd_sc_hd__decap_12
X$4333 VPWR VPWR VGND VGND sky130_fd_sc_hd__decap_12
X$4334 VPWR VPWR VGND VGND sky130_fd_sc_hd__decap_12
X$4335 VPWR VPWR VGND VGND sky130_fd_sc_hd__decap_6
X$4337 VPWR VPWR VGND VGND sky130_fd_sc_hd__decap_12
X$4338 VPWR VPWR VGND VGND sky130_fd_sc_hd__decap_12
X$4339 VPWR VPWR VGND VGND sky130_fd_sc_hd__decap_8
X$4341 VPWR VPWR \$4446 \$4243 VGND \$4233 VGND sky130_fd_sc_hd__xnor2_1
X$4342 VPWR VPWR VGND VGND sky130_fd_sc_hd__decap_6
X$4344 VPWR VPWR \$4242 \$4444 VGND \$4427 \$4529 VGND sky130_fd_sc_hd__o21ai_0
X$4345 VPWR VPWR VGND \$4444 \$4332 VGND sky130_fd_sc_hd__clkinv_1
X$4346 VGND \$2782 \$4433 TICK \$4440 VPWR VPWR VGND sky130_fd_sc_hd__dfrtp_1
X$4347 VPWR VPWR VGND VGND sky130_fd_sc_hd__decap_8
X$4348 VPWR VGND VPWR VGND sky130_fd_sc_hd__decap_3
X$4350 VPWR VPWR VGND VGND sky130_fd_sc_hd__decap_12
X$4354 VPWR VPWR VGND VGND sky130_fd_sc_hd__decap_12
X$4356 VPWR VPWR VGND VGND sky130_fd_sc_hd__decap_12
X$4357 VPWR VPWR VGND VGND sky130_fd_sc_hd__decap_12
X$4358 VPWR VPWR VGND VGND sky130_fd_sc_hd__decap_12
X$4359 VPWR VPWR VGND VGND sky130_fd_sc_hd__decap_12
X$4361 VPWR VPWR VGND VGND sky130_fd_sc_hd__decap_12
X$4362 VPWR VPWR VGND VGND sky130_fd_sc_hd__decap_12
X$4365 VPWR VPWR VGND VGND sky130_fd_sc_hd__decap_12
X$4367 VPWR VPWR VGND VGND sky130_fd_sc_hd__decap_12
X$4368 VPWR VPWR VGND VGND sky130_fd_sc_hd__decap_12
X$4369 VPWR VPWR VGND \$4536 \$4271 VGND sky130_fd_sc_hd__clkinv_1
X$4370 VPWR \$4177 VPWR VGND \$4268 \$4536 VGND sky130_fd_sc_hd__nand2_1
X$4371 VPWR VPWR VGND \$4539 \$4177 VGND sky130_fd_sc_hd__clkinv_1
X$4372 VPWR VPWR \$4410 \$4539 VGND \$4407 \$4311 VGND sky130_fd_sc_hd__o21ai_0
X$4373 VPWR VPWR \$4491 \$4271 VGND \$4268 VGND sky130_fd_sc_hd__xnor2_1
X$4375 VPWR VGND VPWR VGND sky130_fd_sc_hd__decap_4
X$4377 VPWR \$4491 \$4413 \$4371 VPWR VGND \$4407 VGND sky130_fd_sc_hd__and3_1
X$4378 VPWR \$4413 VPWR \$4414 \$4415 \$4491 \$4407 VGND VGND
+ sky130_fd_sc_hd__nand4_1
X$4379 VPWR VGND VPWR VGND sky130_fd_sc_hd__decap_4
X$4381 VPWR VPWR \$4209 \$4497 VGND \$4495 \$4415 VGND sky130_fd_sc_hd__o21ai_0
X$4382 VPWR VGND VPWR VGND sky130_fd_sc_hd__decap_4
X$4385 VPWR VPWR VGND VGND sky130_fd_sc_hd__decap_12
X$4387 VPWR \$4480 VGND \$4495 VPWR \$4498 VGND sky130_fd_sc_hd__nor2_1
X$4388 VPWR VPWR VGND VGND sky130_fd_sc_hd__decap_12
X$4389 VPWR \$4482 VPWR VGND \$4502 \$4418 VGND sky130_fd_sc_hd__nand2_1
X$4390 VPWR VPWR VGND VGND sky130_fd_sc_hd__decap_8
X$4391 VPWR \$4394 \$4418 VPWR VGND \$4647 VGND sky130_fd_sc_hd__nand2b_1
X$4392 VPWR VPWR VGND VGND sky130_fd_sc_hd__decap_12
X$4395 VPWR \$4574 VPWR VGND \$4322 \$4320 VGND sky130_fd_sc_hd__nand2_1
X$4396 VPWR VPWR VGND VGND sky130_fd_sc_hd__decap_12
X$4398 VPWR VGND \$4468 \$4221 \$4463 VPWR VGND sky130_fd_sc_hd__xor2_1
X$4399 VPWR \$4466 VPWR VGND \$4576 \$4572 VGND sky130_fd_sc_hd__nand2_1
X$4402 VPWR VGND VPWR VGND sky130_fd_sc_hd__decap_4
X$4403 VPWR VGND \$4463 \$4423 \$4507 VPWR VGND sky130_fd_sc_hd__xor2_1
X$4404 VPWR VPWR VGND VGND sky130_fd_sc_hd__decap_12
X$4406 VPWR VPWR VGND VGND sky130_fd_sc_hd__decap_6
X$4408 VPWR \$4513 \$4515 VGND \$4454 \$4511 VPWR VGND sky130_fd_sc_hd__nor3_1
X$4409 VPWR VGND \$4545 VPWR \$4546 \$4547 \$4515 VGND sky130_fd_sc_hd__a21oi_1
X$4410 VPWR VPWR VGND VGND sky130_fd_sc_hd__decap_12
X$4411 VPWR VPWR VGND VGND sky130_fd_sc_hd__decap_12
X$4413 VPWR VPWR VGND VGND sky130_fd_sc_hd__decap_12
X$4414 VPWR VGND VPWR VGND sky130_fd_sc_hd__decap_3
X$4415 VPWR VPWR \$4353 \$4446 VGND \$4242 VGND sky130_fd_sc_hd__xnor2_1
X$4418 VPWR VPWR VGND VGND sky130_fd_sc_hd__decap_6
X$4419 VPWR VPWR \$4333 \$4427 VGND \$4332 VGND sky130_fd_sc_hd__xnor2_1
X$4422 VPWR \$4334 VPWR \$4433 \$4432 VGND VGND sky130_fd_sc_hd__and2_0
X$4423 VPWR \$4335 VGND \$4432 VPWR \$4433 VGND sky130_fd_sc_hd__nor2_1
X$4424 VPWR VPWR VGND VGND sky130_fd_sc_hd__decap_12
X$4425 VPWR VPWR VGND VGND sky130_fd_sc_hd__decap_12
X$4426 VPWR VPWR VGND VGND sky130_fd_sc_hd__decap_8
X$4447 VPWR VPWR VGND VGND sky130_fd_sc_hd__decap_12
X$4449 VPWR VPWR VGND VGND sky130_fd_sc_hd__decap_12
X$4450 VPWR VGND VPWR VGND sky130_fd_sc_hd__decap_4
X$4452 VPWR VGND \$3343 VPWR \$3592 \$3709 \$3540 VGND sky130_fd_sc_hd__a21oi_1
X$4453 VPWR VPWR \$3706 \$3343 VGND \$3345 VGND sky130_fd_sc_hd__xnor2_1
X$4456 VPWR VPWR VGND VGND sky130_fd_sc_hd__decap_8
X$4457 VPWR \$3751 VPWR VGND \$3594 \$3706 VGND sky130_fd_sc_hd__nand2_1
X$4458 VPWR \$3753 VGND \$3709 \$3751 \$3597 \$3491 \$3861 VPWR VGND
+ sky130_fd_sc_hd__o41ai_1
X$4459 VPWR VPWR VGND VGND sky130_fd_sc_hd__decap_12
X$4460 VPWR VPWR VGND VGND sky130_fd_sc_hd__decap_12
X$4461 VPWR VPWR VGND VGND sky130_fd_sc_hd__decap_6
X$4462 VPWR VGND \$3493 \$3764 \$3711 VPWR VGND
+ sky130_fd_sc_hd__lpflow_isobufsrc_1
X$4463 VPWR VPWR VGND VGND sky130_fd_sc_hd__decap_12
X$4464 VPWR VGND VPWR VGND sky130_fd_sc_hd__decap_4
X$4466 VPWR \$3668 \$3299 \$3497 VPWR VGND \$3603 VGND sky130_fd_sc_hd__and3_1
X$4467 VPWR VPWR VGND VGND sky130_fd_sc_hd__decap_6
X$4468 VPWR \$3676 VPWR VGND \$3667 \$3603 \$3783 VGND sky130_fd_sc_hd__nand3_1
X$4470 VPWR VGND \$3667 \$3781 \$3718 VPWR VGND sky130_fd_sc_hd__xor2_1
X$4471 VPWR VGND \$3718 VPWR \$3670 \$3722 \$3497 VGND sky130_fd_sc_hd__a21oi_1
X$4472 VPWR VPWR VGND VGND sky130_fd_sc_hd__decap_12
X$4473 VPWR VPWR VGND VGND sky130_fd_sc_hd__decap_8
X$4474 VPWR \$3503 VPWR VGND \$3682 \$3722 \$3789 VGND sky130_fd_sc_hd__nand3_1
X$4475 VPWR VPWR VGND VGND sky130_fd_sc_hd__decap_12
X$4476 VPWR VGND VPWR VGND sky130_fd_sc_hd__decap_3
X$4477 VPWR \$3441 VPWR VGND \$3780 \$3682 VGND sky130_fd_sc_hd__nand2_1
X$4478 VPWR VPWR VGND VGND sky130_fd_sc_hd__decap_8
X$4480 VPWR VGND \$3770 VPWR \$3769 \$3850 \$3780 VGND sky130_fd_sc_hd__a21oi_1
X$4481 VPWR VPWR VGND VGND sky130_fd_sc_hd__decap_12
X$4483 VPWR \$3471 VPWR VGND \$3614 \$3700 VGND sky130_fd_sc_hd__nand2_1
X$4486 VPWR VPWR VGND VGND sky130_fd_sc_hd__decap_12
X$4487 VPWR VPWR VGND VGND sky130_fd_sc_hd__decap_6
X$4489 VPWR \$3617 VGND \$3689 VPWR \$3762 VGND sky130_fd_sc_hd__nor2_1
X$4490 VPWR VPWR VGND VGND sky130_fd_sc_hd__decap_6
X$4491 VPWR VGND \$3756 \$3689 \$3447 VPWR VGND sky130_fd_sc_hd__xor2_1
X$4492 VPWR VPWR VGND VGND sky130_fd_sc_hd__decap_12
X$4493 VPWR VPWR VGND VGND sky130_fd_sc_hd__decap_12
X$4494 VPWR VPWR VGND VGND sky130_fd_sc_hd__decap_12
X$4495 VPWR VPWR VGND VGND sky130_fd_sc_hd__decap_12
X$4498 VPWR VPWR VGND VGND sky130_fd_sc_hd__decap_12
X$4499 VPWR VPWR VGND VGND sky130_fd_sc_hd__decap_12
X$4500 VPWR VPWR VGND VGND sky130_fd_sc_hd__decap_12
X$4501 VPWR VPWR VGND VGND sky130_fd_sc_hd__decap_12
X$4502 VPWR VPWR VGND VGND sky130_fd_sc_hd__decap_12
X$4503 VPWR VPWR VGND VGND sky130_fd_sc_hd__decap_12
X$4504 VPWR VPWR VGND VGND sky130_fd_sc_hd__decap_12
X$4507 VPWR VPWR VGND VGND sky130_fd_sc_hd__decap_12
X$4511 VPWR VPWR VGND VGND sky130_fd_sc_hd__decap_12
X$4513 VPWR VPWR VGND VGND sky130_fd_sc_hd__decap_12
X$4514 VPWR VPWR VGND VGND sky130_fd_sc_hd__decap_12
X$4515 VPWR VGND \$3753 \$3540 \$3639 VPWR VGND
+ sky130_fd_sc_hd__lpflow_isobufsrc_1
X$4516 VPWR VPWR \$3833 \$3592 VGND \$3706 \$3639 VGND sky130_fd_sc_hd__o21ai_0
X$4517 VPWR VPWR VGND VGND sky130_fd_sc_hd__decap_8
X$4520 VPWR \$3838 VGND \$3709 VPWR \$3753 VGND sky130_fd_sc_hd__nor2_1
X$4521 VPWR VGND \$3395 VPWR \$3466 \$3753 \$3863 VGND sky130_fd_sc_hd__a21o_1
X$4522 VPWR \$3844 VPWR VGND \$3395 \$3466 \$3753 VGND sky130_fd_sc_hd__nand3_1
X$4523 VPWR VPWR VGND VGND sky130_fd_sc_hd__decap_12
X$4524 VPWR VPWR VGND VGND sky130_fd_sc_hd__decap_6
X$4526 VPWR VPWR VGND VGND sky130_fd_sc_hd__decap_6
X$4528 VPWR VGND \$3711 \$3764 \$3802 VPWR VGND sky130_fd_sc_hd__xor2_1
X$4530 VPWR VPWR VGND VGND sky130_fd_sc_hd__decap_8
X$4532 VPWR \$3668 VGND \$3852 VPWR \$3802 VGND sky130_fd_sc_hd__nor2_1
X$4533 VPWR VPWR VGND VGND sky130_fd_sc_hd__decap_12
X$4534 VPWR VGND VPWR VGND sky130_fd_sc_hd__decap_3
X$4535 VPWR \$3781 VPWR VGND \$3783 \$3603 VGND sky130_fd_sc_hd__nand2_1
X$4536 VPWR \$3855 VGND \$3783 VPWR \$3668 VGND sky130_fd_sc_hd__nor2_1
X$4537 VPWR VGND \$3855 \$3603 \$3805 VPWR VGND sky130_fd_sc_hd__xor2_1
X$4539 VPWR VPWR VGND VGND sky130_fd_sc_hd__decap_8
X$4541 VPWR \$3805 \$3502 \$3722 \$3682 \$3866 VGND VPWR VGND
+ sky130_fd_sc_hd__nand4b_1
X$4543 VPWR \$3789 VGND \$3805 VPWR \$3857 VGND sky130_fd_sc_hd__nor2_1
X$4544 VPWR VPWR VGND VGND sky130_fd_sc_hd__decap_8
X$4548 VPWR \$3808 VPWR VGND \$3872 \$3722 VGND sky130_fd_sc_hd__nand2_1
X$4549 VPWR VPWR \$3810 \$3682 VGND \$3808 VGND sky130_fd_sc_hd__xnor2_1
X$4550 VPWR VGND VPWR VGND sky130_fd_sc_hd__decap_4
X$4553 VPWR \$3769 \$3810 \$3417 VPWR VGND \$3770 VGND sky130_fd_sc_hd__and3_1
X$4554 VPWR VPWR \$3700 \$3850 VGND \$3810 VGND sky130_fd_sc_hd__xnor2_1
X$4555 VPWR VPWR VGND VGND sky130_fd_sc_hd__decap_12
X$4556 VPWR VPWR VGND VGND sky130_fd_sc_hd__decap_12
X$4557 VPWR VGND VPWR VGND sky130_fd_sc_hd__decap_4
X$4560 VPWR \$3762 VPWR VGND \$3840 \$3848 VGND sky130_fd_sc_hd__nand2_1
X$4561 VPWR VGND VPWR VGND sky130_fd_sc_hd__decap_4
X$4563 VPWR \$3574 VGND \$3689 VPWR \$3815 VGND sky130_fd_sc_hd__nor2_1
X$4564 VPWR VPWR \$3756 \$3817 VGND \$3815 \$3762 VGND sky130_fd_sc_hd__o21ai_0
X$4565 VPWR VGND VPWR VGND sky130_fd_sc_hd__decap_3
X$4566 VPWR VGND \$3880 VPWR \$3834 \$3817 \$3618 VGND sky130_fd_sc_hd__a21oi_1
X$4567 VPWR VPWR VGND VGND sky130_fd_sc_hd__decap_6
X$4569 VPWR VPWR VGND VGND sky130_fd_sc_hd__decap_12
X$4572 VPWR VGND \$3827 VPWR \$3826 \$3831 \$3832 VGND sky130_fd_sc_hd__a21oi_1
X$4573 VPWR VPWR VGND VGND sky130_fd_sc_hd__decap_12
X$4574 VPWR VGND VPWR VGND sky130_fd_sc_hd__decap_4
X$4576 VGND \$2782 \$3890 TICK \$3910 VPWR VPWR VGND sky130_fd_sc_hd__dfrtp_1
X$4579 VPWR \$3825 VGND \$3824 \$3821 \$3823 VPWR VGND sky130_fd_sc_hd__maj3_1
X$4580 VPWR VPWR VGND VGND sky130_fd_sc_hd__decap_12
X$4581 VPWR VPWR VGND VGND sky130_fd_sc_hd__decap_8
X$4584 VPWR VPWR VGND VGND sky130_fd_sc_hd__decap_12
X$4585 VPWR VPWR VGND VGND sky130_fd_sc_hd__decap_12
X$4587 VPWR VPWR VGND VGND sky130_fd_sc_hd__decap_12
X$4588 VPWR VPWR VGND VGND sky130_fd_sc_hd__decap_12
X$4589 VPWR VPWR VGND VGND sky130_fd_sc_hd__decap_8
X$4609 VPWR VPWR VGND VGND sky130_fd_sc_hd__decap_12
X$4611 VPWR VPWR VGND VGND sky130_fd_sc_hd__decap_12
X$4612 VPWR VPWR VGND VGND sky130_fd_sc_hd__decap_12
X$4613 VPWR VPWR VGND VGND sky130_fd_sc_hd__decap_6
X$4615 VPWR VPWR VGND VGND sky130_fd_sc_hd__decap_12
X$4616 VPWR VPWR VGND VGND sky130_fd_sc_hd__decap_12
X$4617 VPWR VPWR VGND VGND sky130_fd_sc_hd__decap_12
X$4618 VPWR VPWR VGND VGND sky130_fd_sc_hd__decap_12
X$4619 VPWR VPWR VGND VGND sky130_fd_sc_hd__decap_12
X$4620 VPWR VPWR VGND VGND sky130_fd_sc_hd__decap_12
X$4621 VPWR VPWR VGND VGND sky130_fd_sc_hd__decap_12
X$4624 VPWR VPWR VGND VGND sky130_fd_sc_hd__decap_12
X$4625 VPWR VPWR VGND VGND sky130_fd_sc_hd__decap_6
X$4627 VPWR \$4586 VPWR VGND \$4414 \$4491 VGND sky130_fd_sc_hd__nand2_1
X$4628 VPWR VPWR \$4587 \$4491 VGND \$4414 VGND sky130_fd_sc_hd__xnor2_1
X$4630 VPWR VGND \$4717 \$4410 \$4589 VPWR VGND sky130_fd_sc_hd__xor2_1
X$4631 VPWR VPWR VGND VGND sky130_fd_sc_hd__decap_6
X$4632 VPWR VPWR VGND \$4722 \$4589 VGND sky130_fd_sc_hd__clkinv_1
X$4633 VPWR VGND \$4665 \$4642 \$4183 VPWR VGND sky130_fd_sc_hd__nor2b_1
X$4634 VPWR \$4730 VGND \$4589 \$4495 VPWR VGND
+ sky130_fd_sc_hd__lpflow_inputiso1p_1
X$4636 VPWR \$4664 VGND \$4665 \$4287 \$4730 \$4217 \$4666 VPWR VGND
+ sky130_fd_sc_hd__o41ai_1
X$4637 VPWR \$4669 VGND \$4664 \$4665 VPWR VGND
+ sky130_fd_sc_hd__lpflow_inputiso1p_1
X$4638 VPWR \$4589 \$4502 VGND \$4669 \$4652 VPWR VGND sky130_fd_sc_hd__nor3_1
X$4640 VPWR \$4647 VGND \$4502 \$4735 VPWR VGND
+ sky130_fd_sc_hd__lpflow_inputiso1p_1
X$4641 VPWR VGND VPWR VGND sky130_fd_sc_hd__decap_4
X$4644 VPWR VPWR VGND VGND sky130_fd_sc_hd__decap_6
X$4645 VPWR \$4592 VGND \$4647 VPWR \$4744 VGND sky130_fd_sc_hd__nor2_1
X$4646 VPWR VPWR VGND VGND sky130_fd_sc_hd__decap_8
X$4648 VPWR VGND \$4754 \$4594 \$4759 VPWR VGND sky130_fd_sc_hd__xor2_1
X$4649 VPWR VPWR VGND VGND sky130_fd_sc_hd__decap_12
X$4650 VPWR VGND VPWR VGND sky130_fd_sc_hd__decap_3
X$4651 VPWR \$4762 VPWR VGND \$4423 \$4752 VGND sky130_fd_sc_hd__nand2_1
X$4652 VPWR VGND \$4576 \$4677 \$4517 VPWR VGND sky130_fd_sc_hd__xor2_1
X$4653 VPWR VPWR VGND VGND sky130_fd_sc_hd__decap_8
X$4654 VPWR \$4684 VGND \$4454 \$4513 \$4517 \$4227 \$4679 VPWR VGND
+ sky130_fd_sc_hd__o41ai_1
X$4655 VPWR VGND VPWR VGND sky130_fd_sc_hd__decap_4
X$4656 VPWR \$4686 VPWR VGND \$4679 \$4822 VGND sky130_fd_sc_hd__nand2_1
X$4658 VPWR \$4715 VPWR VGND \$4511 \$4686 VGND sky130_fd_sc_hd__nand2_1
X$4659 VPWR VPWR VGND VGND sky130_fd_sc_hd__decap_8
X$4661 VPWR VGND VPWR VGND sky130_fd_sc_hd__decap_4
X$4663 VPWR \$4601 VGND \$4690 \$4513 VPWR VGND
+ sky130_fd_sc_hd__lpflow_inputiso1p_1
X$4665 VPWR \$4604 VGND \$4693 \$4690 \$4513 VPWR VGND sky130_fd_sc_hd__or3_1
X$4666 VPWR \$4689 VGND \$4690 VPWR \$4693 VGND sky130_fd_sc_hd__nor2_1
X$4667 VPWR VPWR VGND VGND sky130_fd_sc_hd__decap_12
X$4669 VPWR \$4609 VGND \$4798 \$4690 VPWR VGND
+ sky130_fd_sc_hd__lpflow_inputiso1p_1
X$4670 VPWR VGND \$4805 \$4690 \$4427 VPWR VGND sky130_fd_sc_hd__xor2_1
X$4671 VPWR VPWR VGND VGND sky130_fd_sc_hd__decap_12
X$4672 VPWR VPWR VGND VGND sky130_fd_sc_hd__decap_12
X$4673 VPWR VPWR VGND VGND sky130_fd_sc_hd__decap_12
X$4674 VPWR VGND VPWR VGND sky130_fd_sc_hd__decap_4
X$4677 VPWR VPWR VGND VGND sky130_fd_sc_hd__decap_12
X$4681 VPWR VPWR VGND VGND sky130_fd_sc_hd__decap_12
X$4683 VPWR VPWR VGND VGND sky130_fd_sc_hd__decap_12
X$4684 VPWR VPWR VGND VGND sky130_fd_sc_hd__decap_12
X$4685 VPWR VPWR VGND VGND sky130_fd_sc_hd__decap_12
X$4686 VPWR VPWR VGND VGND sky130_fd_sc_hd__decap_12
X$4688 VPWR VPWR VGND VGND sky130_fd_sc_hd__decap_12
X$4689 VPWR VPWR VGND VGND sky130_fd_sc_hd__decap_12
X$4692 VPWR VPWR VGND VGND sky130_fd_sc_hd__decap_12
X$4694 VPWR VPWR VGND VGND sky130_fd_sc_hd__decap_12
X$4695 VPWR VPWR VGND VGND sky130_fd_sc_hd__decap_12
X$4696 VPWR VPWR VGND VGND sky130_fd_sc_hd__decap_12
X$4697 VPWR VPWR VGND VGND sky130_fd_sc_hd__decap_12
X$4699 VPWR VPWR VGND VGND sky130_fd_sc_hd__decap_12
X$4700 VPWR VGND VPWR VGND sky130_fd_sc_hd__decap_4
X$4702 VPWR VPWR \$4642 \$4587 VGND \$4379 VGND sky130_fd_sc_hd__xnor2_1
X$4705 VPWR VPWR VGND \$4379 \$4896 VGND sky130_fd_sc_hd__clkinv_1
X$4706 VPWR VGND VPWR VGND sky130_fd_sc_hd__decap_3
X$4707 VPWR VGND \$4664 \$4183 \$4642 VPWR VGND
+ sky130_fd_sc_hd__lpflow_isobufsrc_1
X$4708 VPWR VPWR VGND VGND sky130_fd_sc_hd__decap_12
X$4710 VPWR VPWR \$4315 \$4669 VGND \$4652 VGND sky130_fd_sc_hd__xnor2_1
X$4711 VPWR FINE_MUX[21] VGND \$4183 VPWR VGND sky130_fd_sc_hd__clkdlybuf4s50_1
X$4712 VPWR VGND VPWR VGND sky130_fd_sc_hd__decap_4
X$4714 VPWR VPWR VGND \$4836 \$4315 VGND sky130_fd_sc_hd__clkinv_1
X$4716 VPWR \$4744 VPWR VGND \$4318 \$4836 VGND sky130_fd_sc_hd__nand2_1
X$4717 VPWR VGND VPWR VGND sky130_fd_sc_hd__decap_4
X$4720 VPWR \$4780 VPWR VGND \$4744 \$4574 VGND sky130_fd_sc_hd__nand2_1
X$4721 VPWR VGND \$4647 \$4780 \$4505 VPWR VGND sky130_fd_sc_hd__xor2_1
X$4722 VPWR \$4754 VGND VPWR \$4505 \$4597 \$4574 \$4647 VGND
+ sky130_fd_sc_hd__o22a_1
X$4723 VPWR VPWR VGND VGND sky130_fd_sc_hd__decap_6
X$4725 VPWR \$4786 VGND \$4505 VPWR \$4762 VGND sky130_fd_sc_hd__nor2_1
X$4726 VPWR \$4840 VPWR VGND \$4597 \$4762 VGND sky130_fd_sc_hd__nand2_1
X$4728 VPWR VGND \$4840 \$4505 \$4454 VPWR VGND sky130_fd_sc_hd__xor2_1
X$4729 VPWR VPWR \$4513 \$4759 VGND \$4786 VGND sky130_fd_sc_hd__xnor2_1
X$4731 VPWR VPWR VGND VGND sky130_fd_sc_hd__decap_8
X$4733 VPWR VPWR VGND \$4822 \$4684 VGND sky130_fd_sc_hd__clkinv_1
X$4734 VPWR VGND \$4684 \$4679 \$4791 VPWR VGND sky130_fd_sc_hd__xor2_1
X$4735 VPWR VGND \$4454 \$4715 \$4690 VPWR VGND sky130_fd_sc_hd__xor2_1
X$4736 VPWR VPWR VGND VGND sky130_fd_sc_hd__decap_6
X$4738 VPWR VPWR VGND \$4795 \$4791 VGND sky130_fd_sc_hd__clkinv_1
X$4739 VPWR VGND \$4791 \$4687 \$4518 VPWR VGND sky130_fd_sc_hd__xor2_1
X$4741 VPWR \$4693 VPWR VGND \$4687 \$4795 VGND sky130_fd_sc_hd__nand2_1
X$4742 VPWR VPWR VGND VGND sky130_fd_sc_hd__decap_8
X$4743 VPWR VPWR VGND \$4807 \$4518 VGND sky130_fd_sc_hd__clkinv_1
X$4744 VPWR \$4798 VPWR VGND \$4522 \$4807 VGND sky130_fd_sc_hd__nand2_1
X$4745 VPWR \$4805 VPWR VGND \$4693 \$4798 VGND sky130_fd_sc_hd__nand2_1
X$4746 VPWR VPWR VGND VGND sky130_fd_sc_hd__decap_6
X$4749 VPWR VPWR VGND VGND sky130_fd_sc_hd__decap_12
X$4750 VPWR VPWR VGND VGND sky130_fd_sc_hd__decap_12
X$4752 VPWR VPWR VGND VGND sky130_fd_sc_hd__decap_12
X$4753 VPWR VPWR VGND VGND sky130_fd_sc_hd__decap_12
X$4754 VPWR VPWR VGND VGND sky130_fd_sc_hd__decap_8
X$4774 VPWR VPWR VGND VGND sky130_fd_sc_hd__decap_12
X$4776 VPWR VPWR VGND VGND sky130_fd_sc_hd__decap_12
X$4777 VPWR VPWR VGND VGND sky130_fd_sc_hd__decap_12
X$4778 VPWR VPWR VGND VGND sky130_fd_sc_hd__decap_6
X$4780 VPWR VPWR VGND VGND sky130_fd_sc_hd__decap_12
X$4781 VPWR VPWR VGND VGND sky130_fd_sc_hd__decap_12
X$4782 VPWR VPWR VGND VGND sky130_fd_sc_hd__decap_12
X$4783 VPWR VPWR VGND VGND sky130_fd_sc_hd__decap_12
X$4784 VPWR VPWR VGND VGND sky130_fd_sc_hd__decap_12
X$4785 VPWR VPWR VGND VGND sky130_fd_sc_hd__decap_12
X$4786 VPWR VPWR VGND VGND sky130_fd_sc_hd__decap_12
X$4789 VPWR VPWR VGND VGND sky130_fd_sc_hd__decap_12
X$4790 VPWR VPWR VGND VGND sky130_fd_sc_hd__decap_8
X$4791 VPWR VGND VPWR VGND sky130_fd_sc_hd__decap_3
X$4792 VPWR VPWR \$4495 \$4632 VGND \$4413 \$4415 VGND sky130_fd_sc_hd__o21ai_0
X$4793 VPWR \$4495 \$4548 VGND \$4410 \$4587 VPWR VGND sky130_fd_sc_hd__nor3_1
X$4794 VPWR \$4497 VGND \$4379 \$4587 \$4410 VPWR VGND sky130_fd_sc_hd__or3_1
X$4795 VPWR VPWR VGND VGND sky130_fd_sc_hd__decap_12
X$4796 VPWR \$4556 VPWR VGND \$4497 \$4498 VGND sky130_fd_sc_hd__nand2_1
X$4797 VPWR VPWR \$4418 \$4556 VGND \$4495 VGND sky130_fd_sc_hd__xnor2_1
X$4798 VPWR VPWR VGND VGND sky130_fd_sc_hd__decap_12
X$4799 VPWR VPWR VGND VGND sky130_fd_sc_hd__decap_6
X$4801 VPWR VPWR \$4580 \$4418 VGND \$4502 VGND sky130_fd_sc_hd__xnor2_1
X$4804 VPWR VGND VPWR VGND sky130_fd_sc_hd__decap_4
X$4805 VPWR VPWR \$4504 \$4317 VGND \$4650 VGND sky130_fd_sc_hd__xnor2_1
X$4806 VPWR VPWR VGND VGND sky130_fd_sc_hd__decap_8
X$4808 VPWR \$4468 \$4323 \$4505 VGND \$4594 \$4504 VPWR VGND
+ sky130_fd_sc_hd__or4_1
X$4810 VPWR VPWR VGND \$4757 \$4468 VGND sky130_fd_sc_hd__clkinv_1
X$4811 VPWR VGND VPWR VGND sky130_fd_sc_hd__decap_3
X$4812 VPWR \$4580 \$4572 VGND \$4505 \$4463 VPWR VGND sky130_fd_sc_hd__nor3_1
X$4813 VPWR VPWR VGND VGND sky130_fd_sc_hd__decap_12
X$4814 VPWR VGND VPWR VGND sky130_fd_sc_hd__decap_4
X$4816 VPWR \$4507 VGND \$4454 \$4513 \$4517 \$4161 \$4510 VPWR VGND
+ sky130_fd_sc_hd__o41ai_1
X$4817 VPWR VPWR VGND \$4567 \$4507 VGND sky130_fd_sc_hd__clkinv_1
X$4818 VPWR \$4511 VPWR VGND \$4510 \$4567 VGND sky130_fd_sc_hd__nand2_1
X$4819 VPWR VGND VPWR VGND sky130_fd_sc_hd__decap_3
X$4820 VPWR \$4454 VPWR \$4721 VGND \$4513 \$4511 VGND sky130_fd_sc_hd__o21a_1
X$4822 VPWR VPWR \$4606 \$4517 VGND \$4547 VGND sky130_fd_sc_hd__xnor2_1
X$4824 VPWR VGND \$4545 \$4546 \$4602 VPWR VGND sky130_fd_sc_hd__xor2_1
X$4825 VPWR VPWR VGND VGND sky130_fd_sc_hd__decap_6
X$4826 VPWR \$4522 \$4520 VPWR VGND \$4601 \$4230 \$4518 VGND
+ sky130_fd_sc_hd__o31ai_1
X$4827 VPWR VGND VPWR VGND sky130_fd_sc_hd__decap_3
X$4828 VPWR \$4541 VPWR VGND \$4521 \$4606 VGND sky130_fd_sc_hd__nand2_1
X$4829 VPWR VPWR \$4072 \$4521 VGND \$4520 \$4541 VGND sky130_fd_sc_hd__o21ai_0
X$4830 VPWR VGND VPWR VGND sky130_fd_sc_hd__decap_4
X$4832 VPWR VPWR \$4432 \$4518 VGND \$4522 VGND sky130_fd_sc_hd__xnor2_1
X$4833 VPWR VPWR VGND VGND sky130_fd_sc_hd__decap_12
X$4835 VPWR \$4529 VPWR VGND \$4334 \$4333 VGND sky130_fd_sc_hd__nand2_1
X$4836 VPWR VPWR VGND VGND sky130_fd_sc_hd__decap_12
X$4837 VPWR VPWR VGND VGND sky130_fd_sc_hd__decap_12
X$4838 VPWR VGND VPWR VGND sky130_fd_sc_hd__decap_4
X$4840 VPWR VPWR VGND VGND sky130_fd_sc_hd__decap_12
X$4844 VPWR VPWR VGND VGND sky130_fd_sc_hd__decap_12
X$4846 VPWR VPWR VGND VGND sky130_fd_sc_hd__decap_12
X$4847 VPWR VPWR VGND VGND sky130_fd_sc_hd__decap_12
X$4848 VPWR VPWR VGND VGND sky130_fd_sc_hd__decap_12
X$4849 VPWR VPWR VGND VGND sky130_fd_sc_hd__decap_12
X$4851 VPWR VPWR VGND VGND sky130_fd_sc_hd__decap_12
X$4852 VPWR VPWR VGND VGND sky130_fd_sc_hd__decap_12
X$4855 VPWR VPWR VGND VGND sky130_fd_sc_hd__decap_12
X$4857 VPWR VPWR VGND VGND sky130_fd_sc_hd__decap_12
X$4858 VPWR VPWR VGND VGND sky130_fd_sc_hd__decap_12
X$4859 VPWR VPWR VGND VGND sky130_fd_sc_hd__decap_12
X$4860 VPWR VPWR VGND VGND sky130_fd_sc_hd__decap_12
X$4862 VPWR VPWR VGND VGND sky130_fd_sc_hd__decap_6
X$4863 VPWR \$4632 VGND \$4410 VPWR \$4586 VGND sky130_fd_sc_hd__nor2_1
X$4865 VPWR VPWR \$4717 \$4379 VGND \$4587 \$4586 VGND sky130_fd_sc_hd__o21ai_0
X$4866 VPWR VPWR VGND VGND sky130_fd_sc_hd__decap_8
X$4869 VPWR \$4212 VGND \$4642 \$4589 \$4495 VPWR VGND sky130_fd_sc_hd__or3_1
X$4870 VPWR VGND VPWR VGND sky130_fd_sc_hd__decap_3
X$4871 VPWR \$4498 VPWR VGND \$4664 \$4722 VGND sky130_fd_sc_hd__nand2_1
X$4872 VPWR VPWR VGND VGND sky130_fd_sc_hd__decap_12
X$4874 VPWR VPWR \$4735 \$4664 VGND \$4667 \$4498 VGND sky130_fd_sc_hd__o21ai_0
X$4875 VPWR VPWR \$4667 \$4652 VGND \$4669 \$4589 VGND sky130_fd_sc_hd__o21ai_0
X$4876 VPWR VPWR VGND VGND sky130_fd_sc_hd__decap_12
X$4878 VPWR VGND \$4592 VPWR \$4418 \$4650 \$4672 VGND sky130_fd_sc_hd__a21oi_1
X$4879 VPWR VGND \$4592 \$4580 \$4594 VPWR VGND sky130_fd_sc_hd__xor2_1
X$4881 VPWR \$4594 \$4672 VGND \$4647 \$4574 VPWR VGND sky130_fd_sc_hd__nor3_1
X$4882 VPWR VGND VPWR VGND sky130_fd_sc_hd__decap_4
X$4884 VPWR \$4580 \$4674 VGND \$4505 \$4597 VPWR VGND sky130_fd_sc_hd__nor3_1
X$4885 VPWR VPWR \$4576 \$4504 VGND \$4674 VGND sky130_fd_sc_hd__xnor2_1
X$4886 VPWR \$4597 VPWR VGND \$4221 \$4757 VGND sky130_fd_sc_hd__nand2_1
X$4887 VPWR VPWR VGND VGND sky130_fd_sc_hd__decap_6
X$4889 VPWR VPWR VGND \$4752 \$4463 VGND sky130_fd_sc_hd__clkinv_1
X$4890 VPWR VPWR VGND VGND sky130_fd_sc_hd__decap_12
X$4893 VPWR VGND \$4507 \$4510 \$4684 VPWR VGND sky130_fd_sc_hd__xor2_1
X$4894 VPWR VPWR VGND VGND sky130_fd_sc_hd__decap_6
X$4895 VPWR \$4546 VGND \$4454 VPWR \$4686 VGND sky130_fd_sc_hd__nor2_1
X$4896 VPWR \$4545 VGND \$4721 VPWR \$4515 VGND sky130_fd_sc_hd__nor2_1
X$4897 VPWR VPWR VGND VGND sky130_fd_sc_hd__decap_8
X$4898 VPWR VGND VPWR VGND sky130_fd_sc_hd__decap_3
X$4899 VPWR \$4687 \$4606 VPWR VGND \$4601 \$4160 \$4791 VGND
+ sky130_fd_sc_hd__o31ai_1
X$4901 VPWR VPWR \$4608 \$4689 VGND \$4602 \$4604 VGND sky130_fd_sc_hd__o21ai_0
X$4903 VPWR VPWR \$4520 \$4606 VGND \$4604 VGND sky130_fd_sc_hd__xnor2_1
X$4904 VPWR VPWR VGND VGND sky130_fd_sc_hd__decap_6
X$4906 VPWR \$4521 VGND \$4608 VPWR \$4609 VGND sky130_fd_sc_hd__nor2_1
X$4907 VPWR VGND \$4608 \$4609 \$4243 VPWR VGND sky130_fd_sc_hd__xor2_1
X$4908 VPWR VGND VPWR VGND sky130_fd_sc_hd__decap_3
X$4910 VPWR VPWR VGND VGND sky130_fd_sc_hd__decap_12
X$4911 VPWR VPWR VGND VGND sky130_fd_sc_hd__decap_12
X$4913 VPWR VPWR VGND VGND sky130_fd_sc_hd__decap_12
X$4914 VPWR VPWR VGND VGND sky130_fd_sc_hd__decap_12
X$4915 VPWR VPWR VGND VGND sky130_fd_sc_hd__decap_8
X$4935 VPWR VPWR VGND VGND sky130_fd_sc_hd__decap_12
X$4937 VPWR VPWR VGND VGND sky130_fd_sc_hd__decap_12
X$4938 VPWR VPWR VGND VGND sky130_fd_sc_hd__decap_12
X$4939 VPWR VPWR VGND VGND sky130_fd_sc_hd__decap_6
X$4941 VPWR VPWR VGND VGND sky130_fd_sc_hd__decap_12
X$4943 VPWR \$3838 VPWR \$3861 \$3862 \$3594 \$3706 VGND VGND
+ sky130_fd_sc_hd__nand4_1
X$4944 VPWR VPWR VGND VGND sky130_fd_sc_hd__decap_12
X$4945 VPWR VGND \$3863 VPWR \$3844 \$3962 \$3862 VGND sky130_fd_sc_hd__a21oi_1
X$4946 VPWR \$3862 \$3863 \$3913 VPWR VGND \$3844 VGND sky130_fd_sc_hd__and3_1
X$4948 VPWR \$4017 VGND \$3833 \$3865 VPWR VGND
+ sky130_fd_sc_hd__lpflow_inputiso1p_1
X$4949 VPWR VPWR VGND VGND sky130_fd_sc_hd__decap_12
X$4950 VPWR VPWR VGND VGND sky130_fd_sc_hd__decap_8
X$4951 VPWR VGND \$3852 \$3802 \$3923 VPWR VGND sky130_fd_sc_hd__xor2_1
X$4952 VPWR VPWR VGND VGND sky130_fd_sc_hd__decap_6
X$4954 VPWR \$3783 VPWR \$3923 \$3927 VGND VGND sky130_fd_sc_hd__and2_0
X$4956 VPWR VPWR VGND VGND sky130_fd_sc_hd__decap_12
X$4957 VPWR VPWR VGND VGND sky130_fd_sc_hd__decap_12
X$4958 VPWR VPWR VGND \$3870 \$3866 VGND sky130_fd_sc_hd__clkinv_1
X$4959 VPWR \$3871 VPWR VGND \$3805 \$3857 \$3870 VGND sky130_fd_sc_hd__nand3_1
X$4960 VPWR VGND \$3857 VPWR \$3870 \$3872 \$3805 VGND sky130_fd_sc_hd__a21oi_1
X$4961 VPWR VPWR VGND VGND sky130_fd_sc_hd__decap_6
X$4963 VPWR VGND \$3935 \$3871 \$3872 VPWR VGND
+ sky130_fd_sc_hd__lpflow_isobufsrc_1
X$4964 VPWR VPWR \$3770 \$4039 VGND \$3722 VGND sky130_fd_sc_hd__xnor2_1
X$4965 VPWR VPWR VGND VGND sky130_fd_sc_hd__decap_12
X$4966 VPWR VPWR \$3875 \$3770 VGND \$3769 VGND sky130_fd_sc_hd__xnor2_1
X$4967 VPWR VPWR VGND VGND sky130_fd_sc_hd__decap_8
X$4969 VPWR \$3614 VGND \$3875 VPWR \$3946 VGND sky130_fd_sc_hd__nor2_1
X$4971 VPWR VGND \$3875 \$3946 \$3848 VPWR VGND sky130_fd_sc_hd__xor2_1
X$4972 VPWR \$3513 VPWR VGND \$3848 \$3949 VGND sky130_fd_sc_hd__nand2_1
X$4974 VPWR \$3878 VGND \$3840 \$3848 \$3949 VPWR VGND sky130_fd_sc_hd__or3_1
X$4975 VPWR \$3815 VPWR VGND \$3513 \$3762 \$3878 VGND sky130_fd_sc_hd__nand3_1
X$4976 VPWR VPWR VGND VGND sky130_fd_sc_hd__decap_8
X$4978 VPWR VGND \$3815 \$3817 \$3881 VPWR VGND sky130_fd_sc_hd__xor2_1
X$4979 VPWR \$3834 \$3574 \$3571 VPWR VGND \$3880 VGND sky130_fd_sc_hd__and3_1
X$4980 VPWR VPWR VGND VGND sky130_fd_sc_hd__decap_6
X$4981 VPWR \$3445 VPWR VGND \$3832 \$3881 VGND sky130_fd_sc_hd__nand2_1
X$4982 VPWR \$3826 \$3881 \$3520 VPWR VGND \$3827 VGND sky130_fd_sc_hd__and3_1
X$4983 VPWR VPWR \$3887 \$3831 VGND \$3881 VGND sky130_fd_sc_hd__xnor2_1
X$4985 VPWR VGND \$3649 \$3887 \$3914 VPWR VGND sky130_fd_sc_hd__nor2b_1
X$4986 VPWR VGND \$3887 \$3914 \$3889 VPWR VGND sky130_fd_sc_hd__xor2_1
X$4987 VPWR VPWR VGND VGND sky130_fd_sc_hd__decap_8
X$4990 VGND \$3910 \$3889 \$3825 \$3890 VPWR VPWR VGND sky130_fd_sc_hd__xor3_1
X$4991 VGND \$2782 \$3823 TICK \$3897 VPWR VPWR VGND sky130_fd_sc_hd__dfrtp_1
X$4992 VPWR VPWR VGND VGND sky130_fd_sc_hd__decap_12
X$4993 VPWR VPWR VGND VGND sky130_fd_sc_hd__decap_12
X$4994 VPWR VPWR VGND VGND sky130_fd_sc_hd__decap_12
X$4995 VPWR VPWR VGND VGND sky130_fd_sc_hd__decap_8
X$4998 VPWR VPWR VGND VGND sky130_fd_sc_hd__decap_12
X$5002 VPWR VPWR VGND VGND sky130_fd_sc_hd__decap_12
X$5004 VPWR VPWR VGND VGND sky130_fd_sc_hd__decap_12
X$5005 VPWR VPWR VGND VGND sky130_fd_sc_hd__decap_12
X$5006 VPWR VPWR VGND VGND sky130_fd_sc_hd__decap_12
X$5007 VPWR VPWR VGND VGND sky130_fd_sc_hd__decap_8
X$5010 VPWR \$4004 VPWR VGND \$3861 \$3594 VGND sky130_fd_sc_hd__nand2_1
X$5011 VPWR VPWR \$3865 \$4088 VGND \$3838 \$3862 VGND sky130_fd_sc_hd__o21ai_0
X$5012 VPWR VPWR VGND VGND sky130_fd_sc_hd__decap_12
X$5014 VPWR VGND \$3863 VPWR \$3844 \$3959 \$3961 VGND sky130_fd_sc_hd__a21o_1
X$5016 VPWR \$3958 VGND \$4017 \$3913 \$3962 \$3711 \$4127 VPWR VGND
+ sky130_fd_sc_hd__o41ai_1
X$5017 VPWR VPWR VGND VGND sky130_fd_sc_hd__decap_12
X$5019 VPWR VPWR VGND VGND sky130_fd_sc_hd__decap_12
X$5020 VPWR VPWR VGND VGND sky130_fd_sc_hd__decap_8
X$5022 VPWR VPWR \$3967 \$3927 VGND \$3923 VGND sky130_fd_sc_hd__xnor2_1
X$5023 VPWR VPWR VGND VGND sky130_fd_sc_hd__decap_8
X$5025 VPWR VGND VPWR VGND sky130_fd_sc_hd__decap_3
X$5026 VPWR \$3971 VPWR VGND \$3967 \$3970 VGND sky130_fd_sc_hd__nand2_1
X$5027 VPWR \$3866 VGND \$3970 VPWR \$3967 VGND sky130_fd_sc_hd__nor2_1
X$5028 VPWR \$3857 VPWR VGND \$3866 \$4034 \$3971 VGND sky130_fd_sc_hd__or3b_1
X$5029 VPWR VPWR VGND VGND sky130_fd_sc_hd__decap_12
X$5033 VPWR VGND \$3871 VPWR \$4038 \$4039 \$3872 VGND sky130_fd_sc_hd__a21oi_1
X$5034 VPWR \$4038 \$3722 \$3780 VPWR VGND \$3935 VGND sky130_fd_sc_hd__and3_1
X$5035 VPWR VPWR VGND VGND sky130_fd_sc_hd__decap_8
X$5038 VPWR VGND \$3769 \$3935 \$4060 VPWR VGND sky130_fd_sc_hd__nor2b_1
X$5039 VPWR VPWR VGND VGND sky130_fd_sc_hd__decap_12
X$5040 VPWR VPWR VGND VGND sky130_fd_sc_hd__decap_12
X$5041 VPWR VPWR VGND VGND sky130_fd_sc_hd__decap_12
X$5043 VPWR VPWR VGND VGND sky130_fd_sc_hd__decap_12
X$5044 VPWR VPWR VGND VGND sky130_fd_sc_hd__decap_12
X$5047 VPWR VPWR VGND VGND sky130_fd_sc_hd__decap_12
X$5048 VPWR VPWR VGND VGND sky130_fd_sc_hd__decap_12
X$5050 VPWR \$3914 VPWR VGND \$3982 \$3827 VGND sky130_fd_sc_hd__nand2_1
X$5051 VPWR VGND \$4092 \$3827 \$3824 VPWR VGND sky130_fd_sc_hd__xor2_1
X$5052 VPWR VPWR VGND VGND sky130_fd_sc_hd__decap_12
X$5053 VPWR VGND VPWR VGND sky130_fd_sc_hd__decap_3
X$5054 VPWR \$3627 VGND \$3889 \$3825 \$3890 VPWR VGND sky130_fd_sc_hd__maj3_1
X$5057 VPWR VPWR \$3993 \$3824 VGND \$3823 VGND sky130_fd_sc_hd__xnor2_1
X$5058 VPWR VPWR VGND VGND sky130_fd_sc_hd__decap_12
X$5059 VPWR VPWR VGND VGND sky130_fd_sc_hd__decap_6
X$5062 VPWR VPWR VGND VGND sky130_fd_sc_hd__decap_12
X$5063 VPWR VPWR VGND VGND sky130_fd_sc_hd__decap_12
X$5065 VPWR VPWR VGND VGND sky130_fd_sc_hd__decap_12
X$5066 VPWR VPWR VGND VGND sky130_fd_sc_hd__decap_12
X$5067 VPWR VPWR VGND VGND sky130_fd_sc_hd__decap_8
.ENDS PLL_COUNTER_DCO_PHYS

.SUBCKT sky130_fd_sc_hd__o2bb2ai_1 VPB A1_N VPWR VGND A2_N Y B2 B1 sky130_gnd
M$1 VPWR A1_N \$5 VPB sky130_fd_pr__pfet_01v8_hvt L=0.15 W=1 AS=0.275 AD=0.135
+ PS=2.55 PD=1.27
M$2 \$5 A2_N VPWR VPB sky130_fd_pr__pfet_01v8_hvt L=0.15 W=1 AS=0.135 AD=0.42
+ PS=1.27 PD=1.84
M$3 VPWR \$5 Y VPB sky130_fd_pr__pfet_01v8_hvt L=0.15 W=1 AS=0.42 AD=0.135
+ PS=1.84 PD=1.27
M$4 Y B2 \$12 VPB sky130_fd_pr__pfet_01v8_hvt L=0.15 W=1 AS=0.135 AD=0.135
+ PS=1.27 PD=1.27
M$5 \$12 B1 VPWR VPB sky130_fd_pr__pfet_01v8_hvt L=0.15 W=1 AS=0.135 AD=0.275
+ PS=1.27 PD=2.55
M$6 Y \$5 \$8 sky130_gnd sky130_fd_pr__nfet_01v8 L=0.15 W=0.65 AS=0.169
+ AD=0.08775 PS=1.82 PD=0.92
M$7 \$8 B2 VGND sky130_gnd sky130_fd_pr__nfet_01v8 L=0.15 W=0.65 AS=0.08775
+ AD=0.08775 PS=0.92 PD=0.92
M$8 VGND B1 \$8 sky130_gnd sky130_fd_pr__nfet_01v8 L=0.15 W=0.65 AS=0.08775
+ AD=0.169 PS=0.92 PD=1.82
M$9 VGND A1_N \$13 sky130_gnd sky130_fd_pr__nfet_01v8 L=0.15 W=0.65 AS=0.17875
+ AD=0.06825 PS=1.85 PD=0.86
M$10 \$13 A2_N \$5 sky130_gnd sky130_fd_pr__nfet_01v8 L=0.15 W=0.65 AS=0.06825
+ AD=0.2405 PS=0.86 PD=2.04
.ENDS sky130_fd_sc_hd__o2bb2ai_1

.SUBCKT sky130_fd_sc_hd__o311a_1 VGND X A1 A2 A3 B1 C1 VPWR VPB sky130_gnd
M$1 X \$5 VPWR VPB sky130_fd_pr__pfet_01v8_hvt L=0.15 W=1 AS=0.26 AD=0.3125
+ PS=2.52 PD=1.625
M$2 VPWR A1 \$13 VPB sky130_fd_pr__pfet_01v8_hvt L=0.15 W=1 AS=0.3125 AD=0.18
+ PS=1.625 PD=1.36
M$3 \$13 A2 \$14 VPB sky130_fd_pr__pfet_01v8_hvt L=0.15 W=1 AS=0.18 AD=0.21
+ PS=1.36 PD=1.42
M$4 \$14 A3 \$5 VPB sky130_fd_pr__pfet_01v8_hvt L=0.15 W=1 AS=0.21 AD=0.1375
+ PS=1.42 PD=1.275
M$5 \$5 B1 VPWR VPB sky130_fd_pr__pfet_01v8_hvt L=0.15 W=1 AS=0.1375 AD=0.15
+ PS=1.275 PD=1.3
M$6 VPWR C1 \$5 VPB sky130_fd_pr__pfet_01v8_hvt L=0.15 W=1 AS=0.15 AD=0.26
+ PS=1.3 PD=2.52
M$7 X \$5 VGND sky130_gnd sky130_fd_pr__nfet_01v8 L=0.15 W=0.65 AS=0.169
+ AD=0.203125 PS=1.82 PD=1.275
M$8 VGND A1 \$4 sky130_gnd sky130_fd_pr__nfet_01v8 L=0.15 W=0.65 AS=0.203125
+ AD=0.117 PS=1.275 PD=1.01
M$9 \$4 A2 VGND sky130_gnd sky130_fd_pr__nfet_01v8 L=0.15 W=0.65 AS=0.117
+ AD=0.1365 PS=1.01 PD=1.07
M$10 VGND A3 \$4 sky130_gnd sky130_fd_pr__nfet_01v8 L=0.15 W=0.65 AS=0.1365
+ AD=0.118625 PS=1.07 PD=1.015
M$11 \$4 B1 \$11 sky130_gnd sky130_fd_pr__nfet_01v8 L=0.15 W=0.65 AS=0.118625
+ AD=0.06825 PS=1.015 PD=0.86
M$12 \$11 C1 \$5 sky130_gnd sky130_fd_pr__nfet_01v8 L=0.15 W=0.65 AS=0.06825
+ AD=0.169 PS=0.86 PD=1.82
.ENDS sky130_fd_sc_hd__o311a_1

.SUBCKT sky130_fd_sc_hd__nand4bb_1 VPB VPWR VGND A_N Y C D B_N sky130_gnd
M$1 VPWR A_N \$2 VPB sky130_fd_pr__pfet_01v8_hvt L=0.15 W=0.42 AS=0.1092
+ AD=0.1827 PS=1.36 PD=1.71
M$2 VPWR B_N \$7 VPB sky130_fd_pr__pfet_01v8_hvt L=0.15 W=0.42 AS=0.17575
+ AD=0.1092 PS=1.395 PD=1.36
M$3 VPWR D Y VPB sky130_fd_pr__pfet_01v8_hvt L=0.15 W=1 AS=0.17575 AD=0.195
+ PS=1.395 PD=1.39
M$4 Y C VPWR VPB sky130_fd_pr__pfet_01v8_hvt L=0.15 W=1 AS=0.195 AD=0.175
+ PS=1.39 PD=1.35
M$5 VPWR \$7 Y VPB sky130_fd_pr__pfet_01v8_hvt L=0.15 W=1 AS=0.175 AD=0.175
+ PS=1.35 PD=1.35
M$6 Y \$2 VPWR VPB sky130_fd_pr__pfet_01v8_hvt L=0.15 W=1 AS=0.175 AD=0.26
+ PS=1.35 PD=2.52
M$7 VGND B_N \$7 sky130_gnd sky130_fd_pr__nfet_01v8 L=0.15 W=0.42 AS=0.11975
+ AD=0.1092 PS=1.045 PD=1.36
M$8 VGND D \$14 sky130_gnd sky130_fd_pr__nfet_01v8 L=0.15 W=0.65 AS=0.11975
+ AD=0.12675 PS=1.045 PD=1.04
M$9 \$14 C \$13 sky130_gnd sky130_fd_pr__nfet_01v8 L=0.15 W=0.65 AS=0.12675
+ AD=0.11375 PS=1.04 PD=1
M$10 \$13 \$7 \$12 sky130_gnd sky130_fd_pr__nfet_01v8 L=0.15 W=0.65 AS=0.11375
+ AD=0.11375 PS=1 PD=1
M$11 \$12 \$2 Y sky130_gnd sky130_fd_pr__nfet_01v8 L=0.15 W=0.65 AS=0.11375
+ AD=0.169 PS=1 PD=1.82
M$12 VGND A_N \$2 sky130_gnd sky130_fd_pr__nfet_01v8 L=0.15 W=0.42 AS=0.1092
+ AD=0.1827 PS=1.36 PD=1.71
.ENDS sky130_fd_sc_hd__nand4bb_1

.SUBCKT sky130_fd_sc_hd__a22o_1 VPB VGND B2 B1 VPWR A1 X A2 sky130_gnd
M$1 VPWR A1 \$4 VPB sky130_fd_pr__pfet_01v8_hvt L=0.15 W=1 AS=0.2529 AD=0.16
+ PS=2.52 PD=1.32
M$2 \$4 A2 VPWR VPB sky130_fd_pr__pfet_01v8_hvt L=0.15 W=1 AS=0.16 AD=0.155
+ PS=1.32 PD=1.31
M$3 VPWR \$6 X VPB sky130_fd_pr__pfet_01v8_hvt L=0.15 W=1 AS=0.155 AD=0.26
+ PS=1.31 PD=2.52
M$4 \$6 B2 \$4 VPB sky130_fd_pr__pfet_01v8_hvt L=0.15 W=1 AS=0.26 AD=0.135
+ PS=2.52 PD=1.27
M$5 \$4 B1 \$6 VPB sky130_fd_pr__pfet_01v8_hvt L=0.15 W=1 AS=0.135 AD=0.25285
+ PS=1.27 PD=2.52
M$6 \$6 A1 \$12 sky130_gnd sky130_fd_pr__nfet_01v8 L=0.15 W=0.65 AS=0.169
+ AD=0.11375 PS=1.82 PD=1
M$7 \$12 A2 VGND sky130_gnd sky130_fd_pr__nfet_01v8 L=0.15 W=0.65 AS=0.11375
+ AD=0.10075 PS=1 PD=0.96
M$8 VGND \$6 X sky130_gnd sky130_fd_pr__nfet_01v8 L=0.15 W=0.65 AS=0.10075
+ AD=0.169 PS=0.96 PD=1.82
M$9 VGND B2 \$13 sky130_gnd sky130_fd_pr__nfet_01v8 L=0.15 W=0.65 AS=0.169
+ AD=0.07475 PS=1.82 PD=0.88
M$10 \$13 B1 \$6 sky130_gnd sky130_fd_pr__nfet_01v8 L=0.15 W=0.65 AS=0.07475
+ AD=0.169 PS=0.88 PD=1.82
.ENDS sky130_fd_sc_hd__a22o_1

.SUBCKT sky130_fd_sc_hd__a22oi_1 VPB A1 VPWR Y B1 B2 VGND A2 sky130_gnd
M$1 VPWR A1 \$2 VPB sky130_fd_pr__pfet_01v8_hvt L=0.15 W=1 AS=0.26 AD=0.135
+ PS=2.52 PD=1.27
M$2 \$2 A2 VPWR VPB sky130_fd_pr__pfet_01v8_hvt L=0.15 W=1 AS=0.135 AD=0.3
+ PS=1.27 PD=2.6
M$3 Y B2 \$2 VPB sky130_fd_pr__pfet_01v8_hvt L=0.15 W=1 AS=0.26 AD=0.135
+ PS=2.52 PD=1.27
M$4 \$2 B1 Y VPB sky130_fd_pr__pfet_01v8_hvt L=0.15 W=1 AS=0.135 AD=0.26
+ PS=1.27 PD=2.52
M$5 Y A1 \$11 sky130_gnd sky130_fd_pr__nfet_01v8 L=0.15 W=0.65 AS=0.169
+ AD=0.06825 PS=1.82 PD=0.86
M$6 \$11 A2 VGND sky130_gnd sky130_fd_pr__nfet_01v8 L=0.15 W=0.65 AS=0.06825
+ AD=0.234 PS=0.86 PD=2.02
M$7 VGND B2 \$12 sky130_gnd sky130_fd_pr__nfet_01v8 L=0.15 W=0.65 AS=0.169
+ AD=0.07475 PS=1.82 PD=0.88
M$8 \$12 B1 Y sky130_gnd sky130_fd_pr__nfet_01v8 L=0.15 W=0.65 AS=0.07475
+ AD=0.169 PS=0.88 PD=1.82
.ENDS sky130_fd_sc_hd__a22oi_1

.SUBCKT sky130_fd_sc_hd__mux2_1 VGND X A1 A0 S VPWR VPB sky130_gnd
M$1 VPWR S \$13 VPB sky130_fd_pr__pfet_01v8_hvt L=0.15 W=0.42 AS=0.15835
+ AD=0.07665 PS=1.395 PD=0.785
M$2 \$13 A0 \$5 VPB sky130_fd_pr__pfet_01v8_hvt L=0.15 W=0.42 AS=0.07665
+ AD=0.1932 PS=0.785 PD=1.34
M$3 \$5 A1 \$14 VPB sky130_fd_pr__pfet_01v8_hvt L=0.15 W=0.42 AS=0.1932
+ AD=0.0441 PS=1.34 PD=0.63
M$4 \$14 \$7 VPWR VPB sky130_fd_pr__pfet_01v8_hvt L=0.15 W=0.42 AS=0.0441
+ AD=0.0693 PS=0.63 PD=0.75
M$5 VPWR S \$7 VPB sky130_fd_pr__pfet_01v8_hvt L=0.15 W=0.42 AS=0.0693
+ AD=0.1176 PS=0.75 PD=1.4
M$6 X \$5 VPWR VPB sky130_fd_pr__pfet_01v8_hvt L=0.15 W=1 AS=0.26 AD=0.15835
+ PS=2.52 PD=1.395
M$7 VGND S \$8 sky130_gnd sky130_fd_pr__nfet_01v8 L=0.15 W=0.42 AS=0.11285
+ AD=0.0693 PS=1.045 PD=0.75
M$8 \$8 A1 \$5 sky130_gnd sky130_fd_pr__nfet_01v8 L=0.15 W=0.42 AS=0.0693
+ AD=0.09975 PS=0.75 PD=0.895
M$9 \$5 A0 \$9 sky130_gnd sky130_fd_pr__nfet_01v8 L=0.15 W=0.42 AS=0.09975
+ AD=0.0693 PS=0.895 PD=0.75
M$10 \$9 \$7 VGND sky130_gnd sky130_fd_pr__nfet_01v8 L=0.15 W=0.42 AS=0.0693
+ AD=0.1449 PS=0.75 PD=1.11
M$11 VGND S \$7 sky130_gnd sky130_fd_pr__nfet_01v8 L=0.15 W=0.42 AS=0.1449
+ AD=0.1092 PS=1.11 PD=1.36
M$12 X \$5 VGND sky130_gnd sky130_fd_pr__nfet_01v8 L=0.15 W=0.65 AS=0.169
+ AD=0.11285 PS=1.82 PD=1.045
.ENDS sky130_fd_sc_hd__mux2_1

.SUBCKT sky130_fd_sc_hd__a211o_1 VPB VPWR X VGND A2 A1 B1 C1 sky130_gnd
M$1 \$6 A2 VPWR VPB sky130_fd_pr__pfet_01v8_hvt L=0.15 W=1 AS=0.265 AD=0.14
+ PS=2.53 PD=1.28
M$2 VPWR A1 \$6 VPB sky130_fd_pr__pfet_01v8_hvt L=0.15 W=1 AS=0.14 AD=0.14
+ PS=1.28 PD=1.28
M$3 \$6 B1 \$12 VPB sky130_fd_pr__pfet_01v8_hvt L=0.15 W=1 AS=0.14 AD=0.155
+ PS=1.28 PD=1.31
M$4 \$12 C1 \$2 VPB sky130_fd_pr__pfet_01v8_hvt L=0.15 W=1 AS=0.155 AD=0.265
+ PS=1.31 PD=2.53
M$5 X \$2 VPWR VPB sky130_fd_pr__pfet_01v8_hvt L=0.15 W=1 AS=0.265 AD=0.265
+ PS=2.53 PD=2.53
M$6 X \$2 VGND sky130_gnd sky130_fd_pr__nfet_01v8 L=0.15 W=0.65 AS=0.17225
+ AD=0.26 PS=1.83 PD=1.45
M$7 VGND A2 \$13 sky130_gnd sky130_fd_pr__nfet_01v8 L=0.15 W=0.65 AS=0.26
+ AD=0.091 PS=1.45 PD=0.93
M$8 \$13 A1 \$2 sky130_gnd sky130_fd_pr__nfet_01v8 L=0.15 W=0.65 AS=0.091
+ AD=0.091 PS=0.93 PD=0.93
M$9 \$2 B1 VGND sky130_gnd sky130_fd_pr__nfet_01v8 L=0.15 W=0.65 AS=0.091
+ AD=0.10075 PS=0.93 PD=0.96
M$10 VGND C1 \$2 sky130_gnd sky130_fd_pr__nfet_01v8 L=0.15 W=0.65 AS=0.10075
+ AD=0.17225 PS=0.96 PD=1.83
.ENDS sky130_fd_sc_hd__a211o_1

.SUBCKT sky130_fd_sc_hd__a311oi_1 VPB A3 VPWR A2 Y VGND B1 C1 A1 sky130_gnd
M$1 VPWR A3 \$4 VPB sky130_fd_pr__pfet_01v8_hvt L=0.15 W=1 AS=0.26 AD=0.1375
+ PS=2.52 PD=1.275
M$2 \$4 A2 VPWR VPB sky130_fd_pr__pfet_01v8_hvt L=0.15 W=1 AS=0.1375 AD=0.14
+ PS=1.275 PD=1.28
M$3 VPWR A1 \$4 VPB sky130_fd_pr__pfet_01v8_hvt L=0.15 W=1 AS=0.14 AD=0.165
+ PS=1.28 PD=1.33
M$4 \$4 B1 \$12 VPB sky130_fd_pr__pfet_01v8_hvt L=0.15 W=1 AS=0.165 AD=0.1725
+ PS=1.33 PD=1.345
M$5 \$12 C1 Y VPB sky130_fd_pr__pfet_01v8_hvt L=0.15 W=1 AS=0.1725 AD=0.26
+ PS=1.345 PD=2.52
M$6 VGND A3 \$14 sky130_gnd sky130_fd_pr__nfet_01v8 L=0.15 W=0.65 AS=0.169
+ AD=0.089375 PS=1.82 PD=0.925
M$7 \$14 A2 \$13 sky130_gnd sky130_fd_pr__nfet_01v8 L=0.15 W=0.65 AS=0.089375
+ AD=0.091 PS=0.925 PD=0.93
M$8 \$13 A1 Y sky130_gnd sky130_fd_pr__nfet_01v8 L=0.15 W=0.65 AS=0.091
+ AD=0.115375 PS=0.93 PD=1.005
M$9 Y B1 VGND sky130_gnd sky130_fd_pr__nfet_01v8 L=0.15 W=0.65 AS=0.115375
+ AD=0.112125 PS=1.005 PD=0.995
M$10 VGND C1 Y sky130_gnd sky130_fd_pr__nfet_01v8 L=0.15 W=0.65 AS=0.112125
+ AD=0.169 PS=0.995 PD=1.82
.ENDS sky130_fd_sc_hd__a311oi_1

.SUBCKT sky130_fd_sc_hd__a32o_1 VGND X A2 A1 B1 A3 B2 VPWR VPB sky130_gnd
M$1 X \$4 VPWR VPB sky130_fd_pr__pfet_01v8_hvt L=0.15 W=1 AS=0.33 AD=0.2425
+ PS=2.66 PD=1.485
M$2 VPWR A3 \$13 VPB sky130_fd_pr__pfet_01v8_hvt L=0.15 W=1 AS=0.2425 AD=0.165
+ PS=1.485 PD=1.33
M$3 \$13 A2 VPWR VPB sky130_fd_pr__pfet_01v8_hvt L=0.15 W=1 AS=0.165 AD=0.225
+ PS=1.33 PD=1.45
M$4 VPWR A1 \$13 VPB sky130_fd_pr__pfet_01v8_hvt L=0.15 W=1 AS=0.225 AD=0.185
+ PS=1.45 PD=1.37
M$5 \$13 B1 \$4 VPB sky130_fd_pr__pfet_01v8_hvt L=0.15 W=1 AS=0.185 AD=0.14
+ PS=1.37 PD=1.28
M$6 \$4 B2 \$13 VPB sky130_fd_pr__pfet_01v8_hvt L=0.15 W=1 AS=0.14 AD=0.265
+ PS=1.28 PD=2.53
M$7 X \$4 VGND sky130_gnd sky130_fd_pr__nfet_01v8 L=0.15 W=0.65 AS=0.2145
+ AD=0.167375 PS=1.96 PD=1.165
M$8 VGND A3 \$11 sky130_gnd sky130_fd_pr__nfet_01v8 L=0.15 W=0.65 AS=0.167375
+ AD=0.0975 PS=1.165 PD=0.95
M$9 \$11 A2 \$12 sky130_gnd sky130_fd_pr__nfet_01v8 L=0.15 W=0.65 AS=0.0975
+ AD=0.14625 PS=0.95 PD=1.1
M$10 \$12 A1 \$4 sky130_gnd sky130_fd_pr__nfet_01v8 L=0.15 W=0.65 AS=0.14625
+ AD=0.143 PS=1.1 PD=1.09
M$11 \$4 B1 \$10 sky130_gnd sky130_fd_pr__nfet_01v8 L=0.15 W=0.65 AS=0.143
+ AD=0.06825 PS=1.09 PD=0.86
M$12 \$10 B2 VGND sky130_gnd sky130_fd_pr__nfet_01v8 L=0.15 W=0.65 AS=0.06825
+ AD=0.17225 PS=0.86 PD=1.83
.ENDS sky130_fd_sc_hd__a32o_1

.SUBCKT sky130_fd_sc_hd__o2bb2a_1 VPB X A1_N VPWR B1 VGND B2 A2_N sky130_gnd
M$1 VPWR A1_N \$3 VPB sky130_fd_pr__pfet_01v8_hvt L=0.15 W=0.42 AS=0.14575
+ AD=0.129 PS=1.335 PD=1.18
M$2 \$3 A2_N VPWR VPB sky130_fd_pr__pfet_01v8_hvt L=0.15 W=0.42 AS=0.129
+ AD=0.20925 PS=1.18 PD=1.345
M$3 VPWR \$3 \$10 VPB sky130_fd_pr__pfet_01v8_hvt L=0.15 W=0.42 AS=0.20925
+ AD=0.0672 PS=1.345 PD=0.74
M$4 \$10 B2 \$13 VPB sky130_fd_pr__pfet_01v8_hvt L=0.15 W=0.42 AS=0.0672
+ AD=0.0441 PS=0.74 PD=0.63
M$5 \$13 B1 VPWR VPB sky130_fd_pr__pfet_01v8_hvt L=0.15 W=0.42 AS=0.0441
+ AD=0.1092 PS=0.63 PD=1.36
M$6 X \$10 VPWR VPB sky130_fd_pr__pfet_01v8_hvt L=0.15 W=1 AS=0.26 AD=0.14575
+ PS=2.52 PD=1.335
M$7 \$10 \$3 \$7 sky130_gnd sky130_fd_pr__nfet_01v8 L=0.15 W=0.42 AS=0.1092
+ AD=0.0567 PS=1.36 PD=0.69
M$8 \$7 B2 VGND sky130_gnd sky130_fd_pr__nfet_01v8 L=0.15 W=0.42 AS=0.0567
+ AD=0.0567 PS=0.69 PD=0.69
M$9 VGND B1 \$7 sky130_gnd sky130_fd_pr__nfet_01v8 L=0.15 W=0.42 AS=0.0567
+ AD=0.1092 PS=0.69 PD=1.36
M$10 VGND A1_N \$14 sky130_gnd sky130_fd_pr__nfet_01v8 L=0.15 W=0.42
+ AS=0.098625 AD=0.06615 PS=0.98 PD=0.735
M$11 \$14 A2_N \$3 sky130_gnd sky130_fd_pr__nfet_01v8 L=0.15 W=0.42 AS=0.06615
+ AD=0.1092 PS=0.735 PD=1.36
M$12 X \$10 VGND sky130_gnd sky130_fd_pr__nfet_01v8 L=0.15 W=0.65 AS=0.169
+ AD=0.098625 PS=1.82 PD=0.98
.ENDS sky130_fd_sc_hd__o2bb2a_1

.SUBCKT sky130_fd_sc_hd__nor4_1 VPB D VGND Y C B VPWR A sky130_gnd
M$1 Y D \$11 VPB sky130_fd_pr__pfet_01v8_hvt L=0.15 W=1 AS=0.26 AD=0.13 PS=2.52
+ PD=1.26
M$2 \$11 C \$10 VPB sky130_fd_pr__pfet_01v8_hvt L=0.15 W=1 AS=0.13 AD=0.19
+ PS=1.26 PD=1.38
M$3 \$10 B \$12 VPB sky130_fd_pr__pfet_01v8_hvt L=0.15 W=1 AS=0.19 AD=0.135
+ PS=1.38 PD=1.27
M$4 \$12 A VPWR VPB sky130_fd_pr__pfet_01v8_hvt L=0.15 W=1 AS=0.135 AD=0.26
+ PS=1.27 PD=2.52
M$5 VGND D Y sky130_gnd sky130_fd_pr__nfet_01v8 L=0.15 W=0.65 AS=0.169
+ AD=0.118625 PS=1.82 PD=1.015
M$6 Y C VGND sky130_gnd sky130_fd_pr__nfet_01v8 L=0.15 W=0.65 AS=0.118625
+ AD=0.089375 PS=1.015 PD=0.925
M$7 VGND B Y sky130_gnd sky130_fd_pr__nfet_01v8 L=0.15 W=0.65 AS=0.089375
+ AD=0.08775 PS=0.925 PD=0.92
M$8 Y A VGND sky130_gnd sky130_fd_pr__nfet_01v8 L=0.15 W=0.65 AS=0.08775
+ AD=0.169 PS=0.92 PD=1.82
.ENDS sky130_fd_sc_hd__nor4_1

.SUBCKT sky130_fd_sc_hd__and3b_1 VPB X VPWR VGND C B A_N sky130_gnd
M$1 \$3 C VPWR VPB sky130_fd_pr__pfet_01v8_hvt L=0.15 W=0.42 AS=0.074375
+ AD=0.142225 PS=0.815 PD=1.335
M$2 \$3 \$8 VPWR VPB sky130_fd_pr__pfet_01v8_hvt L=0.15 W=0.42 AS=0.1085
+ AD=0.0567 PS=1.36 PD=0.69
M$3 \$3 B VPWR VPB sky130_fd_pr__pfet_01v8_hvt L=0.15 W=0.42 AS=0.074375
+ AD=0.0567 PS=0.815 PD=0.69
M$4 VPWR \$3 X VPB sky130_fd_pr__pfet_01v8_hvt L=0.15 W=1 AS=0.142225 AD=0.26
+ PS=1.335 PD=2.52
M$5 VPWR A_N \$8 VPB sky130_fd_pr__pfet_01v8_hvt L=0.15 W=0.42 AS=0.1092
+ AD=0.1087 PS=1.36 PD=1.36
M$6 \$3 \$8 \$12 sky130_gnd sky130_fd_pr__nfet_01v8 L=0.15 W=0.42 AS=0.107825
+ AD=0.0441 PS=1.36 PD=0.63
M$7 \$12 B \$11 sky130_gnd sky130_fd_pr__nfet_01v8 L=0.15 W=0.42 AS=0.0441
+ AD=0.05355 PS=0.63 PD=0.675
M$8 VGND C \$11 sky130_gnd sky130_fd_pr__nfet_01v8 L=0.15 W=0.42 AS=0.122275
+ AD=0.05355 PS=1.08 PD=0.675
M$9 VGND \$3 X sky130_gnd sky130_fd_pr__nfet_01v8 L=0.15 W=0.65 AS=0.122275
+ AD=0.169 PS=1.08 PD=1.82
M$10 VGND A_N \$8 sky130_gnd sky130_fd_pr__nfet_01v8 L=0.15 W=0.42 AS=0.1092
+ AD=0.10785 PS=1.36 PD=1.36
.ENDS sky130_fd_sc_hd__and3b_1

.SUBCKT sky130_fd_sc_hd__nor3b_1 VPB Y VGND B A VPWR C_N sky130_gnd
M$1 VPWR C_N \$8 VPB sky130_fd_pr__pfet_01v8_hvt L=0.15 W=0.42 AS=0.14575
+ AD=0.1092 PS=1.335 PD=1.36
M$2 Y \$8 \$11 VPB sky130_fd_pr__pfet_01v8_hvt L=0.15 W=1 AS=0.32 AD=0.135
+ PS=2.64 PD=1.27
M$3 \$11 B \$10 VPB sky130_fd_pr__pfet_01v8_hvt L=0.15 W=1 AS=0.135 AD=0.135
+ PS=1.27 PD=1.27
M$4 \$10 A VPWR VPB sky130_fd_pr__pfet_01v8_hvt L=0.15 W=1 AS=0.135 AD=0.14575
+ PS=1.27 PD=1.335
M$5 Y \$8 VGND sky130_gnd sky130_fd_pr__nfet_01v8 L=0.15 W=0.65 AS=0.221
+ AD=0.08775 PS=1.98 PD=0.92
M$6 VGND B Y sky130_gnd sky130_fd_pr__nfet_01v8 L=0.15 W=0.65 AS=0.08775
+ AD=0.08775 PS=0.92 PD=0.92
M$7 Y A VGND sky130_gnd sky130_fd_pr__nfet_01v8 L=0.15 W=0.65 AS=0.08775
+ AD=0.10025 PS=0.92 PD=0.985
M$8 VGND C_N \$8 sky130_gnd sky130_fd_pr__nfet_01v8 L=0.15 W=0.42 AS=0.10025
+ AD=0.1092 PS=0.985 PD=1.36
.ENDS sky130_fd_sc_hd__nor3b_1

.SUBCKT sky130_fd_sc_hd__o31a_1 VPB X VPWR VGND A1 A2 A3 B1 sky130_gnd
M$1 X \$9 VPWR VPB sky130_fd_pr__pfet_01v8_hvt L=0.15 W=1 AS=0.36 AD=0.195
+ PS=2.72 PD=1.39
M$2 VPWR A1 \$13 VPB sky130_fd_pr__pfet_01v8_hvt L=0.15 W=1 AS=0.195 AD=0.135
+ PS=1.39 PD=1.27
M$3 \$13 A2 \$12 VPB sky130_fd_pr__pfet_01v8_hvt L=0.15 W=1 AS=0.135 AD=0.165
+ PS=1.27 PD=1.33
M$4 \$12 A3 \$9 VPB sky130_fd_pr__pfet_01v8_hvt L=0.15 W=1 AS=0.165 AD=0.2125
+ PS=1.33 PD=1.425
M$5 \$9 B1 VPWR VPB sky130_fd_pr__pfet_01v8_hvt L=0.15 W=1 AS=0.2125 AD=0.345
+ PS=1.425 PD=2.69
M$6 X \$9 VGND sky130_gnd sky130_fd_pr__nfet_01v8 L=0.15 W=0.65 AS=0.234
+ AD=0.12675 PS=2.02 PD=1.04
M$7 VGND A1 \$6 sky130_gnd sky130_fd_pr__nfet_01v8 L=0.15 W=0.65 AS=0.12675
+ AD=0.08775 PS=1.04 PD=0.92
M$8 \$6 A2 VGND sky130_gnd sky130_fd_pr__nfet_01v8 L=0.15 W=0.65 AS=0.08775
+ AD=0.10725 PS=0.92 PD=0.98
M$9 VGND A3 \$6 sky130_gnd sky130_fd_pr__nfet_01v8 L=0.15 W=0.65 AS=0.10725
+ AD=0.10725 PS=0.98 PD=0.98
M$10 \$6 B1 \$9 sky130_gnd sky130_fd_pr__nfet_01v8 L=0.15 W=0.65 AS=0.10725
+ AD=0.2015 PS=0.98 PD=1.92
.ENDS sky130_fd_sc_hd__o31a_1

.SUBCKT sky130_fd_sc_hd__a31oi_1 VPB A3 VGND A2 VPWR A1 Y B1 sky130_gnd
M$1 VPWR A3 \$4 VPB sky130_fd_pr__pfet_01v8_hvt L=0.15 W=1 AS=0.26 AD=0.135
+ PS=2.52 PD=1.27
M$2 \$4 A2 VPWR VPB sky130_fd_pr__pfet_01v8_hvt L=0.15 W=1 AS=0.135 AD=0.1525
+ PS=1.27 PD=1.305
M$3 VPWR A1 \$4 VPB sky130_fd_pr__pfet_01v8_hvt L=0.15 W=1 AS=0.1525 AD=0.1625
+ PS=1.305 PD=1.325
M$4 \$4 B1 Y VPB sky130_fd_pr__pfet_01v8_hvt L=0.15 W=1 AS=0.1625 AD=0.27
+ PS=1.325 PD=2.54
M$5 VGND A3 \$12 sky130_gnd sky130_fd_pr__nfet_01v8 L=0.15 W=0.65 AS=0.169
+ AD=0.06825 PS=1.82 PD=0.86
M$6 \$12 A2 \$11 sky130_gnd sky130_fd_pr__nfet_01v8 L=0.15 W=0.65 AS=0.06825
+ AD=0.118625 PS=0.86 PD=1.015
M$7 \$11 A1 Y sky130_gnd sky130_fd_pr__nfet_01v8 L=0.15 W=0.65 AS=0.118625
+ AD=0.105625 PS=1.015 PD=0.975
M$8 Y B1 VGND sky130_gnd sky130_fd_pr__nfet_01v8 L=0.15 W=0.65 AS=0.105625
+ AD=0.1755 PS=0.975 PD=1.84
.ENDS sky130_fd_sc_hd__a31oi_1

.SUBCKT sky130_fd_sc_hd__a211oi_1 VPB C1 VGND B1 Y A1 A2 VPWR sky130_gnd
M$1 \$6 A2 VPWR VPB sky130_fd_pr__pfet_01v8_hvt L=0.15 W=1 AS=0.265 AD=0.14
+ PS=2.53 PD=1.28
M$2 VPWR A1 \$6 VPB sky130_fd_pr__pfet_01v8_hvt L=0.15 W=1 AS=0.14 AD=0.14
+ PS=1.28 PD=1.28
M$3 \$6 B1 \$11 VPB sky130_fd_pr__pfet_01v8_hvt L=0.15 W=1 AS=0.14 AD=0.155
+ PS=1.28 PD=1.31
M$4 \$11 C1 Y VPB sky130_fd_pr__pfet_01v8_hvt L=0.15 W=1 AS=0.155 AD=0.265
+ PS=1.31 PD=2.53
M$5 VGND A2 \$12 sky130_gnd sky130_fd_pr__nfet_01v8 L=0.15 W=0.65 AS=0.2665
+ AD=0.091 PS=2.12 PD=0.93
M$6 \$12 A1 Y sky130_gnd sky130_fd_pr__nfet_01v8 L=0.15 W=0.65 AS=0.091
+ AD=0.091 PS=0.93 PD=0.93
M$7 Y B1 VGND sky130_gnd sky130_fd_pr__nfet_01v8 L=0.15 W=0.65 AS=0.091
+ AD=0.10075 PS=0.93 PD=0.96
M$8 VGND C1 Y sky130_gnd sky130_fd_pr__nfet_01v8 L=0.15 W=0.65 AS=0.10075
+ AD=0.17225 PS=0.96 PD=1.83
.ENDS sky130_fd_sc_hd__a211oi_1

.SUBCKT sky130_fd_sc_hd__o211a_1 VPB A2 VGND A1 C1 VPWR B1 X sky130_gnd
M$1 VPWR A1 \$12 VPB sky130_fd_pr__pfet_01v8_hvt L=0.15 W=1 AS=0.26 AD=0.1625
+ PS=2.52 PD=1.325
M$2 \$12 A2 \$2 VPB sky130_fd_pr__pfet_01v8_hvt L=0.15 W=1 AS=0.1625 AD=0.22
+ PS=1.325 PD=1.44
M$3 \$2 B1 VPWR VPB sky130_fd_pr__pfet_01v8_hvt L=0.15 W=1 AS=0.22 AD=0.175
+ PS=1.44 PD=1.35
M$4 VPWR C1 \$2 VPB sky130_fd_pr__pfet_01v8_hvt L=0.15 W=1 AS=0.175 AD=0.3
+ PS=1.35 PD=2.6
M$5 X \$2 VPWR VPB sky130_fd_pr__pfet_01v8_hvt L=0.15 W=1 AS=0.26 AD=0.26
+ PS=2.52 PD=2.52
M$6 \$3 A1 VGND sky130_gnd sky130_fd_pr__nfet_01v8 L=0.15 W=0.65 AS=0.169
+ AD=0.105625 PS=1.82 PD=0.975
M$7 VGND A2 \$3 sky130_gnd sky130_fd_pr__nfet_01v8 L=0.15 W=0.65 AS=0.105625
+ AD=0.143 PS=0.975 PD=1.09
M$8 \$3 B1 \$13 sky130_gnd sky130_fd_pr__nfet_01v8 L=0.15 W=0.65 AS=0.143
+ AD=0.11375 PS=1.09 PD=1
M$9 \$13 C1 \$2 sky130_gnd sky130_fd_pr__nfet_01v8 L=0.15 W=0.65 AS=0.11375
+ AD=0.195 PS=1 PD=1.9
M$10 X \$2 VGND sky130_gnd sky130_fd_pr__nfet_01v8 L=0.15 W=0.65 AS=0.169
+ AD=0.169 PS=1.82 PD=1.82
.ENDS sky130_fd_sc_hd__o211a_1

.SUBCKT sky130_fd_sc_hd__a21o_1 VPB VGND A2 VPWR A1 B1 X sky130_gnd
M$1 \$7 B1 \$3 VPB sky130_fd_pr__pfet_01v8_hvt L=0.15 W=1 AS=0.26 AD=0.1375
+ PS=2.52 PD=1.275
M$2 \$3 A1 VPWR VPB sky130_fd_pr__pfet_01v8_hvt L=0.15 W=1 AS=0.1375 AD=0.14
+ PS=1.275 PD=1.28
M$3 VPWR A2 \$3 VPB sky130_fd_pr__pfet_01v8_hvt L=0.15 W=1 AS=0.14 AD=0.265
+ PS=1.28 PD=2.53
M$4 X \$7 VPWR VPB sky130_fd_pr__pfet_01v8_hvt L=0.15 W=1 AS=0.26 AD=0.26
+ PS=2.52 PD=2.52
M$5 X \$7 VGND sky130_gnd sky130_fd_pr__nfet_01v8 L=0.15 W=0.65 AS=0.169
+ AD=0.25675 PS=1.82 PD=1.44
M$6 VGND B1 \$7 sky130_gnd sky130_fd_pr__nfet_01v8 L=0.15 W=0.65 AS=0.25675
+ AD=0.089375 PS=1.44 PD=0.925
M$7 \$7 A1 \$11 sky130_gnd sky130_fd_pr__nfet_01v8 L=0.15 W=0.65 AS=0.089375
+ AD=0.091 PS=0.925 PD=0.93
M$8 \$11 A2 VGND sky130_gnd sky130_fd_pr__nfet_01v8 L=0.15 W=0.65 AS=0.091
+ AD=0.17225 PS=0.93 PD=1.83
.ENDS sky130_fd_sc_hd__a21o_1

.SUBCKT sky130_fd_sc_hd__mux2i_1 VPB A0 Y A1 VGND S VPWR sky130_gnd
M$1 \$8 S VPWR VPB sky130_fd_pr__pfet_01v8_hvt L=0.15 W=1 AS=0.29 AD=0.26
+ PS=2.58 PD=2.52
M$2 \$4 A0 Y VPB sky130_fd_pr__pfet_01v8_hvt L=0.15 W=1 AS=0.28 AD=0.1525
+ PS=2.56 PD=1.305
M$3 Y A1 \$13 VPB sky130_fd_pr__pfet_01v8_hvt L=0.15 W=1 AS=0.1525 AD=0.1975
+ PS=1.305 PD=1.395
M$4 \$13 \$8 VPWR VPB sky130_fd_pr__pfet_01v8_hvt L=0.15 W=1 AS=0.1975 AD=0.3
+ PS=1.395 PD=1.6
M$5 VPWR S \$4 VPB sky130_fd_pr__pfet_01v8_hvt L=0.15 W=1 AS=0.3 AD=0.26 PS=1.6
+ PD=2.52
M$6 \$8 S VGND sky130_gnd sky130_fd_pr__nfet_01v8 L=0.15 W=0.65 AS=0.169
+ AD=0.169 PS=1.82 PD=1.82
M$7 \$2 A0 Y sky130_gnd sky130_fd_pr__nfet_01v8 L=0.15 W=0.65 AS=0.169
+ AD=0.08775 PS=1.82 PD=0.92
M$8 Y A1 \$7 sky130_gnd sky130_fd_pr__nfet_01v8 L=0.15 W=0.65 AS=0.08775
+ AD=0.182 PS=0.92 PD=1.86
M$9 \$2 \$8 VGND sky130_gnd sky130_fd_pr__nfet_01v8 L=0.15 W=0.65 AS=0.169
+ AD=0.08775 PS=1.82 PD=0.92
M$10 VGND S \$7 sky130_gnd sky130_fd_pr__nfet_01v8 L=0.15 W=0.65 AS=0.08775
+ AD=0.169 PS=0.92 PD=1.82
.ENDS sky130_fd_sc_hd__mux2i_1

.SUBCKT sky130_fd_sc_hd__o22ai_1 VPB B1 VPWR Y B2 A2 A1 VGND sky130_gnd
M$1 VPWR B1 \$12 VPB sky130_fd_pr__pfet_01v8_hvt L=0.15 W=1 AS=0.26 AD=0.1125
+ PS=2.52 PD=1.225
M$2 \$12 B2 Y VPB sky130_fd_pr__pfet_01v8_hvt L=0.15 W=1 AS=0.1125 AD=0.2325
+ PS=1.225 PD=1.465
M$3 Y A2 \$11 VPB sky130_fd_pr__pfet_01v8_hvt L=0.15 W=1 AS=0.2325 AD=0.105
+ PS=1.465 PD=1.21
M$4 \$11 A1 VPWR VPB sky130_fd_pr__pfet_01v8_hvt L=0.15 W=1 AS=0.105 AD=0.27
+ PS=1.21 PD=2.54
M$5 \$4 B1 Y sky130_gnd sky130_fd_pr__nfet_01v8 L=0.15 W=0.65 AS=0.169
+ AD=0.092625 PS=1.82 PD=0.935
M$6 Y B2 \$4 sky130_gnd sky130_fd_pr__nfet_01v8 L=0.15 W=0.65 AS=0.092625
+ AD=0.115375 PS=0.935 PD=1.005
M$7 \$4 A2 VGND sky130_gnd sky130_fd_pr__nfet_01v8 L=0.15 W=0.65 AS=0.115375
+ AD=0.08775 PS=1.005 PD=0.92
M$8 VGND A1 \$4 sky130_gnd sky130_fd_pr__nfet_01v8 L=0.15 W=0.65 AS=0.08775
+ AD=0.169 PS=0.92 PD=1.82
.ENDS sky130_fd_sc_hd__o22ai_1

.SUBCKT sky130_fd_sc_hd__nand4b_1 VPB A_N Y B C D VGND VPWR sky130_gnd
M$1 \$3 A_N VPWR VPB sky130_fd_pr__pfet_01v8_hvt L=0.15 W=0.42 AS=0.1092
+ AD=0.14575 PS=1.36 PD=1.335
M$2 VPWR D Y VPB sky130_fd_pr__pfet_01v8_hvt L=0.15 W=1 AS=0.14575 AD=0.135
+ PS=1.335 PD=1.27
M$3 Y C VPWR VPB sky130_fd_pr__pfet_01v8_hvt L=0.15 W=1 AS=0.135 AD=0.1925
+ PS=1.27 PD=1.385
M$4 VPWR B Y VPB sky130_fd_pr__pfet_01v8_hvt L=0.15 W=1 AS=0.1925 AD=0.195
+ PS=1.385 PD=1.39
M$5 Y \$3 VPWR VPB sky130_fd_pr__pfet_01v8_hvt L=0.15 W=1 AS=0.195 AD=0.28
+ PS=1.39 PD=2.56
M$6 VGND A_N \$3 sky130_gnd sky130_fd_pr__nfet_01v8 L=0.15 W=0.42 AS=0.118125
+ AD=0.1113 PS=1.04 PD=1.37
M$7 VGND D \$11 sky130_gnd sky130_fd_pr__nfet_01v8 L=0.15 W=0.65 AS=0.118125
+ AD=0.08775 PS=1.04 PD=0.92
M$8 \$11 C \$13 sky130_gnd sky130_fd_pr__nfet_01v8 L=0.15 W=0.65 AS=0.08775
+ AD=0.125125 PS=0.92 PD=1.035
M$9 \$13 B \$12 sky130_gnd sky130_fd_pr__nfet_01v8 L=0.15 W=0.65 AS=0.125125
+ AD=0.12675 PS=1.035 PD=1.04
M$10 \$12 \$3 Y sky130_gnd sky130_fd_pr__nfet_01v8 L=0.15 W=0.65 AS=0.12675
+ AD=0.2275 PS=1.04 PD=2
.ENDS sky130_fd_sc_hd__nand4b_1

.SUBCKT sky130_fd_sc_hd__o41a_1 VGND X B1 A4 A3 A2 A1 VPWR VPB sky130_gnd
M$1 X \$4 VPWR VPB sky130_fd_pr__pfet_01v8_hvt L=0.15 W=1 AS=0.425 AD=0.135
+ PS=2.85 PD=1.27
M$2 VPWR B1 \$4 VPB sky130_fd_pr__pfet_01v8_hvt L=0.15 W=1 AS=0.135 AD=0.26
+ PS=1.27 PD=1.52
M$3 \$4 A4 \$13 VPB sky130_fd_pr__pfet_01v8_hvt L=0.15 W=1 AS=0.26 AD=0.22
+ PS=1.52 PD=1.44
M$4 \$13 A3 \$15 VPB sky130_fd_pr__pfet_01v8_hvt L=0.15 W=1 AS=0.22 AD=0.195
+ PS=1.44 PD=1.39
M$5 \$15 A2 \$14 VPB sky130_fd_pr__pfet_01v8_hvt L=0.15 W=1 AS=0.195 AD=0.195
+ PS=1.39 PD=1.39
M$6 \$14 A1 VPWR VPB sky130_fd_pr__pfet_01v8_hvt L=0.15 W=1 AS=0.195 AD=0.28
+ PS=1.39 PD=2.56
M$7 \$4 B1 \$5 sky130_gnd sky130_fd_pr__nfet_01v8 L=0.15 W=0.65 AS=0.169
+ AD=0.08775 PS=1.82 PD=0.92
M$8 \$5 A4 VGND sky130_gnd sky130_fd_pr__nfet_01v8 L=0.15 W=0.65 AS=0.08775
+ AD=0.1235 PS=0.92 PD=1.03
M$9 VGND A3 \$5 sky130_gnd sky130_fd_pr__nfet_01v8 L=0.15 W=0.65 AS=0.1235
+ AD=0.12675 PS=1.03 PD=1.04
M$10 \$5 A2 VGND sky130_gnd sky130_fd_pr__nfet_01v8 L=0.15 W=0.65 AS=0.12675
+ AD=0.12675 PS=1.04 PD=1.04
M$11 VGND A1 \$5 sky130_gnd sky130_fd_pr__nfet_01v8 L=0.15 W=0.65 AS=0.12675
+ AD=0.195 PS=1.04 PD=1.9
M$12 X \$4 VGND sky130_gnd sky130_fd_pr__nfet_01v8 L=0.15 W=0.65 AS=0.247
+ AD=0.169 PS=2.06 PD=1.82
.ENDS sky130_fd_sc_hd__o41a_1

.SUBCKT sky130_fd_sc_hd__or3b_1 VPB X VPWR VGND A B C_N sky130_gnd
M$1 \$6 \$8 \$11 VPB sky130_fd_pr__pfet_01v8_hvt L=0.15 W=0.42 AS=0.1092
+ AD=0.0441 PS=1.36 PD=0.63
M$2 \$11 B \$12 VPB sky130_fd_pr__pfet_01v8_hvt L=0.15 W=0.42 AS=0.0441
+ AD=0.06825 PS=0.63 PD=0.745
M$3 \$12 A VPWR VPB sky130_fd_pr__pfet_01v8_hvt L=0.15 W=0.42 AS=0.06825
+ AD=0.14825 PS=0.745 PD=1.34
M$4 VPWR \$6 X VPB sky130_fd_pr__pfet_01v8_hvt L=0.15 W=1 AS=0.14825 AD=0.275
+ PS=1.34 PD=2.55
M$5 VPWR C_N \$8 VPB sky130_fd_pr__pfet_01v8_hvt L=0.15 W=0.42 AS=0.1092
+ AD=0.1092 PS=1.36 PD=1.36
M$6 \$6 \$8 VGND sky130_gnd sky130_fd_pr__nfet_01v8 L=0.15 W=0.42 AS=0.1092
+ AD=0.0567 PS=1.36 PD=0.69
M$7 VGND B \$6 sky130_gnd sky130_fd_pr__nfet_01v8 L=0.15 W=0.42 AS=0.0567
+ AD=0.0567 PS=0.69 PD=0.69
M$8 VGND A \$6 sky130_gnd sky130_fd_pr__nfet_01v8 L=0.15 W=0.42 AS=0.10025
+ AD=0.0567 PS=0.985 PD=0.69
M$9 VGND \$6 X sky130_gnd sky130_fd_pr__nfet_01v8 L=0.15 W=0.65 AS=0.10025
+ AD=0.17875 PS=0.985 PD=1.85
M$10 VGND C_N \$8 sky130_gnd sky130_fd_pr__nfet_01v8 L=0.15 W=0.42 AS=0.1092
+ AD=0.1092 PS=1.36 PD=1.36
.ENDS sky130_fd_sc_hd__or3b_1

.SUBCKT sky130_fd_sc_hd__nand4_1 VPB D VPWR A Y B C VGND sky130_gnd
M$1 VPWR D Y VPB sky130_fd_pr__pfet_01v8_hvt L=0.15 W=1 AS=0.26 AD=0.135
+ PS=2.52 PD=1.27
M$2 Y C VPWR VPB sky130_fd_pr__pfet_01v8_hvt L=0.15 W=1 AS=0.135 AD=0.135
+ PS=1.27 PD=1.27
M$3 VPWR B Y VPB sky130_fd_pr__pfet_01v8_hvt L=0.15 W=1 AS=0.135 AD=0.165
+ PS=1.27 PD=1.33
M$4 Y A VPWR VPB sky130_fd_pr__pfet_01v8_hvt L=0.15 W=1 AS=0.165 AD=0.3 PS=1.33
+ PD=2.6
M$5 VGND D \$12 sky130_gnd sky130_fd_pr__nfet_01v8 L=0.15 W=0.65 AS=0.169
+ AD=0.08775 PS=1.82 PD=0.92
M$6 \$12 C \$11 sky130_gnd sky130_fd_pr__nfet_01v8 L=0.15 W=0.65 AS=0.08775
+ AD=0.08775 PS=0.92 PD=0.92
M$7 \$11 B \$10 sky130_gnd sky130_fd_pr__nfet_01v8 L=0.15 W=0.65 AS=0.08775
+ AD=0.10725 PS=0.92 PD=0.98
M$8 \$10 A Y sky130_gnd sky130_fd_pr__nfet_01v8 L=0.15 W=0.65 AS=0.10725
+ AD=0.195 PS=0.98 PD=1.9
.ENDS sky130_fd_sc_hd__nand4_1

.SUBCKT sky130_fd_sc_hd__nor4b_1 VPB VGND Y C B A VPWR D_N sky130_gnd
M$1 VPWR D_N \$9 VPB sky130_fd_pr__pfet_01v8_hvt L=0.15 W=0.42 AS=0.14575
+ AD=0.1092 PS=1.335 PD=1.36
M$2 Y \$9 \$13 VPB sky130_fd_pr__pfet_01v8_hvt L=0.15 W=1 AS=0.52 AD=0.135
+ PS=3.04 PD=1.27
M$3 \$13 C \$12 VPB sky130_fd_pr__pfet_01v8_hvt L=0.15 W=1 AS=0.135 AD=0.165
+ PS=1.27 PD=1.33
M$4 \$12 B \$11 VPB sky130_fd_pr__pfet_01v8_hvt L=0.15 W=1 AS=0.165 AD=0.135
+ PS=1.33 PD=1.27
M$5 \$11 A VPWR VPB sky130_fd_pr__pfet_01v8_hvt L=0.15 W=1 AS=0.135 AD=0.14575
+ PS=1.27 PD=1.335
M$6 VGND \$9 Y sky130_gnd sky130_fd_pr__nfet_01v8 L=0.15 W=0.65 AS=0.182
+ AD=0.08775 PS=1.86 PD=0.92
M$7 Y C VGND sky130_gnd sky130_fd_pr__nfet_01v8 L=0.15 W=0.65 AS=0.08775
+ AD=0.10725 PS=0.92 PD=0.98
M$8 VGND B Y sky130_gnd sky130_fd_pr__nfet_01v8 L=0.15 W=0.65 AS=0.10725
+ AD=0.08775 PS=0.98 PD=0.92
M$9 Y A VGND sky130_gnd sky130_fd_pr__nfet_01v8 L=0.15 W=0.65 AS=0.08775
+ AD=0.10025 PS=0.92 PD=0.985
M$10 VGND D_N \$9 sky130_gnd sky130_fd_pr__nfet_01v8 L=0.15 W=0.42 AS=0.10025
+ AD=0.1092 PS=0.985 PD=1.36
.ENDS sky130_fd_sc_hd__nor4b_1

.SUBCKT sky130_fd_sc_hd__nand2_2 VPB VPWR Y B VGND A sky130_gnd
M$1 VPWR B Y VPB sky130_fd_pr__pfet_01v8_hvt L=0.15 W=1 AS=0.26 AD=0.135
+ PS=2.52 PD=1.27
M$2 Y B VPWR VPB sky130_fd_pr__pfet_01v8_hvt L=0.15 W=1 AS=0.135 AD=0.135
+ PS=1.27 PD=1.27
M$3 VPWR A Y VPB sky130_fd_pr__pfet_01v8_hvt L=0.15 W=1 AS=0.135 AD=0.135
+ PS=1.27 PD=1.27
M$4 Y A VPWR VPB sky130_fd_pr__pfet_01v8_hvt L=0.15 W=1 AS=0.135 AD=0.26
+ PS=1.27 PD=2.52
M$5 \$3 B VGND sky130_gnd sky130_fd_pr__nfet_01v8 L=0.15 W=0.65 AS=0.169
+ AD=0.08775 PS=1.82 PD=0.92
M$6 VGND B \$3 sky130_gnd sky130_fd_pr__nfet_01v8 L=0.15 W=0.65 AS=0.08775
+ AD=0.08775 PS=0.92 PD=0.92
M$7 \$3 A Y sky130_gnd sky130_fd_pr__nfet_01v8 L=0.15 W=0.65 AS=0.08775
+ AD=0.08775 PS=0.92 PD=0.92
M$8 Y A \$3 sky130_gnd sky130_fd_pr__nfet_01v8 L=0.15 W=0.65 AS=0.08775
+ AD=0.169 PS=0.92 PD=1.82
.ENDS sky130_fd_sc_hd__nand2_2

.SUBCKT sky130_fd_sc_hd__buf_2 VPB VGND X VPWR A sky130_gnd
M$1 VPWR A \$3 VPB sky130_fd_pr__pfet_01v8_hvt L=0.15 W=0.64 AS=0.149 AD=0.1664
+ PS=1.325 PD=1.8
M$2 VPWR \$3 X VPB sky130_fd_pr__pfet_01v8_hvt L=0.15 W=1 AS=0.149 AD=0.135
+ PS=1.325 PD=1.27
M$3 X \$3 VPWR VPB sky130_fd_pr__pfet_01v8_hvt L=0.15 W=1 AS=0.135 AD=0.265
+ PS=1.27 PD=2.53
M$4 \$3 A VGND sky130_gnd sky130_fd_pr__nfet_01v8 L=0.15 W=0.42 AS=0.1092
+ AD=0.097 PS=1.36 PD=0.975
M$5 VGND \$3 X sky130_gnd sky130_fd_pr__nfet_01v8 L=0.15 W=0.65 AS=0.097
+ AD=0.08775 PS=0.975 PD=0.92
M$6 X \$3 VGND sky130_gnd sky130_fd_pr__nfet_01v8 L=0.15 W=0.65 AS=0.08775
+ AD=0.17225 PS=0.92 PD=1.83
.ENDS sky130_fd_sc_hd__buf_2

.SUBCKT sky130_fd_sc_hd__o2111ai_1 VPB VPWR D1 Y C1 B1 A1 A2 VGND sky130_gnd
M$1 VPWR D1 Y VPB sky130_fd_pr__pfet_01v8_hvt L=0.15 W=1 AS=0.265 AD=0.14
+ PS=2.53 PD=1.28
M$2 Y C1 VPWR VPB sky130_fd_pr__pfet_01v8_hvt L=0.15 W=1 AS=0.14 AD=0.195
+ PS=1.28 PD=1.39
M$3 VPWR B1 Y VPB sky130_fd_pr__pfet_01v8_hvt L=0.15 W=1 AS=0.195 AD=0.2025
+ PS=1.39 PD=1.405
M$4 Y A2 \$12 VPB sky130_fd_pr__pfet_01v8_hvt L=0.15 W=1 AS=0.2025 AD=0.195
+ PS=1.405 PD=1.39
M$5 \$12 A1 VPWR VPB sky130_fd_pr__pfet_01v8_hvt L=0.15 W=1 AS=0.195 AD=0.265
+ PS=1.39 PD=2.53
M$6 Y D1 \$14 sky130_gnd sky130_fd_pr__nfet_01v8 L=0.15 W=0.65 AS=0.17225
+ AD=0.06825 PS=1.83 PD=0.86
M$7 \$14 C1 \$13 sky130_gnd sky130_fd_pr__nfet_01v8 L=0.15 W=0.65 AS=0.06825
+ AD=0.12675 PS=0.86 PD=1.04
M$8 \$13 B1 \$2 sky130_gnd sky130_fd_pr__nfet_01v8 L=0.15 W=0.65 AS=0.12675
+ AD=0.131625 PS=1.04 PD=1.055
M$9 \$2 A2 VGND sky130_gnd sky130_fd_pr__nfet_01v8 L=0.15 W=0.65 AS=0.131625
+ AD=0.12675 PS=1.055 PD=1.04
M$10 VGND A1 \$2 sky130_gnd sky130_fd_pr__nfet_01v8 L=0.15 W=0.65 AS=0.12675
+ AD=0.17225 PS=1.04 PD=1.83
.ENDS sky130_fd_sc_hd__o2111ai_1

.SUBCKT sky130_fd_sc_hd__and4_1 VPB VGND VPWR X D C B A sky130_gnd
M$1 VPWR A \$5 VPB sky130_fd_pr__pfet_01v8_hvt L=0.15 W=0.42 AS=0.1092
+ AD=0.0735 PS=1.36 PD=0.77
M$2 \$5 B VPWR VPB sky130_fd_pr__pfet_01v8_hvt L=0.15 W=0.42 AS=0.0735
+ AD=0.0777 PS=0.77 PD=0.79
M$3 VPWR C \$5 VPB sky130_fd_pr__pfet_01v8_hvt L=0.15 W=0.42 AS=0.0777
+ AD=0.0588 PS=0.79 PD=0.7
M$4 VPWR D \$5 VPB sky130_fd_pr__pfet_01v8_hvt L=0.15 W=0.42 AS=0.31245
+ AD=0.0588 PS=1.68 PD=0.7
M$5 VPWR \$5 X VPB sky130_fd_pr__pfet_01v8_hvt L=0.15 W=1 AS=0.31245 AD=0.26
+ PS=1.68 PD=2.52
M$6 \$5 A \$13 sky130_gnd sky130_fd_pr__nfet_01v8 L=0.15 W=0.42 AS=0.1092
+ AD=0.0609 PS=1.36 PD=0.71
M$7 \$13 B \$11 sky130_gnd sky130_fd_pr__nfet_01v8 L=0.15 W=0.42 AS=0.0609
+ AD=0.0798 PS=0.71 PD=0.8
M$8 \$11 C \$12 sky130_gnd sky130_fd_pr__nfet_01v8 L=0.15 W=0.42 AS=0.0798
+ AD=0.0693 PS=0.8 PD=0.75
M$9 \$12 D VGND sky130_gnd sky130_fd_pr__nfet_01v8 L=0.15 W=0.42 AS=0.0693
+ AD=0.196275 PS=0.75 PD=1.33
M$10 VGND \$5 X sky130_gnd sky130_fd_pr__nfet_01v8 L=0.15 W=0.65 AS=0.196275
+ AD=0.169 PS=1.33 PD=1.82
.ENDS sky130_fd_sc_hd__and4_1

.SUBCKT sky130_fd_sc_hd__a31o_1 VPB X VPWR A3 A2 A1 VGND B1 sky130_gnd
M$1 X \$8 VPWR VPB sky130_fd_pr__pfet_01v8_hvt L=0.15 W=1 AS=0.265 AD=0.1725
+ PS=2.53 PD=1.345
M$2 VPWR A3 \$5 VPB sky130_fd_pr__pfet_01v8_hvt L=0.15 W=1 AS=0.1725 AD=0.16
+ PS=1.345 PD=1.32
M$3 \$5 A2 VPWR VPB sky130_fd_pr__pfet_01v8_hvt L=0.15 W=1 AS=0.16 AD=0.165
+ PS=1.32 PD=1.33
M$4 VPWR A1 \$5 VPB sky130_fd_pr__pfet_01v8_hvt L=0.15 W=1 AS=0.165 AD=0.165
+ PS=1.33 PD=1.33
M$5 \$5 B1 \$8 VPB sky130_fd_pr__pfet_01v8_hvt L=0.15 W=1 AS=0.165 AD=0.32
+ PS=1.33 PD=2.64
M$6 X \$8 VGND sky130_gnd sky130_fd_pr__nfet_01v8 L=0.15 W=0.65 AS=0.17225
+ AD=0.112125 PS=1.83 PD=0.995
M$7 VGND A3 \$13 sky130_gnd sky130_fd_pr__nfet_01v8 L=0.15 W=0.65 AS=0.112125
+ AD=0.104 PS=0.995 PD=0.97
M$8 \$13 A2 \$12 sky130_gnd sky130_fd_pr__nfet_01v8 L=0.15 W=0.65 AS=0.104
+ AD=0.10725 PS=0.97 PD=0.98
M$9 \$12 A1 \$8 sky130_gnd sky130_fd_pr__nfet_01v8 L=0.15 W=0.65 AS=0.10725
+ AD=0.10725 PS=0.98 PD=0.98
M$10 \$8 B1 VGND sky130_gnd sky130_fd_pr__nfet_01v8 L=0.15 W=0.65 AS=0.10725
+ AD=0.208 PS=0.98 PD=1.94
.ENDS sky130_fd_sc_hd__a31o_1

.SUBCKT sky130_fd_sc_hd__o211ai_1 VPB B1 Y VPWR A1 VGND A2 C1 sky130_gnd
M$1 VPWR A1 \$11 VPB sky130_fd_pr__pfet_01v8_hvt L=0.15 W=1 AS=0.265 AD=0.105
+ PS=2.53 PD=1.21
M$2 \$11 A2 Y VPB sky130_fd_pr__pfet_01v8_hvt L=0.15 W=1 AS=0.105 AD=0.195
+ PS=1.21 PD=1.39
M$3 Y B1 VPWR VPB sky130_fd_pr__pfet_01v8_hvt L=0.15 W=1 AS=0.195 AD=0.195
+ PS=1.39 PD=1.39
M$4 VPWR C1 Y VPB sky130_fd_pr__pfet_01v8_hvt L=0.15 W=1 AS=0.195 AD=0.635
+ PS=1.39 PD=3.27
M$5 \$2 A1 VGND sky130_gnd sky130_fd_pr__nfet_01v8 L=0.15 W=0.65 AS=0.17225
+ AD=0.12675 PS=1.83 PD=1.04
M$6 VGND A2 \$2 sky130_gnd sky130_fd_pr__nfet_01v8 L=0.15 W=0.65 AS=0.12675
+ AD=0.12675 PS=1.04 PD=1.04
M$7 \$2 B1 \$12 sky130_gnd sky130_fd_pr__nfet_01v8 L=0.15 W=0.65 AS=0.12675
+ AD=0.06825 PS=1.04 PD=0.86
M$8 \$12 C1 Y sky130_gnd sky130_fd_pr__nfet_01v8 L=0.15 W=0.65 AS=0.06825
+ AD=0.39325 PS=0.86 PD=2.51
.ENDS sky130_fd_sc_hd__o211ai_1

.SUBCKT sky130_fd_sc_hd__nor4bb_1 VPB C_N VGND D_N Y B A VPWR sky130_gnd
M$1 Y \$5 \$14 VPB sky130_fd_pr__pfet_01v8_hvt L=0.15 W=1 AS=0.2559 AD=0.135
+ PS=2.52 PD=1.27
M$2 \$14 \$7 \$13 VPB sky130_fd_pr__pfet_01v8_hvt L=0.15 W=1 AS=0.135 AD=0.165
+ PS=1.27 PD=1.33
M$3 \$13 B \$12 VPB sky130_fd_pr__pfet_01v8_hvt L=0.15 W=1 AS=0.165 AD=0.135
+ PS=1.33 PD=1.27
M$4 \$12 A VPWR VPB sky130_fd_pr__pfet_01v8_hvt L=0.15 W=1 AS=0.135 AD=0.26
+ PS=1.27 PD=2.52
M$5 VPWR D_N \$5 VPB sky130_fd_pr__pfet_01v8_hvt L=0.15 W=0.42 AS=0.1226125
+ AD=0.1085 PS=1.32 PD=1.36
M$6 VPWR C_N \$7 VPB sky130_fd_pr__pfet_01v8_hvt L=0.15 W=0.42 AS=0.1226125
+ AD=0.1092 PS=1.32 PD=1.36
M$7 VGND \$5 Y sky130_gnd sky130_fd_pr__nfet_01v8 L=0.15 W=0.65 AS=0.169
+ AD=0.08775 PS=1.82 PD=0.92
M$8 Y \$7 VGND sky130_gnd sky130_fd_pr__nfet_01v8 L=0.15 W=0.65 AS=0.08775
+ AD=0.10725 PS=0.92 PD=0.98
M$9 VGND B Y sky130_gnd sky130_fd_pr__nfet_01v8 L=0.15 W=0.65 AS=0.10725
+ AD=0.08775 PS=0.98 PD=0.92
M$10 Y A VGND sky130_gnd sky130_fd_pr__nfet_01v8 L=0.15 W=0.65 AS=0.08775
+ AD=0.169 PS=0.92 PD=1.82
M$11 \$7 C_N VGND sky130_gnd sky130_fd_pr__nfet_01v8 L=0.15 W=0.42 AS=0.1092
+ AD=0.0609 PS=1.36 PD=0.71
M$12 VGND D_N \$5 sky130_gnd sky130_fd_pr__nfet_01v8 L=0.15 W=0.42 AS=0.0609
+ AD=0.1092 PS=0.71 PD=1.36
.ENDS sky130_fd_sc_hd__nor4bb_1

.SUBCKT sky130_fd_sc_hd__nor2b_1 VPB VGND Y B_N A VPWR sky130_gnd
M$1 \$4 B_N VPWR VPB sky130_fd_pr__pfet_01v8_hvt L=0.15 W=0.42 AS=0.1092
+ AD=0.1573 PS=1.36 PD=1.39
M$2 VPWR A \$9 VPB sky130_fd_pr__pfet_01v8_hvt L=0.15 W=1 AS=0.1573 AD=0.105
+ PS=1.39 PD=1.21
M$3 \$9 \$4 Y VPB sky130_fd_pr__pfet_01v8_hvt L=0.15 W=1 AS=0.105 AD=0.26
+ PS=1.21 PD=2.52
M$4 \$4 B_N VGND sky130_gnd sky130_fd_pr__nfet_01v8 L=0.15 W=0.42 AS=0.1092
+ AD=0.10025 PS=1.36 PD=0.985
M$5 VGND A Y sky130_gnd sky130_fd_pr__nfet_01v8 L=0.15 W=0.65 AS=0.10025
+ AD=0.08775 PS=0.985 PD=0.92
M$6 Y \$4 VGND sky130_gnd sky130_fd_pr__nfet_01v8 L=0.15 W=0.65 AS=0.08775
+ AD=0.169 PS=0.92 PD=1.82
.ENDS sky130_fd_sc_hd__nor2b_1

.SUBCKT sky130_fd_sc_hd__lpflow_isobufsrc_1 VPB VGND X A SLEEP VPWR sky130_gnd
M$1 \$4 A VPWR VPB sky130_fd_pr__pfet_01v8_hvt L=0.15 W=0.42 AS=0.1092
+ AD=0.1573 PS=1.36 PD=1.39
M$2 VPWR SLEEP \$9 VPB sky130_fd_pr__pfet_01v8_hvt L=0.15 W=1 AS=0.1573
+ AD=0.105 PS=1.39 PD=1.21
M$3 \$9 \$4 X VPB sky130_fd_pr__pfet_01v8_hvt L=0.15 W=1 AS=0.105 AD=0.26
+ PS=1.21 PD=2.52
M$4 \$4 A VGND sky130_gnd sky130_fd_pr__nfet_01v8 L=0.15 W=0.42 AS=0.1092
+ AD=0.10025 PS=1.36 PD=0.985
M$5 VGND SLEEP X sky130_gnd sky130_fd_pr__nfet_01v8 L=0.15 W=0.65 AS=0.10025
+ AD=0.08775 PS=0.985 PD=0.92
M$6 X \$4 VGND sky130_gnd sky130_fd_pr__nfet_01v8 L=0.15 W=0.65 AS=0.08775
+ AD=0.169 PS=0.92 PD=1.82
.ENDS sky130_fd_sc_hd__lpflow_isobufsrc_1

.SUBCKT sky130_fd_sc_hd__or4_1 VPB A X B VGND C D VPWR sky130_gnd
M$1 \$3 D \$13 VPB sky130_fd_pr__pfet_01v8_hvt L=0.15 W=0.42 AS=0.1092
+ AD=0.0693 PS=1.36 PD=0.75
M$2 \$13 C \$12 VPB sky130_fd_pr__pfet_01v8_hvt L=0.15 W=0.42 AS=0.0693
+ AD=0.0441 PS=0.75 PD=0.63
M$3 \$12 B \$11 VPB sky130_fd_pr__pfet_01v8_hvt L=0.15 W=0.42 AS=0.0441
+ AD=0.0693 PS=0.63 PD=0.75
M$4 \$11 A VPWR VPB sky130_fd_pr__pfet_01v8_hvt L=0.15 W=0.42 AS=0.0693
+ AD=0.14825 PS=0.75 PD=1.34
M$5 VPWR \$3 X VPB sky130_fd_pr__pfet_01v8_hvt L=0.15 W=1 AS=0.14825 AD=0.27
+ PS=1.34 PD=2.54
M$6 VGND D \$3 sky130_gnd sky130_fd_pr__nfet_01v8 L=0.15 W=0.42 AS=0.1092
+ AD=0.0693 PS=1.36 PD=0.75
M$7 \$3 C VGND sky130_gnd sky130_fd_pr__nfet_01v8 L=0.15 W=0.42 AS=0.0693
+ AD=0.0567 PS=0.75 PD=0.69
M$8 VGND B \$3 sky130_gnd sky130_fd_pr__nfet_01v8 L=0.15 W=0.42 AS=0.0567
+ AD=0.0567 PS=0.69 PD=0.69
M$9 VGND A \$3 sky130_gnd sky130_fd_pr__nfet_01v8 L=0.15 W=0.42 AS=0.101875
+ AD=0.0567 PS=0.99 PD=0.69
M$10 VGND \$3 X sky130_gnd sky130_fd_pr__nfet_01v8 L=0.15 W=0.65 AS=0.101875
+ AD=0.1755 PS=0.99 PD=1.84
.ENDS sky130_fd_sc_hd__or4_1

.SUBCKT sky130_fd_sc_hd__o311ai_0 VPB VPWR Y B1 A3 VGND A2 A1 C1 sky130_gnd
M$1 VPWR A1 \$13 VPB sky130_fd_pr__pfet_01v8_hvt L=0.15 W=0.64 AS=0.1792
+ AD=0.0864 PS=1.84 PD=0.91
M$2 \$13 A2 \$12 VPB sky130_fd_pr__pfet_01v8_hvt L=0.15 W=0.64 AS=0.0864
+ AD=0.0864 PS=0.91 PD=0.91
M$3 \$12 A3 Y VPB sky130_fd_pr__pfet_01v8_hvt L=0.15 W=0.64 AS=0.0864 AD=0.144
+ PS=0.91 PD=1.09
M$4 Y B1 VPWR VPB sky130_fd_pr__pfet_01v8_hvt L=0.15 W=0.64 AS=0.144 AD=0.1184
+ PS=1.09 PD=1.01
M$5 VPWR C1 Y VPB sky130_fd_pr__pfet_01v8_hvt L=0.15 W=0.64 AS=0.1184 AD=0.1984
+ PS=1.01 PD=1.9
M$6 VGND A1 \$9 sky130_gnd sky130_fd_pr__nfet_01v8 L=0.15 W=0.42 AS=0.1176
+ AD=0.0567 PS=1.4 PD=0.69
M$7 \$9 A2 VGND sky130_gnd sky130_fd_pr__nfet_01v8 L=0.15 W=0.42 AS=0.0567
+ AD=0.0567 PS=0.69 PD=0.69
M$8 VGND A3 \$9 sky130_gnd sky130_fd_pr__nfet_01v8 L=0.15 W=0.42 AS=0.0567
+ AD=0.1281 PS=0.69 PD=1.03
M$9 \$9 B1 \$14 sky130_gnd sky130_fd_pr__nfet_01v8 L=0.15 W=0.42 AS=0.1281
+ AD=0.0441 PS=1.03 PD=0.63
M$10 \$14 C1 Y sky130_gnd sky130_fd_pr__nfet_01v8 L=0.15 W=0.42 AS=0.0441
+ AD=0.1176 PS=0.63 PD=1.4
.ENDS sky130_fd_sc_hd__o311ai_0

.SUBCKT sky130_fd_sc_hd__o22a_1 VPB X VGND VPWR B1 B2 A1 A2 sky130_gnd
M$1 X \$4 VPWR VPB sky130_fd_pr__pfet_01v8_hvt L=0.15 W=1 AS=0.28 AD=0.3725
+ PS=2.56 PD=1.745
M$2 VPWR B1 \$13 VPB sky130_fd_pr__pfet_01v8_hvt L=0.15 W=1 AS=0.3725 AD=0.1175
+ PS=1.745 PD=1.235
M$3 \$13 B2 \$4 VPB sky130_fd_pr__pfet_01v8_hvt L=0.15 W=1 AS=0.1175 AD=0.235
+ PS=1.235 PD=1.47
M$4 \$4 A2 \$12 VPB sky130_fd_pr__pfet_01v8_hvt L=0.15 W=1 AS=0.235 AD=0.105
+ PS=1.47 PD=1.21
M$5 \$12 A1 VPWR VPB sky130_fd_pr__pfet_01v8_hvt L=0.15 W=1 AS=0.105 AD=0.26
+ PS=1.21 PD=2.52
M$6 \$5 B1 \$4 sky130_gnd sky130_fd_pr__nfet_01v8 L=0.15 W=0.65 AS=0.169
+ AD=0.08775 PS=1.82 PD=0.92
M$7 \$4 B2 \$5 sky130_gnd sky130_fd_pr__nfet_01v8 L=0.15 W=0.65 AS=0.08775
+ AD=0.11375 PS=0.92 PD=1
M$8 \$5 A2 VGND sky130_gnd sky130_fd_pr__nfet_01v8 L=0.15 W=0.65 AS=0.11375
+ AD=0.08775 PS=1 PD=0.92
M$9 VGND A1 \$5 sky130_gnd sky130_fd_pr__nfet_01v8 L=0.15 W=0.65 AS=0.08775
+ AD=0.169 PS=0.92 PD=1.82
M$10 X \$4 VGND sky130_gnd sky130_fd_pr__nfet_01v8 L=0.15 W=0.65 AS=0.169
+ AD=0.169 PS=1.82 PD=1.82
.ENDS sky130_fd_sc_hd__o22a_1

.SUBCKT sky130_fd_sc_hd__o41ai_1 VPB A1 VGND A2 A3 A4 Y B1 VPWR sky130_gnd
M$1 VPWR B1 Y VPB sky130_fd_pr__pfet_01v8_hvt L=0.15 W=1 AS=0.26 AD=0.135
+ PS=2.52 PD=1.27
M$2 Y A4 \$14 VPB sky130_fd_pr__pfet_01v8_hvt L=0.15 W=1 AS=0.135 AD=0.3125
+ PS=1.27 PD=1.625
M$3 \$14 A3 \$13 VPB sky130_fd_pr__pfet_01v8_hvt L=0.15 W=1 AS=0.3125 AD=0.135
+ PS=1.625 PD=1.27
M$4 \$13 A2 \$12 VPB sky130_fd_pr__pfet_01v8_hvt L=0.15 W=1 AS=0.135 AD=0.175
+ PS=1.27 PD=1.35
M$5 \$12 A1 VPWR VPB sky130_fd_pr__pfet_01v8_hvt L=0.15 W=1 AS=0.175 AD=0.28
+ PS=1.35 PD=2.56
M$6 Y B1 \$3 sky130_gnd sky130_fd_pr__nfet_01v8 L=0.15 W=0.65 AS=0.169
+ AD=0.203125 PS=1.82 PD=1.275
M$7 \$3 A4 VGND sky130_gnd sky130_fd_pr__nfet_01v8 L=0.15 W=0.65 AS=0.203125
+ AD=0.08775 PS=1.275 PD=0.92
M$8 VGND A3 \$3 sky130_gnd sky130_fd_pr__nfet_01v8 L=0.15 W=0.65 AS=0.08775
+ AD=0.08775 PS=0.92 PD=0.92
M$9 \$3 A2 VGND sky130_gnd sky130_fd_pr__nfet_01v8 L=0.15 W=0.65 AS=0.08775
+ AD=0.11375 PS=0.92 PD=1
M$10 VGND A1 \$3 sky130_gnd sky130_fd_pr__nfet_01v8 L=0.15 W=0.65 AS=0.11375
+ AD=0.182 PS=1 PD=1.86
.ENDS sky130_fd_sc_hd__o41ai_1

.SUBCKT sky130_fd_sc_hd__o21a_1 VPB A2 VPWR X VGND B1 A1 sky130_gnd
M$1 X \$7 VPWR VPB sky130_fd_pr__pfet_01v8_hvt L=0.15 W=1 AS=0.28 AD=0.3275
+ PS=2.56 PD=1.655
M$2 VPWR B1 \$7 VPB sky130_fd_pr__pfet_01v8_hvt L=0.15 W=1 AS=0.3275 AD=0.195
+ PS=1.655 PD=1.39
M$3 \$7 A2 \$11 VPB sky130_fd_pr__pfet_01v8_hvt L=0.15 W=1 AS=0.195 AD=0.1525
+ PS=1.39 PD=1.305
M$4 \$11 A1 VPWR VPB sky130_fd_pr__pfet_01v8_hvt L=0.15 W=1 AS=0.1525 AD=0.26
+ PS=1.305 PD=2.52
M$5 \$7 B1 \$4 sky130_gnd sky130_fd_pr__nfet_01v8 L=0.15 W=0.65 AS=0.169
+ AD=0.10075 PS=1.82 PD=0.96
M$6 \$4 A2 VGND sky130_gnd sky130_fd_pr__nfet_01v8 L=0.15 W=0.65 AS=0.10075
+ AD=0.08775 PS=0.96 PD=0.92
M$7 VGND A1 \$4 sky130_gnd sky130_fd_pr__nfet_01v8 L=0.15 W=0.65 AS=0.08775
+ AD=0.169 PS=0.92 PD=1.82
M$8 X \$7 VGND sky130_gnd sky130_fd_pr__nfet_01v8 L=0.15 W=0.65 AS=0.169
+ AD=0.169 PS=1.82 PD=1.82
.ENDS sky130_fd_sc_hd__o21a_1

.SUBCKT sky130_fd_sc_hd__o31ai_1 VPB B1 A3 VPWR VGND A2 Y A1 sky130_gnd
M$1 VPWR A1 \$12 VPB sky130_fd_pr__pfet_01v8_hvt L=0.15 W=1 AS=0.26 AD=0.135
+ PS=2.52 PD=1.27
M$2 \$12 A2 \$11 VPB sky130_fd_pr__pfet_01v8_hvt L=0.15 W=1 AS=0.135 AD=0.135
+ PS=1.27 PD=1.27
M$3 \$11 A3 Y VPB sky130_fd_pr__pfet_01v8_hvt L=0.15 W=1 AS=0.135 AD=0.3925
+ PS=1.27 PD=1.785
M$4 Y B1 VPWR VPB sky130_fd_pr__pfet_01v8_hvt L=0.15 W=1 AS=0.3925 AD=0.3
+ PS=1.785 PD=2.6
M$5 VGND A1 \$6 sky130_gnd sky130_fd_pr__nfet_01v8 L=0.15 W=0.65 AS=0.169
+ AD=0.08775 PS=1.82 PD=0.92
M$6 \$6 A2 VGND sky130_gnd sky130_fd_pr__nfet_01v8 L=0.15 W=0.65 AS=0.08775
+ AD=0.08775 PS=0.92 PD=0.92
M$7 VGND A3 \$6 sky130_gnd sky130_fd_pr__nfet_01v8 L=0.15 W=0.65 AS=0.08775
+ AD=0.19825 PS=0.92 PD=1.26
M$8 \$6 B1 Y sky130_gnd sky130_fd_pr__nfet_01v8 L=0.15 W=0.65 AS=0.19825
+ AD=0.221 PS=1.26 PD=1.98
.ENDS sky130_fd_sc_hd__o31ai_1

.SUBCKT sky130_fd_sc_hd__lpflow_inputiso1p_1 VPB X VGND A SLEEP VPWR sky130_gnd
M$1 \$5 A \$9 VPB sky130_fd_pr__pfet_01v8_hvt L=0.15 W=0.42 AS=0.1092 AD=0.0441
+ PS=1.36 PD=0.63
M$2 \$9 SLEEP VPWR VPB sky130_fd_pr__pfet_01v8_hvt L=0.15 W=0.42 AS=0.0441
+ AD=0.14575 PS=0.63 PD=1.335
M$3 VPWR \$5 X VPB sky130_fd_pr__pfet_01v8_hvt L=0.15 W=1 AS=0.14575 AD=0.34
+ PS=1.335 PD=2.68
M$4 VGND A \$5 sky130_gnd sky130_fd_pr__nfet_01v8 L=0.15 W=0.42 AS=0.1092
+ AD=0.0567 PS=1.36 PD=0.69
M$5 \$5 SLEEP VGND sky130_gnd sky130_fd_pr__nfet_01v8 L=0.15 W=0.42 AS=0.0567
+ AD=0.10025 PS=0.69 PD=0.985
M$6 VGND \$5 X sky130_gnd sky130_fd_pr__nfet_01v8 L=0.15 W=0.65 AS=0.10025
+ AD=0.169 PS=0.985 PD=1.82
.ENDS sky130_fd_sc_hd__lpflow_inputiso1p_1

.SUBCKT sky130_fd_sc_hd__or3_1 VPB X VGND A B C VPWR sky130_gnd
M$1 \$5 C \$11 VPB sky130_fd_pr__pfet_01v8_hvt L=0.15 W=0.42 AS=0.1092
+ AD=0.0441 PS=1.36 PD=0.63
M$2 \$11 B \$10 VPB sky130_fd_pr__pfet_01v8_hvt L=0.15 W=0.42 AS=0.0441
+ AD=0.0693 PS=0.63 PD=0.75
M$3 \$10 A VPWR VPB sky130_fd_pr__pfet_01v8_hvt L=0.15 W=0.42 AS=0.0693
+ AD=0.14825 PS=0.75 PD=1.34
M$4 VPWR \$5 X VPB sky130_fd_pr__pfet_01v8_hvt L=0.15 W=1 AS=0.14825 AD=0.28
+ PS=1.34 PD=2.56
M$5 \$5 C VGND sky130_gnd sky130_fd_pr__nfet_01v8 L=0.15 W=0.42 AS=0.1092
+ AD=0.0567 PS=1.36 PD=0.69
M$6 VGND B \$5 sky130_gnd sky130_fd_pr__nfet_01v8 L=0.15 W=0.42 AS=0.0567
+ AD=0.0567 PS=0.69 PD=0.69
M$7 VGND A \$5 sky130_gnd sky130_fd_pr__nfet_01v8 L=0.15 W=0.42 AS=0.101875
+ AD=0.0567 PS=0.99 PD=0.69
M$8 VGND \$5 X sky130_gnd sky130_fd_pr__nfet_01v8 L=0.15 W=0.65 AS=0.101875
+ AD=0.182 PS=0.99 PD=1.86
.ENDS sky130_fd_sc_hd__or3_1

.SUBCKT sky130_fd_sc_hd__dfrtp_1 VGND RESET_B Q CLK D VPWR VPB sky130_gnd
M$1 VPWR D \$5 VPB sky130_fd_pr__pfet_01v8_hvt L=0.15 W=0.42 AS=0.1092
+ AD=0.0651 PS=1.36 PD=0.73
M$2 \$5 \$4 \$6 VPB sky130_fd_pr__pfet_01v8_hvt L=0.15 W=0.42 AS=0.0651
+ AD=0.07245 PS=0.73 PD=0.765
M$3 \$6 \$3 \$19 VPB sky130_fd_pr__pfet_01v8_hvt L=0.15 W=0.42 AS=0.07245
+ AD=0.1155 PS=0.765 PD=0.97
M$4 \$19 \$17 VPWR VPB sky130_fd_pr__pfet_01v8_hvt L=0.15 W=0.42 AS=0.1155
+ AD=0.07035 PS=0.97 PD=0.755
M$5 VPWR RESET_B \$19 VPB sky130_fd_pr__pfet_01v8_hvt L=0.15 W=0.42 AS=0.07035
+ AD=0.1092 PS=0.755 PD=1.36
M$6 VPWR \$6 \$17 VPB sky130_fd_pr__pfet_01v8_hvt L=0.15 W=0.84 AS=0.2184
+ AD=0.12915 PS=2.2 PD=1.185
M$7 \$17 \$3 \$8 VPB sky130_fd_pr__pfet_01v8_hvt L=0.15 W=0.42 AS=0.12915
+ AD=0.0588 PS=1.185 PD=0.7
M$8 \$8 \$4 \$21 VPB sky130_fd_pr__pfet_01v8_hvt L=0.15 W=0.42 AS=0.0588
+ AD=0.0567 PS=0.7 PD=0.69
M$9 \$21 \$9 VPWR VPB sky130_fd_pr__pfet_01v8_hvt L=0.15 W=0.42 AS=0.0567
+ AD=0.0819 PS=0.69 PD=0.81
M$10 VPWR RESET_B \$9 VPB sky130_fd_pr__pfet_01v8_hvt L=0.15 W=0.42 AS=0.0819
+ AD=0.0567 PS=0.81 PD=0.69
M$11 \$9 \$8 VPWR VPB sky130_fd_pr__pfet_01v8_hvt L=0.15 W=0.42 AS=0.0567
+ AD=0.1134 PS=0.69 PD=1.38
M$12 \$3 CLK VPWR VPB sky130_fd_pr__pfet_01v8_hvt L=0.15 W=0.64 AS=0.1664
+ AD=0.0864 PS=1.8 PD=0.91
M$13 VPWR \$3 \$4 VPB sky130_fd_pr__pfet_01v8_hvt L=0.15 W=0.64 AS=0.0864
+ AD=0.1664 PS=0.91 PD=1.8
M$14 VPWR \$9 Q VPB sky130_fd_pr__pfet_01v8_hvt L=0.15 W=1 AS=0.3012 AD=0.26
+ PS=2.66 PD=2.52
M$15 \$3 CLK VGND sky130_gnd sky130_fd_pr__nfet_01v8 L=0.15 W=0.42 AS=0.1092
+ AD=0.0567 PS=1.36 PD=0.69
M$16 VGND \$3 \$4 sky130_gnd sky130_fd_pr__nfet_01v8 L=0.15 W=0.42 AS=0.0567
+ AD=0.1092 PS=0.69 PD=1.36
M$17 \$5 \$3 \$6 sky130_gnd sky130_fd_pr__nfet_01v8 L=0.15 W=0.36 AS=0.066
+ AD=0.0594 PS=0.745 PD=0.69
M$18 \$6 \$4 \$13 sky130_gnd sky130_fd_pr__nfet_01v8 L=0.15 W=0.36 AS=0.0594
+ AD=0.1401 PS=0.69 PD=1.1
M$19 \$17 \$4 \$8 sky130_gnd sky130_fd_pr__nfet_01v8 L=0.15 W=0.36 AS=0.0999
+ AD=0.0711 PS=0.985 PD=0.755
M$20 \$8 \$3 \$12 sky130_gnd sky130_fd_pr__nfet_01v8 L=0.15 W=0.36 AS=0.0711
+ AD=0.0669 PS=0.755 PD=0.75
M$21 VGND D \$5 sky130_gnd sky130_fd_pr__nfet_01v8 L=0.15 W=0.42 AS=0.2205
+ AD=0.066 PS=1.89 PD=0.745
M$22 \$13 \$17 \$14 sky130_gnd sky130_fd_pr__nfet_01v8 L=0.15 W=0.42 AS=0.1401
+ AD=0.0441 PS=1.1 PD=0.63
M$23 \$14 RESET_B VGND sky130_gnd sky130_fd_pr__nfet_01v8 L=0.15 W=0.42
+ AS=0.0441 AD=0.1346 PS=0.63 PD=1.15
M$24 \$12 \$9 VGND sky130_gnd sky130_fd_pr__nfet_01v8 L=0.15 W=0.42 AS=0.0669
+ AD=0.12495 PS=0.75 PD=1.015
M$25 VGND RESET_B \$11 sky130_gnd sky130_fd_pr__nfet_01v8 L=0.15 W=0.42
+ AS=0.12495 AD=0.06405 PS=1.015 PD=0.725
M$26 \$11 \$8 \$9 sky130_gnd sky130_fd_pr__nfet_01v8 L=0.15 W=0.42 AS=0.06405
+ AD=0.1092 PS=0.725 PD=1.36
M$27 VGND \$6 \$17 sky130_gnd sky130_fd_pr__nfet_01v8 L=0.15 W=0.64 AS=0.1346
+ AD=0.0999 PS=1.15 PD=0.985
M$28 VGND \$9 Q sky130_gnd sky130_fd_pr__nfet_01v8 L=0.15 W=0.65 AS=0.2087
+ AD=0.169 PS=2.02 PD=1.82
.ENDS sky130_fd_sc_hd__dfrtp_1

.SUBCKT sky130_fd_sc_hd__nand3b_1 VPB Y A_N VPWR VGND C B sky130_gnd
M$1 \$8 A_N VPWR VPB sky130_fd_pr__pfet_01v8_hvt L=0.15 W=0.42 AS=0.1092
+ AD=0.14575 PS=1.36 PD=1.335
M$2 VPWR C Y VPB sky130_fd_pr__pfet_01v8_hvt L=0.15 W=1 AS=0.14575 AD=0.135
+ PS=1.335 PD=1.27
M$3 Y B VPWR VPB sky130_fd_pr__pfet_01v8_hvt L=0.15 W=1 AS=0.135 AD=0.1925
+ PS=1.27 PD=1.385
M$4 VPWR \$8 Y VPB sky130_fd_pr__pfet_01v8_hvt L=0.15 W=1 AS=0.1925 AD=0.28
+ PS=1.385 PD=2.56
M$5 VGND A_N \$8 sky130_gnd sky130_fd_pr__nfet_01v8 L=0.15 W=0.42 AS=0.10025
+ AD=0.1092 PS=0.985 PD=1.36
M$6 VGND C \$11 sky130_gnd sky130_fd_pr__nfet_01v8 L=0.15 W=0.65 AS=0.10025
+ AD=0.08775 PS=0.985 PD=0.92
M$7 \$11 B \$10 sky130_gnd sky130_fd_pr__nfet_01v8 L=0.15 W=0.65 AS=0.08775
+ AD=0.125125 PS=0.92 PD=1.035
M$8 \$10 \$8 Y sky130_gnd sky130_fd_pr__nfet_01v8 L=0.15 W=0.65 AS=0.125125
+ AD=0.182 PS=1.035 PD=1.86
.ENDS sky130_fd_sc_hd__nand3b_1

.SUBCKT sky130_fd_sc_hd__o21bai_1 VPB VPWR A1 A2 Y B1_N VGND sky130_gnd
M$1 VPWR B1_N \$7 VPB sky130_fd_pr__pfet_01v8_hvt L=0.15 W=0.42 AS=0.17825
+ AD=0.1092 PS=1.4 PD=1.36
M$2 VPWR \$7 Y VPB sky130_fd_pr__pfet_01v8_hvt L=0.15 W=1 AS=0.17825 AD=0.1525
+ PS=1.4 PD=1.305
M$3 Y A2 \$11 VPB sky130_fd_pr__pfet_01v8_hvt L=0.15 W=1 AS=0.1525 AD=0.1275
+ PS=1.305 PD=1.255
M$4 \$11 A1 VPWR VPB sky130_fd_pr__pfet_01v8_hvt L=0.15 W=1 AS=0.1275 AD=0.28
+ PS=1.255 PD=2.56
M$5 Y \$7 \$2 sky130_gnd sky130_fd_pr__nfet_01v8 L=0.15 W=0.65 AS=0.169
+ AD=0.10075 PS=1.82 PD=0.96
M$6 \$2 A2 VGND sky130_gnd sky130_fd_pr__nfet_01v8 L=0.15 W=0.65 AS=0.10075
+ AD=0.08775 PS=0.96 PD=0.92
M$7 VGND A1 \$2 sky130_gnd sky130_fd_pr__nfet_01v8 L=0.15 W=0.65 AS=0.08775
+ AD=0.169 PS=0.92 PD=1.82
M$8 VGND B1_N \$7 sky130_gnd sky130_fd_pr__nfet_01v8 L=0.15 W=0.42 AS=0.1092
+ AD=0.1092 PS=1.36 PD=1.36
.ENDS sky130_fd_sc_hd__o21bai_1

.SUBCKT sky130_fd_sc_hd__nor2_1 VPB Y VGND B VPWR A sky130_gnd
M$1 Y B \$8 VPB sky130_fd_pr__pfet_01v8_hvt L=0.15 W=1 AS=0.26 AD=0.105 PS=2.52
+ PD=1.21
M$2 \$8 A VPWR VPB sky130_fd_pr__pfet_01v8_hvt L=0.15 W=1 AS=0.105 AD=0.26
+ PS=1.21 PD=2.52
M$3 VGND B Y sky130_gnd sky130_fd_pr__nfet_01v8 L=0.15 W=0.65 AS=0.169
+ AD=0.08775 PS=1.82 PD=0.92
M$4 Y A VGND sky130_gnd sky130_fd_pr__nfet_01v8 L=0.15 W=0.65 AS=0.08775
+ AD=0.169 PS=0.92 PD=1.82
.ENDS sky130_fd_sc_hd__nor2_1

.SUBCKT sky130_fd_sc_hd__and2_0 VPB X VPWR A B VGND sky130_gnd
M$1 VPWR A \$4 VPB sky130_fd_pr__pfet_01v8_hvt L=0.15 W=0.42 AS=0.1113
+ AD=0.0609 PS=1.37 PD=0.71
M$2 VPWR B \$4 VPB sky130_fd_pr__pfet_01v8_hvt L=0.15 W=0.42 AS=0.1841
+ AD=0.0609 PS=1.26 PD=0.71
M$3 VPWR \$4 X VPB sky130_fd_pr__pfet_01v8_hvt L=0.15 W=0.64 AS=0.1841
+ AD=0.1696 PS=1.26 PD=1.81
M$4 \$4 A \$9 sky130_gnd sky130_fd_pr__nfet_01v8 L=0.15 W=0.42 AS=0.1113
+ AD=0.0441 PS=1.37 PD=0.63
M$5 \$9 B VGND sky130_gnd sky130_fd_pr__nfet_01v8 L=0.15 W=0.42 AS=0.0441
+ AD=0.0966 PS=0.63 PD=0.88
M$6 VGND \$4 X sky130_gnd sky130_fd_pr__nfet_01v8 L=0.15 W=0.42 AS=0.0966
+ AD=0.1113 PS=0.88 PD=1.37
.ENDS sky130_fd_sc_hd__and2_0

.SUBCKT sky130_fd_sc_hd__clkdlybuf4s50_1 VPB A VGND X VPWR sky130_gnd
M$1 VPWR \$5 \$6 VPB sky130_fd_pr__pfet_01v8_hvt L=0.5 W=0.82 AS=0.15575
+ AD=0.2173 PS=1.325 PD=2.17
M$2 VPWR \$6 X VPB sky130_fd_pr__pfet_01v8_hvt L=0.15 W=1 AS=0.15575 AD=0.355
+ PS=1.325 PD=2.71
M$3 \$4 A VPWR VPB sky130_fd_pr__pfet_01v8_hvt L=0.15 W=1 AS=0.27 AD=0.1701
+ PS=2.54 PD=1.36
M$4 VPWR \$4 \$5 VPB sky130_fd_pr__pfet_01v8_hvt L=0.5 W=0.82 AS=0.1701
+ AD=0.2173 PS=1.36 PD=2.17
M$5 VGND \$6 X sky130_gnd sky130_fd_pr__nfet_01v8 L=0.15 W=0.42 AS=0.097
+ AD=0.1491 PS=0.975 PD=1.55
M$6 \$6 \$5 VGND sky130_gnd sky130_fd_pr__nfet_01v8 L=0.5 W=0.65 AS=0.17225
+ AD=0.097 PS=1.83 PD=0.975
M$7 \$4 A VGND sky130_gnd sky130_fd_pr__nfet_01v8 L=0.15 W=0.42 AS=0.1134
+ AD=0.10435 PS=1.38 PD=1.01
M$8 VGND \$4 \$5 sky130_gnd sky130_fd_pr__nfet_01v8 L=0.5 W=0.65 AS=0.10435
+ AD=0.169 PS=1.01 PD=1.82
.ENDS sky130_fd_sc_hd__clkdlybuf4s50_1

.SUBCKT sky130_fd_sc_hd__a21boi_0 VPB A2 VGND B1_N VPWR Y A1 sky130_gnd
M$1 Y \$5 \$3 VPB sky130_fd_pr__pfet_01v8_hvt L=0.15 W=0.64 AS=0.1696 AD=0.0896
+ PS=1.81 PD=0.92
M$2 \$3 A1 VPWR VPB sky130_fd_pr__pfet_01v8_hvt L=0.15 W=0.64 AS=0.0896
+ AD=0.0896 PS=0.92 PD=0.92
M$3 VPWR A2 \$3 VPB sky130_fd_pr__pfet_01v8_hvt L=0.15 W=0.64 AS=0.0896
+ AD=0.1696 PS=0.92 PD=1.81
M$4 \$5 B1_N VPWR VPB sky130_fd_pr__pfet_01v8_hvt L=0.15 W=0.42 AS=0.1113
+ AD=0.1113 PS=1.37 PD=1.37
M$5 \$5 B1_N VGND sky130_gnd sky130_fd_pr__nfet_01v8 L=0.15 W=0.42 AS=0.1113
+ AD=0.1302 PS=1.37 PD=1.04
M$6 VGND \$5 Y sky130_gnd sky130_fd_pr__nfet_01v8 L=0.15 W=0.42 AS=0.1302
+ AD=0.1113 PS=1.04 PD=0.95
M$7 Y A1 \$11 sky130_gnd sky130_fd_pr__nfet_01v8 L=0.15 W=0.42 AS=0.1113
+ AD=0.0441 PS=0.95 PD=0.63
M$8 \$11 A2 VGND sky130_gnd sky130_fd_pr__nfet_01v8 L=0.15 W=0.42 AS=0.0441
+ AD=0.1113 PS=0.63 PD=1.37
.ENDS sky130_fd_sc_hd__a21boi_0

.SUBCKT sky130_fd_sc_hd__and3_1 VPB A C X VPWR VGND B sky130_gnd
M$1 \$3 A VPWR VPB sky130_fd_pr__pfet_01v8_hvt L=0.15 W=0.42 AS=0.1092
+ AD=0.0567 PS=1.36 PD=0.69
M$2 VPWR B \$3 VPB sky130_fd_pr__pfet_01v8_hvt L=0.15 W=0.42 AS=0.0567
+ AD=0.06615 PS=0.69 PD=0.735
M$3 VPWR C \$3 VPB sky130_fd_pr__pfet_01v8_hvt L=0.15 W=0.42 AS=0.142225
+ AD=0.06615 PS=1.335 PD=0.735
M$4 VPWR \$3 X VPB sky130_fd_pr__pfet_01v8_hvt L=0.15 W=1 AS=0.142225 AD=0.26
+ PS=1.335 PD=2.52
M$5 \$3 A \$11 sky130_gnd sky130_fd_pr__nfet_01v8 L=0.15 W=0.42 AS=0.1092
+ AD=0.0441 PS=1.36 PD=0.63
M$6 \$11 B \$10 sky130_gnd sky130_fd_pr__nfet_01v8 L=0.15 W=0.42 AS=0.0441
+ AD=0.0441 PS=0.63 PD=0.63
M$7 \$10 C VGND sky130_gnd sky130_fd_pr__nfet_01v8 L=0.15 W=0.42 AS=0.0441
+ AD=0.13165 PS=0.63 PD=1.14
M$8 VGND \$3 X sky130_gnd sky130_fd_pr__nfet_01v8 L=0.15 W=0.65 AS=0.13165
+ AD=0.169 PS=1.14 PD=1.82
.ENDS sky130_fd_sc_hd__and3_1

.SUBCKT sky130_fd_sc_hd__a21oi_1 VPB VGND A2 VPWR A1 Y B1 sky130_gnd
M$1 Y B1 \$3 VPB sky130_fd_pr__pfet_01v8_hvt L=0.15 W=1 AS=0.265 AD=0.14
+ PS=2.53 PD=1.28
M$2 \$3 A1 VPWR VPB sky130_fd_pr__pfet_01v8_hvt L=0.15 W=1 AS=0.14 AD=0.1475
+ PS=1.28 PD=1.295
M$3 VPWR A2 \$3 VPB sky130_fd_pr__pfet_01v8_hvt L=0.15 W=1 AS=0.1475 AD=0.265
+ PS=1.295 PD=2.53
M$4 VGND B1 Y sky130_gnd sky130_fd_pr__nfet_01v8 L=0.15 W=0.65 AS=0.17225
+ AD=0.091 PS=1.83 PD=0.93
M$5 Y A1 \$10 sky130_gnd sky130_fd_pr__nfet_01v8 L=0.15 W=0.65 AS=0.091
+ AD=0.095875 PS=0.93 PD=0.945
M$6 \$10 A2 VGND sky130_gnd sky130_fd_pr__nfet_01v8 L=0.15 W=0.65 AS=0.095875
+ AD=0.17225 PS=0.945 PD=1.83
.ENDS sky130_fd_sc_hd__a21oi_1

.SUBCKT sky130_fd_sc_hd__nor3_1 VPB C Y VGND B A VPWR sky130_gnd
M$1 Y C \$10 VPB sky130_fd_pr__pfet_01v8_hvt L=0.15 W=1 AS=0.26 AD=0.135
+ PS=2.52 PD=1.27
M$2 \$10 B \$9 VPB sky130_fd_pr__pfet_01v8_hvt L=0.15 W=1 AS=0.135 AD=0.135
+ PS=1.27 PD=1.27
M$3 \$9 A VPWR VPB sky130_fd_pr__pfet_01v8_hvt L=0.15 W=1 AS=0.135 AD=0.26
+ PS=1.27 PD=2.52
M$4 Y C VGND sky130_gnd sky130_fd_pr__nfet_01v8 L=0.15 W=0.65 AS=0.169
+ AD=0.08775 PS=1.82 PD=0.92
M$5 VGND B Y sky130_gnd sky130_fd_pr__nfet_01v8 L=0.15 W=0.65 AS=0.08775
+ AD=0.08775 PS=0.92 PD=0.92
M$6 Y A VGND sky130_gnd sky130_fd_pr__nfet_01v8 L=0.15 W=0.65 AS=0.08775
+ AD=0.169 PS=0.92 PD=1.82
.ENDS sky130_fd_sc_hd__nor3_1

.SUBCKT sky130_fd_sc_hd__o21ai_0 VPB VPWR Y A1 VGND A2 B1 sky130_gnd
M$1 VPWR A1 \$10 VPB sky130_fd_pr__pfet_01v8_hvt L=0.15 W=0.64 AS=0.1696
+ AD=0.0768 PS=1.81 PD=0.88
M$2 \$10 A2 Y VPB sky130_fd_pr__pfet_01v8_hvt L=0.15 W=0.64 AS=0.0768 AD=0.0896
+ PS=0.88 PD=0.92
M$3 Y B1 VPWR VPB sky130_fd_pr__pfet_01v8_hvt L=0.15 W=0.64 AS=0.0896 AD=0.1824
+ PS=0.92 PD=1.85
M$4 \$5 A1 VGND sky130_gnd sky130_fd_pr__nfet_01v8 L=0.15 W=0.42 AS=0.1113
+ AD=0.0588 PS=1.37 PD=0.7
M$5 VGND A2 \$5 sky130_gnd sky130_fd_pr__nfet_01v8 L=0.15 W=0.42 AS=0.0588
+ AD=0.0588 PS=0.7 PD=0.7
M$6 \$5 B1 Y sky130_gnd sky130_fd_pr__nfet_01v8 L=0.15 W=0.42 AS=0.0588
+ AD=0.1113 PS=0.7 PD=1.37
.ENDS sky130_fd_sc_hd__o21ai_0

.SUBCKT sky130_fd_sc_hd__xor2_1 VPB VGND B A X VPWR sky130_gnd
M$1 \$6 \$2 X VPB sky130_fd_pr__pfet_01v8_hvt L=0.15 W=1 AS=0.26 AD=0.3 PS=2.52
+ PD=2.6
M$2 \$2 B \$10 VPB sky130_fd_pr__pfet_01v8_hvt L=0.15 W=1 AS=0.26 AD=0.135
+ PS=2.52 PD=1.27
M$3 \$10 A VPWR VPB sky130_fd_pr__pfet_01v8_hvt L=0.15 W=1 AS=0.135 AD=0.135
+ PS=1.27 PD=1.27
M$4 VPWR A \$6 VPB sky130_fd_pr__pfet_01v8_hvt L=0.15 W=1 AS=0.135 AD=0.135
+ PS=1.27 PD=1.27
M$5 \$6 B VPWR VPB sky130_fd_pr__pfet_01v8_hvt L=0.15 W=1 AS=0.135 AD=0.26
+ PS=1.27 PD=2.52
M$6 VGND B \$2 sky130_gnd sky130_fd_pr__nfet_01v8 L=0.15 W=0.65 AS=0.169
+ AD=0.08775 PS=1.82 PD=0.92
M$7 \$2 A VGND sky130_gnd sky130_fd_pr__nfet_01v8 L=0.15 W=0.65 AS=0.08775
+ AD=0.08775 PS=0.92 PD=0.92
M$8 VGND A \$11 sky130_gnd sky130_fd_pr__nfet_01v8 L=0.15 W=0.65 AS=0.08775
+ AD=0.08775 PS=0.92 PD=0.92
M$9 \$11 B X sky130_gnd sky130_fd_pr__nfet_01v8 L=0.15 W=0.65 AS=0.08775
+ AD=0.25025 PS=0.92 PD=1.42
M$10 X \$2 VGND sky130_gnd sky130_fd_pr__nfet_01v8 L=0.15 W=0.65 AS=0.25025
+ AD=0.208 PS=1.42 PD=1.94
.ENDS sky130_fd_sc_hd__xor2_1

.SUBCKT sky130_fd_sc_hd__xnor3_1 VGND X C B A VPWR VPB sky130_gnd
M$1 VPWR C \$8 VPB sky130_fd_pr__pfet_01v8_hvt L=0.15 W=0.64 AS=0.169 AD=0.1792
+ PS=1.365 PD=1.84
M$2 X \$6 VPWR VPB sky130_fd_pr__pfet_01v8_hvt L=0.15 W=1 AS=0.28 AD=0.169
+ PS=2.56 PD=1.365
M$3 VPWR B \$10 VPB sky130_fd_pr__pfet_01v8_hvt L=0.15 W=1 AS=0.25655 AD=0.26
+ PS=2.52 PD=2.52
M$4 \$6 \$8 \$9 VPB sky130_fd_pr__pfet_01v8_hvt L=0.15 W=0.84 AS=0.15295
+ AD=0.32235 PS=1.315 PD=2.45
M$5 \$6 C \$4 VPB sky130_fd_pr__pfet_01v8_hvt L=0.15 W=0.84 AS=0.15295 AD=0.273
+ PS=1.315 PD=2.33
M$6 \$9 \$10 \$11 VPB sky130_fd_pr__pfet_01v8_hvt L=0.15 W=0.64 AS=0.2431
+ AD=0.246 PS=1.445 PD=1.525
M$7 \$11 B \$4 VPB sky130_fd_pr__pfet_01v8_hvt L=0.15 W=0.64 AS=0.246 AD=0.1458
+ PS=1.525 PD=1.205
M$8 \$5 B \$9 VPB sky130_fd_pr__pfet_01v8_hvt L=0.15 W=0.84 AS=0.3528 AD=0.2431
+ PS=2.52 PD=1.445
M$9 \$5 \$10 \$4 VPB sky130_fd_pr__pfet_01v8_hvt L=0.15 W=0.84 AS=0.1715
+ AD=0.1458 PS=1.355 PD=1.205
M$10 \$5 A VPWR VPB sky130_fd_pr__pfet_01v8_hvt L=0.15 W=1 AS=0.1715 AD=0.135
+ PS=1.355 PD=1.27
M$11 VPWR \$5 \$11 VPB sky130_fd_pr__pfet_01v8_hvt L=0.15 W=1 AS=0.135 AD=0.285
+ PS=1.27 PD=2.57
M$12 \$9 C \$6 sky130_gnd sky130_fd_pr__nfet_01v8 L=0.15 W=0.64 AS=0.1728
+ AD=0.0928 PS=1.82 PD=0.93
M$13 \$6 \$8 \$4 sky130_gnd sky130_fd_pr__nfet_01v8 L=0.15 W=0.64 AS=0.0928
+ AD=0.224 PS=0.93 PD=1.98
M$14 X \$6 VGND sky130_gnd sky130_fd_pr__nfet_01v8 L=0.15 W=0.65 AS=0.169
+ AD=0.1165 PS=1.82 PD=1.035
M$15 VGND C \$8 sky130_gnd sky130_fd_pr__nfet_01v8 L=0.15 W=0.42 AS=0.1165
+ AD=0.1785 PS=1.035 PD=1.69
M$16 \$4 \$10 \$11 sky130_gnd sky130_fd_pr__nfet_01v8 L=0.15 W=0.42 AS=0.18205
+ AD=0.19265 PS=1.245 PD=1.285
M$17 \$9 \$10 \$5 sky130_gnd sky130_fd_pr__nfet_01v8 L=0.15 W=0.6 AS=0.140825
+ AD=0.11 PS=1.1 PD=0.99
M$18 \$5 A VGND sky130_gnd sky130_fd_pr__nfet_01v8 L=0.15 W=0.64 AS=0.11
+ AD=0.0864 PS=0.99 PD=0.91
M$19 VGND \$5 \$11 sky130_gnd sky130_fd_pr__nfet_01v8 L=0.15 W=0.64 AS=0.0864
+ AD=0.1824 PS=0.91 PD=1.85
M$20 \$5 B \$4 sky130_gnd sky130_fd_pr__nfet_01v8 L=0.15 W=0.64 AS=0.16275
+ AD=0.18205 PS=1.8 PD=1.245
M$21 \$9 B \$11 sky130_gnd sky130_fd_pr__nfet_01v8 L=0.15 W=0.64 AS=0.140825
+ AD=0.19265 PS=1.1 PD=1.285
M$22 VGND B \$10 sky130_gnd sky130_fd_pr__nfet_01v8 L=0.15 W=0.65 AS=0.1885
+ AD=0.16515 PS=1.88 PD=1.82
.ENDS sky130_fd_sc_hd__xnor3_1

.SUBCKT sky130_fd_sc_hd__xnor2_1 VPB VPWR Y B VGND A sky130_gnd
M$1 VPWR B \$8 VPB sky130_fd_pr__pfet_01v8_hvt L=0.15 W=1 AS=0.3 AD=0.135
+ PS=2.6 PD=1.27
M$2 \$8 A VPWR VPB sky130_fd_pr__pfet_01v8_hvt L=0.15 W=1 AS=0.135 AD=0.365
+ PS=1.27 PD=1.73
M$3 VPWR A \$10 VPB sky130_fd_pr__pfet_01v8_hvt L=0.15 W=1 AS=0.365 AD=0.105
+ PS=1.73 PD=1.21
M$4 \$10 B Y VPB sky130_fd_pr__pfet_01v8_hvt L=0.15 W=1 AS=0.105 AD=0.165
+ PS=1.21 PD=1.33
M$5 Y \$8 VPWR VPB sky130_fd_pr__pfet_01v8_hvt L=0.15 W=1 AS=0.165 AD=0.36
+ PS=1.33 PD=2.72
M$6 VGND B \$3 sky130_gnd sky130_fd_pr__nfet_01v8 L=0.15 W=0.65 AS=0.169
+ AD=0.08775 PS=1.82 PD=0.92
M$7 \$3 \$8 Y sky130_gnd sky130_fd_pr__nfet_01v8 L=0.15 W=0.65 AS=0.08775
+ AD=0.195 PS=0.92 PD=1.9
M$8 \$8 B \$11 sky130_gnd sky130_fd_pr__nfet_01v8 L=0.15 W=0.65 AS=0.169
+ AD=0.06825 PS=1.82 PD=0.86
M$9 \$11 A VGND sky130_gnd sky130_fd_pr__nfet_01v8 L=0.15 W=0.65 AS=0.06825
+ AD=0.08775 PS=0.86 PD=0.92
M$10 VGND A \$3 sky130_gnd sky130_fd_pr__nfet_01v8 L=0.15 W=0.65 AS=0.08775
+ AD=0.169 PS=0.92 PD=1.82
.ENDS sky130_fd_sc_hd__xnor2_1

.SUBCKT sky130_fd_sc_hd__nand2b_1 VPB Y B VPWR VGND A_N sky130_gnd
M$1 \$2 A_N VPWR VPB sky130_fd_pr__pfet_01v8_hvt L=0.15 W=0.42 AS=0.1092
+ AD=0.14575 PS=1.36 PD=1.335
M$2 VPWR B Y VPB sky130_fd_pr__pfet_01v8_hvt L=0.15 W=1 AS=0.14575 AD=0.135
+ PS=1.335 PD=1.27
M$3 Y \$2 VPWR VPB sky130_fd_pr__pfet_01v8_hvt L=0.15 W=1 AS=0.135 AD=0.265
+ PS=1.27 PD=2.53
M$4 VGND A_N \$2 sky130_gnd sky130_fd_pr__nfet_01v8 L=0.15 W=0.42 AS=0.10025
+ AD=0.1092 PS=0.985 PD=1.36
M$5 VGND B \$9 sky130_gnd sky130_fd_pr__nfet_01v8 L=0.15 W=0.65 AS=0.10025
+ AD=0.08775 PS=0.985 PD=0.92
M$6 \$9 \$2 Y sky130_gnd sky130_fd_pr__nfet_01v8 L=0.15 W=0.65 AS=0.08775
+ AD=0.169 PS=0.92 PD=1.82
.ENDS sky130_fd_sc_hd__nand2b_1

.SUBCKT sky130_fd_sc_hd__xor3_1 VGND X C B A VPWR VPB sky130_gnd
M$1 VPWR B \$10 VPB sky130_fd_pr__pfet_01v8_hvt L=0.15 W=1 AS=0.26 AD=0.2526
+ PS=2.52 PD=2.52
M$2 \$9 \$10 \$11 VPB sky130_fd_pr__pfet_01v8_hvt L=0.15 W=0.64 AS=0.2452
+ AD=0.246 PS=1.45 PD=1.525
M$3 \$11 B \$8 VPB sky130_fd_pr__pfet_01v8_hvt L=0.15 W=0.64 AS=0.246 AD=0.1458
+ PS=1.525 PD=1.205
M$4 \$4 B \$9 VPB sky130_fd_pr__pfet_01v8_hvt L=0.15 W=0.84 AS=0.3536 AD=0.2452
+ PS=2.53 PD=1.45
M$5 \$4 \$10 \$8 VPB sky130_fd_pr__pfet_01v8_hvt L=0.15 W=0.84 AS=0.1715
+ AD=0.1458 PS=1.355 PD=1.205
M$6 \$4 A VPWR VPB sky130_fd_pr__pfet_01v8_hvt L=0.15 W=1 AS=0.1715 AD=0.135
+ PS=1.355 PD=1.27
M$7 VPWR \$4 \$11 VPB sky130_fd_pr__pfet_01v8_hvt L=0.15 W=1 AS=0.135 AD=0.285
+ PS=1.27 PD=2.57
M$8 VPWR C \$7 VPB sky130_fd_pr__pfet_01v8_hvt L=0.15 W=0.64 AS=0.2115
+ AD=0.1792 PS=1.45 PD=1.84
M$9 X \$5 VPWR VPB sky130_fd_pr__pfet_01v8_hvt L=0.15 W=1 AS=0.28 AD=0.2115
+ PS=2.56 PD=1.45
M$10 \$9 C \$5 VPB sky130_fd_pr__pfet_01v8_hvt L=0.15 W=0.84 AS=0.2688
+ AD=0.1596 PS=2.32 PD=1.22
M$11 \$5 \$7 \$8 VPB sky130_fd_pr__pfet_01v8_hvt L=0.15 W=0.84 AS=0.1596
+ AD=0.441 PS=1.22 PD=2.73
M$12 \$8 C \$5 sky130_gnd sky130_fd_pr__nfet_01v8 L=0.15 W=0.64 AS=0.1728
+ AD=0.128 PS=1.82 PD=1.04
M$13 \$5 \$7 \$9 sky130_gnd sky130_fd_pr__nfet_01v8 L=0.15 W=0.64 AS=0.128
+ AD=0.3168 PS=1.04 PD=2.27
M$14 \$8 \$10 \$11 sky130_gnd sky130_fd_pr__nfet_01v8 L=0.15 W=0.42 AS=0.18365
+ AD=0.19265 PS=1.25 PD=1.285
M$15 \$9 \$10 \$4 sky130_gnd sky130_fd_pr__nfet_01v8 L=0.15 W=0.6 AS=0.140825
+ AD=0.11 PS=1.1 PD=0.99
M$16 \$4 A VGND sky130_gnd sky130_fd_pr__nfet_01v8 L=0.15 W=0.64 AS=0.11
+ AD=0.0864 PS=0.99 PD=0.91
M$17 VGND \$4 \$11 sky130_gnd sky130_fd_pr__nfet_01v8 L=0.15 W=0.64 AS=0.0864
+ AD=0.1824 PS=0.91 PD=1.85
M$18 \$4 B \$8 sky130_gnd sky130_fd_pr__nfet_01v8 L=0.15 W=0.64 AS=0.1628
+ AD=0.18365 PS=1.8 PD=1.25
M$19 \$9 B \$11 sky130_gnd sky130_fd_pr__nfet_01v8 L=0.15 W=0.64 AS=0.140825
+ AD=0.19265 PS=1.1 PD=1.285
M$20 X \$5 VGND sky130_gnd sky130_fd_pr__nfet_01v8 L=0.15 W=0.65 AS=0.169
+ AD=0.144125 PS=1.82 PD=1.12
M$21 VGND C \$7 sky130_gnd sky130_fd_pr__nfet_01v8 L=0.15 W=0.42 AS=0.144125
+ AD=0.1764 PS=1.12 PD=1.68
M$22 VGND B \$10 sky130_gnd sky130_fd_pr__nfet_01v8 L=0.15 W=0.65 AS=0.195
+ AD=0.1653 PS=1.9 PD=1.82
.ENDS sky130_fd_sc_hd__xor3_1

.SUBCKT sky130_fd_sc_hd__maj3_1 VPB X VGND C B A VPWR sky130_gnd
M$1 \$5 C \$11 VPB sky130_fd_pr__pfet_01v8_hvt L=0.15 W=0.42 AS=0.1092
+ AD=0.0441 PS=1.36 PD=0.63
M$2 \$11 A VPWR VPB sky130_fd_pr__pfet_01v8_hvt L=0.15 W=0.42 AS=0.0441
+ AD=0.0567 PS=0.63 PD=0.69
M$3 VPWR A \$10 VPB sky130_fd_pr__pfet_01v8_hvt L=0.15 W=0.42 AS=0.0567
+ AD=0.0441 PS=0.69 PD=0.63
M$4 \$10 B \$5 VPB sky130_fd_pr__pfet_01v8_hvt L=0.15 W=0.42 AS=0.0441
+ AD=0.0567 PS=0.63 PD=0.69
M$5 \$5 B \$12 VPB sky130_fd_pr__pfet_01v8_hvt L=0.15 W=0.42 AS=0.0567
+ AD=0.0441 PS=0.69 PD=0.63
M$6 VPWR C \$12 VPB sky130_fd_pr__pfet_01v8_hvt L=0.15 W=0.42 AS=0.2492
+ AD=0.0441 PS=1.565 PD=0.63
M$7 VPWR \$5 X VPB sky130_fd_pr__pfet_01v8_hvt L=0.15 W=1 AS=0.2492 AD=0.365
+ PS=1.565 PD=2.73
M$8 \$5 C \$15 sky130_gnd sky130_fd_pr__nfet_01v8 L=0.15 W=0.42 AS=0.1092
+ AD=0.0441 PS=1.36 PD=0.63
M$9 \$15 A VGND sky130_gnd sky130_fd_pr__nfet_01v8 L=0.15 W=0.42 AS=0.0441
+ AD=0.0567 PS=0.63 PD=0.69
M$10 VGND A \$14 sky130_gnd sky130_fd_pr__nfet_01v8 L=0.15 W=0.42 AS=0.0567
+ AD=0.0441 PS=0.69 PD=0.63
M$11 \$14 B \$5 sky130_gnd sky130_fd_pr__nfet_01v8 L=0.15 W=0.42 AS=0.0441
+ AD=0.0567 PS=0.63 PD=0.69
M$12 \$5 B \$13 sky130_gnd sky130_fd_pr__nfet_01v8 L=0.15 W=0.42 AS=0.0567
+ AD=0.0441 PS=0.69 PD=0.63
M$13 \$13 C VGND sky130_gnd sky130_fd_pr__nfet_01v8 L=0.15 W=0.42 AS=0.0441
+ AD=0.1474 PS=0.63 PD=1.215
M$14 VGND \$5 X sky130_gnd sky130_fd_pr__nfet_01v8 L=0.15 W=0.65 AS=0.1474
+ AD=0.23725 PS=1.215 PD=2.03
.ENDS sky130_fd_sc_hd__maj3_1

.SUBCKT sky130_fd_sc_hd__nand3_1 VPB Y VPWR VGND C B A sky130_gnd
M$1 VPWR C Y VPB sky130_fd_pr__pfet_01v8_hvt L=0.15 W=1 AS=0.26 AD=0.135
+ PS=2.52 PD=1.27
M$2 Y B VPWR VPB sky130_fd_pr__pfet_01v8_hvt L=0.15 W=1 AS=0.135 AD=0.165
+ PS=1.27 PD=1.33
M$3 VPWR A Y VPB sky130_fd_pr__pfet_01v8_hvt L=0.15 W=1 AS=0.165 AD=0.26
+ PS=1.33 PD=2.52
M$4 VGND C \$10 sky130_gnd sky130_fd_pr__nfet_01v8 L=0.15 W=0.65 AS=0.169
+ AD=0.08775 PS=1.82 PD=0.92
M$5 \$10 B \$9 sky130_gnd sky130_fd_pr__nfet_01v8 L=0.15 W=0.65 AS=0.08775
+ AD=0.10725 PS=0.92 PD=0.98
M$6 \$9 A Y sky130_gnd sky130_fd_pr__nfet_01v8 L=0.15 W=0.65 AS=0.10725
+ AD=0.169 PS=0.98 PD=1.82
.ENDS sky130_fd_sc_hd__nand3_1

.SUBCKT sky130_fd_sc_hd__nand2_1 VPB Y VPWR VGND A B sky130_gnd
M$1 VPWR B Y VPB sky130_fd_pr__pfet_01v8_hvt L=0.15 W=1 AS=0.26 AD=0.135
+ PS=2.52 PD=1.27
M$2 Y A VPWR VPB sky130_fd_pr__pfet_01v8_hvt L=0.15 W=1 AS=0.135 AD=0.26
+ PS=1.27 PD=2.52
M$3 VGND B \$8 sky130_gnd sky130_fd_pr__nfet_01v8 L=0.15 W=0.65 AS=0.169
+ AD=0.08775 PS=1.82 PD=0.92
M$4 \$8 A Y sky130_gnd sky130_fd_pr__nfet_01v8 L=0.15 W=0.65 AS=0.08775
+ AD=0.169 PS=0.92 PD=1.82
.ENDS sky130_fd_sc_hd__nand2_1

.SUBCKT sky130_fd_sc_hd__clkinv_1 VPB VPWR VGND Y A sky130_gnd
M$1 VPWR A Y VPB sky130_fd_pr__pfet_01v8_hvt L=0.15 W=0.84 AS=0.2184 AD=0.1134
+ PS=2.2 PD=1.11
M$2 Y A VPWR VPB sky130_fd_pr__pfet_01v8_hvt L=0.15 W=0.84 AS=0.1134 AD=0.2352
+ PS=1.11 PD=2.24
M$3 Y A VGND sky130_gnd sky130_fd_pr__nfet_01v8 L=0.15 W=0.42 AS=0.1092
+ AD=0.1197 PS=1.36 PD=1.41
.ENDS sky130_fd_sc_hd__clkinv_1

.SUBCKT sky130_fd_sc_hd__decap_3 VPB VGND VPWR sky130_gnd
M$1 VPWR VGND VPWR VPB sky130_fd_pr__pfet_01v8_hvt L=0.59 W=0.87 AS=0.2262
+ AD=0.2262 PS=2.26 PD=2.26
M$2 VGND VPWR VGND sky130_gnd sky130_fd_pr__nfet_01v8 L=0.59 W=0.55 AS=0.143
+ AD=0.143 PS=1.62 PD=1.62
.ENDS sky130_fd_sc_hd__decap_3

.SUBCKT sky130_fd_sc_hd__decap_8 VPB VPWR VGND sky130_gnd
M$1 VPWR VGND VPWR VPB sky130_fd_pr__pfet_01v8_hvt L=2.89 W=0.87 AS=0.2262
+ AD=0.2262 PS=2.26 PD=2.26
M$2 VGND VPWR VGND sky130_gnd sky130_fd_pr__nfet_01v8 L=2.89 W=0.55 AS=0.143
+ AD=0.143 PS=1.62 PD=1.62
.ENDS sky130_fd_sc_hd__decap_8

.SUBCKT sky130_fd_sc_hd__decap_4 VPB VGND VPWR sky130_gnd
M$1 VPWR VGND VPWR VPB sky130_fd_pr__pfet_01v8_hvt L=1.05 W=0.87 AS=0.2262
+ AD=0.2262 PS=2.26 PD=2.26
M$2 VGND VPWR VGND sky130_gnd sky130_fd_pr__nfet_01v8 L=1.05 W=0.55 AS=0.143
+ AD=0.143 PS=1.62 PD=1.62
.ENDS sky130_fd_sc_hd__decap_4

.SUBCKT sky130_fd_sc_hd__decap_6 VPB VPWR VGND sky130_gnd
M$1 VPWR VGND VPWR VPB sky130_fd_pr__pfet_01v8_hvt L=1.97 W=0.87 AS=0.2262
+ AD=0.2262 PS=2.26 PD=2.26
M$2 VGND VPWR VGND sky130_gnd sky130_fd_pr__nfet_01v8 L=1.97 W=0.55 AS=0.143
+ AD=0.143 PS=1.62 PD=1.62
.ENDS sky130_fd_sc_hd__decap_6

.SUBCKT sky130_fd_sc_hd__decap_12 VPB VPWR VGND sky130_gnd
M$1 VPWR VGND VPWR VPB sky130_fd_pr__pfet_01v8_hvt L=4.73 W=0.87 AS=0.2262
+ AD=0.2262 PS=2.26 PD=2.26
M$2 VGND VPWR VGND sky130_gnd sky130_fd_pr__nfet_01v8 L=4.73 W=0.55 AS=0.143
+ AD=0.143 PS=1.62 PD=1.62
.ENDS sky130_fd_sc_hd__decap_12
