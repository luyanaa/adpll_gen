* Extracted by KLayout with SKY130 LVS runset on : 31/10/2026 12:26

.SUBCKT PLL_COUNTER_DCO_PHYS A|MID_MUX[14] A|MID_MUX[13] A|MID_MUX[12]
+ A|MID_MUX[11] A|MID_MUX[10] A|MID_MUX[9] A|MID_MUX[7] A|MID_MUX[8]
+ A|MID_MUX[6] A|MID_MUX[4] A|MID_MUX[3] A|MID_MUX[2] A|MID_MUX[1]
+ A|COARSE_MUX[14] A|X A|A1|B|B1|X A|B1|X A|B|B1|X A|B1|C|X B|X A|B|C1|X
+ A|A1|B|C1|X A|COARSE_MUX[12] B|B1|X A|A1|X B|C|X A|COARSE_MUX[9]
+ A|COARSE_MUX[10] VPB|VPWR A1|B|C|SLEEP|X A|A1|Y A|B1|Y A|B2|X A2|Y A|A2|B|C|X
+ A|B|Y A|Y A1|B|C|X A|MID_MUX[5] A|A1|B1|X C|Y A2|B|C|X A|COARSE_MUX[11]
+ A|MID_MUX[0] B|Y B|B2|Y A2|A_N|B|B1|C|X B|C|Y A1|Y A|C|Y A|COARSE_MUX[7]
+ A2|B|X A|B|X A|B|C|X A|B|C|Y A|B|B1_N|X B|B1_N|Y A1|B|Y A|SLEEP|Y A2|B|Y
+ A2|B|C|SLEEP|Y A3|B|Y A1|S|Y B|SLEEP|Y A3|B|X A_N|B|Y A2|B1|Y A2|A3|B|X
+ A|A2|B|Y A|A1|B|C|Y A|A3|B|Y A|A2|B|SLEEP|Y B1|Y A|B1_N|Y A0|Y A2|B|C|D|X
+ A|A1|B|X A|COARSE_MUX[8] C|X A2|X A3|A_N|B|C|X A2|A4|B|X A1|A2|B|X
+ A2|B|B1|C|Y A1|A2|Y A|COARSE_MUX[13] A1|A1_N|C|X A|A2|SLEEP|X A|C|X A3|Y
+ A_N|C|Y A2|A2_N|B|D|X A|A1|A_N|B1|X A|A1|C1|Y B2|Y A|A2|B|X A|A0|X
+ B|B1|SLEEP|Y A|S|X A1|D|X B2|D|SLEEP|Y B1|B2|D|X A|A1|B|B1|Y B|SLEEP|X D|Y
+ A|B|B1|B_N|Y A|C|C1|X A1|X A|B|C1|Y A|A1|B1|Y A|B1|C|Y B2|D|Y A|A_N|B1|Y
+ A2|B1|SLEEP|Y A|D_N|Y A|A1|B1|C_N|X A1|A2|X C|SLEEP|Y A1|B1|C_N|Y B1|X S|Y
+ B|B_N|C|X A|A_N|Y A|C1|Y A|B2|Y B1|C|X A|A2|Y A2|C|Y B1|C|Y A|A1|B|Y B|B1|Y
+ A|B|B_N|X A|B|B2|Y B|C|SLEEP|Y A|A2|X SLEEP|Y B|B1|C|X A3|X C1|Y D1|Y
+ A|A1_N|Y A2_N|B|Y D|X A|COARSE_MUX[6] A|FINE_MUX[2] A|FINE_MUX[0]
+ A|A0|B|SLEEP|X C1|X A|COARSE_MUX[5] A_N|B|C|X A|A1|D|X A|FINE_MUX[1] A2|C|X
+ B|B_N|Y A|B|B1|C1|X A|COARSE_MUX[3] A|C_N|S|Y A|B1_N|X A|COARSE_MUX[1]
+ A|COARSE_MUX[4] A2|B|C|Y A0|A1|X A|B|SLEEP|X A|COARSE_MUX[0] A|FINE_MUX[3]
+ B1|SLEEP|Y A|B|SLEEP|Y A|A1|A2|B|C|X A|A_N|B|Y A|COARSE_MUX[2] A|FINE_MUX[4]
+ B|C1|Y A|A3|C|D|X A|FINE_MUX[5] A|B|B1|Y B|B1|D_N|X A2|A3|Y A|FINE_MUX[6]
+ A|B|C|D|Y A_N|B1_N|Y A|A_N|X A|FINE_MUX[7] A2|B|SLEEP|Y A|REF A|FINE_MUX[8]
+ B|D|X A|FINE_MUX[9] A|A1|C|Y A|Q OUT|X INJ_EDGE|X C|C_N|X SS_BBPD[1]|X
+ SS_BBPD[0]|X B1|C1|X B1|C1|Y B|B_N|X B|C|D_N|X A|FINE_MUX[10] A1|B|C|Y
+ RESET_B|X CLK|TICK A|C1|Q B_N|Y MID_OUT|X A0|A2|X A|B1|Q A|DCO_EN A|D1|Q
+ A3|SLEEP|Y A1|B1|Y A3|D|Y A|FINE_MUX[12] A|FINE_MUX[11] A2|SLEEP|X A_N|Y
+ B1|B_N|X B|C_N|Y A1|B1_N|Y A2|C1|X A_N|B1|C|Y A2|B|SLEEP|X A3|B|C|Y
+ A|FINE_MUX[13] A|A2|B|B_N|X A1|B|SLEEP|X A|FINE_MUX[14] A3|A4|X A|A0|B|Y
+ A2|D|Y A_N|B|B1|C|X A|D|Y A|B1|SLEEP|Y A|A2|B|C_N|Y A2|A4|Y A1|A3|X A2|A3|C|X
+ C_N|Y A|S|Y A1|A2|B|Y A|C|SLEEP|Y A3|B1|Y A4|B2|X A2|A3|C|Y D_N|Y A2|C|D|Y
+ A|B1|C1|X A2|A3|X A1|A3|B|X A2|C|D|X A2|A_N|B|X A3|B1|C|SLEEP|Y
+ A|A2|B|C|SLEEP|Y B|D|Y A4|B|X A|B|B1|C|X A|B_N|SLEEP|Y A2|SLEEP|Y A4|X
+ A|FINE_MUX[21] A|FINE_MUX[25] A|FINE_MUX[15] A|FINE_MUX[16] A|FINE_MUX[17]
+ A|FINE_MUX[18] A|FINE_MUX[19] A|FINE_MUX[20] A|FINE_MUX[22] A|FINE_MUX[23]
+ A|FINE_MUX[24] A|FINE_MUX[26] A|FINE_MUX[27] A|FINE_MUX[28] A|FINE_MUX[29]
+ A|FINE_MUX[30] VGND
M$1 A|A1|B1|C_N|X \$17 VPB|VPWR VPB|VPWR sky130_fd_pr__pfet_01v8_hvt L=0.15 W=1
+ AS=0.355 AD=0.15575 PS=2.71 PD=1.325
M$2 VPB|VPWR \$18 \$17 VPB|VPWR sky130_fd_pr__pfet_01v8_hvt L=0.5 W=0.82
+ AS=0.15575 AD=0.2173 PS=1.325 PD=2.17
M$3 VPB|VPWR \$19 \$18 VPB|VPWR sky130_fd_pr__pfet_01v8_hvt L=0.5 W=0.82
+ AS=0.1701 AD=0.2173 PS=1.36 PD=2.17
M$4 VPB|VPWR A|MID_MUX[14] \$19 VPB|VPWR sky130_fd_pr__pfet_01v8_hvt L=0.15 W=1
+ AS=0.1701 AD=0.27 PS=1.36 PD=2.54
M$5 A|X \$21 VPB|VPWR VPB|VPWR sky130_fd_pr__pfet_01v8_hvt L=0.15 W=1 AS=0.355
+ AD=0.15575 PS=2.71 PD=1.325
M$6 VPB|VPWR \$22 \$21 VPB|VPWR sky130_fd_pr__pfet_01v8_hvt L=0.5 W=0.82
+ AS=0.15575 AD=0.2173 PS=1.325 PD=2.17
M$7 VPB|VPWR \$23 \$22 VPB|VPWR sky130_fd_pr__pfet_01v8_hvt L=0.5 W=0.82
+ AS=0.1701 AD=0.2173 PS=1.36 PD=2.17
M$8 VPB|VPWR A|MID_MUX[13] \$23 VPB|VPWR sky130_fd_pr__pfet_01v8_hvt L=0.15 W=1
+ AS=0.1701 AD=0.27 PS=1.36 PD=2.54
M$9 A|A1|B|B1|X \$25 VPB|VPWR VPB|VPWR sky130_fd_pr__pfet_01v8_hvt L=0.15 W=1
+ AS=0.355 AD=0.15575 PS=2.71 PD=1.325
M$10 VPB|VPWR \$26 \$25 VPB|VPWR sky130_fd_pr__pfet_01v8_hvt L=0.5 W=0.82
+ AS=0.15575 AD=0.2173 PS=1.325 PD=2.17
M$11 VPB|VPWR \$27 \$26 VPB|VPWR sky130_fd_pr__pfet_01v8_hvt L=0.5 W=0.82
+ AS=0.1701 AD=0.2173 PS=1.36 PD=2.17
M$12 VPB|VPWR A|MID_MUX[12] \$27 VPB|VPWR sky130_fd_pr__pfet_01v8_hvt L=0.15
+ W=1 AS=0.1701 AD=0.27 PS=1.36 PD=2.54
M$13 A|B1|X \$29 VPB|VPWR VPB|VPWR sky130_fd_pr__pfet_01v8_hvt L=0.15 W=1
+ AS=0.355 AD=0.15575 PS=2.71 PD=1.325
M$14 VPB|VPWR \$30 \$29 VPB|VPWR sky130_fd_pr__pfet_01v8_hvt L=0.5 W=0.82
+ AS=0.15575 AD=0.2173 PS=1.325 PD=2.17
M$15 VPB|VPWR \$31 \$30 VPB|VPWR sky130_fd_pr__pfet_01v8_hvt L=0.5 W=0.82
+ AS=0.1701 AD=0.2173 PS=1.36 PD=2.17
M$16 VPB|VPWR A|MID_MUX[11] \$31 VPB|VPWR sky130_fd_pr__pfet_01v8_hvt L=0.15
+ W=1 AS=0.1701 AD=0.27 PS=1.36 PD=2.54
M$17 A|B|B1|X \$33 VPB|VPWR VPB|VPWR sky130_fd_pr__pfet_01v8_hvt L=0.15 W=1
+ AS=0.355 AD=0.15575 PS=2.71 PD=1.325
M$18 VPB|VPWR \$34 \$33 VPB|VPWR sky130_fd_pr__pfet_01v8_hvt L=0.5 W=0.82
+ AS=0.15575 AD=0.2173 PS=1.325 PD=2.17
M$19 VPB|VPWR \$35 \$34 VPB|VPWR sky130_fd_pr__pfet_01v8_hvt L=0.5 W=0.82
+ AS=0.1701 AD=0.2173 PS=1.36 PD=2.17
M$20 VPB|VPWR A|MID_MUX[10] \$35 VPB|VPWR sky130_fd_pr__pfet_01v8_hvt L=0.15
+ W=1 AS=0.1701 AD=0.27 PS=1.36 PD=2.54
M$21 A|B1|X \$37 VPB|VPWR VPB|VPWR sky130_fd_pr__pfet_01v8_hvt L=0.15 W=1
+ AS=0.355 AD=0.15575 PS=2.71 PD=1.325
M$22 VPB|VPWR \$38 \$37 VPB|VPWR sky130_fd_pr__pfet_01v8_hvt L=0.5 W=0.82
+ AS=0.15575 AD=0.2173 PS=1.325 PD=2.17
M$23 VPB|VPWR \$39 \$38 VPB|VPWR sky130_fd_pr__pfet_01v8_hvt L=0.5 W=0.82
+ AS=0.1701 AD=0.2173 PS=1.36 PD=2.17
M$24 VPB|VPWR A|MID_MUX[9] \$39 VPB|VPWR sky130_fd_pr__pfet_01v8_hvt L=0.15 W=1
+ AS=0.1701 AD=0.27 PS=1.36 PD=2.54
M$25 A|X \$41 VPB|VPWR VPB|VPWR sky130_fd_pr__pfet_01v8_hvt L=0.15 W=1 AS=0.355
+ AD=0.15575 PS=2.71 PD=1.325
M$26 VPB|VPWR \$42 \$41 VPB|VPWR sky130_fd_pr__pfet_01v8_hvt L=0.5 W=0.82
+ AS=0.15575 AD=0.2173 PS=1.325 PD=2.17
M$27 VPB|VPWR \$43 \$42 VPB|VPWR sky130_fd_pr__pfet_01v8_hvt L=0.5 W=0.82
+ AS=0.1701 AD=0.2173 PS=1.36 PD=2.17
M$28 VPB|VPWR A|MID_MUX[7] \$43 VPB|VPWR sky130_fd_pr__pfet_01v8_hvt L=0.15 W=1
+ AS=0.1701 AD=0.27 PS=1.36 PD=2.54
M$29 A|B|B1|X \$45 VPB|VPWR VPB|VPWR sky130_fd_pr__pfet_01v8_hvt L=0.15 W=1
+ AS=0.355 AD=0.15575 PS=2.71 PD=1.325
M$30 VPB|VPWR \$46 \$45 VPB|VPWR sky130_fd_pr__pfet_01v8_hvt L=0.5 W=0.82
+ AS=0.15575 AD=0.2173 PS=1.325 PD=2.17
M$31 VPB|VPWR \$47 \$46 VPB|VPWR sky130_fd_pr__pfet_01v8_hvt L=0.5 W=0.82
+ AS=0.1701 AD=0.2173 PS=1.36 PD=2.17
M$32 VPB|VPWR A|MID_MUX[8] \$47 VPB|VPWR sky130_fd_pr__pfet_01v8_hvt L=0.15 W=1
+ AS=0.1701 AD=0.27 PS=1.36 PD=2.54
M$33 A|B|B1|X \$48 VPB|VPWR VPB|VPWR sky130_fd_pr__pfet_01v8_hvt L=0.15 W=1
+ AS=0.355 AD=0.15575 PS=2.71 PD=1.325
M$34 VPB|VPWR \$49 \$48 VPB|VPWR sky130_fd_pr__pfet_01v8_hvt L=0.5 W=0.82
+ AS=0.15575 AD=0.2173 PS=1.325 PD=2.17
M$35 VPB|VPWR \$50 \$49 VPB|VPWR sky130_fd_pr__pfet_01v8_hvt L=0.5 W=0.82
+ AS=0.1701 AD=0.2173 PS=1.36 PD=2.17
M$36 VPB|VPWR A|MID_MUX[6] \$50 VPB|VPWR sky130_fd_pr__pfet_01v8_hvt L=0.15 W=1
+ AS=0.1701 AD=0.27 PS=1.36 PD=2.54
M$37 A|B|B1|X \$52 VPB|VPWR VPB|VPWR sky130_fd_pr__pfet_01v8_hvt L=0.15 W=1
+ AS=0.355 AD=0.15575 PS=2.71 PD=1.325
M$38 VPB|VPWR \$53 \$52 VPB|VPWR sky130_fd_pr__pfet_01v8_hvt L=0.5 W=0.82
+ AS=0.15575 AD=0.2173 PS=1.325 PD=2.17
M$39 VPB|VPWR \$54 \$53 VPB|VPWR sky130_fd_pr__pfet_01v8_hvt L=0.5 W=0.82
+ AS=0.1701 AD=0.2173 PS=1.36 PD=2.17
M$40 VPB|VPWR A|MID_MUX[4] \$54 VPB|VPWR sky130_fd_pr__pfet_01v8_hvt L=0.15 W=1
+ AS=0.1701 AD=0.27 PS=1.36 PD=2.54
M$41 \$55 A|MID_MUX[3] VPB|VPWR VPB|VPWR sky130_fd_pr__pfet_01v8_hvt L=0.15 W=1
+ AS=0.27 AD=0.1701 PS=2.54 PD=1.36
M$42 VPB|VPWR \$55 \$56 VPB|VPWR sky130_fd_pr__pfet_01v8_hvt L=0.5 W=0.82
+ AS=0.1701 AD=0.2173 PS=1.36 PD=2.17
M$43 VPB|VPWR \$56 \$57 VPB|VPWR sky130_fd_pr__pfet_01v8_hvt L=0.5 W=0.82
+ AS=0.15575 AD=0.2173 PS=1.325 PD=2.17
M$44 VPB|VPWR \$57 A|A1|B1|X VPB|VPWR sky130_fd_pr__pfet_01v8_hvt L=0.15 W=1
+ AS=0.15575 AD=0.355 PS=1.325 PD=2.71
M$45 A|B1|C|X \$59 VPB|VPWR VPB|VPWR sky130_fd_pr__pfet_01v8_hvt L=0.15 W=1
+ AS=0.355 AD=0.15575 PS=2.71 PD=1.325
M$46 VPB|VPWR \$60 \$59 VPB|VPWR sky130_fd_pr__pfet_01v8_hvt L=0.5 W=0.82
+ AS=0.15575 AD=0.2173 PS=1.325 PD=2.17
M$47 VPB|VPWR \$61 \$60 VPB|VPWR sky130_fd_pr__pfet_01v8_hvt L=0.5 W=0.82
+ AS=0.1701 AD=0.2173 PS=1.36 PD=2.17
M$48 VPB|VPWR A|MID_MUX[2] \$61 VPB|VPWR sky130_fd_pr__pfet_01v8_hvt L=0.15 W=1
+ AS=0.1701 AD=0.27 PS=1.36 PD=2.54
M$49 A|Y B|B1|X \$169 VPB|VPWR sky130_fd_pr__pfet_01v8_hvt L=0.15 W=1 AS=0.26
+ AD=0.105 PS=2.52 PD=1.21
M$50 \$169 A|A1|X VPB|VPWR VPB|VPWR sky130_fd_pr__pfet_01v8_hvt L=0.15 W=1
+ AS=0.105 AD=0.26 PS=1.21 PD=2.52
M$51 B|B1|X \$62 VPB|VPWR VPB|VPWR sky130_fd_pr__pfet_01v8_hvt L=0.15 W=1
+ AS=0.355 AD=0.15575 PS=2.71 PD=1.325
M$52 VPB|VPWR \$63 \$62 VPB|VPWR sky130_fd_pr__pfet_01v8_hvt L=0.5 W=0.82
+ AS=0.15575 AD=0.2173 PS=1.325 PD=2.17
M$53 VPB|VPWR \$64 \$63 VPB|VPWR sky130_fd_pr__pfet_01v8_hvt L=0.5 W=0.82
+ AS=0.1701 AD=0.2173 PS=1.36 PD=2.17
M$54 VPB|VPWR A|MID_MUX[1] \$64 VPB|VPWR sky130_fd_pr__pfet_01v8_hvt L=0.15 W=1
+ AS=0.1701 AD=0.27 PS=1.36 PD=2.54
M$55 VPB|VPWR B|C|X \$166 VPB|VPWR sky130_fd_pr__pfet_01v8_hvt L=0.15 W=0.42
+ AS=0.2492 AD=0.0441 PS=1.565 PD=0.63
M$56 \$166 A|B|C1|X \$66 VPB|VPWR sky130_fd_pr__pfet_01v8_hvt L=0.15 W=0.42
+ AS=0.0441 AD=0.0567 PS=0.63 PD=0.69
M$57 \$66 A|B|C1|X \$167 VPB|VPWR sky130_fd_pr__pfet_01v8_hvt L=0.15 W=0.42
+ AS=0.0567 AD=0.0441 PS=0.69 PD=0.63
M$58 \$167 A|X VPB|VPWR VPB|VPWR sky130_fd_pr__pfet_01v8_hvt L=0.15 W=0.42
+ AS=0.0441 AD=0.0567 PS=0.63 PD=0.69
M$59 VPB|VPWR A|X \$165 VPB|VPWR sky130_fd_pr__pfet_01v8_hvt L=0.15 W=0.42
+ AS=0.0567 AD=0.0441 PS=0.69 PD=0.63
M$60 \$165 B|C|X \$66 VPB|VPWR sky130_fd_pr__pfet_01v8_hvt L=0.15 W=0.42
+ AS=0.0441 AD=0.1092 PS=0.63 PD=1.36
M$61 B|X \$66 VPB|VPWR VPB|VPWR sky130_fd_pr__pfet_01v8_hvt L=0.15 W=1 AS=0.365
+ AD=0.2492 PS=2.73 PD=1.565
M$62 \$68 A|COARSE_MUX[9] VPB|VPWR VPB|VPWR sky130_fd_pr__pfet_01v8_hvt L=0.15
+ W=1 AS=0.27 AD=0.1701 PS=2.54 PD=1.36
M$63 VPB|VPWR \$68 \$69 VPB|VPWR sky130_fd_pr__pfet_01v8_hvt L=0.5 W=0.82
+ AS=0.1701 AD=0.2173 PS=1.36 PD=2.17
M$64 VPB|VPWR \$69 \$70 VPB|VPWR sky130_fd_pr__pfet_01v8_hvt L=0.5 W=0.82
+ AS=0.15575 AD=0.2173 PS=1.325 PD=2.17
M$65 VPB|VPWR \$70 A|X VPB|VPWR sky130_fd_pr__pfet_01v8_hvt L=0.15 W=1
+ AS=0.15575 AD=0.355 PS=1.325 PD=2.71
M$66 A|A1|B|C1|X \$73 VPB|VPWR VPB|VPWR sky130_fd_pr__pfet_01v8_hvt L=0.15 W=1
+ AS=0.355 AD=0.15575 PS=2.71 PD=1.325
M$67 VPB|VPWR \$74 \$73 VPB|VPWR sky130_fd_pr__pfet_01v8_hvt L=0.5 W=0.82
+ AS=0.15575 AD=0.2173 PS=1.325 PD=2.17
M$68 VPB|VPWR \$75 \$74 VPB|VPWR sky130_fd_pr__pfet_01v8_hvt L=0.5 W=0.82
+ AS=0.1701 AD=0.2173 PS=1.36 PD=2.17
M$69 VPB|VPWR A|COARSE_MUX[12] \$75 VPB|VPWR sky130_fd_pr__pfet_01v8_hvt L=0.15
+ W=1 AS=0.1701 AD=0.27 PS=1.36 PD=2.54
M$70 \$77 A|COARSE_MUX[10] VPB|VPWR VPB|VPWR sky130_fd_pr__pfet_01v8_hvt L=0.15
+ W=1 AS=0.27 AD=0.1701 PS=2.54 PD=1.36
M$71 VPB|VPWR \$77 \$78 VPB|VPWR sky130_fd_pr__pfet_01v8_hvt L=0.5 W=0.82
+ AS=0.1701 AD=0.2173 PS=1.36 PD=2.17
M$72 VPB|VPWR \$78 \$79 VPB|VPWR sky130_fd_pr__pfet_01v8_hvt L=0.5 W=0.82
+ AS=0.15575 AD=0.2173 PS=1.325 PD=2.17
M$73 VPB|VPWR \$79 A|X VPB|VPWR sky130_fd_pr__pfet_01v8_hvt L=0.15 W=1
+ AS=0.15575 AD=0.355 PS=1.325 PD=2.71
M$74 A|B|C1|X \$81 VPB|VPWR VPB|VPWR sky130_fd_pr__pfet_01v8_hvt L=0.15 W=1
+ AS=0.355 AD=0.15575 PS=2.71 PD=1.325
M$75 VPB|VPWR \$82 \$81 VPB|VPWR sky130_fd_pr__pfet_01v8_hvt L=0.5 W=0.82
+ AS=0.15575 AD=0.2173 PS=1.325 PD=2.17
M$76 VPB|VPWR \$83 \$82 VPB|VPWR sky130_fd_pr__pfet_01v8_hvt L=0.5 W=0.82
+ AS=0.1701 AD=0.2173 PS=1.36 PD=2.17
M$77 VPB|VPWR A|COARSE_MUX[14] \$83 VPB|VPWR sky130_fd_pr__pfet_01v8_hvt L=0.15
+ W=1 AS=0.1701 AD=0.27 PS=1.36 PD=2.54
M$78 VPB|VPWR VGND VPB|VPWR VPB|VPWR sky130_fd_pr__pfet_01v8_hvt L=4.73 W=1044
+ AS=271.44 AD=271.44 PS=2712 PD=2712
M$81 VPB|VPWR VGND VPB|VPWR VPB|VPWR sky130_fd_pr__pfet_01v8_hvt L=1.97
+ W=146.16 AS=38.0016 AD=38.0016 PS=379.68 PD=379.68
M$87 VPB|VPWR VGND VPB|VPWR VPB|VPWR sky130_fd_pr__pfet_01v8_hvt L=1.05
+ W=147.03 AS=38.2278 AD=38.2278 PS=381.94 PD=381.94
M$92 VPB|VPWR VGND VPB|VPWR VPB|VPWR sky130_fd_pr__pfet_01v8_hvt L=2.89
+ W=205.32 AS=53.3832 AD=53.3832 PS=533.36 PD=533.36
M$96 VPB|VPWR VGND VPB|VPWR VPB|VPWR sky130_fd_pr__pfet_01v8_hvt L=0.59
+ W=108.75 AS=28.275 AD=28.275 PS=282.5 PD=282.5
M$117 A1|B|C|X \$173 VPB|VPWR VPB|VPWR sky130_fd_pr__pfet_01v8_hvt L=0.15 W=1
+ AS=0.28 AD=0.169 PS=2.56 PD=1.365
M$118 VPB|VPWR A1|B|C|SLEEP|X \$174 VPB|VPWR sky130_fd_pr__pfet_01v8_hvt L=0.15
+ W=0.64 AS=0.169 AD=0.1792 PS=1.365 PD=1.84
M$119 \$175 A1|B|C|SLEEP|X \$173 VPB|VPWR sky130_fd_pr__pfet_01v8_hvt L=0.15
+ W=0.84 AS=0.273 AD=0.15295 PS=2.33 PD=1.315
M$120 \$173 \$174 \$176 VPB|VPWR sky130_fd_pr__pfet_01v8_hvt L=0.15 W=0.84
+ AS=0.15295 AD=0.32235 PS=1.315 PD=2.45
M$121 VPB|VPWR A|B|B1|X \$177 VPB|VPWR sky130_fd_pr__pfet_01v8_hvt L=0.15 W=1
+ AS=0.25655 AD=0.26 PS=2.52 PD=2.52
M$122 \$175 A|B|B1|X \$179 VPB|VPWR sky130_fd_pr__pfet_01v8_hvt L=0.15 W=0.64
+ AS=0.1458 AD=0.246 PS=1.205 PD=1.525
M$123 \$175 \$177 \$178 VPB|VPWR sky130_fd_pr__pfet_01v8_hvt L=0.15 W=0.84
+ AS=0.1458 AD=0.1715 PS=1.205 PD=1.355
M$124 \$178 A|B|B1|X \$176 VPB|VPWR sky130_fd_pr__pfet_01v8_hvt L=0.15 W=0.84
+ AS=0.3528 AD=0.2431 PS=2.52 PD=1.445
M$125 \$176 \$177 \$179 VPB|VPWR sky130_fd_pr__pfet_01v8_hvt L=0.15 W=0.64
+ AS=0.2431 AD=0.246 PS=1.445 PD=1.525
M$126 \$178 A|Y VPB|VPWR VPB|VPWR sky130_fd_pr__pfet_01v8_hvt L=0.15 W=1
+ AS=0.1715 AD=0.135 PS=1.355 PD=1.27
M$127 VPB|VPWR \$178 \$179 VPB|VPWR sky130_fd_pr__pfet_01v8_hvt L=0.15 W=1
+ AS=0.135 AD=0.285 PS=1.27 PD=2.57
M$128 VPB|VPWR \$182 A|A1|Y VPB|VPWR sky130_fd_pr__pfet_01v8_hvt L=0.15 W=1
+ AS=0.36 AD=0.165 PS=2.72 PD=1.33
M$129 A|A1|Y A1|B|C|SLEEP|X \$259 VPB|VPWR sky130_fd_pr__pfet_01v8_hvt L=0.15
+ W=1 AS=0.165 AD=0.105 PS=1.33 PD=1.21
M$130 \$259 A|Y VPB|VPWR VPB|VPWR sky130_fd_pr__pfet_01v8_hvt L=0.15 W=1
+ AS=0.105 AD=0.365 PS=1.21 PD=1.73
M$131 VPB|VPWR A|Y \$182 VPB|VPWR sky130_fd_pr__pfet_01v8_hvt L=0.15 W=1
+ AS=0.365 AD=0.135 PS=1.73 PD=1.27
M$132 \$182 A1|B|C|SLEEP|X VPB|VPWR VPB|VPWR sky130_fd_pr__pfet_01v8_hvt L=0.15
+ W=1 AS=0.135 AD=0.3 PS=1.27 PD=2.6
M$133 VPB|VPWR A|B1|X A|Y VPB|VPWR sky130_fd_pr__pfet_01v8_hvt L=0.15 W=10.36
+ AS=2.3347 AD=2.0836 PS=19.975 PD=19.46
M$136 A1|B|C|SLEEP|X \$183 VPB|VPWR VPB|VPWR sky130_fd_pr__pfet_01v8_hvt L=0.15
+ W=1 AS=0.28 AD=0.169 PS=2.56 PD=1.365
M$137 VPB|VPWR A1|B|C|X \$184 VPB|VPWR sky130_fd_pr__pfet_01v8_hvt L=0.15
+ W=0.64 AS=0.169 AD=0.1792 PS=1.365 PD=1.84
M$138 \$185 A1|B|C|X \$183 VPB|VPWR sky130_fd_pr__pfet_01v8_hvt L=0.15 W=0.84
+ AS=0.273 AD=0.15295 PS=2.33 PD=1.315
M$139 \$183 \$184 \$186 VPB|VPWR sky130_fd_pr__pfet_01v8_hvt L=0.15 W=0.84
+ AS=0.15295 AD=0.32235 PS=1.315 PD=2.45
M$140 VPB|VPWR A|B|B1|X \$187 VPB|VPWR sky130_fd_pr__pfet_01v8_hvt L=0.15 W=1
+ AS=0.25655 AD=0.26 PS=2.52 PD=2.52
M$141 \$185 A|B|B1|X \$189 VPB|VPWR sky130_fd_pr__pfet_01v8_hvt L=0.15 W=0.64
+ AS=0.1458 AD=0.246 PS=1.205 PD=1.525
M$142 \$185 \$187 \$188 VPB|VPWR sky130_fd_pr__pfet_01v8_hvt L=0.15 W=0.84
+ AS=0.1458 AD=0.1715 PS=1.205 PD=1.355
M$143 \$188 A|B|B1|X \$186 VPB|VPWR sky130_fd_pr__pfet_01v8_hvt L=0.15 W=0.84
+ AS=0.3528 AD=0.2431 PS=2.52 PD=1.445
M$144 \$186 \$187 \$189 VPB|VPWR sky130_fd_pr__pfet_01v8_hvt L=0.15 W=0.64
+ AS=0.2431 AD=0.246 PS=1.445 PD=1.525
M$145 \$188 A|X VPB|VPWR VPB|VPWR sky130_fd_pr__pfet_01v8_hvt L=0.15 W=1
+ AS=0.1715 AD=0.135 PS=1.355 PD=1.27
M$146 VPB|VPWR \$188 \$189 VPB|VPWR sky130_fd_pr__pfet_01v8_hvt L=0.15 W=1
+ AS=0.135 AD=0.285 PS=1.27 PD=2.57
M$147 VPB|VPWR A|X A|B1|Y VPB|VPWR sky130_fd_pr__pfet_01v8_hvt L=0.15 W=6.36
+ AS=1.2236 AD=1.4222 PS=11.74 PD=13.15
M$149 A1|B|C|X \$191 VPB|VPWR VPB|VPWR sky130_fd_pr__pfet_01v8_hvt L=0.15 W=1
+ AS=0.28 AD=0.2115 PS=2.56 PD=1.45
M$150 VPB|VPWR B|C|X \$192 VPB|VPWR sky130_fd_pr__pfet_01v8_hvt L=0.15 W=0.64
+ AS=0.2115 AD=0.1792 PS=1.45 PD=1.84
M$151 \$194 B|C|X \$191 VPB|VPWR sky130_fd_pr__pfet_01v8_hvt L=0.15 W=0.84
+ AS=0.2688 AD=0.1596 PS=2.32 PD=1.22
M$152 \$191 \$192 \$195 VPB|VPWR sky130_fd_pr__pfet_01v8_hvt L=0.15 W=0.84
+ AS=0.1596 AD=0.441 PS=1.22 PD=2.73
M$153 VPB|VPWR A|B|B1|X \$196 VPB|VPWR sky130_fd_pr__pfet_01v8_hvt L=0.15 W=1
+ AS=0.26 AD=0.2526 PS=2.52 PD=2.52
M$154 \$195 A|B|B1|X \$198 VPB|VPWR sky130_fd_pr__pfet_01v8_hvt L=0.15 W=0.64
+ AS=0.1458 AD=0.246 PS=1.205 PD=1.525
M$155 \$195 \$196 \$197 VPB|VPWR sky130_fd_pr__pfet_01v8_hvt L=0.15 W=0.84
+ AS=0.1458 AD=0.1715 PS=1.205 PD=1.355
M$156 \$197 A|B|B1|X \$194 VPB|VPWR sky130_fd_pr__pfet_01v8_hvt L=0.15 W=0.84
+ AS=0.3536 AD=0.2452 PS=2.53 PD=1.45
M$157 \$194 \$196 \$198 VPB|VPWR sky130_fd_pr__pfet_01v8_hvt L=0.15 W=0.64
+ AS=0.2452 AD=0.246 PS=1.45 PD=1.525
M$158 \$197 A|B1|X VPB|VPWR VPB|VPWR sky130_fd_pr__pfet_01v8_hvt L=0.15 W=1
+ AS=0.1715 AD=0.135 PS=1.355 PD=1.27
M$159 VPB|VPWR \$197 \$198 VPB|VPWR sky130_fd_pr__pfet_01v8_hvt L=0.15 W=1
+ AS=0.135 AD=0.285 PS=1.27 PD=2.57
M$160 VPB|VPWR B|C|X \$200 VPB|VPWR sky130_fd_pr__pfet_01v8_hvt L=0.15 W=0.42
+ AS=0.1841 AD=0.0609 PS=1.26 PD=0.71
M$161 \$200 A|B1|X VPB|VPWR VPB|VPWR sky130_fd_pr__pfet_01v8_hvt L=0.15 W=0.42
+ AS=0.0609 AD=0.1113 PS=0.71 PD=1.37
M$162 A|B2|X \$200 VPB|VPWR VPB|VPWR sky130_fd_pr__pfet_01v8_hvt L=0.15 W=0.64
+ AS=0.1696 AD=0.1841 PS=1.81 PD=1.26
M$163 VPB|VPWR \$202 \$203 VPB|VPWR sky130_fd_pr__pfet_01v8_hvt L=0.5 W=0.82
+ AS=0.1701 AD=0.2173 PS=1.36 PD=2.17
M$164 \$202 A|MID_MUX[5] VPB|VPWR VPB|VPWR sky130_fd_pr__pfet_01v8_hvt L=0.15
+ W=1 AS=0.27 AD=0.1701 PS=2.54 PD=1.36
M$165 \$204 \$203 VPB|VPWR VPB|VPWR sky130_fd_pr__pfet_01v8_hvt L=0.5 W=0.82
+ AS=0.2173 AD=0.15575 PS=2.17 PD=1.325
M$166 VPB|VPWR \$204 A|B1|X VPB|VPWR sky130_fd_pr__pfet_01v8_hvt L=0.15 W=1
+ AS=0.15575 AD=0.355 PS=1.325 PD=2.71
M$167 VPB|VPWR A|B1|X A2|Y VPB|VPWR sky130_fd_pr__pfet_01v8_hvt L=0.15 W=1
+ AS=0.26 AD=0.135 PS=2.52 PD=1.27
M$168 A2|Y B|C|X VPB|VPWR VPB|VPWR sky130_fd_pr__pfet_01v8_hvt L=0.15 W=3
+ AS=0.4625 AD=0.54075 PS=3.925 PD=5.125
M$169 B|C|X \$206 VPB|VPWR VPB|VPWR sky130_fd_pr__pfet_01v8_hvt L=0.15 W=1
+ AS=0.28 AD=0.2115 PS=2.56 PD=1.45
M$170 VPB|VPWR A|A2|B|C|X \$207 VPB|VPWR sky130_fd_pr__pfet_01v8_hvt L=0.15
+ W=0.64 AS=0.2115 AD=0.1792 PS=1.45 PD=1.84
M$171 \$208 A|A2|B|C|X \$206 VPB|VPWR sky130_fd_pr__pfet_01v8_hvt L=0.15 W=0.84
+ AS=0.2688 AD=0.1596 PS=2.32 PD=1.22
M$172 \$206 \$207 \$209 VPB|VPWR sky130_fd_pr__pfet_01v8_hvt L=0.15 W=0.84
+ AS=0.1596 AD=0.441 PS=1.22 PD=2.73
M$173 VPB|VPWR A|B|B1|X \$210 VPB|VPWR sky130_fd_pr__pfet_01v8_hvt L=0.15 W=1
+ AS=0.26 AD=0.2526 PS=2.52 PD=2.52
M$174 \$209 A|B|B1|X \$212 VPB|VPWR sky130_fd_pr__pfet_01v8_hvt L=0.15 W=0.64
+ AS=0.1458 AD=0.246 PS=1.205 PD=1.525
M$175 \$209 \$210 \$211 VPB|VPWR sky130_fd_pr__pfet_01v8_hvt L=0.15 W=0.84
+ AS=0.1458 AD=0.1715 PS=1.205 PD=1.355
M$176 \$211 A|B|B1|X \$208 VPB|VPWR sky130_fd_pr__pfet_01v8_hvt L=0.15 W=0.84
+ AS=0.3536 AD=0.2452 PS=2.53 PD=1.45
M$177 \$208 \$210 \$212 VPB|VPWR sky130_fd_pr__pfet_01v8_hvt L=0.15 W=0.64
+ AS=0.2452 AD=0.246 PS=1.45 PD=1.525
M$178 \$211 A|A1|B1|X VPB|VPWR VPB|VPWR sky130_fd_pr__pfet_01v8_hvt L=0.15 W=1
+ AS=0.1715 AD=0.135 PS=1.355 PD=1.27
M$179 VPB|VPWR \$211 \$212 VPB|VPWR sky130_fd_pr__pfet_01v8_hvt L=0.15 W=1
+ AS=0.135 AD=0.285 PS=1.27 PD=2.57
M$181 A2|A_N|B|B1|C|X \$213 VPB|VPWR VPB|VPWR sky130_fd_pr__pfet_01v8_hvt
+ L=0.15 W=1 AS=0.28 AD=0.169 PS=2.56 PD=1.365
M$182 VPB|VPWR C|Y \$215 VPB|VPWR sky130_fd_pr__pfet_01v8_hvt L=0.15 W=0.64
+ AS=0.169 AD=0.1792 PS=1.365 PD=1.84
M$183 \$216 C|Y \$213 VPB|VPWR sky130_fd_pr__pfet_01v8_hvt L=0.15 W=0.84
+ AS=0.273 AD=0.15295 PS=2.33 PD=1.315
M$184 \$213 \$215 \$217 VPB|VPWR sky130_fd_pr__pfet_01v8_hvt L=0.15 W=0.84
+ AS=0.15295 AD=0.32235 PS=1.315 PD=2.45
M$185 VPB|VPWR B|X \$218 VPB|VPWR sky130_fd_pr__pfet_01v8_hvt L=0.15 W=1
+ AS=0.25655 AD=0.26 PS=2.52 PD=2.52
M$186 \$216 B|X \$220 VPB|VPWR sky130_fd_pr__pfet_01v8_hvt L=0.15 W=0.64
+ AS=0.1458 AD=0.246 PS=1.205 PD=1.525
M$187 \$216 \$218 \$219 VPB|VPWR sky130_fd_pr__pfet_01v8_hvt L=0.15 W=0.84
+ AS=0.1458 AD=0.1715 PS=1.205 PD=1.355
M$188 \$219 B|X \$217 VPB|VPWR sky130_fd_pr__pfet_01v8_hvt L=0.15 W=0.84
+ AS=0.3528 AD=0.2431 PS=2.52 PD=1.445
M$189 \$217 \$218 \$220 VPB|VPWR sky130_fd_pr__pfet_01v8_hvt L=0.15 W=0.64
+ AS=0.2431 AD=0.246 PS=1.445 PD=1.525
M$190 \$219 A|Y VPB|VPWR VPB|VPWR sky130_fd_pr__pfet_01v8_hvt L=0.15 W=1
+ AS=0.1715 AD=0.135 PS=1.355 PD=1.27
M$191 VPB|VPWR \$219 \$220 VPB|VPWR sky130_fd_pr__pfet_01v8_hvt L=0.15 W=1
+ AS=0.135 AD=0.285 PS=1.27 PD=2.57
M$192 VPB|VPWR \$222 B|C|Y VPB|VPWR sky130_fd_pr__pfet_01v8_hvt L=0.15 W=1
+ AS=0.36 AD=0.165 PS=2.72 PD=1.33
M$193 B|C|Y B|X \$263 VPB|VPWR sky130_fd_pr__pfet_01v8_hvt L=0.15 W=1 AS=0.165
+ AD=0.105 PS=1.33 PD=1.21
M$194 \$263 A|Y VPB|VPWR VPB|VPWR sky130_fd_pr__pfet_01v8_hvt L=0.15 W=1
+ AS=0.105 AD=0.365 PS=1.21 PD=1.73
M$195 VPB|VPWR A|Y \$222 VPB|VPWR sky130_fd_pr__pfet_01v8_hvt L=0.15 W=1
+ AS=0.365 AD=0.135 PS=1.73 PD=1.27
M$196 \$222 B|X VPB|VPWR VPB|VPWR sky130_fd_pr__pfet_01v8_hvt L=0.15 W=1
+ AS=0.135 AD=0.3 PS=1.27 PD=2.6
M$197 A|A2|B|C|X \$223 VPB|VPWR VPB|VPWR sky130_fd_pr__pfet_01v8_hvt L=0.15 W=1
+ AS=0.28 AD=0.169 PS=2.56 PD=1.365
M$198 VPB|VPWR A|B1|C|X \$224 VPB|VPWR sky130_fd_pr__pfet_01v8_hvt L=0.15
+ W=0.64 AS=0.169 AD=0.1792 PS=1.365 PD=1.84
M$199 \$225 A|B1|C|X \$223 VPB|VPWR sky130_fd_pr__pfet_01v8_hvt L=0.15 W=0.84
+ AS=0.273 AD=0.15295 PS=2.33 PD=1.315
M$200 \$223 \$224 \$226 VPB|VPWR sky130_fd_pr__pfet_01v8_hvt L=0.15 W=0.84
+ AS=0.15295 AD=0.32235 PS=1.315 PD=2.45
M$201 VPB|VPWR B|B1|X \$227 VPB|VPWR sky130_fd_pr__pfet_01v8_hvt L=0.15 W=1
+ AS=0.25655 AD=0.26 PS=2.52 PD=2.52
M$202 \$225 B|B1|X \$229 VPB|VPWR sky130_fd_pr__pfet_01v8_hvt L=0.15 W=0.64
+ AS=0.1458 AD=0.246 PS=1.205 PD=1.525
M$203 \$225 \$227 \$228 VPB|VPWR sky130_fd_pr__pfet_01v8_hvt L=0.15 W=0.84
+ AS=0.1458 AD=0.1715 PS=1.205 PD=1.355
M$204 \$228 B|B1|X \$226 VPB|VPWR sky130_fd_pr__pfet_01v8_hvt L=0.15 W=0.84
+ AS=0.3528 AD=0.2431 PS=2.52 PD=1.445
M$205 \$226 \$227 \$229 VPB|VPWR sky130_fd_pr__pfet_01v8_hvt L=0.15 W=0.64
+ AS=0.2431 AD=0.246 PS=1.445 PD=1.525
M$206 \$228 A|A1|X VPB|VPWR VPB|VPWR sky130_fd_pr__pfet_01v8_hvt L=0.15 W=1
+ AS=0.1715 AD=0.135 PS=1.355 PD=1.27
M$207 VPB|VPWR \$228 \$229 VPB|VPWR sky130_fd_pr__pfet_01v8_hvt L=0.15 W=1
+ AS=0.135 AD=0.285 PS=1.27 PD=2.57
M$209 B|X \$230 VPB|VPWR VPB|VPWR sky130_fd_pr__pfet_01v8_hvt L=0.15 W=1
+ AS=0.28 AD=0.169 PS=2.56 PD=1.365
M$210 VPB|VPWR B|C|X \$231 VPB|VPWR sky130_fd_pr__pfet_01v8_hvt L=0.15 W=0.64
+ AS=0.169 AD=0.1792 PS=1.365 PD=1.84
M$211 \$232 B|C|X \$230 VPB|VPWR sky130_fd_pr__pfet_01v8_hvt L=0.15 W=0.84
+ AS=0.273 AD=0.15295 PS=2.33 PD=1.315
M$212 \$230 \$231 \$233 VPB|VPWR sky130_fd_pr__pfet_01v8_hvt L=0.15 W=0.84
+ AS=0.15295 AD=0.32235 PS=1.315 PD=2.45
M$213 VPB|VPWR A|B|C1|X \$234 VPB|VPWR sky130_fd_pr__pfet_01v8_hvt L=0.15 W=1
+ AS=0.25655 AD=0.26 PS=2.52 PD=2.52
M$214 \$232 A|B|C1|X \$236 VPB|VPWR sky130_fd_pr__pfet_01v8_hvt L=0.15 W=0.64
+ AS=0.1458 AD=0.246 PS=1.205 PD=1.525
M$215 \$232 \$234 \$235 VPB|VPWR sky130_fd_pr__pfet_01v8_hvt L=0.15 W=0.84
+ AS=0.1458 AD=0.1715 PS=1.205 PD=1.355
M$216 \$235 A|B|C1|X \$233 VPB|VPWR sky130_fd_pr__pfet_01v8_hvt L=0.15 W=0.84
+ AS=0.3528 AD=0.2431 PS=2.52 PD=1.445
M$217 \$233 \$234 \$236 VPB|VPWR sky130_fd_pr__pfet_01v8_hvt L=0.15 W=0.64
+ AS=0.2431 AD=0.246 PS=1.445 PD=1.525
M$218 \$235 A|B1|Y VPB|VPWR VPB|VPWR sky130_fd_pr__pfet_01v8_hvt L=0.15 W=1
+ AS=0.1715 AD=0.135 PS=1.355 PD=1.27
M$219 VPB|VPWR \$235 \$236 VPB|VPWR sky130_fd_pr__pfet_01v8_hvt L=0.15 W=1
+ AS=0.135 AD=0.285 PS=1.27 PD=2.57
M$223 B|C|X \$237 VPB|VPWR VPB|VPWR sky130_fd_pr__pfet_01v8_hvt L=0.15 W=1
+ AS=0.28 AD=0.2115 PS=2.56 PD=1.45
M$224 VPB|VPWR A2|B|C|X \$238 VPB|VPWR sky130_fd_pr__pfet_01v8_hvt L=0.15
+ W=0.64 AS=0.2115 AD=0.1792 PS=1.45 PD=1.84
M$225 \$239 A2|B|C|X \$237 VPB|VPWR sky130_fd_pr__pfet_01v8_hvt L=0.15 W=0.84
+ AS=0.2688 AD=0.1596 PS=2.32 PD=1.22
M$226 \$237 \$238 \$240 VPB|VPWR sky130_fd_pr__pfet_01v8_hvt L=0.15 W=0.84
+ AS=0.1596 AD=0.441 PS=1.22 PD=2.73
M$227 VPB|VPWR A|A1|B|C1|X \$241 VPB|VPWR sky130_fd_pr__pfet_01v8_hvt L=0.15
+ W=1 AS=0.26 AD=0.2526 PS=2.52 PD=2.52
M$228 \$240 A|A1|B|C1|X \$243 VPB|VPWR sky130_fd_pr__pfet_01v8_hvt L=0.15
+ W=0.64 AS=0.1458 AD=0.246 PS=1.205 PD=1.525
M$229 \$240 \$241 \$242 VPB|VPWR sky130_fd_pr__pfet_01v8_hvt L=0.15 W=0.84
+ AS=0.1458 AD=0.1715 PS=1.205 PD=1.355
M$230 \$242 A|A1|B|C1|X \$239 VPB|VPWR sky130_fd_pr__pfet_01v8_hvt L=0.15
+ W=0.84 AS=0.3536 AD=0.2452 PS=2.53 PD=1.45
M$231 \$239 \$241 \$243 VPB|VPWR sky130_fd_pr__pfet_01v8_hvt L=0.15 W=0.64
+ AS=0.2452 AD=0.246 PS=1.45 PD=1.525
M$232 \$242 A|A1|X VPB|VPWR VPB|VPWR sky130_fd_pr__pfet_01v8_hvt L=0.15 W=1
+ AS=0.1715 AD=0.135 PS=1.355 PD=1.27
M$233 VPB|VPWR \$242 \$243 VPB|VPWR sky130_fd_pr__pfet_01v8_hvt L=0.15 W=1
+ AS=0.135 AD=0.285 PS=1.27 PD=2.57
M$234 A2|B|C|X \$245 VPB|VPWR VPB|VPWR sky130_fd_pr__pfet_01v8_hvt L=0.15 W=1
+ AS=0.28 AD=0.169 PS=2.56 PD=1.365
M$235 VPB|VPWR B|C|X \$246 VPB|VPWR sky130_fd_pr__pfet_01v8_hvt L=0.15 W=0.64
+ AS=0.169 AD=0.1792 PS=1.365 PD=1.84
M$236 \$247 B|C|X \$245 VPB|VPWR sky130_fd_pr__pfet_01v8_hvt L=0.15 W=0.84
+ AS=0.273 AD=0.15295 PS=2.33 PD=1.315
M$237 \$245 \$246 \$248 VPB|VPWR sky130_fd_pr__pfet_01v8_hvt L=0.15 W=0.84
+ AS=0.15295 AD=0.32235 PS=1.315 PD=2.45
M$238 VPB|VPWR A|B|Y \$249 VPB|VPWR sky130_fd_pr__pfet_01v8_hvt L=0.15 W=1
+ AS=0.25655 AD=0.26 PS=2.52 PD=2.52
M$239 \$247 A|B|Y \$251 VPB|VPWR sky130_fd_pr__pfet_01v8_hvt L=0.15 W=0.64
+ AS=0.1458 AD=0.246 PS=1.205 PD=1.525
M$240 \$247 \$249 \$250 VPB|VPWR sky130_fd_pr__pfet_01v8_hvt L=0.15 W=0.84
+ AS=0.1458 AD=0.1715 PS=1.205 PD=1.355
M$241 \$250 A|B|Y \$248 VPB|VPWR sky130_fd_pr__pfet_01v8_hvt L=0.15 W=0.84
+ AS=0.3528 AD=0.2431 PS=2.52 PD=1.445
M$242 \$248 \$249 \$251 VPB|VPWR sky130_fd_pr__pfet_01v8_hvt L=0.15 W=0.64
+ AS=0.2431 AD=0.246 PS=1.445 PD=1.525
M$243 \$250 A|B|Y VPB|VPWR VPB|VPWR sky130_fd_pr__pfet_01v8_hvt L=0.15 W=1
+ AS=0.1715 AD=0.135 PS=1.355 PD=1.27
M$244 VPB|VPWR \$250 \$251 VPB|VPWR sky130_fd_pr__pfet_01v8_hvt L=0.15 W=1
+ AS=0.135 AD=0.285 PS=1.27 PD=2.57
M$245 VPB|VPWR A|X A|B|Y VPB|VPWR sky130_fd_pr__pfet_01v8_hvt L=0.15 W=6.36
+ AS=1.3486 AD=1.2272 PS=12.99 PD=11.76
M$249 VPB|VPWR \$254 \$253 VPB|VPWR sky130_fd_pr__pfet_01v8_hvt L=0.5 W=0.82
+ AS=0.15575 AD=0.2173 PS=1.325 PD=2.17
M$250 A|A1|X \$253 VPB|VPWR VPB|VPWR sky130_fd_pr__pfet_01v8_hvt L=0.15 W=1
+ AS=0.355 AD=0.15575 PS=2.71 PD=1.325
M$251 \$254 \$255 VPB|VPWR VPB|VPWR sky130_fd_pr__pfet_01v8_hvt L=0.5 W=0.82
+ AS=0.2173 AD=0.1701 PS=2.17 PD=1.36
M$252 VPB|VPWR A|COARSE_MUX[11] \$255 VPB|VPWR sky130_fd_pr__pfet_01v8_hvt
+ L=0.15 W=1 AS=0.1701 AD=0.27 PS=1.36 PD=2.54
M$253 VPB|VPWR A1|B|C|X \$290 VPB|VPWR sky130_fd_pr__pfet_01v8_hvt L=0.15
+ W=0.64 AS=0.169 AD=0.1792 PS=1.365 PD=1.84
M$254 A|A2|B|X \$289 VPB|VPWR VPB|VPWR sky130_fd_pr__pfet_01v8_hvt L=0.15 W=1
+ AS=0.28 AD=0.169 PS=2.56 PD=1.365
M$255 \$289 \$290 \$291 VPB|VPWR sky130_fd_pr__pfet_01v8_hvt L=0.15 W=0.84
+ AS=0.15295 AD=0.32235 PS=1.315 PD=2.45
M$256 \$289 A1|B|C|X \$292 VPB|VPWR sky130_fd_pr__pfet_01v8_hvt L=0.15 W=0.84
+ AS=0.15295 AD=0.273 PS=1.315 PD=2.33
M$257 VPB|VPWR A|A1|B|B1|X \$293 VPB|VPWR sky130_fd_pr__pfet_01v8_hvt L=0.15
+ W=1 AS=0.25655 AD=0.26 PS=2.52 PD=2.52
M$258 \$291 \$293 \$295 VPB|VPWR sky130_fd_pr__pfet_01v8_hvt L=0.15 W=0.64
+ AS=0.2431 AD=0.246 PS=1.445 PD=1.525
M$259 \$295 A|A1|B|B1|X \$292 VPB|VPWR sky130_fd_pr__pfet_01v8_hvt L=0.15
+ W=0.64 AS=0.246 AD=0.1458 PS=1.525 PD=1.205
M$260 \$294 A|A1|B|B1|X \$291 VPB|VPWR sky130_fd_pr__pfet_01v8_hvt L=0.15
+ W=0.84 AS=0.3528 AD=0.2431 PS=2.52 PD=1.445
M$261 \$294 \$293 \$292 VPB|VPWR sky130_fd_pr__pfet_01v8_hvt L=0.15 W=0.84
+ AS=0.1715 AD=0.1458 PS=1.355 PD=1.205
M$262 \$294 A|Y VPB|VPWR VPB|VPWR sky130_fd_pr__pfet_01v8_hvt L=0.15 W=1
+ AS=0.1715 AD=0.135 PS=1.355 PD=1.27
M$263 VPB|VPWR \$294 \$295 VPB|VPWR sky130_fd_pr__pfet_01v8_hvt L=0.15 W=1
+ AS=0.135 AD=0.285 PS=1.27 PD=2.57
M$264 VPB|VPWR A|B|C|X \$514 VPB|VPWR sky130_fd_pr__pfet_01v8_hvt L=0.15 W=0.42
+ AS=0.2492 AD=0.0441 PS=1.565 PD=0.63
M$265 \$514 A|B|Y \$297 VPB|VPWR sky130_fd_pr__pfet_01v8_hvt L=0.15 W=0.42
+ AS=0.0441 AD=0.0567 PS=0.63 PD=0.69
M$266 \$297 A|B|Y \$515 VPB|VPWR sky130_fd_pr__pfet_01v8_hvt L=0.15 W=0.42
+ AS=0.0567 AD=0.0441 PS=0.69 PD=0.63
M$267 \$515 A|Y VPB|VPWR VPB|VPWR sky130_fd_pr__pfet_01v8_hvt L=0.15 W=0.42
+ AS=0.0441 AD=0.0567 PS=0.63 PD=0.69
M$268 VPB|VPWR A|Y \$516 VPB|VPWR sky130_fd_pr__pfet_01v8_hvt L=0.15 W=0.42
+ AS=0.0567 AD=0.0441 PS=0.69 PD=0.63
M$269 \$516 A|B|C|X \$297 VPB|VPWR sky130_fd_pr__pfet_01v8_hvt L=0.15 W=0.42
+ AS=0.0441 AD=0.1092 PS=0.63 PD=1.36
M$270 B|C|X \$297 VPB|VPWR VPB|VPWR sky130_fd_pr__pfet_01v8_hvt L=0.15 W=1
+ AS=0.365 AD=0.2492 PS=2.73 PD=1.565
M$271 A|Y A1|B|C|SLEEP|X \$536 VPB|VPWR sky130_fd_pr__pfet_01v8_hvt L=0.15 W=1
+ AS=0.26 AD=0.105 PS=2.52 PD=1.21
M$272 \$536 A|Y VPB|VPWR VPB|VPWR sky130_fd_pr__pfet_01v8_hvt L=0.15 W=1
+ AS=0.105 AD=0.26 PS=1.21 PD=2.52
M$273 VPB|VPWR A|B|Y C|Y VPB|VPWR sky130_fd_pr__pfet_01v8_hvt L=0.15 W=2
+ AS=0.52 AD=0.27 PS=5.04 PD=2.54
M$274 C|Y A|B2|X VPB|VPWR VPB|VPWR sky130_fd_pr__pfet_01v8_hvt L=0.15 W=1
+ AS=0.135 AD=0.26 PS=1.27 PD=2.52
M$275 \$299 A|Y \$517 VPB|VPWR sky130_fd_pr__pfet_01v8_hvt L=0.15 W=0.42
+ AS=0.1092 AD=0.0441 PS=1.36 PD=0.63
M$276 \$517 A1|B|C|SLEEP|X VPB|VPWR VPB|VPWR sky130_fd_pr__pfet_01v8_hvt L=0.15
+ W=0.42 AS=0.0441 AD=0.14575 PS=0.63 PD=1.335
M$277 VPB|VPWR \$299 A|B2|X VPB|VPWR sky130_fd_pr__pfet_01v8_hvt L=0.15 W=1
+ AS=0.14575 AD=0.34 PS=1.335 PD=2.68
M$278 VPB|VPWR A1|B|C|X A|Y VPB|VPWR sky130_fd_pr__pfet_01v8_hvt L=0.15 W=1
+ AS=0.26 AD=0.135 PS=2.52 PD=1.27
M$279 A|Y A|X VPB|VPWR VPB|VPWR sky130_fd_pr__pfet_01v8_hvt L=0.15 W=7 AS=1.32
+ AD=1.445 PS=12.64 PD=13.89
M$280 VPB|VPWR \$488 A|B|Y VPB|VPWR sky130_fd_pr__pfet_01v8_hvt L=0.15 W=1
+ AS=0.36 AD=0.165 PS=2.72 PD=1.33
M$281 A|B|Y A1|B|C|X \$535 VPB|VPWR sky130_fd_pr__pfet_01v8_hvt L=0.15 W=1
+ AS=0.165 AD=0.105 PS=1.33 PD=1.21
M$282 \$535 A|B1|Y VPB|VPWR VPB|VPWR sky130_fd_pr__pfet_01v8_hvt L=0.15 W=1
+ AS=0.105 AD=0.365 PS=1.21 PD=1.73
M$283 VPB|VPWR A|B1|Y \$488 VPB|VPWR sky130_fd_pr__pfet_01v8_hvt L=0.15 W=1
+ AS=0.365 AD=0.135 PS=1.73 PD=1.27
M$284 \$488 A1|B|C|X VPB|VPWR VPB|VPWR sky130_fd_pr__pfet_01v8_hvt L=0.15 W=1
+ AS=0.135 AD=0.3 PS=1.27 PD=2.6
M$285 \$503 A2|Y VPB|VPWR VPB|VPWR sky130_fd_pr__pfet_01v8_hvt L=0.15 W=1
+ AS=0.265 AD=0.1475 PS=2.53 PD=1.295
M$286 VPB|VPWR A1|B|C|X \$503 VPB|VPWR sky130_fd_pr__pfet_01v8_hvt L=0.15 W=1
+ AS=0.1475 AD=0.14 PS=1.295 PD=1.28
M$287 \$503 A|B1|Y B|B2|Y VPB|VPWR sky130_fd_pr__pfet_01v8_hvt L=0.15 W=1
+ AS=0.14 AD=0.265 PS=1.28 PD=2.53
M$288 VPB|VPWR A2|A_N|B|B1|C|X \$305 VPB|VPWR sky130_fd_pr__pfet_01v8_hvt
+ L=0.15 W=0.64 AS=0.169 AD=0.1792 PS=1.365 PD=1.84
M$289 A|B|C|X \$304 VPB|VPWR VPB|VPWR sky130_fd_pr__pfet_01v8_hvt L=0.15 W=1
+ AS=0.28 AD=0.169 PS=2.56 PD=1.365
M$290 \$304 \$305 \$306 VPB|VPWR sky130_fd_pr__pfet_01v8_hvt L=0.15 W=0.84
+ AS=0.15295 AD=0.32235 PS=1.315 PD=2.45
M$291 \$304 A2|A_N|B|B1|C|X \$307 VPB|VPWR sky130_fd_pr__pfet_01v8_hvt L=0.15
+ W=0.84 AS=0.15295 AD=0.273 PS=1.315 PD=2.33
M$292 VPB|VPWR B|Y \$308 VPB|VPWR sky130_fd_pr__pfet_01v8_hvt L=0.15 W=1
+ AS=0.25655 AD=0.26 PS=2.52 PD=2.52
M$293 \$306 \$308 \$310 VPB|VPWR sky130_fd_pr__pfet_01v8_hvt L=0.15 W=0.64
+ AS=0.2431 AD=0.246 PS=1.445 PD=1.525
M$294 \$310 B|Y \$307 VPB|VPWR sky130_fd_pr__pfet_01v8_hvt L=0.15 W=0.64
+ AS=0.246 AD=0.1458 PS=1.525 PD=1.205
M$295 \$309 B|Y \$306 VPB|VPWR sky130_fd_pr__pfet_01v8_hvt L=0.15 W=0.84
+ AS=0.3528 AD=0.2431 PS=2.52 PD=1.445
M$296 \$309 \$308 \$307 VPB|VPWR sky130_fd_pr__pfet_01v8_hvt L=0.15 W=0.84
+ AS=0.1715 AD=0.1458 PS=1.355 PD=1.205
M$297 \$309 A|A1|Y VPB|VPWR VPB|VPWR sky130_fd_pr__pfet_01v8_hvt L=0.15 W=1
+ AS=0.1715 AD=0.135 PS=1.355 PD=1.27
M$298 VPB|VPWR \$309 \$310 VPB|VPWR sky130_fd_pr__pfet_01v8_hvt L=0.15 W=1
+ AS=0.135 AD=0.285 PS=1.27 PD=2.57
M$299 \$504 A2|Y VPB|VPWR VPB|VPWR sky130_fd_pr__pfet_01v8_hvt L=0.15 W=1
+ AS=0.265 AD=0.1475 PS=2.53 PD=1.295
M$300 VPB|VPWR A|A1|Y \$504 VPB|VPWR sky130_fd_pr__pfet_01v8_hvt L=0.15 W=1
+ AS=0.1475 AD=0.14 PS=1.295 PD=1.28
M$301 \$504 A2|A_N|B|B1|C|X B|Y VPB|VPWR sky130_fd_pr__pfet_01v8_hvt L=0.15 W=1
+ AS=0.14 AD=0.265 PS=1.28 PD=2.53
M$302 VPB|VPWR A|B|B1|X A|A1|Y VPB|VPWR sky130_fd_pr__pfet_01v8_hvt L=0.15 W=1
+ AS=0.26 AD=0.135 PS=2.52 PD=1.27
M$303 A|A1|Y B|C|X VPB|VPWR VPB|VPWR sky130_fd_pr__pfet_01v8_hvt L=0.15 W=3
+ AS=0.435 AD=0.655 PS=3.87 PD=6.31
M$304 B|C|X \$314 \$506 VPB|VPWR sky130_fd_pr__pfet_01v8_hvt L=0.15 W=1 AS=0.3
+ AD=0.26 PS=2.6 PD=2.52
M$305 VPB|VPWR A|A2|B|C|X \$506 VPB|VPWR sky130_fd_pr__pfet_01v8_hvt L=0.15 W=1
+ AS=0.26 AD=0.135 PS=2.52 PD=1.27
M$306 \$506 A|A1|B1|X VPB|VPWR VPB|VPWR sky130_fd_pr__pfet_01v8_hvt L=0.15 W=1
+ AS=0.135 AD=0.135 PS=1.27 PD=1.27
M$307 VPB|VPWR A|A1|B1|X \$532 VPB|VPWR sky130_fd_pr__pfet_01v8_hvt L=0.15 W=1
+ AS=0.135 AD=0.135 PS=1.27 PD=1.27
M$308 \$532 A|A2|B|C|X \$314 VPB|VPWR sky130_fd_pr__pfet_01v8_hvt L=0.15 W=1
+ AS=0.135 AD=0.26 PS=1.27 PD=2.52
M$309 VPB|VPWR B|C|Y \$316 VPB|VPWR sky130_fd_pr__pfet_01v8_hvt L=0.15 W=0.42
+ AS=0.142225 AD=0.06615 PS=1.335 PD=0.735
M$310 \$316 A|A2|B|C|X VPB|VPWR VPB|VPWR sky130_fd_pr__pfet_01v8_hvt L=0.15
+ W=0.42 AS=0.06615 AD=0.0567 PS=0.735 PD=0.69
M$311 VPB|VPWR A|A1|B1|X \$316 VPB|VPWR sky130_fd_pr__pfet_01v8_hvt L=0.15
+ W=0.42 AS=0.0567 AD=0.1092 PS=0.69 PD=1.36
M$312 A|X \$316 VPB|VPWR VPB|VPWR sky130_fd_pr__pfet_01v8_hvt L=0.15 W=1
+ AS=0.26 AD=0.142225 PS=2.52 PD=1.335
M$313 VPB|VPWR B|C|Y A1|Y VPB|VPWR sky130_fd_pr__pfet_01v8_hvt L=0.15 W=2
+ AS=0.425 AD=0.27 PS=3.85 PD=2.54
M$314 A1|Y A|B|Y VPB|VPWR VPB|VPWR sky130_fd_pr__pfet_01v8_hvt L=0.15 W=5.68
+ AS=1.2636 AD=1.0268 PS=12.18 PD=9.7
M$315 VPB|VPWR \$492 A|B|Y VPB|VPWR sky130_fd_pr__pfet_01v8_hvt L=0.15 W=1
+ AS=0.36 AD=0.165 PS=2.72 PD=1.33
M$316 A|B|Y B|B1|X \$531 VPB|VPWR sky130_fd_pr__pfet_01v8_hvt L=0.15 W=1
+ AS=0.165 AD=0.105 PS=1.33 PD=1.21
M$317 \$531 A|A1|X VPB|VPWR VPB|VPWR sky130_fd_pr__pfet_01v8_hvt L=0.15 W=1
+ AS=0.105 AD=0.365 PS=1.21 PD=1.73
M$318 VPB|VPWR A|A1|X \$492 VPB|VPWR sky130_fd_pr__pfet_01v8_hvt L=0.15 W=1
+ AS=0.365 AD=0.135 PS=1.73 PD=1.27
M$319 \$492 B|B1|X VPB|VPWR VPB|VPWR sky130_fd_pr__pfet_01v8_hvt L=0.15 W=1
+ AS=0.135 AD=0.3 PS=1.27 PD=2.6
M$320 VPB|VPWR \$493 A|C|Y VPB|VPWR sky130_fd_pr__pfet_01v8_hvt L=0.15 W=1
+ AS=0.36 AD=0.165 PS=2.72 PD=1.33
M$321 A|C|Y A|B|Y \$529 VPB|VPWR sky130_fd_pr__pfet_01v8_hvt L=0.15 W=1
+ AS=0.165 AD=0.105 PS=1.33 PD=1.21
M$322 \$529 A|B|C1|X VPB|VPWR VPB|VPWR sky130_fd_pr__pfet_01v8_hvt L=0.15 W=1
+ AS=0.105 AD=0.365 PS=1.21 PD=1.73
M$323 VPB|VPWR A|B|C1|X \$493 VPB|VPWR sky130_fd_pr__pfet_01v8_hvt L=0.15 W=1
+ AS=0.365 AD=0.135 PS=1.73 PD=1.27
M$324 \$493 A|B|Y VPB|VPWR VPB|VPWR sky130_fd_pr__pfet_01v8_hvt L=0.15 W=1
+ AS=0.135 AD=0.3 PS=1.27 PD=2.6
M$325 VPB|VPWR \$495 A2|B|Y VPB|VPWR sky130_fd_pr__pfet_01v8_hvt L=0.15 W=1
+ AS=0.36 AD=0.165 PS=2.72 PD=1.33
M$326 A2|B|Y B|X \$528 VPB|VPWR sky130_fd_pr__pfet_01v8_hvt L=0.15 W=1 AS=0.165
+ AD=0.105 PS=1.33 PD=1.21
M$327 \$528 A|B|C|Y VPB|VPWR VPB|VPWR sky130_fd_pr__pfet_01v8_hvt L=0.15 W=1
+ AS=0.105 AD=0.365 PS=1.21 PD=1.73
M$328 VPB|VPWR A|B|C|Y \$495 VPB|VPWR sky130_fd_pr__pfet_01v8_hvt L=0.15 W=1
+ AS=0.365 AD=0.135 PS=1.73 PD=1.27
M$329 \$495 B|X VPB|VPWR VPB|VPWR sky130_fd_pr__pfet_01v8_hvt L=0.15 W=1
+ AS=0.135 AD=0.3 PS=1.27 PD=2.6
M$330 VPB|VPWR \$497 A|B|Y VPB|VPWR sky130_fd_pr__pfet_01v8_hvt L=0.15 W=1
+ AS=0.36 AD=0.165 PS=2.72 PD=1.33
M$331 A|B|Y B|C|X \$526 VPB|VPWR sky130_fd_pr__pfet_01v8_hvt L=0.15 W=1
+ AS=0.165 AD=0.105 PS=1.33 PD=1.21
M$332 \$526 A|B1|Y VPB|VPWR VPB|VPWR sky130_fd_pr__pfet_01v8_hvt L=0.15 W=1
+ AS=0.105 AD=0.365 PS=1.21 PD=1.73
M$333 VPB|VPWR A|B1|Y \$497 VPB|VPWR sky130_fd_pr__pfet_01v8_hvt L=0.15 W=1
+ AS=0.365 AD=0.135 PS=1.73 PD=1.27
M$334 \$497 B|C|X VPB|VPWR VPB|VPWR sky130_fd_pr__pfet_01v8_hvt L=0.15 W=1
+ AS=0.135 AD=0.3 PS=1.27 PD=2.6
M$335 VPB|VPWR \$498 A|B|Y VPB|VPWR sky130_fd_pr__pfet_01v8_hvt L=0.15 W=1
+ AS=0.36 AD=0.165 PS=2.72 PD=1.33
M$336 A|B|Y A|B|B1_N|X \$525 VPB|VPWR sky130_fd_pr__pfet_01v8_hvt L=0.15 W=1
+ AS=0.165 AD=0.105 PS=1.33 PD=1.21
M$337 \$525 A|A1|B|C1|X VPB|VPWR VPB|VPWR sky130_fd_pr__pfet_01v8_hvt L=0.15
+ W=1 AS=0.105 AD=0.365 PS=1.21 PD=1.73
M$338 VPB|VPWR A|A1|B|C1|X \$498 VPB|VPWR sky130_fd_pr__pfet_01v8_hvt L=0.15
+ W=1 AS=0.365 AD=0.135 PS=1.73 PD=1.27
M$339 \$498 A|B|B1_N|X VPB|VPWR VPB|VPWR sky130_fd_pr__pfet_01v8_hvt L=0.15 W=1
+ AS=0.135 AD=0.3 PS=1.27 PD=2.6
M$340 A|B|B1_N|X \$328 \$510 VPB|VPWR sky130_fd_pr__pfet_01v8_hvt L=0.15 W=1
+ AS=0.3 AD=0.26 PS=2.6 PD=2.52
M$341 VPB|VPWR A2|B|C|X \$510 VPB|VPWR sky130_fd_pr__pfet_01v8_hvt L=0.15 W=1
+ AS=0.26 AD=0.135 PS=2.52 PD=1.27
M$342 \$510 A|A1|X VPB|VPWR VPB|VPWR sky130_fd_pr__pfet_01v8_hvt L=0.15 W=1
+ AS=0.135 AD=0.135 PS=1.27 PD=1.27
M$343 VPB|VPWR A|A1|X \$524 VPB|VPWR sky130_fd_pr__pfet_01v8_hvt L=0.15 W=1
+ AS=0.135 AD=0.135 PS=1.27 PD=1.27
M$344 \$524 A2|B|C|X \$328 VPB|VPWR sky130_fd_pr__pfet_01v8_hvt L=0.15 W=1
+ AS=0.135 AD=0.26 PS=1.27 PD=2.52
M$345 A|A1|X \$329 VPB|VPWR VPB|VPWR sky130_fd_pr__pfet_01v8_hvt L=0.15 W=1
+ AS=0.355 AD=0.15575 PS=2.71 PD=1.325
M$346 VPB|VPWR \$330 \$329 VPB|VPWR sky130_fd_pr__pfet_01v8_hvt L=0.5 W=0.82
+ AS=0.15575 AD=0.2173 PS=1.325 PD=2.17
M$347 VPB|VPWR \$331 \$330 VPB|VPWR sky130_fd_pr__pfet_01v8_hvt L=0.5 W=0.82
+ AS=0.1701 AD=0.2173 PS=1.36 PD=2.17
M$348 VPB|VPWR A|MID_MUX[0] \$331 VPB|VPWR sky130_fd_pr__pfet_01v8_hvt L=0.15
+ W=1 AS=0.1701 AD=0.27 PS=1.36 PD=2.54
M$349 \$333 A|COARSE_MUX[7] VPB|VPWR VPB|VPWR sky130_fd_pr__pfet_01v8_hvt
+ L=0.15 W=1 AS=0.27 AD=0.1701 PS=2.54 PD=1.36
M$350 VPB|VPWR \$333 \$334 VPB|VPWR sky130_fd_pr__pfet_01v8_hvt L=0.5 W=0.82
+ AS=0.1701 AD=0.2173 PS=1.36 PD=2.17
M$351 VPB|VPWR \$334 \$335 VPB|VPWR sky130_fd_pr__pfet_01v8_hvt L=0.5 W=0.82
+ AS=0.15575 AD=0.2173 PS=1.325 PD=2.17
M$352 VPB|VPWR \$335 A|X VPB|VPWR sky130_fd_pr__pfet_01v8_hvt L=0.15 W=1
+ AS=0.15575 AD=0.355 PS=1.325 PD=2.71
M$353 VPB|VPWR C|Y \$513 VPB|VPWR sky130_fd_pr__pfet_01v8_hvt L=0.15 W=0.42
+ AS=0.2492 AD=0.0441 PS=1.565 PD=0.63
M$354 \$513 A|B|Y \$338 VPB|VPWR sky130_fd_pr__pfet_01v8_hvt L=0.15 W=0.42
+ AS=0.0441 AD=0.0567 PS=0.63 PD=0.69
M$355 \$338 A|B|Y \$512 VPB|VPWR sky130_fd_pr__pfet_01v8_hvt L=0.15 W=0.42
+ AS=0.0567 AD=0.0441 PS=0.69 PD=0.63
M$356 \$512 A|Y VPB|VPWR VPB|VPWR sky130_fd_pr__pfet_01v8_hvt L=0.15 W=0.42
+ AS=0.0441 AD=0.0567 PS=0.63 PD=0.69
M$357 VPB|VPWR A|Y \$511 VPB|VPWR sky130_fd_pr__pfet_01v8_hvt L=0.15 W=0.42
+ AS=0.0567 AD=0.0441 PS=0.69 PD=0.63
M$358 \$511 C|Y \$338 VPB|VPWR sky130_fd_pr__pfet_01v8_hvt L=0.15 W=0.42
+ AS=0.0441 AD=0.1092 PS=0.63 PD=1.36
M$359 A2|B|X \$338 VPB|VPWR VPB|VPWR sky130_fd_pr__pfet_01v8_hvt L=0.15 W=1
+ AS=0.365 AD=0.2492 PS=2.73 PD=1.565
M$380 A|B1|Y A1|B|C|X \$576 VPB|VPWR sky130_fd_pr__pfet_01v8_hvt L=0.15 W=1
+ AS=0.26 AD=0.105 PS=2.52 PD=1.21
M$381 \$576 A|Y VPB|VPWR VPB|VPWR sky130_fd_pr__pfet_01v8_hvt L=0.15 W=1
+ AS=0.105 AD=0.26 PS=1.21 PD=2.52
M$382 VPB|VPWR A1|B|C|X \$537 VPB|VPWR sky130_fd_pr__pfet_01v8_hvt L=0.15 W=1
+ AS=0.3 AD=0.135 PS=2.6 PD=1.27
M$383 \$537 A|Y VPB|VPWR VPB|VPWR sky130_fd_pr__pfet_01v8_hvt L=0.15 W=1
+ AS=0.135 AD=0.365 PS=1.27 PD=1.73
M$384 VPB|VPWR A|Y \$577 VPB|VPWR sky130_fd_pr__pfet_01v8_hvt L=0.15 W=1
+ AS=0.365 AD=0.105 PS=1.73 PD=1.21
M$385 \$577 A1|B|C|X A|A1|Y VPB|VPWR sky130_fd_pr__pfet_01v8_hvt L=0.15 W=1
+ AS=0.105 AD=0.165 PS=1.21 PD=1.33
M$386 A|A1|Y \$537 VPB|VPWR VPB|VPWR sky130_fd_pr__pfet_01v8_hvt L=0.15 W=1
+ AS=0.165 AD=0.36 PS=1.33 PD=2.72
M$391 A|B|C|X \$539 VPB|VPWR VPB|VPWR sky130_fd_pr__pfet_01v8_hvt L=0.15 W=1
+ AS=0.28 AD=0.2115 PS=2.56 PD=1.45
M$392 VPB|VPWR C|Y \$540 VPB|VPWR sky130_fd_pr__pfet_01v8_hvt L=0.15 W=0.64
+ AS=0.2115 AD=0.1792 PS=1.45 PD=1.84
M$393 VPB|VPWR A|B|C|X \$543 VPB|VPWR sky130_fd_pr__pfet_01v8_hvt L=0.15 W=1
+ AS=0.26 AD=0.2526 PS=2.52 PD=2.52
M$394 \$542 A|B|C|X \$545 VPB|VPWR sky130_fd_pr__pfet_01v8_hvt L=0.15 W=0.64
+ AS=0.1458 AD=0.246 PS=1.205 PD=1.525
M$395 \$542 \$543 \$544 VPB|VPWR sky130_fd_pr__pfet_01v8_hvt L=0.15 W=0.84
+ AS=0.1458 AD=0.1715 PS=1.205 PD=1.355
M$396 \$544 A|B|C|X \$541 VPB|VPWR sky130_fd_pr__pfet_01v8_hvt L=0.15 W=0.84
+ AS=0.3536 AD=0.2452 PS=2.53 PD=1.45
M$397 \$541 \$543 \$545 VPB|VPWR sky130_fd_pr__pfet_01v8_hvt L=0.15 W=0.64
+ AS=0.2452 AD=0.246 PS=1.45 PD=1.525
M$398 \$544 A|B|Y VPB|VPWR VPB|VPWR sky130_fd_pr__pfet_01v8_hvt L=0.15 W=1
+ AS=0.1715 AD=0.135 PS=1.355 PD=1.27
M$399 VPB|VPWR \$544 \$545 VPB|VPWR sky130_fd_pr__pfet_01v8_hvt L=0.15 W=1
+ AS=0.135 AD=0.285 PS=1.27 PD=2.57
M$402 VPB|VPWR A|A1|Y B|Y VPB|VPWR sky130_fd_pr__pfet_01v8_hvt L=0.15 W=4.68
+ AS=0.8786 AD=0.9868 PS=8.41 PD=9.62
M$404 VPB|VPWR B|Y A|B|Y VPB|VPWR sky130_fd_pr__pfet_01v8_hvt L=0.15 W=6
+ AS=1.435 AD=0.935 PS=13.87 PD=8.87
M$405 A|B|Y A|B|B1|X VPB|VPWR VPB|VPWR sky130_fd_pr__pfet_01v8_hvt L=0.15 W=1
+ AS=0.135 AD=0.26 PS=1.27 PD=2.52
M$409 VPB|VPWR A1|B|Y A|B|Y VPB|VPWR sky130_fd_pr__pfet_01v8_hvt L=0.15 W=1
+ AS=0.26 AD=0.135 PS=2.52 PD=1.27
M$410 A|B|Y A|Y VPB|VPWR VPB|VPWR sky130_fd_pr__pfet_01v8_hvt L=0.15 W=2
+ AS=0.27 AD=0.52 PS=2.54 PD=5.04
M$412 VPB|VPWR A|B|B1|X A1|B|Y VPB|VPWR sky130_fd_pr__pfet_01v8_hvt L=0.15 W=1
+ AS=0.26 AD=0.135 PS=2.52 PD=1.27
M$413 A1|B|Y A|B|Y VPB|VPWR VPB|VPWR sky130_fd_pr__pfet_01v8_hvt L=0.15 W=1
+ AS=0.135 AD=0.26 PS=1.27 PD=2.52
M$417 VPB|VPWR B|C|X \$547 VPB|VPWR sky130_fd_pr__pfet_01v8_hvt L=0.15 W=1
+ AS=0.3 AD=0.135 PS=2.6 PD=1.27
M$418 \$547 A|B1|X VPB|VPWR VPB|VPWR sky130_fd_pr__pfet_01v8_hvt L=0.15 W=1
+ AS=0.135 AD=0.365 PS=1.27 PD=1.73
M$419 VPB|VPWR A|B1|X \$580 VPB|VPWR sky130_fd_pr__pfet_01v8_hvt L=0.15 W=1
+ AS=0.365 AD=0.105 PS=1.73 PD=1.21
M$420 \$580 B|C|X A|SLEEP|Y VPB|VPWR sky130_fd_pr__pfet_01v8_hvt L=0.15 W=1
+ AS=0.105 AD=0.165 PS=1.21 PD=1.33
M$421 A|SLEEP|Y \$547 VPB|VPWR VPB|VPWR sky130_fd_pr__pfet_01v8_hvt L=0.15 W=1
+ AS=0.165 AD=0.36 PS=1.33 PD=2.72
M$422 VPB|VPWR A|B2|X \$581 VPB|VPWR sky130_fd_pr__pfet_01v8_hvt L=0.15 W=1
+ AS=0.26 AD=0.105 PS=2.52 PD=1.21
M$423 \$581 A|B|X B|Y VPB|VPWR sky130_fd_pr__pfet_01v8_hvt L=0.15 W=1 AS=0.105
+ AD=0.26 PS=1.21 PD=2.52
M$430 A1|Y A|A2|B|C|X VPB|VPWR VPB|VPWR sky130_fd_pr__pfet_01v8_hvt L=0.15 W=1
+ AS=0.26 AD=0.165 PS=2.52 PD=1.33
M$432 A1|Y B|C|X VPB|VPWR VPB|VPWR sky130_fd_pr__pfet_01v8_hvt L=0.15 W=1
+ AS=0.135 AD=0.26 PS=1.27 PD=2.52
M$433 \$507 A|A2|B|C|X VPB|VPWR VPB|VPWR sky130_fd_pr__pfet_01v8_hvt L=0.15
+ W=0.64 AS=0.1696 AD=0.0896 PS=1.81 PD=0.92
M$434 VPB|VPWR A|A1|B1|X \$507 VPB|VPWR sky130_fd_pr__pfet_01v8_hvt L=0.15
+ W=0.64 AS=0.0896 AD=0.0896 PS=0.92 PD=0.92
M$435 \$507 \$318 C|Y VPB|VPWR sky130_fd_pr__pfet_01v8_hvt L=0.15 W=0.64
+ AS=0.0896 AD=0.1696 PS=0.92 PD=1.81
M$436 VPB|VPWR B|B1_N|Y \$318 VPB|VPWR sky130_fd_pr__pfet_01v8_hvt L=0.15
+ W=0.42 AS=0.1113 AD=0.1113 PS=1.37 PD=1.37
M$439 B|X \$551 VPB|VPWR VPB|VPWR sky130_fd_pr__pfet_01v8_hvt L=0.15 W=1
+ AS=0.36 AD=0.195 PS=2.72 PD=1.39
M$440 VPB|VPWR A1|Y \$585 VPB|VPWR sky130_fd_pr__pfet_01v8_hvt L=0.15 W=1
+ AS=0.195 AD=0.135 PS=1.39 PD=1.27
M$441 \$585 A2|B|Y \$586 VPB|VPWR sky130_fd_pr__pfet_01v8_hvt L=0.15 W=1
+ AS=0.135 AD=0.165 PS=1.27 PD=1.33
M$442 \$586 A3|B|X \$551 VPB|VPWR sky130_fd_pr__pfet_01v8_hvt L=0.15 W=1
+ AS=0.165 AD=0.2125 PS=1.33 PD=1.425
M$443 \$551 A|B1|C|X VPB|VPWR VPB|VPWR sky130_fd_pr__pfet_01v8_hvt L=0.15 W=1
+ AS=0.2125 AD=0.345 PS=1.425 PD=2.69
M$444 \$320 A|C|Y \$520 VPB|VPWR sky130_fd_pr__pfet_01v8_hvt L=0.15 W=0.42
+ AS=0.1092 AD=0.0441 PS=1.36 PD=0.63
M$445 \$520 A|Y VPB|VPWR VPB|VPWR sky130_fd_pr__pfet_01v8_hvt L=0.15 W=0.42
+ AS=0.0441 AD=0.0567 PS=0.63 PD=0.69
M$446 VPB|VPWR A|Y \$519 VPB|VPWR sky130_fd_pr__pfet_01v8_hvt L=0.15 W=0.42
+ AS=0.0567 AD=0.0441 PS=0.69 PD=0.63
M$447 \$519 B|B1_N|Y \$320 VPB|VPWR sky130_fd_pr__pfet_01v8_hvt L=0.15 W=0.42
+ AS=0.0441 AD=0.0567 PS=0.63 PD=0.69
M$448 \$320 B|B1_N|Y \$518 VPB|VPWR sky130_fd_pr__pfet_01v8_hvt L=0.15 W=0.42
+ AS=0.0567 AD=0.0441 PS=0.69 PD=0.63
M$449 VPB|VPWR A|C|Y \$518 VPB|VPWR sky130_fd_pr__pfet_01v8_hvt L=0.15 W=0.42
+ AS=0.2492 AD=0.0441 PS=1.565 PD=0.63
M$450 VPB|VPWR \$320 A|X VPB|VPWR sky130_fd_pr__pfet_01v8_hvt L=0.15 W=1
+ AS=0.2492 AD=0.365 PS=1.565 PD=2.73
M$451 VPB|VPWR A|B1|C|X B|B1_N|Y VPB|VPWR sky130_fd_pr__pfet_01v8_hvt L=0.15
+ W=1 AS=0.26 AD=0.135 PS=2.52 PD=1.27
M$452 B|B1_N|Y A|B|Y VPB|VPWR VPB|VPWR sky130_fd_pr__pfet_01v8_hvt L=0.15 W=1
+ AS=0.135 AD=0.26 PS=1.27 PD=2.52
M$455 A2|B|X \$554 VPB|VPWR VPB|VPWR sky130_fd_pr__pfet_01v8_hvt L=0.15 W=1
+ AS=0.28 AD=0.14825 PS=2.56 PD=1.34
M$456 VPB|VPWR A|C|Y \$587 VPB|VPWR sky130_fd_pr__pfet_01v8_hvt L=0.15 W=0.42
+ AS=0.14825 AD=0.0693 PS=1.34 PD=0.75
M$457 \$587 A2|B|Y \$588 VPB|VPWR sky130_fd_pr__pfet_01v8_hvt L=0.15 W=0.42
+ AS=0.0693 AD=0.0441 PS=0.75 PD=0.63
M$458 \$588 A2|B|C|SLEEP|Y \$554 VPB|VPWR sky130_fd_pr__pfet_01v8_hvt L=0.15
+ W=0.42 AS=0.0441 AD=0.1092 PS=0.63 PD=1.36
M$461 VPB|VPWR A|B|C|Y \$557 VPB|VPWR sky130_fd_pr__pfet_01v8_hvt L=0.15 W=0.42
+ AS=0.142225 AD=0.06615 PS=1.335 PD=0.735
M$462 \$557 A|B|Y VPB|VPWR VPB|VPWR sky130_fd_pr__pfet_01v8_hvt L=0.15 W=0.42
+ AS=0.06615 AD=0.0567 PS=0.735 PD=0.69
M$463 VPB|VPWR A|B|C1|X \$557 VPB|VPWR sky130_fd_pr__pfet_01v8_hvt L=0.15
+ W=0.42 AS=0.0567 AD=0.1092 PS=0.69 PD=1.36
M$464 A|X \$557 VPB|VPWR VPB|VPWR sky130_fd_pr__pfet_01v8_hvt L=0.15 W=1
+ AS=0.26 AD=0.142225 PS=2.52 PD=1.335
M$467 A1|Y A|B|C|Y VPB|VPWR VPB|VPWR sky130_fd_pr__pfet_01v8_hvt L=0.15 W=1
+ AS=0.135 AD=0.26 PS=1.27 PD=2.52
M$471 VPB|VPWR A|B|Y \$584 VPB|VPWR sky130_fd_pr__pfet_01v8_hvt L=0.15 W=1
+ AS=0.26 AD=0.105 PS=2.52 PD=1.21
M$472 \$584 A1|B|C|X A3|B|Y VPB|VPWR sky130_fd_pr__pfet_01v8_hvt L=0.15 W=1
+ AS=0.105 AD=0.26 PS=1.21 PD=2.52
M$474 VPB|VPWR A|A1|B|C1|X A1|S|Y VPB|VPWR sky130_fd_pr__pfet_01v8_hvt L=0.15
+ W=1 AS=0.26 AD=0.135 PS=2.52 PD=1.27
M$475 A1|S|Y A|B|B1_N|X VPB|VPWR VPB|VPWR sky130_fd_pr__pfet_01v8_hvt L=0.15
+ W=1 AS=0.135 AD=0.26 PS=1.27 PD=2.52
M$478 VPB|VPWR A|A1|X A1|B|Y VPB|VPWR sky130_fd_pr__pfet_01v8_hvt L=0.15 W=1
+ AS=0.26 AD=0.135 PS=2.52 PD=1.27
M$479 A1|B|Y A2|B|C|X VPB|VPWR VPB|VPWR sky130_fd_pr__pfet_01v8_hvt L=0.15 W=2
+ AS=0.395 AD=0.395 PS=3.79 PD=3.79
M$482 VPB|VPWR B|C|X \$563 VPB|VPWR sky130_fd_pr__pfet_01v8_hvt L=0.15 W=1
+ AS=0.3 AD=0.135 PS=2.6 PD=1.27
M$483 \$563 A|B|Y VPB|VPWR VPB|VPWR sky130_fd_pr__pfet_01v8_hvt L=0.15 W=1
+ AS=0.135 AD=0.365 PS=1.27 PD=1.73
M$484 VPB|VPWR A|B|Y \$578 VPB|VPWR sky130_fd_pr__pfet_01v8_hvt L=0.15 W=1
+ AS=0.365 AD=0.105 PS=1.73 PD=1.21
M$485 \$578 B|C|X B|SLEEP|Y VPB|VPWR sky130_fd_pr__pfet_01v8_hvt L=0.15 W=1
+ AS=0.105 AD=0.165 PS=1.21 PD=1.33
M$486 B|SLEEP|Y \$563 VPB|VPWR VPB|VPWR sky130_fd_pr__pfet_01v8_hvt L=0.15 W=1
+ AS=0.165 AD=0.36 PS=1.33 PD=2.72
M$487 B|C|X \$565 VPB|VPWR VPB|VPWR sky130_fd_pr__pfet_01v8_hvt L=0.15 W=1
+ AS=0.28 AD=0.169 PS=2.56 PD=1.365
M$488 VPB|VPWR B|C|X \$566 VPB|VPWR sky130_fd_pr__pfet_01v8_hvt L=0.15 W=0.64
+ AS=0.169 AD=0.1792 PS=1.365 PD=1.84
M$489 VPB|VPWR A|B|X \$570 VPB|VPWR sky130_fd_pr__pfet_01v8_hvt L=0.15 W=1
+ AS=0.25655 AD=0.26 PS=2.52 PD=2.52
M$490 \$567 A|B|X \$572 VPB|VPWR sky130_fd_pr__pfet_01v8_hvt L=0.15 W=0.64
+ AS=0.1458 AD=0.246 PS=1.205 PD=1.525
M$491 \$567 \$570 \$571 VPB|VPWR sky130_fd_pr__pfet_01v8_hvt L=0.15 W=0.84
+ AS=0.1458 AD=0.1715 PS=1.205 PD=1.355
M$492 \$571 A|B|X \$569 VPB|VPWR sky130_fd_pr__pfet_01v8_hvt L=0.15 W=0.84
+ AS=0.3528 AD=0.2431 PS=2.52 PD=1.445
M$493 \$569 \$570 \$572 VPB|VPWR sky130_fd_pr__pfet_01v8_hvt L=0.15 W=0.64
+ AS=0.2431 AD=0.246 PS=1.445 PD=1.525
M$494 \$571 A|X VPB|VPWR VPB|VPWR sky130_fd_pr__pfet_01v8_hvt L=0.15 W=1
+ AS=0.1715 AD=0.135 PS=1.355 PD=1.27
M$495 VPB|VPWR \$571 \$572 VPB|VPWR sky130_fd_pr__pfet_01v8_hvt L=0.15 W=1
+ AS=0.135 AD=0.285 PS=1.27 PD=2.57
M$496 VPB|VPWR A|B|X A|Y VPB|VPWR sky130_fd_pr__pfet_01v8_hvt L=0.15 W=8.36
+ AS=1.5886 AD=1.7472 PS=15.47 PD=16.8
M$498 B|X \$616 VPB|VPWR VPB|VPWR sky130_fd_pr__pfet_01v8_hvt L=0.15 W=1
+ AS=0.26 AD=0.26 PS=2.52 PD=2.52
M$499 \$616 A|B1|Y \$812 VPB|VPWR sky130_fd_pr__pfet_01v8_hvt L=0.15 W=1
+ AS=0.26 AD=0.1375 PS=2.52 PD=1.275
M$500 \$812 A|A1|B|B1|X VPB|VPWR VPB|VPWR sky130_fd_pr__pfet_01v8_hvt L=0.15
+ W=1 AS=0.1375 AD=0.14 PS=1.275 PD=1.28
M$501 VPB|VPWR A2|B|Y \$812 VPB|VPWR sky130_fd_pr__pfet_01v8_hvt L=0.15 W=1
+ AS=0.14 AD=0.265 PS=1.28 PD=2.53
M$502 \$541 C|Y \$539 VPB|VPWR sky130_fd_pr__pfet_01v8_hvt L=0.15 W=0.84
+ AS=0.2688 AD=0.1596 PS=2.32 PD=1.22
M$503 \$539 \$540 \$542 VPB|VPWR sky130_fd_pr__pfet_01v8_hvt L=0.15 W=0.84
+ AS=0.1596 AD=0.441 PS=1.22 PD=2.73
M$504 VPB|VPWR \$618 A_N|B|Y VPB|VPWR sky130_fd_pr__pfet_01v8_hvt L=0.15 W=1
+ AS=0.36 AD=0.165 PS=2.72 PD=1.33
M$505 A_N|B|Y A|B|C|X \$826 VPB|VPWR sky130_fd_pr__pfet_01v8_hvt L=0.15 W=1
+ AS=0.165 AD=0.105 PS=1.33 PD=1.21
M$506 \$826 A|B|Y VPB|VPWR VPB|VPWR sky130_fd_pr__pfet_01v8_hvt L=0.15 W=1
+ AS=0.105 AD=0.365 PS=1.21 PD=1.73
M$507 VPB|VPWR A|B|Y \$618 VPB|VPWR sky130_fd_pr__pfet_01v8_hvt L=0.15 W=1
+ AS=0.365 AD=0.135 PS=1.73 PD=1.27
M$508 \$618 A|B|C|X VPB|VPWR VPB|VPWR sky130_fd_pr__pfet_01v8_hvt L=0.15 W=1
+ AS=0.135 AD=0.3 PS=1.27 PD=2.6
M$509 VPB|VPWR A1|B|C|SLEEP|X \$830 VPB|VPWR sky130_fd_pr__pfet_01v8_hvt L=0.15
+ W=1 AS=0.26 AD=0.135 PS=2.52 PD=1.27
M$510 \$830 A2|B1|Y \$829 VPB|VPWR sky130_fd_pr__pfet_01v8_hvt L=0.15 W=1
+ AS=0.135 AD=0.135 PS=1.27 PD=1.27
M$511 \$829 A2|A3|B|X B|C|Y VPB|VPWR sky130_fd_pr__pfet_01v8_hvt L=0.15 W=1
+ AS=0.135 AD=0.3925 PS=1.27 PD=1.785
M$512 B|C|Y A|B1|X VPB|VPWR VPB|VPWR sky130_fd_pr__pfet_01v8_hvt L=0.15 W=3
+ AS=1.045 AD=0.735 PS=6.09 PD=6.47
M$513 VPB|VPWR A2|B1|Y \$831 VPB|VPWR sky130_fd_pr__pfet_01v8_hvt L=0.15 W=1
+ AS=0.26 AD=0.1125 PS=2.52 PD=1.225
M$514 \$831 A|B2|X A|Y VPB|VPWR sky130_fd_pr__pfet_01v8_hvt L=0.15 W=1
+ AS=0.1125 AD=0.2325 PS=1.225 PD=1.465
M$515 A|Y A|A2|B|Y \$832 VPB|VPWR sky130_fd_pr__pfet_01v8_hvt L=0.15 W=1
+ AS=0.2325 AD=0.105 PS=1.465 PD=1.21
M$516 \$832 A1|B|Y VPB|VPWR VPB|VPWR sky130_fd_pr__pfet_01v8_hvt L=0.15 W=1
+ AS=0.105 AD=0.27 PS=1.21 PD=2.54
M$517 VPB|VPWR A|Y \$834 VPB|VPWR sky130_fd_pr__pfet_01v8_hvt L=0.15 W=1
+ AS=0.26 AD=0.105 PS=2.52 PD=1.21
M$518 \$834 A|A2|B|Y B|Y VPB|VPWR sky130_fd_pr__pfet_01v8_hvt L=0.15 W=1
+ AS=0.105 AD=0.26 PS=1.21 PD=2.52
M$520 VPB|VPWR A|B|C|X A1|Y VPB|VPWR sky130_fd_pr__pfet_01v8_hvt L=0.15 W=1
+ AS=0.165 AD=0.135 PS=1.33 PD=1.27
M$521 A1|Y A|A1|B|C|Y VPB|VPWR VPB|VPWR sky130_fd_pr__pfet_01v8_hvt L=0.15 W=2
+ AS=0.395 AD=0.395 PS=3.79 PD=3.79
M$522 VPB|VPWR A|A2|B|Y \$836 VPB|VPWR sky130_fd_pr__pfet_01v8_hvt L=0.15 W=1
+ AS=0.26 AD=0.105 PS=2.52 PD=1.21
M$523 \$836 A|B|Y A2|Y VPB|VPWR sky130_fd_pr__pfet_01v8_hvt L=0.15 W=1 AS=0.105
+ AD=0.26 PS=1.21 PD=2.52
M$524 VPB|VPWR A|B|C|X A|A2|B|Y VPB|VPWR sky130_fd_pr__pfet_01v8_hvt L=0.15 W=1
+ AS=0.26 AD=0.135 PS=2.52 PD=1.27
M$525 A|A2|B|Y A|A1|B|C|Y VPB|VPWR VPB|VPWR sky130_fd_pr__pfet_01v8_hvt L=0.15
+ W=2 AS=0.395 AD=0.395 PS=3.79 PD=3.79
M$526 \$629 A|B|B1|X VPB|VPWR VPB|VPWR sky130_fd_pr__pfet_01v8_hvt L=0.15
+ W=0.42 AS=0.1092 AD=0.1573 PS=1.36 PD=1.39
M$527 VPB|VPWR A|SLEEP|Y \$839 VPB|VPWR sky130_fd_pr__pfet_01v8_hvt L=0.15 W=1
+ AS=0.1573 AD=0.105 PS=1.39 PD=1.21
M$528 \$839 \$629 A|B|X VPB|VPWR sky130_fd_pr__pfet_01v8_hvt L=0.15 W=1
+ AS=0.105 AD=0.26 PS=1.21 PD=2.52
M$529 VPB|VPWR \$630 A|A1|B|C|Y VPB|VPWR sky130_fd_pr__pfet_01v8_hvt L=0.15 W=1
+ AS=0.36 AD=0.165 PS=2.72 PD=1.33
M$530 A|A1|B|C|Y B|Y \$841 VPB|VPWR sky130_fd_pr__pfet_01v8_hvt L=0.15 W=1
+ AS=0.165 AD=0.105 PS=1.33 PD=1.21
M$531 \$841 A|A3|B|Y VPB|VPWR VPB|VPWR sky130_fd_pr__pfet_01v8_hvt L=0.15 W=1
+ AS=0.105 AD=0.365 PS=1.21 PD=1.73
M$532 VPB|VPWR A|A3|B|Y \$630 VPB|VPWR sky130_fd_pr__pfet_01v8_hvt L=0.15 W=1
+ AS=0.365 AD=0.135 PS=1.73 PD=1.27
M$533 \$630 B|Y VPB|VPWR VPB|VPWR sky130_fd_pr__pfet_01v8_hvt L=0.15 W=1
+ AS=0.135 AD=0.3 PS=1.27 PD=2.6
M$534 VPB|VPWR \$634 A|A2|B|SLEEP|Y VPB|VPWR sky130_fd_pr__pfet_01v8_hvt L=0.15
+ W=1 AS=0.36 AD=0.165 PS=2.72 PD=1.33
M$535 A|A2|B|SLEEP|Y A2|A_N|B|B1|C|X \$842 VPB|VPWR sky130_fd_pr__pfet_01v8_hvt
+ L=0.15 W=1 AS=0.165 AD=0.105 PS=1.33 PD=1.21
M$536 \$842 A|A1|Y VPB|VPWR VPB|VPWR sky130_fd_pr__pfet_01v8_hvt L=0.15 W=1
+ AS=0.105 AD=0.365 PS=1.21 PD=1.73
M$537 VPB|VPWR A|A1|Y \$634 VPB|VPWR sky130_fd_pr__pfet_01v8_hvt L=0.15 W=1
+ AS=0.365 AD=0.135 PS=1.73 PD=1.27
M$538 \$634 A2|A_N|B|B1|C|X VPB|VPWR VPB|VPWR sky130_fd_pr__pfet_01v8_hvt
+ L=0.15 W=1 AS=0.135 AD=0.3 PS=1.27 PD=2.6
M$539 VPB|VPWR A|A1|Y \$844 VPB|VPWR sky130_fd_pr__pfet_01v8_hvt L=0.15 W=1
+ AS=0.26 AD=0.135 PS=2.52 PD=1.27
M$540 \$844 A2|A_N|B|B1|C|X \$845 VPB|VPWR sky130_fd_pr__pfet_01v8_hvt L=0.15
+ W=1 AS=0.135 AD=0.135 PS=1.27 PD=1.27
M$541 \$845 A|A3|B|Y A|Y VPB|VPWR sky130_fd_pr__pfet_01v8_hvt L=0.15 W=1
+ AS=0.135 AD=0.3925 PS=1.27 PD=1.785
M$542 A|Y B1|Y VPB|VPWR VPB|VPWR sky130_fd_pr__pfet_01v8_hvt L=0.15 W=1
+ AS=0.3925 AD=0.3 PS=1.785 PD=2.6
M$543 VPB|VPWR A|X B1|Y VPB|VPWR sky130_fd_pr__pfet_01v8_hvt L=0.15 W=6.36
+ AS=1.2572 AD=1.3586 PS=11.82 PD=13.01
M$544 B1|Y B|C|X VPB|VPWR VPB|VPWR sky130_fd_pr__pfet_01v8_hvt L=0.15 W=2
+ AS=0.3 AD=0.395 PS=2.6 PD=3.79
M$545 VPB|VPWR \$640 A|A3|B|Y VPB|VPWR sky130_fd_pr__pfet_01v8_hvt L=0.15 W=1
+ AS=0.36 AD=0.165 PS=2.72 PD=1.33
M$546 A|A3|B|Y B|C|X \$843 VPB|VPWR sky130_fd_pr__pfet_01v8_hvt L=0.15 W=1
+ AS=0.165 AD=0.105 PS=1.33 PD=1.21
M$547 \$843 A|X VPB|VPWR VPB|VPWR sky130_fd_pr__pfet_01v8_hvt L=0.15 W=1
+ AS=0.105 AD=0.365 PS=1.21 PD=1.73
M$548 VPB|VPWR A|X \$640 VPB|VPWR sky130_fd_pr__pfet_01v8_hvt L=0.15 W=1
+ AS=0.365 AD=0.135 PS=1.73 PD=1.27
M$549 \$640 B|C|X VPB|VPWR VPB|VPWR sky130_fd_pr__pfet_01v8_hvt L=0.15 W=1
+ AS=0.135 AD=0.3 PS=1.27 PD=2.6
M$550 B|C|X \$642 \$815 VPB|VPWR sky130_fd_pr__pfet_01v8_hvt L=0.15 W=1 AS=0.3
+ AD=0.26 PS=2.6 PD=2.52
M$551 VPB|VPWR A2|B|Y \$815 VPB|VPWR sky130_fd_pr__pfet_01v8_hvt L=0.15 W=1
+ AS=0.26 AD=0.135 PS=2.52 PD=1.27
M$552 \$815 A|X VPB|VPWR VPB|VPWR sky130_fd_pr__pfet_01v8_hvt L=0.15 W=1
+ AS=0.135 AD=0.135 PS=1.27 PD=1.27
M$553 VPB|VPWR A|X \$840 VPB|VPWR sky130_fd_pr__pfet_01v8_hvt L=0.15 W=1
+ AS=0.135 AD=0.135 PS=1.27 PD=1.27
M$554 \$840 A2|B|Y \$642 VPB|VPWR sky130_fd_pr__pfet_01v8_hvt L=0.15 W=1
+ AS=0.135 AD=0.26 PS=1.27 PD=2.52
M$555 A|Y A2|B|Y \$837 VPB|VPWR sky130_fd_pr__pfet_01v8_hvt L=0.15 W=1 AS=0.26
+ AD=0.105 PS=2.52 PD=1.21
M$556 \$837 A|X VPB|VPWR VPB|VPWR sky130_fd_pr__pfet_01v8_hvt L=0.15 W=1
+ AS=0.105 AD=0.26 PS=1.21 PD=2.52
M$557 A3|B|X \$644 \$816 VPB|VPWR sky130_fd_pr__pfet_01v8_hvt L=0.15 W=1 AS=0.3
+ AD=0.26 PS=2.6 PD=2.52
M$558 VPB|VPWR A2|B|C|SLEEP|Y \$816 VPB|VPWR sky130_fd_pr__pfet_01v8_hvt L=0.15
+ W=1 AS=0.26 AD=0.135 PS=2.52 PD=1.27
M$559 \$816 A|X VPB|VPWR VPB|VPWR sky130_fd_pr__pfet_01v8_hvt L=0.15 W=1
+ AS=0.135 AD=0.135 PS=1.27 PD=1.27
M$560 VPB|VPWR A|X \$833 VPB|VPWR sky130_fd_pr__pfet_01v8_hvt L=0.15 W=1
+ AS=0.135 AD=0.135 PS=1.27 PD=1.27
M$561 \$833 A2|B|C|SLEEP|Y \$644 VPB|VPWR sky130_fd_pr__pfet_01v8_hvt L=0.15
+ W=1 AS=0.135 AD=0.26 PS=1.27 PD=2.52
M$562 VPB|VPWR A|B1|Y \$827 VPB|VPWR sky130_fd_pr__pfet_01v8_hvt L=0.15 W=1
+ AS=0.26 AD=0.135 PS=2.52 PD=1.27
M$563 \$827 A|B|Y \$828 VPB|VPWR sky130_fd_pr__pfet_01v8_hvt L=0.15 W=1
+ AS=0.135 AD=0.135 PS=1.27 PD=1.27
M$564 \$828 A1|B|C|X A|B1_N|Y VPB|VPWR sky130_fd_pr__pfet_01v8_hvt L=0.15 W=1
+ AS=0.135 AD=0.26 PS=1.27 PD=2.52
M$565 VPB|VPWR A1|S|Y \$646 VPB|VPWR sky130_fd_pr__pfet_01v8_hvt L=0.15 W=1
+ AS=0.26 AD=0.29 PS=2.52 PD=2.58
M$566 \$811 A1|S|Y VPB|VPWR VPB|VPWR sky130_fd_pr__pfet_01v8_hvt L=0.15 W=1
+ AS=0.26 AD=0.3 PS=2.52 PD=1.6
M$567 VPB|VPWR \$646 \$825 VPB|VPWR sky130_fd_pr__pfet_01v8_hvt L=0.15 W=1
+ AS=0.3 AD=0.1975 PS=1.6 PD=1.395
M$568 \$825 A1|B|C|X A|B|C|Y VPB|VPWR sky130_fd_pr__pfet_01v8_hvt L=0.15 W=1
+ AS=0.1975 AD=0.1525 PS=1.395 PD=1.305
M$569 A|B|C|Y A0|Y \$811 VPB|VPWR sky130_fd_pr__pfet_01v8_hvt L=0.15 W=1
+ AS=0.1525 AD=0.28 PS=1.305 PD=2.56
M$570 VPB|VPWR A2|B|C|D|X \$652 VPB|VPWR sky130_fd_pr__pfet_01v8_hvt L=0.15
+ W=0.64 AS=0.169 AD=0.1792 PS=1.365 PD=1.84
M$571 A1|B|C|X \$650 VPB|VPWR VPB|VPWR sky130_fd_pr__pfet_01v8_hvt L=0.15 W=1
+ AS=0.28 AD=0.169 PS=2.56 PD=1.365
M$572 \$650 \$652 \$653 VPB|VPWR sky130_fd_pr__pfet_01v8_hvt L=0.15 W=0.84
+ AS=0.15295 AD=0.32235 PS=1.315 PD=2.45
M$573 \$650 A2|B|C|D|X \$654 VPB|VPWR sky130_fd_pr__pfet_01v8_hvt L=0.15 W=0.84
+ AS=0.15295 AD=0.273 PS=1.315 PD=2.33
M$574 VPB|VPWR A1|B|Y \$655 VPB|VPWR sky130_fd_pr__pfet_01v8_hvt L=0.15 W=1
+ AS=0.25655 AD=0.26 PS=2.52 PD=2.52
M$575 \$653 \$655 \$657 VPB|VPWR sky130_fd_pr__pfet_01v8_hvt L=0.15 W=0.64
+ AS=0.2431 AD=0.246 PS=1.445 PD=1.525
M$576 \$657 A1|B|Y \$654 VPB|VPWR sky130_fd_pr__pfet_01v8_hvt L=0.15 W=0.64
+ AS=0.246 AD=0.1458 PS=1.525 PD=1.205
M$577 \$656 A1|B|Y \$653 VPB|VPWR sky130_fd_pr__pfet_01v8_hvt L=0.15 W=0.84
+ AS=0.3528 AD=0.2431 PS=2.52 PD=1.445
M$578 \$656 \$655 \$654 VPB|VPWR sky130_fd_pr__pfet_01v8_hvt L=0.15 W=0.84
+ AS=0.1715 AD=0.1458 PS=1.355 PD=1.205
M$579 \$656 A|A1|B|X VPB|VPWR VPB|VPWR sky130_fd_pr__pfet_01v8_hvt L=0.15 W=1
+ AS=0.1715 AD=0.135 PS=1.355 PD=1.27
M$580 VPB|VPWR \$656 \$657 VPB|VPWR sky130_fd_pr__pfet_01v8_hvt L=0.15 W=1
+ AS=0.135 AD=0.285 PS=1.27 PD=2.57
M$581 VPB|VPWR \$659 A0|Y VPB|VPWR sky130_fd_pr__pfet_01v8_hvt L=0.15 W=1
+ AS=0.36 AD=0.165 PS=2.72 PD=1.33
M$582 A0|Y A2|B|C|D|X \$823 VPB|VPWR sky130_fd_pr__pfet_01v8_hvt L=0.15 W=1
+ AS=0.165 AD=0.105 PS=1.33 PD=1.21
M$583 \$823 A|A1|B|X VPB|VPWR VPB|VPWR sky130_fd_pr__pfet_01v8_hvt L=0.15 W=1
+ AS=0.105 AD=0.365 PS=1.21 PD=1.73
M$584 VPB|VPWR A|A1|B|X \$659 VPB|VPWR sky130_fd_pr__pfet_01v8_hvt L=0.15 W=1
+ AS=0.365 AD=0.135 PS=1.73 PD=1.27
M$585 \$659 A2|B|C|D|X VPB|VPWR VPB|VPWR sky130_fd_pr__pfet_01v8_hvt L=0.15 W=1
+ AS=0.135 AD=0.3 PS=1.27 PD=2.6
M$586 A|A1|Y B|SLEEP|Y \$822 VPB|VPWR sky130_fd_pr__pfet_01v8_hvt L=0.15 W=1
+ AS=0.26 AD=0.105 PS=2.52 PD=1.21
M$587 \$822 A|B|Y VPB|VPWR VPB|VPWR sky130_fd_pr__pfet_01v8_hvt L=0.15 W=1
+ AS=0.105 AD=0.26 PS=1.21 PD=2.52
M$588 \$567 B|C|X \$565 VPB|VPWR sky130_fd_pr__pfet_01v8_hvt L=0.15 W=0.84
+ AS=0.273 AD=0.15295 PS=2.33 PD=1.315
M$589 \$565 \$566 \$569 VPB|VPWR sky130_fd_pr__pfet_01v8_hvt L=0.15 W=0.84
+ AS=0.15295 AD=0.32235 PS=1.315 PD=2.45
M$591 C|Y B|SLEEP|Y VPB|VPWR VPB|VPWR sky130_fd_pr__pfet_01v8_hvt L=0.15 W=1
+ AS=0.135 AD=0.26 PS=1.27 PD=2.52
M$592 A|B|X \$662 VPB|VPWR VPB|VPWR sky130_fd_pr__pfet_01v8_hvt L=0.15 W=1
+ AS=0.355 AD=0.15575 PS=2.71 PD=1.325
M$593 VPB|VPWR \$663 \$662 VPB|VPWR sky130_fd_pr__pfet_01v8_hvt L=0.5 W=0.82
+ AS=0.15575 AD=0.2173 PS=1.325 PD=2.17
M$594 VPB|VPWR \$664 \$663 VPB|VPWR sky130_fd_pr__pfet_01v8_hvt L=0.5 W=0.82
+ AS=0.1701 AD=0.2173 PS=1.36 PD=2.17
M$595 VPB|VPWR A|COARSE_MUX[8] \$664 VPB|VPWR sky130_fd_pr__pfet_01v8_hvt
+ L=0.15 W=1 AS=0.1701 AD=0.27 PS=1.36 PD=2.54
M$613 C|X \$847 VPB|VPWR VPB|VPWR sky130_fd_pr__pfet_01v8_hvt L=0.15 W=1
+ AS=0.36 AD=0.195 PS=2.72 PD=1.39
M$614 VPB|VPWR A|A1|Y \$892 VPB|VPWR sky130_fd_pr__pfet_01v8_hvt L=0.15 W=1
+ AS=0.195 AD=0.135 PS=1.39 PD=1.27
M$615 \$892 A|A2|B|X \$893 VPB|VPWR sky130_fd_pr__pfet_01v8_hvt L=0.15 W=1
+ AS=0.135 AD=0.165 PS=1.27 PD=1.33
M$616 \$893 A|A3|B|Y \$847 VPB|VPWR sky130_fd_pr__pfet_01v8_hvt L=0.15 W=1
+ AS=0.165 AD=0.2125 PS=1.33 PD=1.425
M$617 \$847 B1|Y VPB|VPWR VPB|VPWR sky130_fd_pr__pfet_01v8_hvt L=0.15 W=1
+ AS=0.2125 AD=0.345 PS=1.425 PD=2.69
M$619 VPB|VPWR \$849 A|A3|B|Y VPB|VPWR sky130_fd_pr__pfet_01v8_hvt L=0.15 W=1
+ AS=0.36 AD=0.165 PS=2.72 PD=1.33
M$620 A|A3|B|Y B|X \$894 VPB|VPWR sky130_fd_pr__pfet_01v8_hvt L=0.15 W=1
+ AS=0.165 AD=0.105 PS=1.33 PD=1.21
M$621 \$894 A|B|C|X VPB|VPWR VPB|VPWR sky130_fd_pr__pfet_01v8_hvt L=0.15 W=1
+ AS=0.105 AD=0.365 PS=1.21 PD=1.73
M$622 VPB|VPWR A|B|C|X \$849 VPB|VPWR sky130_fd_pr__pfet_01v8_hvt L=0.15 W=1
+ AS=0.365 AD=0.135 PS=1.73 PD=1.27
M$623 \$849 B|X VPB|VPWR VPB|VPWR sky130_fd_pr__pfet_01v8_hvt L=0.15 W=1
+ AS=0.135 AD=0.3 PS=1.27 PD=2.6
M$624 VPB|VPWR A|B|C|X B1|Y VPB|VPWR sky130_fd_pr__pfet_01v8_hvt L=0.15 W=1
+ AS=0.26 AD=0.135 PS=2.52 PD=1.27
M$625 B1|Y A2|B|Y VPB|VPWR VPB|VPWR sky130_fd_pr__pfet_01v8_hvt L=0.15 W=1
+ AS=0.135 AD=0.165 PS=1.27 PD=1.33
M$626 VPB|VPWR A|A1|B|B1|X B1|Y VPB|VPWR sky130_fd_pr__pfet_01v8_hvt L=0.15 W=1
+ AS=0.165 AD=0.26 PS=1.33 PD=2.52
M$627 VPB|VPWR A|B1|Y B|Y VPB|VPWR sky130_fd_pr__pfet_01v8_hvt L=0.15 W=4.2
+ AS=1.0792 AD=0.6758 PS=10.84 PD=6.8
M$628 B|Y A|B|C|X VPB|VPWR VPB|VPWR sky130_fd_pr__pfet_01v8_hvt L=0.15 W=2
+ AS=0.28075 AD=0.395 PS=2.605 PD=3.79
M$631 VPB|VPWR A|A1|Y A2|B|Y VPB|VPWR sky130_fd_pr__pfet_01v8_hvt L=0.15 W=1.68
+ AS=0.3486 AD=0.3318 PS=3.35 PD=3.31
M$636 A2|X \$922 \$852 VPB|VPWR sky130_fd_pr__pfet_01v8_hvt L=0.15 W=1 AS=0.3
+ AD=0.26 PS=2.6 PD=2.52
M$637 VPB|VPWR B|C|X \$852 VPB|VPWR sky130_fd_pr__pfet_01v8_hvt L=0.15 W=1
+ AS=0.26 AD=0.135 PS=2.52 PD=1.27
M$638 \$852 A|B|X VPB|VPWR VPB|VPWR sky130_fd_pr__pfet_01v8_hvt L=0.15 W=1
+ AS=0.135 AD=0.135 PS=1.27 PD=1.27
M$639 VPB|VPWR A|B|X \$896 VPB|VPWR sky130_fd_pr__pfet_01v8_hvt L=0.15 W=1
+ AS=0.135 AD=0.135 PS=1.27 PD=1.27
M$640 \$896 B|C|X \$922 VPB|VPWR sky130_fd_pr__pfet_01v8_hvt L=0.15 W=1
+ AS=0.135 AD=0.26 PS=1.27 PD=2.52
M$641 A|A1|Y A_N|B|Y \$897 VPB|VPWR sky130_fd_pr__pfet_01v8_hvt L=0.15 W=1
+ AS=0.26 AD=0.105 PS=2.52 PD=1.21
M$642 \$897 A|B|Y VPB|VPWR VPB|VPWR sky130_fd_pr__pfet_01v8_hvt L=0.15 W=1
+ AS=0.105 AD=0.26 PS=1.21 PD=2.52
M$643 VPB|VPWR A_N|B|Y \$854 VPB|VPWR sky130_fd_pr__pfet_01v8_hvt L=0.15 W=0.42
+ AS=0.14575 AD=0.1092 PS=1.335 PD=1.36
M$644 VPB|VPWR A|B|X A2|B1|Y VPB|VPWR sky130_fd_pr__pfet_01v8_hvt L=0.15 W=1
+ AS=0.14575 AD=0.135 PS=1.335 PD=1.27
M$645 A2|B1|Y \$854 VPB|VPWR VPB|VPWR sky130_fd_pr__pfet_01v8_hvt L=0.15 W=1
+ AS=0.135 AD=0.265 PS=1.27 PD=2.53
M$647 B|C|X \$856 VPB|VPWR VPB|VPWR sky130_fd_pr__pfet_01v8_hvt L=0.15 W=1
+ AS=0.36 AD=0.195 PS=2.72 PD=1.39
M$648 VPB|VPWR A|A1|Y \$898 VPB|VPWR sky130_fd_pr__pfet_01v8_hvt L=0.15 W=1
+ AS=0.195 AD=0.135 PS=1.39 PD=1.27
M$649 \$898 A2|B1|Y \$899 VPB|VPWR sky130_fd_pr__pfet_01v8_hvt L=0.15 W=1
+ AS=0.135 AD=0.165 PS=1.27 PD=1.33
M$650 \$899 A3|A_N|B|C|X \$856 VPB|VPWR sky130_fd_pr__pfet_01v8_hvt L=0.15 W=1
+ AS=0.165 AD=0.2125 PS=1.33 PD=1.425
M$651 \$856 A|B|B1|X VPB|VPWR VPB|VPWR sky130_fd_pr__pfet_01v8_hvt L=0.15 W=1
+ AS=0.2125 AD=0.345 PS=1.425 PD=2.69
M$652 A3|A_N|B|C|X \$924 \$858 VPB|VPWR sky130_fd_pr__pfet_01v8_hvt L=0.15 W=1
+ AS=0.3 AD=0.26 PS=2.6 PD=2.52
M$653 VPB|VPWR A2|A3|B|X \$858 VPB|VPWR sky130_fd_pr__pfet_01v8_hvt L=0.15 W=1
+ AS=0.26 AD=0.135 PS=2.52 PD=1.27
M$654 \$858 A|Y VPB|VPWR VPB|VPWR sky130_fd_pr__pfet_01v8_hvt L=0.15 W=1
+ AS=0.135 AD=0.135 PS=1.27 PD=1.27
M$655 VPB|VPWR A|Y \$901 VPB|VPWR sky130_fd_pr__pfet_01v8_hvt L=0.15 W=1
+ AS=0.135 AD=0.135 PS=1.27 PD=1.27
M$656 \$901 A2|A3|B|X \$924 VPB|VPWR sky130_fd_pr__pfet_01v8_hvt L=0.15 W=1
+ AS=0.135 AD=0.26 PS=1.27 PD=2.52
M$659 VPB|VPWR A1|Y \$902 VPB|VPWR sky130_fd_pr__pfet_01v8_hvt L=0.15 W=0.64
+ AS=0.1696 AD=0.0768 PS=1.81 PD=0.88
M$660 \$902 A2|A3|B|X B|C|Y VPB|VPWR sky130_fd_pr__pfet_01v8_hvt L=0.15 W=0.64
+ AS=0.0768 AD=0.0896 PS=0.88 PD=0.92
M$661 B|C|Y A|B|B1|X VPB|VPWR VPB|VPWR sky130_fd_pr__pfet_01v8_hvt L=0.15
+ W=0.64 AS=0.0896 AD=0.1824 PS=0.92 PD=1.85
M$662 A2|A3|B|X \$925 \$859 VPB|VPWR sky130_fd_pr__pfet_01v8_hvt L=0.15 W=1
+ AS=0.3 AD=0.26 PS=2.6 PD=2.52
M$663 VPB|VPWR B|Y \$859 VPB|VPWR sky130_fd_pr__pfet_01v8_hvt L=0.15 W=1
+ AS=0.26 AD=0.135 PS=2.52 PD=1.27
M$664 \$859 A|B|Y VPB|VPWR VPB|VPWR sky130_fd_pr__pfet_01v8_hvt L=0.15 W=1
+ AS=0.135 AD=0.135 PS=1.27 PD=1.27
M$665 VPB|VPWR A|B|Y \$903 VPB|VPWR sky130_fd_pr__pfet_01v8_hvt L=0.15 W=1
+ AS=0.135 AD=0.135 PS=1.27 PD=1.27
M$666 \$903 B|Y \$925 VPB|VPWR sky130_fd_pr__pfet_01v8_hvt L=0.15 W=1 AS=0.135
+ AD=0.26 PS=1.27 PD=2.52
M$670 A1|Y B|Y VPB|VPWR VPB|VPWR sky130_fd_pr__pfet_01v8_hvt L=0.15 W=1
+ AS=0.135 AD=0.26 PS=1.27 PD=2.52
M$671 A2|B|X \$861 \$905 VPB|VPWR sky130_fd_pr__pfet_01v8_hvt L=0.15 W=1
+ AS=0.26 AD=0.105 PS=2.52 PD=1.21
M$672 \$905 A|A2|B|SLEEP|Y VPB|VPWR VPB|VPWR sky130_fd_pr__pfet_01v8_hvt L=0.15
+ W=1 AS=0.105 AD=0.1573 PS=1.21 PD=1.39
M$673 VPB|VPWR A|B|X \$861 VPB|VPWR sky130_fd_pr__pfet_01v8_hvt L=0.15 W=0.42
+ AS=0.1573 AD=0.1092 PS=1.39 PD=1.36
M$674 VPB|VPWR A2|B|X \$863 VPB|VPWR sky130_fd_pr__pfet_01v8_hvt L=0.15 W=1
+ AS=0.3 AD=0.135 PS=2.6 PD=1.27
M$675 \$863 A|A1|B|C|Y VPB|VPWR VPB|VPWR sky130_fd_pr__pfet_01v8_hvt L=0.15 W=1
+ AS=0.135 AD=0.26 PS=1.27 PD=2.52
M$677 A|Y B1|Y \$863 VPB|VPWR sky130_fd_pr__pfet_01v8_hvt L=0.15 W=1 AS=0.26
+ AD=0.135 PS=2.52 PD=1.27
M$678 \$863 A|B2|X A|Y VPB|VPWR sky130_fd_pr__pfet_01v8_hvt L=0.15 W=1 AS=0.135
+ AD=0.26 PS=1.27 PD=2.52
M$679 VPB|VPWR A|SLEEP|Y \$906 VPB|VPWR sky130_fd_pr__pfet_01v8_hvt L=0.15 W=1
+ AS=0.26 AD=0.105 PS=2.52 PD=1.21
M$680 \$906 A|A2|B|SLEEP|Y B|Y VPB|VPWR sky130_fd_pr__pfet_01v8_hvt L=0.15 W=1
+ AS=0.105 AD=0.26 PS=1.21 PD=2.52
M$682 B1|Y A|A3|B|Y \$907 VPB|VPWR sky130_fd_pr__pfet_01v8_hvt L=0.15 W=1
+ AS=0.26 AD=0.105 PS=2.52 PD=1.21
M$683 \$907 A|A2|B|SLEEP|Y VPB|VPWR VPB|VPWR sky130_fd_pr__pfet_01v8_hvt L=0.15
+ W=1 AS=0.105 AD=0.26 PS=1.21 PD=2.52
M$684 VPB|VPWR A|B1|X A2|B|Y VPB|VPWR sky130_fd_pr__pfet_01v8_hvt L=0.15 W=3
+ AS=1.045 AD=0.735 PS=6.09 PD=6.47
M$685 A2|B|Y A2|A4|B|X \$908 VPB|VPWR sky130_fd_pr__pfet_01v8_hvt L=0.15 W=1
+ AS=0.135 AD=0.3125 PS=1.27 PD=1.625
M$686 \$908 A|A3|B|Y \$909 VPB|VPWR sky130_fd_pr__pfet_01v8_hvt L=0.15 W=1
+ AS=0.3125 AD=0.135 PS=1.625 PD=1.27
M$687 \$909 A|A2|B|SLEEP|Y \$910 VPB|VPWR sky130_fd_pr__pfet_01v8_hvt L=0.15
+ W=1 AS=0.135 AD=0.175 PS=1.27 PD=1.35
M$688 \$910 A1|Y VPB|VPWR VPB|VPWR sky130_fd_pr__pfet_01v8_hvt L=0.15 W=1
+ AS=0.175 AD=0.28 PS=1.35 PD=2.56
M$690 VPB|VPWR \$867 A1|Y VPB|VPWR sky130_fd_pr__pfet_01v8_hvt L=0.15 W=1
+ AS=0.36 AD=0.165 PS=2.72 PD=1.33
M$691 A1|Y B|C|X \$911 VPB|VPWR sky130_fd_pr__pfet_01v8_hvt L=0.15 W=1 AS=0.165
+ AD=0.105 PS=1.33 PD=1.21
M$692 \$911 A|B|B1|X VPB|VPWR VPB|VPWR sky130_fd_pr__pfet_01v8_hvt L=0.15 W=1
+ AS=0.105 AD=0.365 PS=1.21 PD=1.73
M$693 VPB|VPWR A|B|B1|X \$867 VPB|VPWR sky130_fd_pr__pfet_01v8_hvt L=0.15 W=1
+ AS=0.365 AD=0.135 PS=1.73 PD=1.27
M$694 \$867 B|C|X VPB|VPWR VPB|VPWR sky130_fd_pr__pfet_01v8_hvt L=0.15 W=1
+ AS=0.135 AD=0.3 PS=1.27 PD=2.6
M$695 A2|A4|B|X \$928 \$868 VPB|VPWR sky130_fd_pr__pfet_01v8_hvt L=0.15 W=1
+ AS=0.3 AD=0.26 PS=2.6 PD=2.52
M$696 VPB|VPWR A1|A2|B|X \$868 VPB|VPWR sky130_fd_pr__pfet_01v8_hvt L=0.15 W=1
+ AS=0.26 AD=0.135 PS=2.52 PD=1.27
M$697 \$868 A|Y VPB|VPWR VPB|VPWR sky130_fd_pr__pfet_01v8_hvt L=0.15 W=1
+ AS=0.135 AD=0.135 PS=1.27 PD=1.27
M$698 VPB|VPWR A|Y \$912 VPB|VPWR sky130_fd_pr__pfet_01v8_hvt L=0.15 W=1
+ AS=0.135 AD=0.135 PS=1.27 PD=1.27
M$699 \$912 A1|A2|B|X \$928 VPB|VPWR sky130_fd_pr__pfet_01v8_hvt L=0.15 W=1
+ AS=0.135 AD=0.26 PS=1.27 PD=2.52
M$700 A2|Y \$929 VPB|VPWR VPB|VPWR sky130_fd_pr__pfet_01v8_hvt L=0.15 W=1
+ AS=0.28 AD=0.1925 PS=2.56 PD=1.385
M$703 VPB|VPWR A2|A_N|B|B1|C|X \$929 VPB|VPWR sky130_fd_pr__pfet_01v8_hvt
+ L=0.15 W=0.42 AS=0.14575 AD=0.1092 PS=1.335 PD=1.36
M$705 VPB|VPWR A1|Y \$914 VPB|VPWR sky130_fd_pr__pfet_01v8_hvt L=0.15 W=0.64
+ AS=0.1696 AD=0.0768 PS=1.81 PD=0.88
M$706 \$914 A1|A2|B|X B|SLEEP|Y VPB|VPWR sky130_fd_pr__pfet_01v8_hvt L=0.15
+ W=0.64 AS=0.0768 AD=0.0896 PS=0.88 PD=0.92
M$707 B|SLEEP|Y A|A1|B1|X VPB|VPWR VPB|VPWR sky130_fd_pr__pfet_01v8_hvt L=0.15
+ W=0.64 AS=0.0896 AD=0.1824 PS=0.92 PD=1.85
M$710 A1|A2|B|X \$930 \$871 VPB|VPWR sky130_fd_pr__pfet_01v8_hvt L=0.15 W=1
+ AS=0.3 AD=0.26 PS=2.6 PD=2.52
M$711 VPB|VPWR A3|B|X \$871 VPB|VPWR sky130_fd_pr__pfet_01v8_hvt L=0.15 W=1
+ AS=0.26 AD=0.135 PS=2.52 PD=1.27
M$712 \$871 A|Y VPB|VPWR VPB|VPWR sky130_fd_pr__pfet_01v8_hvt L=0.15 W=1
+ AS=0.135 AD=0.135 PS=1.27 PD=1.27
M$713 VPB|VPWR A|Y \$917 VPB|VPWR sky130_fd_pr__pfet_01v8_hvt L=0.15 W=1
+ AS=0.135 AD=0.135 PS=1.27 PD=1.27
M$714 \$917 A3|B|X \$930 VPB|VPWR sky130_fd_pr__pfet_01v8_hvt L=0.15 W=1
+ AS=0.135 AD=0.26 PS=1.27 PD=2.52
M$717 VPB|VPWR A2|B|X A|Y VPB|VPWR sky130_fd_pr__pfet_01v8_hvt L=0.15 W=2
+ AS=0.395 AD=0.395 PS=3.79 PD=3.79
M$718 A|Y A|A1|X VPB|VPWR VPB|VPWR sky130_fd_pr__pfet_01v8_hvt L=0.15 W=4
+ AS=0.915 AD=0.755 PS=8.83 PD=6.51
M$719 A2|B|C|X \$874 VPB|VPWR VPB|VPWR sky130_fd_pr__pfet_01v8_hvt L=0.15 W=1
+ AS=0.28 AD=0.3275 PS=2.56 PD=1.655
M$720 VPB|VPWR B|B1|X \$874 VPB|VPWR sky130_fd_pr__pfet_01v8_hvt L=0.15 W=1
+ AS=0.3275 AD=0.195 PS=1.655 PD=1.39
M$721 \$874 A2|B|X \$918 VPB|VPWR sky130_fd_pr__pfet_01v8_hvt L=0.15 W=1
+ AS=0.195 AD=0.1525 PS=1.39 PD=1.305
M$722 \$918 A|A1|X VPB|VPWR VPB|VPWR sky130_fd_pr__pfet_01v8_hvt L=0.15 W=1
+ AS=0.1525 AD=0.26 PS=1.305 PD=2.52
M$725 VPB|VPWR A|A1|X \$875 VPB|VPWR sky130_fd_pr__pfet_01v8_hvt L=0.15 W=0.42
+ AS=0.1113 AD=0.0609 PS=1.37 PD=0.71
M$726 \$875 A2|B|X VPB|VPWR VPB|VPWR sky130_fd_pr__pfet_01v8_hvt L=0.15 W=0.42
+ AS=0.0609 AD=0.1841 PS=0.71 PD=1.26
M$727 VPB|VPWR \$875 A1|A1_N|C|X VPB|VPWR sky130_fd_pr__pfet_01v8_hvt L=0.15
+ W=0.64 AS=0.1841 AD=0.1696 PS=1.26 PD=1.81
M$729 VPB|VPWR A|X \$876 VPB|VPWR sky130_fd_pr__pfet_01v8_hvt L=0.15 W=0.42
+ AS=0.1573 AD=0.1092 PS=1.39 PD=1.36
M$730 VPB|VPWR A2|B|C|SLEEP|Y \$919 VPB|VPWR sky130_fd_pr__pfet_01v8_hvt L=0.15
+ W=1 AS=0.1573 AD=0.105 PS=1.39 PD=1.21
M$731 \$919 \$876 A|X VPB|VPWR sky130_fd_pr__pfet_01v8_hvt L=0.15 W=1 AS=0.105
+ AD=0.26 PS=1.21 PD=2.52
M$736 VPB|VPWR A|B1_N|Y \$878 VPB|VPWR sky130_fd_pr__pfet_01v8_hvt L=0.15
+ W=0.42 AS=0.17825 AD=0.1092 PS=1.4 PD=1.36
M$737 VPB|VPWR \$878 B|Y VPB|VPWR sky130_fd_pr__pfet_01v8_hvt L=0.15 W=1
+ AS=0.17825 AD=0.1525 PS=1.4 PD=1.305
M$738 B|Y A1|A2|Y \$916 VPB|VPWR sky130_fd_pr__pfet_01v8_hvt L=0.15 W=1
+ AS=0.1525 AD=0.1275 PS=1.305 PD=1.255
M$739 \$916 A1|S|Y VPB|VPWR VPB|VPWR sky130_fd_pr__pfet_01v8_hvt L=0.15 W=1
+ AS=0.1275 AD=0.28 PS=1.255 PD=2.56
M$743 VPB|VPWR A2|B|B1|C|Y A2|Y VPB|VPWR sky130_fd_pr__pfet_01v8_hvt L=0.15
+ W=0.64 AS=0.1824 AD=0.0896 PS=1.85 PD=0.92
M$744 A2|Y A2|B|C|X \$904 VPB|VPWR sky130_fd_pr__pfet_01v8_hvt L=0.15 W=0.64
+ AS=0.0896 AD=0.0768 PS=0.92 PD=0.88
M$745 \$904 A|A1|X VPB|VPWR VPB|VPWR sky130_fd_pr__pfet_01v8_hvt L=0.15 W=0.64
+ AS=0.0768 AD=0.1696 PS=0.88 PD=1.81
M$746 B|Y B1|Y \$882 VPB|VPWR sky130_fd_pr__pfet_01v8_hvt L=0.15 W=1 AS=0.265
+ AD=0.14 PS=2.53 PD=1.28
M$747 \$882 A1|B|Y VPB|VPWR VPB|VPWR sky130_fd_pr__pfet_01v8_hvt L=0.15 W=1
+ AS=0.14 AD=0.1475 PS=1.28 PD=1.295
M$748 VPB|VPWR A1|A2|Y \$882 VPB|VPWR sky130_fd_pr__pfet_01v8_hvt L=0.15 W=1
+ AS=0.1475 AD=0.265 PS=1.295 PD=2.53
M$751 A|A1|B|X \$883 VPB|VPWR VPB|VPWR sky130_fd_pr__pfet_01v8_hvt L=0.15 W=1
+ AS=0.34 AD=0.14575 PS=2.68 PD=1.335
M$752 VPB|VPWR B|SLEEP|Y \$895 VPB|VPWR sky130_fd_pr__pfet_01v8_hvt L=0.15
+ W=0.42 AS=0.14575 AD=0.0441 PS=1.335 PD=0.63
M$753 \$895 A|B|Y \$883 VPB|VPWR sky130_fd_pr__pfet_01v8_hvt L=0.15 W=0.42
+ AS=0.0441 AD=0.1092 PS=0.63 PD=1.36
M$754 VPB|VPWR B|C|X \$884 VPB|VPWR sky130_fd_pr__pfet_01v8_hvt L=0.15 W=1
+ AS=0.3 AD=0.135 PS=2.6 PD=1.27
M$755 \$884 A|X VPB|VPWR VPB|VPWR sky130_fd_pr__pfet_01v8_hvt L=0.15 W=1
+ AS=0.135 AD=0.365 PS=1.27 PD=1.73
M$756 VPB|VPWR A|X \$891 VPB|VPWR sky130_fd_pr__pfet_01v8_hvt L=0.15 W=1
+ AS=0.365 AD=0.105 PS=1.73 PD=1.21
M$757 \$891 B|C|X C|Y VPB|VPWR sky130_fd_pr__pfet_01v8_hvt L=0.15 W=1 AS=0.105
+ AD=0.165 PS=1.21 PD=1.33
M$758 C|Y \$884 VPB|VPWR VPB|VPWR sky130_fd_pr__pfet_01v8_hvt L=0.15 W=1
+ AS=0.165 AD=0.36 PS=1.33 PD=2.72
M$759 VPB|VPWR \$886 \$885 VPB|VPWR sky130_fd_pr__pfet_01v8_hvt L=0.5 W=0.82
+ AS=0.15575 AD=0.2173 PS=1.325 PD=2.17
M$760 A|X \$885 VPB|VPWR VPB|VPWR sky130_fd_pr__pfet_01v8_hvt L=0.15 W=1
+ AS=0.355 AD=0.15575 PS=2.71 PD=1.325
M$761 \$886 \$887 VPB|VPWR VPB|VPWR sky130_fd_pr__pfet_01v8_hvt L=0.5 W=0.82
+ AS=0.2173 AD=0.1701 PS=2.17 PD=1.36
M$762 VPB|VPWR A|COARSE_MUX[13] \$887 VPB|VPWR sky130_fd_pr__pfet_01v8_hvt
+ L=0.15 W=1 AS=0.1701 AD=0.27 PS=1.36 PD=2.54
M$779 VPB|VPWR C|X \$976 VPB|VPWR sky130_fd_pr__pfet_01v8_hvt L=0.15 W=0.64
+ AS=0.169 AD=0.1792 PS=1.365 PD=1.84
M$780 B|C|X \$975 VPB|VPWR VPB|VPWR sky130_fd_pr__pfet_01v8_hvt L=0.15 W=1
+ AS=0.28 AD=0.169 PS=2.56 PD=1.365
M$781 \$975 \$976 \$977 VPB|VPWR sky130_fd_pr__pfet_01v8_hvt L=0.15 W=0.84
+ AS=0.15295 AD=0.32235 PS=1.315 PD=2.45
M$782 \$975 C|X \$978 VPB|VPWR sky130_fd_pr__pfet_01v8_hvt L=0.15 W=0.84
+ AS=0.15295 AD=0.273 PS=1.315 PD=2.33
M$783 VPB|VPWR B|Y \$979 VPB|VPWR sky130_fd_pr__pfet_01v8_hvt L=0.15 W=1
+ AS=0.25655 AD=0.26 PS=2.52 PD=2.52
M$784 \$977 \$979 \$981 VPB|VPWR sky130_fd_pr__pfet_01v8_hvt L=0.15 W=0.64
+ AS=0.2431 AD=0.246 PS=1.445 PD=1.525
M$785 \$981 B|Y \$978 VPB|VPWR sky130_fd_pr__pfet_01v8_hvt L=0.15 W=0.64
+ AS=0.246 AD=0.1458 PS=1.525 PD=1.205
M$786 \$980 B|Y \$977 VPB|VPWR sky130_fd_pr__pfet_01v8_hvt L=0.15 W=0.84
+ AS=0.3528 AD=0.2431 PS=2.52 PD=1.445
M$787 \$980 \$979 \$978 VPB|VPWR sky130_fd_pr__pfet_01v8_hvt L=0.15 W=0.84
+ AS=0.1715 AD=0.1458 PS=1.355 PD=1.205
M$788 \$980 A|A2|SLEEP|X VPB|VPWR VPB|VPWR sky130_fd_pr__pfet_01v8_hvt L=0.15
+ W=1 AS=0.1715 AD=0.135 PS=1.355 PD=1.27
M$789 VPB|VPWR \$980 \$981 VPB|VPWR sky130_fd_pr__pfet_01v8_hvt L=0.15 W=1
+ AS=0.135 AD=0.285 PS=1.27 PD=2.57
M$791 VPB|VPWR A|A2|SLEEP|X \$983 VPB|VPWR sky130_fd_pr__pfet_01v8_hvt L=0.15
+ W=0.42 AS=0.1113 AD=0.0609 PS=1.37 PD=0.71
M$792 VPB|VPWR B|Y \$983 VPB|VPWR sky130_fd_pr__pfet_01v8_hvt L=0.15 W=0.42
+ AS=0.1841 AD=0.0609 PS=1.26 PD=0.71
M$793 VPB|VPWR \$983 B|X VPB|VPWR sky130_fd_pr__pfet_01v8_hvt L=0.15 W=0.64
+ AS=0.1841 AD=0.1696 PS=1.26 PD=1.81
M$794 A|Y C|X \$1216 VPB|VPWR sky130_fd_pr__pfet_01v8_hvt L=0.15 W=1 AS=0.26
+ AD=0.135 PS=2.52 PD=1.27
M$795 \$1216 B|X \$1217 VPB|VPWR sky130_fd_pr__pfet_01v8_hvt L=0.15 W=1
+ AS=0.135 AD=0.135 PS=1.27 PD=1.27
M$796 \$1217 A|B1|Y VPB|VPWR VPB|VPWR sky130_fd_pr__pfet_01v8_hvt L=0.15 W=1
+ AS=0.135 AD=0.26 PS=1.27 PD=2.52
M$797 VPB|VPWR A|A2|SLEEP|X \$1178 VPB|VPWR sky130_fd_pr__pfet_01v8_hvt L=0.15
+ W=1 AS=0.26 AD=0.105 PS=2.52 PD=1.21
M$798 \$1178 B|Y A|B1|Y VPB|VPWR sky130_fd_pr__pfet_01v8_hvt L=0.15 W=1
+ AS=0.105 AD=0.26 PS=1.21 PD=2.52
M$801 A|B|Y A|B1|Y \$1194 VPB|VPWR sky130_fd_pr__pfet_01v8_hvt L=0.15 W=1
+ AS=0.265 AD=0.14 PS=2.53 PD=1.28
M$802 \$1194 A|A1|Y VPB|VPWR VPB|VPWR sky130_fd_pr__pfet_01v8_hvt L=0.15 W=1
+ AS=0.14 AD=0.1475 PS=1.28 PD=1.295
M$803 VPB|VPWR A2|X \$1194 VPB|VPWR sky130_fd_pr__pfet_01v8_hvt L=0.15 W=1
+ AS=0.1475 AD=0.265 PS=1.295 PD=2.53
M$805 VPB|VPWR A1|B|C|X \$1219 VPB|VPWR sky130_fd_pr__pfet_01v8_hvt L=0.15 W=1
+ AS=0.26 AD=0.135 PS=2.52 PD=1.27
M$806 \$1219 A|A2|SLEEP|X \$1218 VPB|VPWR sky130_fd_pr__pfet_01v8_hvt L=0.15
+ W=1 AS=0.135 AD=0.135 PS=1.27 PD=1.27
M$807 \$1218 A3|Y B|Y VPB|VPWR sky130_fd_pr__pfet_01v8_hvt L=0.15 W=1 AS=0.135
+ AD=0.3925 PS=1.27 PD=1.785
M$808 B|Y A|B1|X VPB|VPWR VPB|VPWR sky130_fd_pr__pfet_01v8_hvt L=0.15 W=2.64
+ AS=0.6171 AD=0.7424 PS=3.975 PD=6.97
M$809 A|C|X \$989 VPB|VPWR VPB|VPWR sky130_fd_pr__pfet_01v8_hvt L=0.15 W=1
+ AS=0.36 AD=0.195 PS=2.72 PD=1.39
M$810 VPB|VPWR A|A1|Y \$1180 VPB|VPWR sky130_fd_pr__pfet_01v8_hvt L=0.15 W=1
+ AS=0.195 AD=0.135 PS=1.39 PD=1.27
M$811 \$1180 A|A2|SLEEP|X \$1181 VPB|VPWR sky130_fd_pr__pfet_01v8_hvt L=0.15
+ W=1 AS=0.135 AD=0.165 PS=1.27 PD=1.33
M$812 \$1181 A3|Y \$989 VPB|VPWR sky130_fd_pr__pfet_01v8_hvt L=0.15 W=1
+ AS=0.165 AD=0.2125 PS=1.33 PD=1.425
M$813 \$989 A|A1|B|B1|X VPB|VPWR VPB|VPWR sky130_fd_pr__pfet_01v8_hvt L=0.15
+ W=1 AS=0.2125 AD=0.345 PS=1.425 PD=2.69
M$814 VPB|VPWR A|B1|X \$1196 VPB|VPWR sky130_fd_pr__pfet_01v8_hvt L=0.15 W=1
+ AS=0.345 AD=0.2125 PS=2.69 PD=1.425
M$815 \$1196 A3|Y \$1221 VPB|VPWR sky130_fd_pr__pfet_01v8_hvt L=0.15 W=1
+ AS=0.2125 AD=0.165 PS=1.425 PD=1.33
M$816 \$1221 A|A2|SLEEP|X \$1220 VPB|VPWR sky130_fd_pr__pfet_01v8_hvt L=0.15
+ W=1 AS=0.165 AD=0.135 PS=1.33 PD=1.27
M$817 \$1220 A1|B|C|X VPB|VPWR VPB|VPWR sky130_fd_pr__pfet_01v8_hvt L=0.15 W=1
+ AS=0.135 AD=0.195 PS=1.27 PD=1.39
M$818 VPB|VPWR \$1196 C|X VPB|VPWR sky130_fd_pr__pfet_01v8_hvt L=0.15 W=1
+ AS=0.195 AD=0.36 PS=1.39 PD=2.72
M$819 VPB|VPWR A3|A_N|B|C|X \$990 VPB|VPWR sky130_fd_pr__pfet_01v8_hvt L=0.15
+ W=0.42 AS=0.14575 AD=0.1092 PS=1.335 PD=1.36
M$820 VPB|VPWR \$990 A3|Y VPB|VPWR sky130_fd_pr__pfet_01v8_hvt L=0.15 W=1
+ AS=0.265 AD=0.135 PS=2.53 PD=1.27
M$821 A3|Y A|B|C|X VPB|VPWR VPB|VPWR sky130_fd_pr__pfet_01v8_hvt L=0.15 W=1
+ AS=0.135 AD=0.14575 PS=1.27 PD=1.335
M$822 VPB|VPWR B|C|X \$992 VPB|VPWR sky130_fd_pr__pfet_01v8_hvt L=0.15 W=0.64
+ AS=0.169 AD=0.1792 PS=1.365 PD=1.84
M$823 A|A2|SLEEP|X \$991 VPB|VPWR VPB|VPWR sky130_fd_pr__pfet_01v8_hvt L=0.15
+ W=1 AS=0.28 AD=0.169 PS=2.56 PD=1.365
M$825 \$991 \$992 \$993 VPB|VPWR sky130_fd_pr__pfet_01v8_hvt L=0.15 W=0.84
+ AS=0.15295 AD=0.32235 PS=1.315 PD=2.45
M$826 \$991 B|C|X \$994 VPB|VPWR sky130_fd_pr__pfet_01v8_hvt L=0.15 W=0.84
+ AS=0.15295 AD=0.273 PS=1.315 PD=2.33
M$827 VPB|VPWR A|B|X \$995 VPB|VPWR sky130_fd_pr__pfet_01v8_hvt L=0.15 W=1
+ AS=0.25655 AD=0.26 PS=2.52 PD=2.52
M$828 \$993 \$995 \$997 VPB|VPWR sky130_fd_pr__pfet_01v8_hvt L=0.15 W=0.64
+ AS=0.2431 AD=0.246 PS=1.445 PD=1.525
M$829 \$997 A|B|X \$994 VPB|VPWR sky130_fd_pr__pfet_01v8_hvt L=0.15 W=0.64
+ AS=0.246 AD=0.1458 PS=1.525 PD=1.205
M$830 \$996 A|B|X \$993 VPB|VPWR sky130_fd_pr__pfet_01v8_hvt L=0.15 W=0.84
+ AS=0.3528 AD=0.2431 PS=2.52 PD=1.445
M$831 \$996 \$995 \$994 VPB|VPWR sky130_fd_pr__pfet_01v8_hvt L=0.15 W=0.84
+ AS=0.1715 AD=0.1458 PS=1.355 PD=1.205
M$832 \$996 A|A1|Y VPB|VPWR VPB|VPWR sky130_fd_pr__pfet_01v8_hvt L=0.15 W=1
+ AS=0.1715 AD=0.135 PS=1.355 PD=1.27
M$833 VPB|VPWR \$996 \$997 VPB|VPWR sky130_fd_pr__pfet_01v8_hvt L=0.15 W=1
+ AS=0.135 AD=0.285 PS=1.27 PD=2.57
M$843 A|B|X \$998 \$1169 VPB|VPWR sky130_fd_pr__pfet_01v8_hvt L=0.15 W=1 AS=0.3
+ AD=0.26 PS=2.6 PD=2.52
M$844 VPB|VPWR A2|B|X \$1169 VPB|VPWR sky130_fd_pr__pfet_01v8_hvt L=0.15 W=1
+ AS=0.26 AD=0.135 PS=2.52 PD=1.27
M$845 \$1169 A|A1|B|C|Y VPB|VPWR VPB|VPWR sky130_fd_pr__pfet_01v8_hvt L=0.15
+ W=1 AS=0.135 AD=0.135 PS=1.27 PD=1.27
M$846 VPB|VPWR A|A1|B|C|Y \$1186 VPB|VPWR sky130_fd_pr__pfet_01v8_hvt L=0.15
+ W=1 AS=0.135 AD=0.135 PS=1.27 PD=1.27
M$847 \$1186 A2|B|X \$998 VPB|VPWR sky130_fd_pr__pfet_01v8_hvt L=0.15 W=1
+ AS=0.135 AD=0.26 PS=1.27 PD=2.52
M$849 VPB|VPWR A1|Y \$1187 VPB|VPWR sky130_fd_pr__pfet_01v8_hvt L=0.15 W=1
+ AS=0.26 AD=0.1525 PS=2.52 PD=1.305
M$850 \$1187 A2|A4|B|X \$1000 VPB|VPWR sky130_fd_pr__pfet_01v8_hvt L=0.15 W=1
+ AS=0.1525 AD=0.195 PS=1.305 PD=1.39
M$851 \$1000 A|B|B1|X VPB|VPWR VPB|VPWR sky130_fd_pr__pfet_01v8_hvt L=0.15 W=1
+ AS=0.195 AD=0.3275 PS=1.39 PD=1.655
M$852 VPB|VPWR \$1000 A2|B|C|X VPB|VPWR sky130_fd_pr__pfet_01v8_hvt L=0.15 W=1
+ AS=0.3275 AD=0.28 PS=1.655 PD=2.56
M$853 VPB|VPWR \$1002 A|B|Y VPB|VPWR sky130_fd_pr__pfet_01v8_hvt L=0.15 W=1
+ AS=0.36 AD=0.165 PS=2.72 PD=1.33
M$854 A|B|Y A2|A4|B|X \$1190 VPB|VPWR sky130_fd_pr__pfet_01v8_hvt L=0.15 W=1
+ AS=0.165 AD=0.105 PS=1.33 PD=1.21
M$855 \$1190 A|Y VPB|VPWR VPB|VPWR sky130_fd_pr__pfet_01v8_hvt L=0.15 W=1
+ AS=0.105 AD=0.365 PS=1.21 PD=1.73
M$856 VPB|VPWR A|Y \$1002 VPB|VPWR sky130_fd_pr__pfet_01v8_hvt L=0.15 W=1
+ AS=0.365 AD=0.135 PS=1.73 PD=1.27
M$857 \$1002 A2|A4|B|X VPB|VPWR VPB|VPWR sky130_fd_pr__pfet_01v8_hvt L=0.15 W=1
+ AS=0.135 AD=0.3 PS=1.27 PD=2.6
M$864 VPB|VPWR A|B|B1|X A_N|C|Y VPB|VPWR sky130_fd_pr__pfet_01v8_hvt L=0.15
+ W=0.64 AS=0.1824 AD=0.0896 PS=1.85 PD=0.92
M$865 A_N|C|Y A2|Y \$1192 VPB|VPWR sky130_fd_pr__pfet_01v8_hvt L=0.15 W=0.64
+ AS=0.0896 AD=0.0768 PS=0.92 PD=0.88
M$866 \$1192 A1|A2|B|X VPB|VPWR VPB|VPWR sky130_fd_pr__pfet_01v8_hvt L=0.15
+ W=0.64 AS=0.0768 AD=0.1696 PS=0.88 PD=1.81
M$872 A|X \$1198 VPB|VPWR VPB|VPWR sky130_fd_pr__pfet_01v8_hvt L=0.15 W=1
+ AS=0.28 AD=0.169 PS=2.56 PD=1.365
M$873 VPB|VPWR A2|B|C|X \$1199 VPB|VPWR sky130_fd_pr__pfet_01v8_hvt L=0.15
+ W=0.64 AS=0.169 AD=0.1792 PS=1.365 PD=1.84
M$875 VPB|VPWR A2|A2_N|B|D|X \$1202 VPB|VPWR sky130_fd_pr__pfet_01v8_hvt L=0.15
+ W=1 AS=0.25655 AD=0.26 PS=2.52 PD=2.52
M$876 VPB|VPWR \$1007 A|A1|Y VPB|VPWR sky130_fd_pr__pfet_01v8_hvt L=0.15 W=1
+ AS=0.36 AD=0.165 PS=2.72 PD=1.33
M$877 A|A1|Y A2|A2_N|B|D|X \$1191 VPB|VPWR sky130_fd_pr__pfet_01v8_hvt L=0.15
+ W=1 AS=0.165 AD=0.105 PS=1.33 PD=1.21
M$878 \$1191 A|Y VPB|VPWR VPB|VPWR sky130_fd_pr__pfet_01v8_hvt L=0.15 W=1
+ AS=0.105 AD=0.365 PS=1.21 PD=1.73
M$879 VPB|VPWR A|Y \$1007 VPB|VPWR sky130_fd_pr__pfet_01v8_hvt L=0.15 W=1
+ AS=0.365 AD=0.135 PS=1.73 PD=1.27
M$880 \$1007 A2|A2_N|B|D|X VPB|VPWR VPB|VPWR sky130_fd_pr__pfet_01v8_hvt L=0.15
+ W=1 AS=0.135 AD=0.3 PS=1.27 PD=2.6
M$881 \$1200 A2|A2_N|B|D|X \$1204 VPB|VPWR sky130_fd_pr__pfet_01v8_hvt L=0.15
+ W=0.64 AS=0.1458 AD=0.246 PS=1.205 PD=1.525
M$882 \$1200 \$1202 \$1203 VPB|VPWR sky130_fd_pr__pfet_01v8_hvt L=0.15 W=0.84
+ AS=0.1458 AD=0.1715 PS=1.205 PD=1.355
M$883 \$1203 A2|A2_N|B|D|X \$1201 VPB|VPWR sky130_fd_pr__pfet_01v8_hvt L=0.15
+ W=0.84 AS=0.3528 AD=0.2431 PS=2.52 PD=1.445
M$884 \$1201 \$1202 \$1204 VPB|VPWR sky130_fd_pr__pfet_01v8_hvt L=0.15 W=0.64
+ AS=0.2431 AD=0.246 PS=1.445 PD=1.525
M$885 \$1203 A|Y VPB|VPWR VPB|VPWR sky130_fd_pr__pfet_01v8_hvt L=0.15 W=1
+ AS=0.1715 AD=0.135 PS=1.355 PD=1.27
M$886 VPB|VPWR \$1203 \$1204 VPB|VPWR sky130_fd_pr__pfet_01v8_hvt L=0.15 W=1
+ AS=0.135 AD=0.285 PS=1.27 PD=2.57
M$889 VPB|VPWR A1|A1_N|C|X \$1205 VPB|VPWR sky130_fd_pr__pfet_01v8_hvt L=0.15
+ W=1 AS=0.275 AD=0.135 PS=2.55 PD=1.27
M$890 \$1205 A2|A2_N|B|D|X VPB|VPWR VPB|VPWR sky130_fd_pr__pfet_01v8_hvt L=0.15
+ W=1 AS=0.135 AD=0.42 PS=1.27 PD=1.84
M$891 VPB|VPWR \$1205 B2|D|Y VPB|VPWR sky130_fd_pr__pfet_01v8_hvt L=0.15 W=1
+ AS=0.42 AD=0.135 PS=1.84 PD=1.27
M$892 B2|D|Y B2|Y \$1227 VPB|VPWR sky130_fd_pr__pfet_01v8_hvt L=0.15 W=1
+ AS=0.135 AD=0.135 PS=1.27 PD=1.27
M$893 \$1227 A|A1|A_N|B1|X VPB|VPWR VPB|VPWR sky130_fd_pr__pfet_01v8_hvt L=0.15
+ W=1 AS=0.135 AD=0.275 PS=1.27 PD=2.55
M$894 A2|A2_N|B|D|X \$1010 \$1170 VPB|VPWR sky130_fd_pr__pfet_01v8_hvt L=0.15
+ W=1 AS=0.3 AD=0.26 PS=2.6 PD=2.52
M$895 VPB|VPWR A3|B|Y \$1170 VPB|VPWR sky130_fd_pr__pfet_01v8_hvt L=0.15 W=1
+ AS=0.26 AD=0.135 PS=2.52 PD=1.27
M$896 \$1170 A|X VPB|VPWR VPB|VPWR sky130_fd_pr__pfet_01v8_hvt L=0.15 W=1
+ AS=0.135 AD=0.135 PS=1.27 PD=1.27
M$897 VPB|VPWR A|X \$1185 VPB|VPWR sky130_fd_pr__pfet_01v8_hvt L=0.15 W=1
+ AS=0.135 AD=0.135 PS=1.27 PD=1.27
M$898 \$1185 A3|B|Y \$1010 VPB|VPWR sky130_fd_pr__pfet_01v8_hvt L=0.15 W=1
+ AS=0.135 AD=0.26 PS=1.27 PD=2.52
M$900 A|A1|A_N|B1|X \$1013 VPB|VPWR VPB|VPWR sky130_fd_pr__pfet_01v8_hvt L=0.15
+ W=1 AS=0.26 AD=0.3125 PS=2.52 PD=1.625
M$901 VPB|VPWR A1|Y \$1184 VPB|VPWR sky130_fd_pr__pfet_01v8_hvt L=0.15 W=1
+ AS=0.3125 AD=0.18 PS=1.625 PD=1.36
M$902 \$1184 A2|B|C|SLEEP|Y \$1183 VPB|VPWR sky130_fd_pr__pfet_01v8_hvt L=0.15
+ W=1 AS=0.18 AD=0.21 PS=1.36 PD=1.42
M$903 \$1183 A3|B|Y \$1013 VPB|VPWR sky130_fd_pr__pfet_01v8_hvt L=0.15 W=1
+ AS=0.21 AD=0.1375 PS=1.42 PD=1.275
M$904 \$1013 B|B1|SLEEP|Y VPB|VPWR VPB|VPWR sky130_fd_pr__pfet_01v8_hvt L=0.15
+ W=1 AS=0.1375 AD=0.15 PS=1.275 PD=1.3
M$905 VPB|VPWR A|B|C1|X \$1013 VPB|VPWR sky130_fd_pr__pfet_01v8_hvt L=0.15 W=1
+ AS=0.15 AD=0.26 PS=1.3 PD=2.52
M$908 VPB|VPWR A|X \$1226 VPB|VPWR sky130_fd_pr__pfet_01v8_hvt L=0.15 W=1
+ AS=0.26 AD=0.105 PS=2.52 PD=1.21
M$909 \$1226 A3|B|Y A0|Y VPB|VPWR sky130_fd_pr__pfet_01v8_hvt L=0.15 W=1
+ AS=0.105 AD=0.26 PS=1.21 PD=2.52
M$910 VPB|VPWR \$1015 A2|B|C|SLEEP|Y VPB|VPWR sky130_fd_pr__pfet_01v8_hvt
+ L=0.15 W=1 AS=0.36 AD=0.165 PS=2.72 PD=1.33
M$911 A2|B|C|SLEEP|Y B|Y \$1182 VPB|VPWR sky130_fd_pr__pfet_01v8_hvt L=0.15 W=1
+ AS=0.165 AD=0.105 PS=1.33 PD=1.21
M$912 \$1182 A|B|Y VPB|VPWR VPB|VPWR sky130_fd_pr__pfet_01v8_hvt L=0.15 W=1
+ AS=0.105 AD=0.365 PS=1.21 PD=1.73
M$913 VPB|VPWR A|B|Y \$1015 VPB|VPWR sky130_fd_pr__pfet_01v8_hvt L=0.15 W=1
+ AS=0.365 AD=0.135 PS=1.73 PD=1.27
M$914 \$1015 B|Y VPB|VPWR VPB|VPWR sky130_fd_pr__pfet_01v8_hvt L=0.15 W=1
+ AS=0.135 AD=0.3 PS=1.27 PD=2.6
M$915 VPB|VPWR \$1208 A3|B|Y VPB|VPWR sky130_fd_pr__pfet_01v8_hvt L=0.15 W=1
+ AS=0.36 AD=0.165 PS=2.72 PD=1.33
M$916 A3|B|Y B|Y \$1225 VPB|VPWR sky130_fd_pr__pfet_01v8_hvt L=0.15 W=1
+ AS=0.165 AD=0.105 PS=1.33 PD=1.21
M$917 \$1225 A|Y VPB|VPWR VPB|VPWR sky130_fd_pr__pfet_01v8_hvt L=0.15 W=1
+ AS=0.105 AD=0.365 PS=1.21 PD=1.73
M$918 VPB|VPWR A|Y \$1208 VPB|VPWR sky130_fd_pr__pfet_01v8_hvt L=0.15 W=1
+ AS=0.365 AD=0.135 PS=1.73 PD=1.27
M$919 \$1208 B|Y VPB|VPWR VPB|VPWR sky130_fd_pr__pfet_01v8_hvt L=0.15 W=1
+ AS=0.135 AD=0.3 PS=1.27 PD=2.6
M$920 VPB|VPWR A|B1_N|Y A|Y VPB|VPWR sky130_fd_pr__pfet_01v8_hvt L=0.15 W=1
+ AS=0.26 AD=0.135 PS=2.52 PD=1.27
M$921 A|Y A|B|Y VPB|VPWR VPB|VPWR sky130_fd_pr__pfet_01v8_hvt L=0.15 W=9.68
+ AS=1.8036 AD=2.0368 PS=17.26 PD=19.72
M$925 VPB|VPWR A|B|B1_N|X \$1020 VPB|VPWR sky130_fd_pr__pfet_01v8_hvt L=0.15
+ W=0.42 AS=0.17825 AD=0.1092 PS=1.4 PD=1.36
M$926 VPB|VPWR A1|A2|Y \$1177 VPB|VPWR sky130_fd_pr__pfet_01v8_hvt L=0.15 W=1
+ AS=0.28 AD=0.1275 PS=2.56 PD=1.255
M$927 \$1177 A2|Y A2|B1|Y VPB|VPWR sky130_fd_pr__pfet_01v8_hvt L=0.15 W=1
+ AS=0.1275 AD=0.1525 PS=1.255 PD=1.305
M$928 A2|B1|Y \$1020 VPB|VPWR VPB|VPWR sky130_fd_pr__pfet_01v8_hvt L=0.15 W=1
+ AS=0.1525 AD=0.17825 PS=1.305 PD=1.4
M$930 B1|Y A2|B|B1|C|Y \$1176 VPB|VPWR sky130_fd_pr__pfet_01v8_hvt L=0.15 W=1
+ AS=0.26 AD=0.105 PS=2.52 PD=1.21
M$931 \$1176 A|A1|C1|Y VPB|VPWR VPB|VPWR sky130_fd_pr__pfet_01v8_hvt L=0.15 W=1
+ AS=0.105 AD=0.26 PS=1.21 PD=2.52
M$932 VPB|VPWR \$1022 A1|A2|Y VPB|VPWR sky130_fd_pr__pfet_01v8_hvt L=0.15 W=1
+ AS=0.36 AD=0.165 PS=2.72 PD=1.33
M$933 A1|A2|Y A2|B|C|D|X \$1175 VPB|VPWR sky130_fd_pr__pfet_01v8_hvt L=0.15 W=1
+ AS=0.165 AD=0.105 PS=1.33 PD=1.21
M$934 \$1175 A|A1|Y VPB|VPWR VPB|VPWR sky130_fd_pr__pfet_01v8_hvt L=0.15 W=1
+ AS=0.105 AD=0.365 PS=1.21 PD=1.73
M$935 VPB|VPWR A|A1|Y \$1022 VPB|VPWR sky130_fd_pr__pfet_01v8_hvt L=0.15 W=1
+ AS=0.365 AD=0.135 PS=1.73 PD=1.27
M$936 \$1022 A2|B|C|D|X VPB|VPWR VPB|VPWR sky130_fd_pr__pfet_01v8_hvt L=0.15
+ W=1 AS=0.135 AD=0.3 PS=1.27 PD=2.6
M$940 VPB|VPWR A|A1|X A|A1|C1|Y VPB|VPWR sky130_fd_pr__pfet_01v8_hvt L=0.15 W=1
+ AS=0.3 AD=0.165 PS=2.6 PD=1.33
M$941 A|A1|C1|Y A|A1|B|X VPB|VPWR VPB|VPWR sky130_fd_pr__pfet_01v8_hvt L=0.15
+ W=1 AS=0.165 AD=0.135 PS=1.33 PD=1.27
M$942 VPB|VPWR C|Y A|A1|C1|Y VPB|VPWR sky130_fd_pr__pfet_01v8_hvt L=0.15 W=1
+ AS=0.135 AD=0.135 PS=1.27 PD=1.27
M$943 A|A1|C1|Y A2|B|C|D|X VPB|VPWR VPB|VPWR sky130_fd_pr__pfet_01v8_hvt L=0.15
+ W=1 AS=0.135 AD=0.26 PS=1.27 PD=2.52
M$945 A2|B|C|D|X \$1210 \$1211 VPB|VPWR sky130_fd_pr__pfet_01v8_hvt L=0.15 W=1
+ AS=0.3 AD=0.26 PS=2.6 PD=2.52
M$946 VPB|VPWR A2|B|X \$1211 VPB|VPWR sky130_fd_pr__pfet_01v8_hvt L=0.15 W=1
+ AS=0.26 AD=0.135 PS=2.52 PD=1.27
M$947 \$1211 A|A1|Y VPB|VPWR VPB|VPWR sky130_fd_pr__pfet_01v8_hvt L=0.15 W=1
+ AS=0.135 AD=0.135 PS=1.27 PD=1.27
M$948 VPB|VPWR A|A1|Y \$1214 VPB|VPWR sky130_fd_pr__pfet_01v8_hvt L=0.15 W=1
+ AS=0.135 AD=0.135 PS=1.27 PD=1.27
M$949 \$1214 A2|B|X \$1210 VPB|VPWR sky130_fd_pr__pfet_01v8_hvt L=0.15 W=1
+ AS=0.135 AD=0.26 PS=1.27 PD=2.52
M$959 B1|Y A|A2|B|X \$1435 VPB|VPWR sky130_fd_pr__pfet_01v8_hvt L=0.15 W=1
+ AS=0.26 AD=0.105 PS=2.52 PD=1.21
M$960 \$1435 A|A1|Y VPB|VPWR VPB|VPWR sky130_fd_pr__pfet_01v8_hvt L=0.15 W=1
+ AS=0.105 AD=0.26 PS=1.21 PD=2.52
M$963 A|A0|X \$1245 \$1423 VPB|VPWR sky130_fd_pr__pfet_01v8_hvt L=0.15 W=1
+ AS=0.3 AD=0.26 PS=2.6 PD=2.52
M$964 VPB|VPWR A3|A_N|B|C|X \$1423 VPB|VPWR sky130_fd_pr__pfet_01v8_hvt L=0.15
+ W=1 AS=0.26 AD=0.135 PS=2.52 PD=1.27
M$965 \$1423 A|B|Y VPB|VPWR VPB|VPWR sky130_fd_pr__pfet_01v8_hvt L=0.15 W=1
+ AS=0.135 AD=0.135 PS=1.27 PD=1.27
M$966 VPB|VPWR A|B|Y \$1436 VPB|VPWR sky130_fd_pr__pfet_01v8_hvt L=0.15 W=1
+ AS=0.135 AD=0.135 PS=1.27 PD=1.27
M$967 \$1436 A3|A_N|B|C|X \$1245 VPB|VPWR sky130_fd_pr__pfet_01v8_hvt L=0.15
+ W=1 AS=0.135 AD=0.26 PS=1.27 PD=2.52
M$971 VPB|VPWR C|X \$1440 VPB|VPWR sky130_fd_pr__pfet_01v8_hvt L=0.15 W=0.42
+ AS=0.2492 AD=0.0441 PS=1.565 PD=0.63
M$972 \$1440 B|C|X \$1247 VPB|VPWR sky130_fd_pr__pfet_01v8_hvt L=0.15 W=0.42
+ AS=0.0441 AD=0.0567 PS=0.63 PD=0.69
M$973 \$1247 B|C|X \$1439 VPB|VPWR sky130_fd_pr__pfet_01v8_hvt L=0.15 W=0.42
+ AS=0.0567 AD=0.0441 PS=0.69 PD=0.63
M$974 \$1439 A|X VPB|VPWR VPB|VPWR sky130_fd_pr__pfet_01v8_hvt L=0.15 W=0.42
+ AS=0.0441 AD=0.0567 PS=0.63 PD=0.69
M$975 VPB|VPWR A|X \$1441 VPB|VPWR sky130_fd_pr__pfet_01v8_hvt L=0.15 W=0.42
+ AS=0.0567 AD=0.0441 PS=0.69 PD=0.63
M$976 \$1441 C|X \$1247 VPB|VPWR sky130_fd_pr__pfet_01v8_hvt L=0.15 W=0.42
+ AS=0.0441 AD=0.1092 PS=0.63 PD=1.36
M$977 B|X \$1247 VPB|VPWR VPB|VPWR sky130_fd_pr__pfet_01v8_hvt L=0.15 W=1
+ AS=0.365 AD=0.2492 PS=2.73 PD=1.565
M$980 VPB|VPWR A|X \$1444 VPB|VPWR sky130_fd_pr__pfet_01v8_hvt L=0.15 W=1
+ AS=0.26 AD=0.105 PS=2.52 PD=1.21
M$981 \$1444 B|C|Y A|Y VPB|VPWR sky130_fd_pr__pfet_01v8_hvt L=0.15 W=1 AS=0.105
+ AD=0.26 PS=1.21 PD=2.52
M$982 VPB|VPWR B|C|Y \$1255 VPB|VPWR sky130_fd_pr__pfet_01v8_hvt L=0.15 W=0.64
+ AS=0.2115 AD=0.1792 PS=1.45 PD=1.84
M$983 A|X \$1253 VPB|VPWR VPB|VPWR sky130_fd_pr__pfet_01v8_hvt L=0.15 W=1
+ AS=0.28 AD=0.2115 PS=2.56 PD=1.45
M$984 VPB|VPWR B|B2|Y \$1258 VPB|VPWR sky130_fd_pr__pfet_01v8_hvt L=0.15 W=1
+ AS=0.26 AD=0.2526 PS=2.52 PD=2.52
M$985 \$1257 \$1258 \$1260 VPB|VPWR sky130_fd_pr__pfet_01v8_hvt L=0.15 W=0.64
+ AS=0.2452 AD=0.246 PS=1.45 PD=1.525
M$986 \$1260 B|B2|Y \$1256 VPB|VPWR sky130_fd_pr__pfet_01v8_hvt L=0.15 W=0.64
+ AS=0.246 AD=0.1458 PS=1.525 PD=1.205
M$987 \$1259 B|B2|Y \$1257 VPB|VPWR sky130_fd_pr__pfet_01v8_hvt L=0.15 W=0.84
+ AS=0.3536 AD=0.2452 PS=2.53 PD=1.45
M$988 \$1259 \$1258 \$1256 VPB|VPWR sky130_fd_pr__pfet_01v8_hvt L=0.15 W=0.84
+ AS=0.1715 AD=0.1458 PS=1.355 PD=1.205
M$989 \$1259 A|B1|X VPB|VPWR VPB|VPWR sky130_fd_pr__pfet_01v8_hvt L=0.15 W=1
+ AS=0.1715 AD=0.135 PS=1.355 PD=1.27
M$990 VPB|VPWR \$1259 \$1260 VPB|VPWR sky130_fd_pr__pfet_01v8_hvt L=0.15 W=1
+ AS=0.135 AD=0.285 PS=1.27 PD=2.57
M$994 A|A1|X \$1262 \$1424 VPB|VPWR sky130_fd_pr__pfet_01v8_hvt L=0.15 W=1
+ AS=0.3 AD=0.26 PS=2.6 PD=2.52
M$995 VPB|VPWR A2|B|Y \$1424 VPB|VPWR sky130_fd_pr__pfet_01v8_hvt L=0.15 W=1
+ AS=0.26 AD=0.135 PS=2.52 PD=1.27
M$996 \$1424 A|A1|X VPB|VPWR VPB|VPWR sky130_fd_pr__pfet_01v8_hvt L=0.15 W=1
+ AS=0.135 AD=0.135 PS=1.27 PD=1.27
M$997 VPB|VPWR A|A1|X \$1448 VPB|VPWR sky130_fd_pr__pfet_01v8_hvt L=0.15 W=1
+ AS=0.135 AD=0.135 PS=1.27 PD=1.27
M$998 \$1448 A2|B|Y \$1262 VPB|VPWR sky130_fd_pr__pfet_01v8_hvt L=0.15 W=1
+ AS=0.135 AD=0.26 PS=1.27 PD=2.52
M$1000 VPB|VPWR A_N|C|Y \$1265 VPB|VPWR sky130_fd_pr__pfet_01v8_hvt L=0.15
+ W=0.64 AS=0.2115 AD=0.1792 PS=1.45 PD=1.84
M$1001 A|A1|X \$1264 VPB|VPWR VPB|VPWR sky130_fd_pr__pfet_01v8_hvt L=0.15 W=1
+ AS=0.28 AD=0.2115 PS=2.56 PD=1.45
M$1002 VPB|VPWR B|SLEEP|Y \$1268 VPB|VPWR sky130_fd_pr__pfet_01v8_hvt L=0.15
+ W=1 AS=0.26 AD=0.2526 PS=2.52 PD=2.52
M$1003 \$1267 \$1268 \$1270 VPB|VPWR sky130_fd_pr__pfet_01v8_hvt L=0.15 W=0.64
+ AS=0.2452 AD=0.246 PS=1.45 PD=1.525
M$1004 \$1270 B|SLEEP|Y \$1266 VPB|VPWR sky130_fd_pr__pfet_01v8_hvt L=0.15
+ W=0.64 AS=0.246 AD=0.1458 PS=1.525 PD=1.205
M$1005 \$1269 B|SLEEP|Y \$1267 VPB|VPWR sky130_fd_pr__pfet_01v8_hvt L=0.15
+ W=0.84 AS=0.3536 AD=0.2452 PS=2.53 PD=1.45
M$1006 \$1269 \$1268 \$1266 VPB|VPWR sky130_fd_pr__pfet_01v8_hvt L=0.15 W=0.84
+ AS=0.1715 AD=0.1458 PS=1.355 PD=1.205
M$1007 \$1269 A|Y VPB|VPWR VPB|VPWR sky130_fd_pr__pfet_01v8_hvt L=0.15 W=1
+ AS=0.1715 AD=0.135 PS=1.355 PD=1.27
M$1008 VPB|VPWR \$1269 \$1270 VPB|VPWR sky130_fd_pr__pfet_01v8_hvt L=0.15 W=1
+ AS=0.135 AD=0.285 PS=1.27 PD=2.57
M$1010 VPB|VPWR \$1273 A|Y VPB|VPWR sky130_fd_pr__pfet_01v8_hvt L=0.15 W=1
+ AS=0.36 AD=0.165 PS=2.72 PD=1.33
M$1011 A|Y B|X \$1446 VPB|VPWR sky130_fd_pr__pfet_01v8_hvt L=0.15 W=1 AS=0.165
+ AD=0.105 PS=1.33 PD=1.21
M$1012 \$1446 A|X VPB|VPWR VPB|VPWR sky130_fd_pr__pfet_01v8_hvt L=0.15 W=1
+ AS=0.105 AD=0.365 PS=1.21 PD=1.73
M$1013 VPB|VPWR A|X \$1273 VPB|VPWR sky130_fd_pr__pfet_01v8_hvt L=0.15 W=1
+ AS=0.365 AD=0.135 PS=1.73 PD=1.27
M$1014 \$1273 B|X VPB|VPWR VPB|VPWR sky130_fd_pr__pfet_01v8_hvt L=0.15 W=1
+ AS=0.135 AD=0.3 PS=1.27 PD=2.6
M$1016 \$1200 A2|B|C|X \$1198 VPB|VPWR sky130_fd_pr__pfet_01v8_hvt L=0.15
+ W=0.84 AS=0.273 AD=0.15295 PS=2.33 PD=1.315
M$1017 \$1198 \$1199 \$1201 VPB|VPWR sky130_fd_pr__pfet_01v8_hvt L=0.15 W=0.84
+ AS=0.15295 AD=0.32235 PS=1.315 PD=2.45
M$1020 VPB|VPWR A|A1|A_N|B1|X \$1275 VPB|VPWR sky130_fd_pr__pfet_01v8_hvt
+ L=0.15 W=0.42 AS=0.14575 AD=0.1092 PS=1.335 PD=1.36
M$1021 VPB|VPWR \$1275 A|B1|C|Y VPB|VPWR sky130_fd_pr__pfet_01v8_hvt L=0.15 W=1
+ AS=0.28 AD=0.195 PS=2.56 PD=1.39
M$1022 A|B1|C|Y A3|B|X VPB|VPWR VPB|VPWR sky130_fd_pr__pfet_01v8_hvt L=0.15 W=1
+ AS=0.195 AD=0.1925 PS=1.39 PD=1.385
M$1023 VPB|VPWR A1|A1_N|C|X A|B1|C|Y VPB|VPWR sky130_fd_pr__pfet_01v8_hvt
+ L=0.15 W=1 AS=0.1925 AD=0.135 PS=1.385 PD=1.27
M$1024 A|B1|C|Y A2|A2_N|B|D|X VPB|VPWR VPB|VPWR sky130_fd_pr__pfet_01v8_hvt
+ L=0.15 W=1 AS=0.135 AD=0.14575 PS=1.27 PD=1.335
M$1025 VPB|VPWR B|B1|SLEEP|Y \$1443 VPB|VPWR sky130_fd_pr__pfet_01v8_hvt L=0.15
+ W=0.42 AS=0.14575 AD=0.0441 PS=1.335 PD=0.63
M$1026 \$1443 A|B|C1|X \$1277 VPB|VPWR sky130_fd_pr__pfet_01v8_hvt L=0.15
+ W=0.42 AS=0.0441 AD=0.1092 PS=0.63 PD=1.36
M$1027 A3|B|X \$1277 VPB|VPWR VPB|VPWR sky130_fd_pr__pfet_01v8_hvt L=0.15 W=1
+ AS=0.34 AD=0.14575 PS=2.68 PD=1.335
M$1028 B2|Y B|B1|SLEEP|Y \$1442 VPB|VPWR sky130_fd_pr__pfet_01v8_hvt L=0.15 W=1
+ AS=0.26 AD=0.105 PS=2.52 PD=1.21
M$1029 \$1442 A|B|C1|X VPB|VPWR VPB|VPWR sky130_fd_pr__pfet_01v8_hvt L=0.15 W=1
+ AS=0.105 AD=0.26 PS=1.21 PD=2.52
M$1031 \$1419 A0|Y B|B1|SLEEP|Y VPB|VPWR sky130_fd_pr__pfet_01v8_hvt L=0.15 W=1
+ AS=0.28 AD=0.1525 PS=2.56 PD=1.305
M$1032 B|B1|SLEEP|Y A1|B|Y \$1438 VPB|VPWR sky130_fd_pr__pfet_01v8_hvt L=0.15
+ W=1 AS=0.1525 AD=0.1975 PS=1.305 PD=1.395
M$1033 \$1438 \$1282 VPB|VPWR VPB|VPWR sky130_fd_pr__pfet_01v8_hvt L=0.15 W=1
+ AS=0.1975 AD=0.3 PS=1.395 PD=1.6
M$1034 VPB|VPWR A|S|X \$1419 VPB|VPWR sky130_fd_pr__pfet_01v8_hvt L=0.15 W=1
+ AS=0.3 AD=0.26 PS=1.6 PD=2.52
M$1035 \$1282 A|S|X VPB|VPWR VPB|VPWR sky130_fd_pr__pfet_01v8_hvt L=0.15 W=1
+ AS=0.29 AD=0.26 PS=2.58 PD=2.52
M$1036 A1|B|Y A|B1|Y \$1425 VPB|VPWR sky130_fd_pr__pfet_01v8_hvt L=0.15 W=1
+ AS=0.27 AD=0.1625 PS=2.54 PD=1.325
M$1037 \$1425 A1|D|X VPB|VPWR VPB|VPWR sky130_fd_pr__pfet_01v8_hvt L=0.15 W=1
+ AS=0.1625 AD=0.1525 PS=1.325 PD=1.305
M$1038 VPB|VPWR A2|B1|Y \$1425 VPB|VPWR sky130_fd_pr__pfet_01v8_hvt L=0.15 W=1
+ AS=0.1525 AD=0.135 PS=1.305 PD=1.27
M$1039 \$1425 A3|B|Y VPB|VPWR VPB|VPWR sky130_fd_pr__pfet_01v8_hvt L=0.15 W=1
+ AS=0.135 AD=0.26 PS=1.27 PD=2.52
M$1042 VPB|VPWR A2|B|C|D|X B|Y VPB|VPWR sky130_fd_pr__pfet_01v8_hvt L=0.15 W=1
+ AS=0.26 AD=0.135 PS=2.52 PD=1.27
M$1044 A|A1|B|B1|Y A2|B1|Y \$1420 VPB|VPWR sky130_fd_pr__pfet_01v8_hvt L=0.15
+ W=1 AS=0.265 AD=0.14 PS=2.53 PD=1.28
M$1045 \$1420 A|A1|Y VPB|VPWR VPB|VPWR sky130_fd_pr__pfet_01v8_hvt L=0.15 W=1
+ AS=0.14 AD=0.1475 PS=1.28 PD=1.295
M$1046 VPB|VPWR A2|B|C|D|X \$1420 VPB|VPWR sky130_fd_pr__pfet_01v8_hvt L=0.15
+ W=1 AS=0.1475 AD=0.265 PS=1.295 PD=2.53
M$1048 B2|D|SLEEP|Y B1|B2|D|X \$1431 VPB|VPWR sky130_fd_pr__pfet_01v8_hvt
+ L=0.15 W=1 AS=0.26 AD=0.13 PS=2.52 PD=1.26
M$1049 \$1431 A2|B|B1|C|Y \$1430 VPB|VPWR sky130_fd_pr__pfet_01v8_hvt L=0.15
+ W=1 AS=0.13 AD=0.19 PS=1.26 PD=1.38
M$1050 \$1430 A2|B|X \$1429 VPB|VPWR sky130_fd_pr__pfet_01v8_hvt L=0.15 W=1
+ AS=0.19 AD=0.135 PS=1.38 PD=1.27
M$1051 \$1429 A|A1|Y VPB|VPWR VPB|VPWR sky130_fd_pr__pfet_01v8_hvt L=0.15 W=1
+ AS=0.135 AD=0.26 PS=1.27 PD=2.52
M$1060 A|Y B1|Y \$1450 VPB|VPWR sky130_fd_pr__pfet_01v8_hvt L=0.15 W=1 AS=0.265
+ AD=0.14 PS=2.53 PD=1.28
M$1061 \$1450 A|A1|B1|C_N|X VPB|VPWR VPB|VPWR sky130_fd_pr__pfet_01v8_hvt
+ L=0.15 W=1 AS=0.14 AD=0.1475 PS=1.28 PD=1.295
M$1062 VPB|VPWR A2|Y \$1450 VPB|VPWR sky130_fd_pr__pfet_01v8_hvt L=0.15 W=1
+ AS=0.1475 AD=0.265 PS=1.295 PD=2.53
M$1063 VPB|VPWR A|A2|B|X A2|Y VPB|VPWR sky130_fd_pr__pfet_01v8_hvt L=0.15 W=1
+ AS=0.26 AD=0.135 PS=2.52 PD=1.27
M$1064 A2|Y A|A1|Y VPB|VPWR VPB|VPWR sky130_fd_pr__pfet_01v8_hvt L=0.15 W=1
+ AS=0.135 AD=0.26 PS=1.27 PD=2.52
M$1066 A3|B|X \$1453 VPB|VPWR VPB|VPWR sky130_fd_pr__pfet_01v8_hvt L=0.15 W=1
+ AS=0.34 AD=0.14575 PS=2.68 PD=1.335
M$1067 VPB|VPWR A|A2|SLEEP|X \$1534 VPB|VPWR sky130_fd_pr__pfet_01v8_hvt L=0.15
+ W=0.42 AS=0.14575 AD=0.0441 PS=1.335 PD=0.63
M$1068 \$1534 A|A3|B|Y \$1453 VPB|VPWR sky130_fd_pr__pfet_01v8_hvt L=0.15
+ W=0.42 AS=0.0441 AD=0.1092 PS=0.63 PD=1.36
M$1069 A1|A2|X \$1454 VPB|VPWR VPB|VPWR sky130_fd_pr__pfet_01v8_hvt L=0.15 W=1
+ AS=0.28 AD=0.169 PS=2.56 PD=1.365
M$1070 VPB|VPWR A3|A_N|B|C|X \$1455 VPB|VPWR sky130_fd_pr__pfet_01v8_hvt L=0.15
+ W=0.64 AS=0.169 AD=0.1792 PS=1.365 PD=1.84
M$1071 VPB|VPWR A|X A|A1|Y VPB|VPWR sky130_fd_pr__pfet_01v8_hvt L=0.15 W=2.68
+ AS=0.6086 AD=0.4668 PS=5.87 PD=4.58
M$1073 VPB|VPWR A|B|Y \$1458 VPB|VPWR sky130_fd_pr__pfet_01v8_hvt L=0.15 W=1
+ AS=0.25655 AD=0.26 PS=2.52 PD=2.52
M$1074 \$1456 A|B|Y \$1460 VPB|VPWR sky130_fd_pr__pfet_01v8_hvt L=0.15 W=0.64
+ AS=0.1458 AD=0.246 PS=1.205 PD=1.525
M$1075 \$1456 \$1458 \$1459 VPB|VPWR sky130_fd_pr__pfet_01v8_hvt L=0.15 W=0.84
+ AS=0.1458 AD=0.1715 PS=1.205 PD=1.355
M$1076 \$1459 A|B|Y \$1457 VPB|VPWR sky130_fd_pr__pfet_01v8_hvt L=0.15 W=0.84
+ AS=0.3528 AD=0.2431 PS=2.52 PD=1.445
M$1077 \$1457 \$1458 \$1460 VPB|VPWR sky130_fd_pr__pfet_01v8_hvt L=0.15 W=0.64
+ AS=0.2431 AD=0.246 PS=1.445 PD=1.525
M$1078 \$1459 A|Y VPB|VPWR VPB|VPWR sky130_fd_pr__pfet_01v8_hvt L=0.15 W=1
+ AS=0.1715 AD=0.135 PS=1.355 PD=1.27
M$1079 VPB|VPWR \$1459 \$1460 VPB|VPWR sky130_fd_pr__pfet_01v8_hvt L=0.15 W=1
+ AS=0.135 AD=0.285 PS=1.27 PD=2.57
M$1082 VPB|VPWR \$1462 A|Y VPB|VPWR sky130_fd_pr__pfet_01v8_hvt L=0.15 W=1
+ AS=0.36 AD=0.165 PS=2.72 PD=1.33
M$1083 A|Y B|Y \$1540 VPB|VPWR sky130_fd_pr__pfet_01v8_hvt L=0.15 W=1 AS=0.165
+ AD=0.105 PS=1.33 PD=1.21
M$1084 \$1540 A|X VPB|VPWR VPB|VPWR sky130_fd_pr__pfet_01v8_hvt L=0.15 W=1
+ AS=0.105 AD=0.365 PS=1.21 PD=1.73
M$1085 VPB|VPWR A|X \$1462 VPB|VPWR sky130_fd_pr__pfet_01v8_hvt L=0.15 W=1
+ AS=0.365 AD=0.135 PS=1.73 PD=1.27
M$1086 \$1462 B|Y VPB|VPWR VPB|VPWR sky130_fd_pr__pfet_01v8_hvt L=0.15 W=1
+ AS=0.135 AD=0.3 PS=1.27 PD=2.6
M$1088 A|X \$1463 VPB|VPWR VPB|VPWR sky130_fd_pr__pfet_01v8_hvt L=0.15 W=1
+ AS=0.28 AD=0.169 PS=2.56 PD=1.365
M$1089 VPB|VPWR B|C|X \$1464 VPB|VPWR sky130_fd_pr__pfet_01v8_hvt L=0.15 W=0.64
+ AS=0.169 AD=0.1792 PS=1.365 PD=1.84
M$1090 VPB|VPWR B|C|Y \$1467 VPB|VPWR sky130_fd_pr__pfet_01v8_hvt L=0.15 W=1
+ AS=0.25655 AD=0.26 PS=2.52 PD=2.52
M$1091 VPB|VPWR A|X \$1249 VPB|VPWR sky130_fd_pr__pfet_01v8_hvt L=0.15 W=0.42
+ AS=0.1113 AD=0.0609 PS=1.37 PD=0.71
M$1092 VPB|VPWR B|C|X \$1249 VPB|VPWR sky130_fd_pr__pfet_01v8_hvt L=0.15 W=0.42
+ AS=0.1841 AD=0.0609 PS=1.26 PD=0.71
M$1093 VPB|VPWR \$1249 A|A1|X VPB|VPWR sky130_fd_pr__pfet_01v8_hvt L=0.15
+ W=0.64 AS=0.1841 AD=0.1696 PS=1.26 PD=1.81
M$1094 \$1465 B|C|Y \$1469 VPB|VPWR sky130_fd_pr__pfet_01v8_hvt L=0.15 W=0.64
+ AS=0.1458 AD=0.246 PS=1.205 PD=1.525
M$1095 \$1465 \$1467 \$1468 VPB|VPWR sky130_fd_pr__pfet_01v8_hvt L=0.15 W=0.84
+ AS=0.1458 AD=0.1715 PS=1.205 PD=1.355
M$1096 \$1468 B|C|Y \$1466 VPB|VPWR sky130_fd_pr__pfet_01v8_hvt L=0.15 W=0.84
+ AS=0.3528 AD=0.2431 PS=2.52 PD=1.445
M$1097 \$1466 \$1467 \$1469 VPB|VPWR sky130_fd_pr__pfet_01v8_hvt L=0.15 W=0.64
+ AS=0.2431 AD=0.246 PS=1.445 PD=1.525
M$1098 \$1468 A|X VPB|VPWR VPB|VPWR sky130_fd_pr__pfet_01v8_hvt L=0.15 W=1
+ AS=0.1715 AD=0.135 PS=1.355 PD=1.27
M$1099 VPB|VPWR \$1468 \$1469 VPB|VPWR sky130_fd_pr__pfet_01v8_hvt L=0.15 W=1
+ AS=0.135 AD=0.285 PS=1.27 PD=2.57
M$1100 A|X \$1512 \$1470 VPB|VPWR sky130_fd_pr__pfet_01v8_hvt L=0.15 W=1 AS=0.3
+ AD=0.26 PS=2.6 PD=2.52
M$1101 VPB|VPWR B|C|Y \$1470 VPB|VPWR sky130_fd_pr__pfet_01v8_hvt L=0.15 W=1
+ AS=0.26 AD=0.135 PS=2.52 PD=1.27
M$1102 \$1470 A|X VPB|VPWR VPB|VPWR sky130_fd_pr__pfet_01v8_hvt L=0.15 W=1
+ AS=0.135 AD=0.135 PS=1.27 PD=1.27
M$1103 VPB|VPWR A|X \$1544 VPB|VPWR sky130_fd_pr__pfet_01v8_hvt L=0.15 W=1
+ AS=0.135 AD=0.135 PS=1.27 PD=1.27
M$1104 \$1544 B|C|Y \$1512 VPB|VPWR sky130_fd_pr__pfet_01v8_hvt L=0.15 W=1
+ AS=0.135 AD=0.26 PS=1.27 PD=2.52
M$1105 VPB|VPWR B|C|Y \$1505 VPB|VPWR sky130_fd_pr__pfet_01v8_hvt L=0.15 W=0.42
+ AS=0.2492 AD=0.0441 PS=1.565 PD=0.63
M$1106 \$1505 B|C|Y \$1472 VPB|VPWR sky130_fd_pr__pfet_01v8_hvt L=0.15 W=0.42
+ AS=0.0441 AD=0.0567 PS=0.63 PD=0.69
M$1107 \$1472 B|C|Y \$1506 VPB|VPWR sky130_fd_pr__pfet_01v8_hvt L=0.15 W=0.42
+ AS=0.0567 AD=0.0441 PS=0.69 PD=0.63
M$1108 \$1506 A|Y VPB|VPWR VPB|VPWR sky130_fd_pr__pfet_01v8_hvt L=0.15 W=0.42
+ AS=0.0441 AD=0.0567 PS=0.63 PD=0.69
M$1109 VPB|VPWR A|Y \$1507 VPB|VPWR sky130_fd_pr__pfet_01v8_hvt L=0.15 W=0.42
+ AS=0.0567 AD=0.0441 PS=0.69 PD=0.63
M$1110 \$1507 B|C|Y \$1472 VPB|VPWR sky130_fd_pr__pfet_01v8_hvt L=0.15 W=0.42
+ AS=0.0441 AD=0.1092 PS=0.63 PD=1.36
M$1111 B|SLEEP|X \$1472 VPB|VPWR VPB|VPWR sky130_fd_pr__pfet_01v8_hvt L=0.15
+ W=1 AS=0.365 AD=0.2492 PS=2.73 PD=1.565
M$1112 \$1257 B|C|Y \$1253 VPB|VPWR sky130_fd_pr__pfet_01v8_hvt L=0.15 W=0.84
+ AS=0.2688 AD=0.1596 PS=2.32 PD=1.22
M$1113 \$1253 \$1255 \$1256 VPB|VPWR sky130_fd_pr__pfet_01v8_hvt L=0.15 W=0.84
+ AS=0.1596 AD=0.441 PS=1.22 PD=2.73
M$1115 A|Y B|C|Y \$1542 VPB|VPWR sky130_fd_pr__pfet_01v8_hvt L=0.15 W=1 AS=0.26
+ AD=0.105 PS=2.52 PD=1.21
M$1116 \$1542 A|Y VPB|VPWR VPB|VPWR sky130_fd_pr__pfet_01v8_hvt L=0.15 W=1
+ AS=0.105 AD=0.26 PS=1.21 PD=2.52
M$1117 VPB|VPWR \$1475 A|Y VPB|VPWR sky130_fd_pr__pfet_01v8_hvt L=0.15 W=1
+ AS=0.36 AD=0.165 PS=2.72 PD=1.33
M$1118 A|Y B|B2|Y \$1541 VPB|VPWR sky130_fd_pr__pfet_01v8_hvt L=0.15 W=1
+ AS=0.165 AD=0.105 PS=1.33 PD=1.21
M$1119 \$1541 A|B1|X VPB|VPWR VPB|VPWR sky130_fd_pr__pfet_01v8_hvt L=0.15 W=1
+ AS=0.105 AD=0.365 PS=1.21 PD=1.73
M$1120 VPB|VPWR A|B1|X \$1475 VPB|VPWR sky130_fd_pr__pfet_01v8_hvt L=0.15 W=1
+ AS=0.365 AD=0.135 PS=1.73 PD=1.27
M$1121 \$1475 B|B2|Y VPB|VPWR VPB|VPWR sky130_fd_pr__pfet_01v8_hvt L=0.15 W=1
+ AS=0.135 AD=0.3 PS=1.27 PD=2.6
M$1122 B|Y B|B2|Y \$1479 VPB|VPWR sky130_fd_pr__pfet_01v8_hvt L=0.15 W=1
+ AS=0.26 AD=0.135 PS=2.52 PD=1.27
M$1123 \$1479 A|B1|X B|Y VPB|VPWR sky130_fd_pr__pfet_01v8_hvt L=0.15 W=1
+ AS=0.135 AD=0.26 PS=1.27 PD=2.52
M$1124 VPB|VPWR A|A1|X \$1479 VPB|VPWR sky130_fd_pr__pfet_01v8_hvt L=0.15 W=1
+ AS=0.26 AD=0.135 PS=2.52 PD=1.27
M$1125 \$1479 A2|B|C|X VPB|VPWR VPB|VPWR sky130_fd_pr__pfet_01v8_hvt L=0.15 W=1
+ AS=0.135 AD=0.3 PS=1.27 PD=2.6
M$1126 A|B1|X \$1480 VPB|VPWR VPB|VPWR sky130_fd_pr__pfet_01v8_hvt L=0.15 W=1
+ AS=0.28 AD=0.2115 PS=2.56 PD=1.45
M$1127 VPB|VPWR A2|B|C|X \$1481 VPB|VPWR sky130_fd_pr__pfet_01v8_hvt L=0.15
+ W=0.64 AS=0.2115 AD=0.1792 PS=1.45 PD=1.84
M$1128 VPB|VPWR A2|B|Y \$1484 VPB|VPWR sky130_fd_pr__pfet_01v8_hvt L=0.15 W=1
+ AS=0.26 AD=0.2526 PS=2.52 PD=2.52
M$1129 \$1483 A2|B|Y \$1486 VPB|VPWR sky130_fd_pr__pfet_01v8_hvt L=0.15 W=0.64
+ AS=0.1458 AD=0.246 PS=1.205 PD=1.525
M$1130 \$1483 \$1484 \$1485 VPB|VPWR sky130_fd_pr__pfet_01v8_hvt L=0.15 W=0.84
+ AS=0.1458 AD=0.1715 PS=1.205 PD=1.355
M$1131 \$1485 A2|B|Y \$1482 VPB|VPWR sky130_fd_pr__pfet_01v8_hvt L=0.15 W=0.84
+ AS=0.3536 AD=0.2452 PS=2.53 PD=1.45
M$1132 \$1482 \$1484 \$1486 VPB|VPWR sky130_fd_pr__pfet_01v8_hvt L=0.15 W=0.64
+ AS=0.2452 AD=0.246 PS=1.45 PD=1.525
M$1133 \$1485 A|A1|X VPB|VPWR VPB|VPWR sky130_fd_pr__pfet_01v8_hvt L=0.15 W=1
+ AS=0.1715 AD=0.135 PS=1.355 PD=1.27
M$1134 VPB|VPWR \$1485 \$1486 VPB|VPWR sky130_fd_pr__pfet_01v8_hvt L=0.15 W=1
+ AS=0.135 AD=0.285 PS=1.27 PD=2.57
M$1135 B|X \$1487 VPB|VPWR VPB|VPWR sky130_fd_pr__pfet_01v8_hvt L=0.15 W=1
+ AS=0.36 AD=0.195 PS=2.72 PD=1.39
M$1136 VPB|VPWR A|A1|X \$1539 VPB|VPWR sky130_fd_pr__pfet_01v8_hvt L=0.15 W=1
+ AS=0.195 AD=0.135 PS=1.39 PD=1.27
M$1137 \$1539 A2|B|Y \$1538 VPB|VPWR sky130_fd_pr__pfet_01v8_hvt L=0.15 W=1
+ AS=0.135 AD=0.165 PS=1.27 PD=1.33
M$1138 \$1538 A|A3|B|Y \$1487 VPB|VPWR sky130_fd_pr__pfet_01v8_hvt L=0.15 W=1
+ AS=0.165 AD=0.2125 PS=1.33 PD=1.425
M$1139 \$1487 A|B1|Y VPB|VPWR VPB|VPWR sky130_fd_pr__pfet_01v8_hvt L=0.15 W=1
+ AS=0.2125 AD=0.345 PS=1.425 PD=2.69
M$1141 \$1267 A_N|C|Y \$1264 VPB|VPWR sky130_fd_pr__pfet_01v8_hvt L=0.15 W=0.84
+ AS=0.2688 AD=0.1596 PS=2.32 PD=1.22
M$1142 \$1264 \$1265 \$1266 VPB|VPWR sky130_fd_pr__pfet_01v8_hvt L=0.15 W=0.84
+ AS=0.1596 AD=0.441 PS=1.22 PD=2.73
M$1143 VPB|VPWR B|SLEEP|Y D|Y VPB|VPWR sky130_fd_pr__pfet_01v8_hvt L=0.15 W=1
+ AS=0.26 AD=0.135 PS=2.52 PD=1.27
M$1144 D|Y A|Y VPB|VPWR VPB|VPWR sky130_fd_pr__pfet_01v8_hvt L=0.15 W=1
+ AS=0.135 AD=0.26 PS=1.27 PD=2.52
M$1145 VPB|VPWR A_N|C|Y \$1508 VPB|VPWR sky130_fd_pr__pfet_01v8_hvt L=0.15
+ W=0.42 AS=0.2492 AD=0.0441 PS=1.565 PD=0.63
M$1146 \$1508 B|SLEEP|Y \$1490 VPB|VPWR sky130_fd_pr__pfet_01v8_hvt L=0.15
+ W=0.42 AS=0.0441 AD=0.0567 PS=0.63 PD=0.69
M$1147 \$1490 B|SLEEP|Y \$1509 VPB|VPWR sky130_fd_pr__pfet_01v8_hvt L=0.15
+ W=0.42 AS=0.0567 AD=0.0441 PS=0.69 PD=0.63
M$1148 \$1509 A|Y VPB|VPWR VPB|VPWR sky130_fd_pr__pfet_01v8_hvt L=0.15 W=0.42
+ AS=0.0441 AD=0.0567 PS=0.63 PD=0.69
M$1149 VPB|VPWR A|Y \$1510 VPB|VPWR sky130_fd_pr__pfet_01v8_hvt L=0.15 W=0.42
+ AS=0.0567 AD=0.0441 PS=0.69 PD=0.63
M$1150 \$1510 A_N|C|Y \$1490 VPB|VPWR sky130_fd_pr__pfet_01v8_hvt L=0.15 W=0.42
+ AS=0.0441 AD=0.1092 PS=0.63 PD=1.36
M$1151 B|X \$1490 VPB|VPWR VPB|VPWR sky130_fd_pr__pfet_01v8_hvt L=0.15 W=1
+ AS=0.365 AD=0.2492 PS=2.73 PD=1.565
M$1152 VPB|VPWR A|X \$1494 VPB|VPWR sky130_fd_pr__pfet_01v8_hvt L=0.15 W=0.42
+ AS=0.1113 AD=0.0609 PS=1.37 PD=0.71
M$1153 \$1494 B|X VPB|VPWR VPB|VPWR sky130_fd_pr__pfet_01v8_hvt L=0.15 W=0.42
+ AS=0.0609 AD=0.1841 PS=0.71 PD=1.26
M$1154 VPB|VPWR \$1494 A1|X VPB|VPWR sky130_fd_pr__pfet_01v8_hvt L=0.15 W=0.64
+ AS=0.1841 AD=0.1696 PS=1.26 PD=1.81
M$1155 VPB|VPWR A1|X \$1535 VPB|VPWR sky130_fd_pr__pfet_01v8_hvt L=0.15 W=1
+ AS=0.265 AD=0.105 PS=2.53 PD=1.21
M$1156 \$1535 A2|X A|B|B1|B_N|Y VPB|VPWR sky130_fd_pr__pfet_01v8_hvt L=0.15 W=1
+ AS=0.105 AD=0.195 PS=1.21 PD=1.39
M$1157 A|B|B1|B_N|Y A|A1|B1|Y VPB|VPWR VPB|VPWR sky130_fd_pr__pfet_01v8_hvt
+ L=0.15 W=1 AS=0.195 AD=0.195 PS=1.39 PD=1.39
M$1158 VPB|VPWR A|B|C1|Y A|B|B1|B_N|Y VPB|VPWR sky130_fd_pr__pfet_01v8_hvt
+ L=0.15 W=1 AS=0.195 AD=0.635 PS=1.39 PD=3.27
M$1159 A2|X \$1499 VPB|VPWR VPB|VPWR sky130_fd_pr__pfet_01v8_hvt L=0.15 W=1
+ AS=0.26 AD=0.155 PS=2.52 PD=1.31
M$1160 VPB|VPWR A2|B|C|X \$1498 VPB|VPWR sky130_fd_pr__pfet_01v8_hvt L=0.15 W=1
+ AS=0.155 AD=0.16 PS=1.31 PD=1.32
M$1161 \$1498 A|A1|Y VPB|VPWR VPB|VPWR sky130_fd_pr__pfet_01v8_hvt L=0.15 W=1
+ AS=0.16 AD=0.2529 PS=1.32 PD=2.52
M$1162 \$1499 A|B1|C|Y \$1498 VPB|VPWR sky130_fd_pr__pfet_01v8_hvt L=0.15 W=1
+ AS=0.25285 AD=0.135 PS=2.52 PD=1.27
M$1163 \$1498 B2|D|Y \$1499 VPB|VPWR sky130_fd_pr__pfet_01v8_hvt L=0.15 W=1
+ AS=0.135 AD=0.26 PS=1.27 PD=2.52
M$1164 VPB|VPWR A|A1|Y A|B|C1|Y VPB|VPWR sky130_fd_pr__pfet_01v8_hvt L=0.15 W=1
+ AS=0.3 AD=0.165 PS=2.6 PD=1.33
M$1165 A|B|C1|Y A2|B|C|X VPB|VPWR VPB|VPWR sky130_fd_pr__pfet_01v8_hvt L=0.15
+ W=1 AS=0.165 AD=0.135 PS=1.33 PD=1.27
M$1166 VPB|VPWR A|B1|C|Y A|B|C1|Y VPB|VPWR sky130_fd_pr__pfet_01v8_hvt L=0.15
+ W=1 AS=0.135 AD=0.135 PS=1.27 PD=1.27
M$1167 A|B|C1|Y B2|D|Y VPB|VPWR VPB|VPWR sky130_fd_pr__pfet_01v8_hvt L=0.15 W=1
+ AS=0.135 AD=0.26 PS=1.27 PD=2.52
M$1169 A|Y A|A1|A_N|B1|X \$1501 VPB|VPWR sky130_fd_pr__pfet_01v8_hvt L=0.15 W=1
+ AS=0.27 AD=0.1625 PS=2.54 PD=1.325
M$1170 \$1501 A1|A1_N|C|X VPB|VPWR VPB|VPWR sky130_fd_pr__pfet_01v8_hvt L=0.15
+ W=1 AS=0.1625 AD=0.1525 PS=1.325 PD=1.305
M$1171 VPB|VPWR A2|A2_N|B|D|X \$1501 VPB|VPWR sky130_fd_pr__pfet_01v8_hvt
+ L=0.15 W=1 AS=0.1525 AD=0.135 PS=1.305 PD=1.27
M$1172 \$1501 A3|B|X VPB|VPWR VPB|VPWR sky130_fd_pr__pfet_01v8_hvt L=0.15 W=1
+ AS=0.135 AD=0.26 PS=1.27 PD=2.52
M$1176 A|S|X \$1502 VPB|VPWR VPB|VPWR sky130_fd_pr__pfet_01v8_hvt L=0.15 W=1
+ AS=0.28 AD=0.3275 PS=2.56 PD=1.655
M$1177 VPB|VPWR A|A_N|B1|Y \$1502 VPB|VPWR sky130_fd_pr__pfet_01v8_hvt L=0.15
+ W=1 AS=0.3275 AD=0.195 PS=1.655 PD=1.39
M$1178 \$1502 A2|B1|Y \$1531 VPB|VPWR sky130_fd_pr__pfet_01v8_hvt L=0.15 W=1
+ AS=0.195 AD=0.1525 PS=1.39 PD=1.305
M$1179 \$1531 A|A1|B|C1|X VPB|VPWR VPB|VPWR sky130_fd_pr__pfet_01v8_hvt L=0.15
+ W=1 AS=0.1525 AD=0.26 PS=1.305 PD=2.52
M$1180 A|A_N|B1|Y A|A1|B|C1|X VPB|VPWR VPB|VPWR sky130_fd_pr__pfet_01v8_hvt
+ L=0.15 W=1 AS=0.635 AD=0.195 PS=3.27 PD=1.39
M$1181 VPB|VPWR A2|B1|Y A|A_N|B1|Y VPB|VPWR sky130_fd_pr__pfet_01v8_hvt L=0.15
+ W=1 AS=0.195 AD=0.195 PS=1.39 PD=1.39
M$1182 A|A_N|B1|Y A2|B1|SLEEP|Y \$1530 VPB|VPWR sky130_fd_pr__pfet_01v8_hvt
+ L=0.15 W=1 AS=0.195 AD=0.105 PS=1.39 PD=1.21
M$1183 \$1530 A|A1|B|B1|Y VPB|VPWR VPB|VPWR sky130_fd_pr__pfet_01v8_hvt L=0.15
+ W=1 AS=0.105 AD=0.265 PS=1.21 PD=2.53
M$1184 VPB|VPWR A|B|B1_N|X A2|B1|SLEEP|Y VPB|VPWR sky130_fd_pr__pfet_01v8_hvt
+ L=0.15 W=1 AS=0.3 AD=0.165 PS=2.6 PD=1.33
M$1185 A2|B1|SLEEP|Y B|Y VPB|VPWR VPB|VPWR sky130_fd_pr__pfet_01v8_hvt L=0.15
+ W=1 AS=0.165 AD=0.135 PS=1.33 PD=1.27
M$1186 VPB|VPWR C|Y A2|B1|SLEEP|Y VPB|VPWR sky130_fd_pr__pfet_01v8_hvt L=0.15
+ W=1 AS=0.135 AD=0.135 PS=1.27 PD=1.27
M$1187 A2|B1|SLEEP|Y A1|D|X VPB|VPWR VPB|VPWR sky130_fd_pr__pfet_01v8_hvt
+ L=0.15 W=1 AS=0.135 AD=0.26 PS=1.27 PD=2.52
M$1189 VPB|VPWR A|A1|B|X C|Y VPB|VPWR sky130_fd_pr__pfet_01v8_hvt L=0.15 W=1
+ AS=0.26 AD=0.135 PS=2.52 PD=1.27
M$1190 C|Y A2|B|Y VPB|VPWR VPB|VPWR sky130_fd_pr__pfet_01v8_hvt L=0.15 W=1
+ AS=0.135 AD=0.26 PS=1.27 PD=2.52
M$1191 A1|D|X \$1522 VPB|VPWR VPB|VPWR sky130_fd_pr__pfet_01v8_hvt L=0.15 W=1
+ AS=0.34 AD=0.14575 PS=2.68 PD=1.335
M$1192 VPB|VPWR B2|D|SLEEP|Y \$1529 VPB|VPWR sky130_fd_pr__pfet_01v8_hvt L=0.15
+ W=0.42 AS=0.14575 AD=0.0441 PS=1.335 PD=0.63
M$1193 \$1529 A|B1|C|X \$1522 VPB|VPWR sky130_fd_pr__pfet_01v8_hvt L=0.15
+ W=0.42 AS=0.0441 AD=0.1092 PS=0.63 PD=1.36
M$1195 VPB|VPWR B1|B2|D|X A2|B1|Y VPB|VPWR sky130_fd_pr__pfet_01v8_hvt L=0.15
+ W=0.64 AS=0.1824 AD=0.0896 PS=1.85 PD=0.92
M$1196 A2|B1|Y A2|B|X \$1434 VPB|VPWR sky130_fd_pr__pfet_01v8_hvt L=0.15 W=0.64
+ AS=0.0896 AD=0.0768 PS=0.92 PD=0.88
M$1197 \$1434 A|A1|Y VPB|VPWR VPB|VPWR sky130_fd_pr__pfet_01v8_hvt L=0.15
+ W=0.64 AS=0.0768 AD=0.1696 PS=0.88 PD=1.81
M$1198 A|B1|C|X \$1503 VPB|VPWR VPB|VPWR sky130_fd_pr__pfet_01v8_hvt L=0.15 W=1
+ AS=0.28 AD=0.3725 PS=2.56 PD=1.745
M$1199 VPB|VPWR A2|B|B1|C|Y \$1528 VPB|VPWR sky130_fd_pr__pfet_01v8_hvt L=0.15
+ W=1 AS=0.3725 AD=0.1175 PS=1.745 PD=1.235
M$1200 \$1528 B1|B2|D|X \$1503 VPB|VPWR sky130_fd_pr__pfet_01v8_hvt L=0.15 W=1
+ AS=0.1175 AD=0.235 PS=1.235 PD=1.47
M$1201 \$1503 A2|B|X \$1527 VPB|VPWR sky130_fd_pr__pfet_01v8_hvt L=0.15 W=1
+ AS=0.235 AD=0.105 PS=1.47 PD=1.21
M$1202 \$1527 A|A1|Y VPB|VPWR VPB|VPWR sky130_fd_pr__pfet_01v8_hvt L=0.15 W=1
+ AS=0.105 AD=0.26 PS=1.21 PD=2.52
M$1203 VPB|VPWR \$1504 A2|B|Y VPB|VPWR sky130_fd_pr__pfet_01v8_hvt L=0.15 W=1
+ AS=0.36 AD=0.165 PS=2.72 PD=1.33
M$1204 A2|B|Y A2|B|X \$1526 VPB|VPWR sky130_fd_pr__pfet_01v8_hvt L=0.15 W=1
+ AS=0.165 AD=0.105 PS=1.33 PD=1.21
M$1205 \$1526 A|A1|Y VPB|VPWR VPB|VPWR sky130_fd_pr__pfet_01v8_hvt L=0.15 W=1
+ AS=0.105 AD=0.365 PS=1.21 PD=1.73
M$1206 VPB|VPWR A|A1|Y \$1504 VPB|VPWR sky130_fd_pr__pfet_01v8_hvt L=0.15 W=1
+ AS=0.365 AD=0.135 PS=1.73 PD=1.27
M$1207 \$1504 A2|B|X VPB|VPWR VPB|VPWR sky130_fd_pr__pfet_01v8_hvt L=0.15 W=1
+ AS=0.135 AD=0.3 PS=1.27 PD=2.6
M$1215 B|C|X \$1592 \$1769 VPB|VPWR sky130_fd_pr__pfet_01v8_hvt L=0.15 W=1
+ AS=0.3 AD=0.26 PS=2.6 PD=2.52
M$1216 VPB|VPWR A|A3|B|Y \$1769 VPB|VPWR sky130_fd_pr__pfet_01v8_hvt L=0.15 W=1
+ AS=0.26 AD=0.135 PS=2.52 PD=1.27
M$1217 \$1769 A|Y VPB|VPWR VPB|VPWR sky130_fd_pr__pfet_01v8_hvt L=0.15 W=1
+ AS=0.135 AD=0.135 PS=1.27 PD=1.27
M$1218 VPB|VPWR A|Y \$1781 VPB|VPWR sky130_fd_pr__pfet_01v8_hvt L=0.15 W=1
+ AS=0.135 AD=0.135 PS=1.27 PD=1.27
M$1219 \$1781 A|A3|B|Y \$1592 VPB|VPWR sky130_fd_pr__pfet_01v8_hvt L=0.15 W=1
+ AS=0.135 AD=0.26 PS=1.27 PD=2.52
M$1220 VPB|VPWR \$1593 A1|B|Y VPB|VPWR sky130_fd_pr__pfet_01v8_hvt L=0.15 W=1
+ AS=0.36 AD=0.165 PS=2.72 PD=1.33
M$1221 A1|B|Y A|A2|B|X \$1782 VPB|VPWR sky130_fd_pr__pfet_01v8_hvt L=0.15 W=1
+ AS=0.165 AD=0.105 PS=1.33 PD=1.21
M$1222 \$1782 A|A1|Y VPB|VPWR VPB|VPWR sky130_fd_pr__pfet_01v8_hvt L=0.15 W=1
+ AS=0.105 AD=0.365 PS=1.21 PD=1.73
M$1223 VPB|VPWR A|A1|Y \$1593 VPB|VPWR sky130_fd_pr__pfet_01v8_hvt L=0.15 W=1
+ AS=0.365 AD=0.135 PS=1.73 PD=1.27
M$1224 \$1593 A|A2|B|X VPB|VPWR VPB|VPWR sky130_fd_pr__pfet_01v8_hvt L=0.15 W=1
+ AS=0.135 AD=0.3 PS=1.27 PD=2.6
M$1226 B|Y A3|B|X \$1784 VPB|VPWR sky130_fd_pr__pfet_01v8_hvt L=0.15 W=1
+ AS=0.26 AD=0.105 PS=2.52 PD=1.21
M$1227 \$1784 A|A2|B|X VPB|VPWR VPB|VPWR sky130_fd_pr__pfet_01v8_hvt L=0.15 W=1
+ AS=0.105 AD=0.26 PS=1.21 PD=2.52
M$1228 \$1456 A3|A_N|B|C|X \$1454 VPB|VPWR sky130_fd_pr__pfet_01v8_hvt L=0.15
+ W=0.84 AS=0.273 AD=0.15295 PS=2.33 PD=1.315
M$1229 \$1454 \$1455 \$1457 VPB|VPWR sky130_fd_pr__pfet_01v8_hvt L=0.15 W=0.84
+ AS=0.15295 AD=0.32235 PS=1.315 PD=2.45
M$1230 VPB|VPWR B|Y B|Y VPB|VPWR sky130_fd_pr__pfet_01v8_hvt L=0.15 W=4 AS=1.04
+ AD=0.54 PS=10.08 PD=5.08
M$1231 B|Y A|A0|X VPB|VPWR VPB|VPWR sky130_fd_pr__pfet_01v8_hvt L=0.15 W=1
+ AS=0.135 AD=0.26 PS=1.27 PD=2.52
M$1234 VPB|VPWR A|C|X \$1598 VPB|VPWR sky130_fd_pr__pfet_01v8_hvt L=0.15 W=0.64
+ AS=0.169 AD=0.1792 PS=1.365 PD=1.84
M$1235 A|X \$1597 VPB|VPWR VPB|VPWR sky130_fd_pr__pfet_01v8_hvt L=0.15 W=1
+ AS=0.28 AD=0.169 PS=2.56 PD=1.365
M$1236 \$1597 \$1598 \$1599 VPB|VPWR sky130_fd_pr__pfet_01v8_hvt L=0.15 W=0.84
+ AS=0.15295 AD=0.32235 PS=1.315 PD=2.45
M$1237 \$1597 A|C|X \$1600 VPB|VPWR sky130_fd_pr__pfet_01v8_hvt L=0.15 W=0.84
+ AS=0.15295 AD=0.273 PS=1.315 PD=2.33
M$1238 VPB|VPWR B|Y \$1601 VPB|VPWR sky130_fd_pr__pfet_01v8_hvt L=0.15 W=1
+ AS=0.25655 AD=0.26 PS=2.52 PD=2.52
M$1239 \$1599 \$1601 \$1603 VPB|VPWR sky130_fd_pr__pfet_01v8_hvt L=0.15 W=0.64
+ AS=0.2431 AD=0.246 PS=1.445 PD=1.525
M$1240 \$1603 B|Y \$1600 VPB|VPWR sky130_fd_pr__pfet_01v8_hvt L=0.15 W=0.64
+ AS=0.246 AD=0.1458 PS=1.525 PD=1.205
M$1241 \$1602 B|Y \$1599 VPB|VPWR sky130_fd_pr__pfet_01v8_hvt L=0.15 W=0.84
+ AS=0.3528 AD=0.2431 PS=2.52 PD=1.445
M$1242 \$1602 \$1601 \$1600 VPB|VPWR sky130_fd_pr__pfet_01v8_hvt L=0.15 W=0.84
+ AS=0.1715 AD=0.1458 PS=1.355 PD=1.205
M$1243 \$1602 A|X VPB|VPWR VPB|VPWR sky130_fd_pr__pfet_01v8_hvt L=0.15 W=1
+ AS=0.1715 AD=0.135 PS=1.355 PD=1.27
M$1244 VPB|VPWR \$1602 \$1603 VPB|VPWR sky130_fd_pr__pfet_01v8_hvt L=0.15 W=1
+ AS=0.135 AD=0.285 PS=1.27 PD=2.57
M$1245 A|Y B|Y \$1788 VPB|VPWR sky130_fd_pr__pfet_01v8_hvt L=0.15 W=1 AS=0.26
+ AD=0.105 PS=2.52 PD=1.21
M$1246 \$1788 A|X VPB|VPWR VPB|VPWR sky130_fd_pr__pfet_01v8_hvt L=0.15 W=1
+ AS=0.105 AD=0.26 PS=1.21 PD=2.52
M$1248 \$1465 B|C|X \$1463 VPB|VPWR sky130_fd_pr__pfet_01v8_hvt L=0.15 W=0.84
+ AS=0.273 AD=0.15295 PS=2.33 PD=1.315
M$1249 \$1463 \$1464 \$1466 VPB|VPWR sky130_fd_pr__pfet_01v8_hvt L=0.15 W=0.84
+ AS=0.15295 AD=0.32235 PS=1.315 PD=2.45
M$1254 \$1476 A|B1|X VPB|VPWR VPB|VPWR sky130_fd_pr__pfet_01v8_hvt L=0.15
+ W=0.42 AS=0.1092 AD=0.0567 PS=1.36 PD=0.69
M$1255 VPB|VPWR B|B2|Y \$1476 VPB|VPWR sky130_fd_pr__pfet_01v8_hvt L=0.15
+ W=0.42 AS=0.0567 AD=0.06615 PS=0.69 PD=0.735
M$1256 VPB|VPWR A|C|Y \$1476 VPB|VPWR sky130_fd_pr__pfet_01v8_hvt L=0.15 W=0.42
+ AS=0.142225 AD=0.06615 PS=1.335 PD=0.735
M$1257 VPB|VPWR \$1476 A|A1|X VPB|VPWR sky130_fd_pr__pfet_01v8_hvt L=0.15 W=1
+ AS=0.142225 AD=0.26 PS=1.335 PD=2.52
M$1258 VPB|VPWR \$1605 A|B|Y VPB|VPWR sky130_fd_pr__pfet_01v8_hvt L=0.15 W=1
+ AS=0.36 AD=0.165 PS=2.72 PD=1.33
M$1259 A|B|Y B|Y \$1790 VPB|VPWR sky130_fd_pr__pfet_01v8_hvt L=0.15 W=1
+ AS=0.165 AD=0.105 PS=1.33 PD=1.21
M$1260 \$1790 A|C|Y VPB|VPWR VPB|VPWR sky130_fd_pr__pfet_01v8_hvt L=0.15 W=1
+ AS=0.105 AD=0.365 PS=1.21 PD=1.73
M$1261 VPB|VPWR A|C|Y \$1605 VPB|VPWR sky130_fd_pr__pfet_01v8_hvt L=0.15 W=1
+ AS=0.365 AD=0.135 PS=1.73 PD=1.27
M$1262 \$1605 B|Y VPB|VPWR VPB|VPWR sky130_fd_pr__pfet_01v8_hvt L=0.15 W=1
+ AS=0.135 AD=0.3 PS=1.27 PD=2.6
M$1265 VPB|VPWR A2|B|C|X A|Y VPB|VPWR sky130_fd_pr__pfet_01v8_hvt L=0.15 W=1
+ AS=0.165 AD=0.135 PS=1.33 PD=1.27
M$1266 A|Y A|C|Y VPB|VPWR VPB|VPWR sky130_fd_pr__pfet_01v8_hvt L=0.15 W=2
+ AS=0.395 AD=0.395 PS=3.79 PD=3.79
M$1268 \$1482 A2|B|C|X \$1480 VPB|VPWR sky130_fd_pr__pfet_01v8_hvt L=0.15
+ W=0.84 AS=0.2688 AD=0.1596 PS=2.32 PD=1.22
M$1269 \$1480 \$1481 \$1483 VPB|VPWR sky130_fd_pr__pfet_01v8_hvt L=0.15 W=0.84
+ AS=0.1596 AD=0.441 PS=1.22 PD=2.73
M$1270 VPB|VPWR A|A1|X \$1793 VPB|VPWR sky130_fd_pr__pfet_01v8_hvt L=0.15 W=1
+ AS=0.26 AD=0.105 PS=2.52 PD=1.21
M$1271 \$1793 A2|B|Y A|D_N|Y VPB|VPWR sky130_fd_pr__pfet_01v8_hvt L=0.15 W=1
+ AS=0.105 AD=0.26 PS=1.21 PD=2.52
M$1272 VPB|VPWR \$1609 A|C|Y VPB|VPWR sky130_fd_pr__pfet_01v8_hvt L=0.15 W=1
+ AS=0.36 AD=0.165 PS=2.72 PD=1.33
M$1273 A|C|Y A|A3|B|Y \$1791 VPB|VPWR sky130_fd_pr__pfet_01v8_hvt L=0.15 W=1
+ AS=0.165 AD=0.105 PS=1.33 PD=1.21
M$1274 \$1791 A|D_N|Y VPB|VPWR VPB|VPWR sky130_fd_pr__pfet_01v8_hvt L=0.15 W=1
+ AS=0.105 AD=0.365 PS=1.21 PD=1.73
M$1275 VPB|VPWR A|D_N|Y \$1609 VPB|VPWR sky130_fd_pr__pfet_01v8_hvt L=0.15 W=1
+ AS=0.365 AD=0.135 PS=1.73 PD=1.27
M$1276 \$1609 A|A3|B|Y VPB|VPWR VPB|VPWR sky130_fd_pr__pfet_01v8_hvt L=0.15 W=1
+ AS=0.135 AD=0.3 PS=1.27 PD=2.6
M$1278 VPB|VPWR \$1612 A|A3|B|Y VPB|VPWR sky130_fd_pr__pfet_01v8_hvt L=0.15 W=1
+ AS=0.36 AD=0.165 PS=2.72 PD=1.33
M$1279 A|A3|B|Y B|X \$1789 VPB|VPWR sky130_fd_pr__pfet_01v8_hvt L=0.15 W=1
+ AS=0.165 AD=0.105 PS=1.33 PD=1.21
M$1280 \$1789 A|B|B1|B_N|Y VPB|VPWR VPB|VPWR sky130_fd_pr__pfet_01v8_hvt L=0.15
+ W=1 AS=0.105 AD=0.365 PS=1.21 PD=1.73
M$1281 VPB|VPWR A|B|B1|B_N|Y \$1612 VPB|VPWR sky130_fd_pr__pfet_01v8_hvt L=0.15
+ W=1 AS=0.365 AD=0.135 PS=1.73 PD=1.27
M$1282 \$1612 B|X VPB|VPWR VPB|VPWR sky130_fd_pr__pfet_01v8_hvt L=0.15 W=1
+ AS=0.135 AD=0.3 PS=1.27 PD=2.6
M$1283 VPB|VPWR A|B|B1|B_N|Y \$1614 VPB|VPWR sky130_fd_pr__pfet_01v8_hvt L=0.15
+ W=0.42 AS=0.17575 AD=0.1092 PS=1.395 PD=1.36
M$1284 VPB|VPWR D|Y A|B1|Y VPB|VPWR sky130_fd_pr__pfet_01v8_hvt L=0.15 W=1
+ AS=0.17575 AD=0.195 PS=1.395 PD=1.39
M$1285 A|B1|Y A|C|C1|X VPB|VPWR VPB|VPWR sky130_fd_pr__pfet_01v8_hvt L=0.15 W=1
+ AS=0.195 AD=0.175 PS=1.39 PD=1.35
M$1286 VPB|VPWR \$1614 A|B1|Y VPB|VPWR sky130_fd_pr__pfet_01v8_hvt L=0.15 W=1
+ AS=0.175 AD=0.175 PS=1.35 PD=1.35
M$1287 A|B1|Y \$1615 VPB|VPWR VPB|VPWR sky130_fd_pr__pfet_01v8_hvt L=0.15 W=1
+ AS=0.175 AD=0.26 PS=1.35 PD=2.52
M$1289 \$1491 A|Y \$1536 VPB|VPWR sky130_fd_pr__pfet_01v8_hvt L=0.15 W=0.42
+ AS=0.1092 AD=0.0441 PS=1.36 PD=0.63
M$1290 VPB|VPWR B|SLEEP|Y \$1536 VPB|VPWR sky130_fd_pr__pfet_01v8_hvt L=0.15
+ W=0.42 AS=0.14575 AD=0.0441 PS=1.335 PD=0.63
M$1291 VPB|VPWR \$1491 A|C|C1|X VPB|VPWR sky130_fd_pr__pfet_01v8_hvt L=0.15 W=1
+ AS=0.14575 AD=0.34 PS=1.335 PD=2.68
M$1292 VPB|VPWR A|X A|A1|B1|Y VPB|VPWR sky130_fd_pr__pfet_01v8_hvt L=0.15
+ W=2.68 AS=0.6486 AD=0.4968 PS=5.95 PD=4.64
M$1293 A|A1|B1|Y B|X VPB|VPWR VPB|VPWR sky130_fd_pr__pfet_01v8_hvt L=0.15 W=1
+ AS=0.165 AD=0.135 PS=1.33 PD=1.27
M$1294 VPB|VPWR A|B1|C|Y A|A1|B1|Y VPB|VPWR sky130_fd_pr__pfet_01v8_hvt L=0.15
+ W=1 AS=0.135 AD=0.135 PS=1.27 PD=1.27
M$1295 A|A1|B1|Y B2|D|Y VPB|VPWR VPB|VPWR sky130_fd_pr__pfet_01v8_hvt L=0.15
+ W=1 AS=0.135 AD=0.26 PS=1.27 PD=2.52
M$1301 VPB|VPWR A|B|Y \$1617 VPB|VPWR sky130_fd_pr__pfet_01v8_hvt L=0.15 W=1
+ AS=0.3 AD=0.135 PS=2.6 PD=1.27
M$1302 \$1617 A|A1|C1|Y VPB|VPWR VPB|VPWR sky130_fd_pr__pfet_01v8_hvt L=0.15
+ W=1 AS=0.135 AD=0.365 PS=1.27 PD=1.73
M$1303 VPB|VPWR A|A1|C1|Y \$1785 VPB|VPWR sky130_fd_pr__pfet_01v8_hvt L=0.15
+ W=1 AS=0.365 AD=0.105 PS=1.73 PD=1.21
M$1304 \$1785 A|B|Y A|B|Y VPB|VPWR sky130_fd_pr__pfet_01v8_hvt L=0.15 W=1
+ AS=0.105 AD=0.165 PS=1.21 PD=1.33
M$1305 A|B|Y \$1617 VPB|VPWR VPB|VPWR sky130_fd_pr__pfet_01v8_hvt L=0.15 W=1
+ AS=0.165 AD=0.36 PS=1.33 PD=2.72
M$1307 VPB|VPWR \$1620 A2|B|Y VPB|VPWR sky130_fd_pr__pfet_01v8_hvt L=0.15 W=1
+ AS=0.36 AD=0.165 PS=2.72 PD=1.33
M$1308 A2|B|Y B|Y \$1783 VPB|VPWR sky130_fd_pr__pfet_01v8_hvt L=0.15 W=1
+ AS=0.165 AD=0.105 PS=1.33 PD=1.21
M$1309 \$1783 A|A_N|B1|Y VPB|VPWR VPB|VPWR sky130_fd_pr__pfet_01v8_hvt L=0.15
+ W=1 AS=0.105 AD=0.365 PS=1.21 PD=1.73
M$1310 VPB|VPWR A|A_N|B1|Y \$1620 VPB|VPWR sky130_fd_pr__pfet_01v8_hvt L=0.15
+ W=1 AS=0.365 AD=0.135 PS=1.73 PD=1.27
M$1311 \$1620 B|Y VPB|VPWR VPB|VPWR sky130_fd_pr__pfet_01v8_hvt L=0.15 W=1
+ AS=0.135 AD=0.3 PS=1.27 PD=2.6
M$1312 \$1622 A|A_N|B1|Y VPB|VPWR VPB|VPWR sky130_fd_pr__pfet_01v8_hvt L=0.15
+ W=0.42 AS=0.1092 AD=0.14575 PS=1.36 PD=1.335
M$1313 VPB|VPWR B|Y B1|Y VPB|VPWR sky130_fd_pr__pfet_01v8_hvt L=0.15 W=3
+ AS=0.54075 AD=0.53 PS=5.125 PD=5.06
M$1314 B1|Y \$1622 VPB|VPWR VPB|VPWR sky130_fd_pr__pfet_01v8_hvt L=0.15 W=1
+ AS=0.135 AD=0.265 PS=1.27 PD=2.53
M$1316 VPB|VPWR A|A1|B|X \$1780 VPB|VPWR sky130_fd_pr__pfet_01v8_hvt L=0.15 W=1
+ AS=0.27 AD=0.105 PS=2.54 PD=1.21
M$1317 \$1780 A2|B|Y A|A1|Y VPB|VPWR sky130_fd_pr__pfet_01v8_hvt L=0.15 W=1
+ AS=0.105 AD=0.2325 PS=1.21 PD=1.465
M$1318 A|A1|Y B2|D|SLEEP|Y \$1779 VPB|VPWR sky130_fd_pr__pfet_01v8_hvt L=0.15
+ W=1 AS=0.2325 AD=0.1125 PS=1.465 PD=1.225
M$1319 \$1779 A|B1|C|X VPB|VPWR VPB|VPWR sky130_fd_pr__pfet_01v8_hvt L=0.15 W=1
+ AS=0.1125 AD=0.26 PS=1.225 PD=2.52
M$1320 VPB|VPWR A|A1|B|X \$1775 VPB|VPWR sky130_fd_pr__pfet_01v8_hvt L=0.15
+ W=0.42 AS=0.14825 AD=0.0693 PS=1.34 PD=0.75
M$1321 \$1775 A2|B|Y \$1776 VPB|VPWR sky130_fd_pr__pfet_01v8_hvt L=0.15 W=0.42
+ AS=0.0693 AD=0.0441 PS=0.75 PD=0.63
M$1322 \$1776 A|B1|C|X \$1777 VPB|VPWR sky130_fd_pr__pfet_01v8_hvt L=0.15
+ W=0.42 AS=0.0441 AD=0.0693 PS=0.63 PD=0.75
M$1323 \$1777 B2|D|SLEEP|Y \$1625 VPB|VPWR sky130_fd_pr__pfet_01v8_hvt L=0.15
+ W=0.42 AS=0.0693 AD=0.1092 PS=0.75 PD=1.36
M$1324 A2|B|X \$1625 VPB|VPWR VPB|VPWR sky130_fd_pr__pfet_01v8_hvt L=0.15 W=1
+ AS=0.27 AD=0.14825 PS=2.54 PD=1.34
M$1334 A2|B|C|X \$1795 \$1796 VPB|VPWR sky130_fd_pr__pfet_01v8_hvt L=0.15 W=1
+ AS=0.3 AD=0.26 PS=2.6 PD=2.52
M$1335 VPB|VPWR A1|B|Y \$1796 VPB|VPWR sky130_fd_pr__pfet_01v8_hvt L=0.15 W=1
+ AS=0.26 AD=0.135 PS=2.52 PD=1.27
M$1336 \$1796 A|A1|B1|C_N|X VPB|VPWR VPB|VPWR sky130_fd_pr__pfet_01v8_hvt
+ L=0.15 W=1 AS=0.135 AD=0.135 PS=1.27 PD=1.27
M$1337 VPB|VPWR A|A1|B1|C_N|X \$1827 VPB|VPWR sky130_fd_pr__pfet_01v8_hvt
+ L=0.15 W=1 AS=0.135 AD=0.135 PS=1.27 PD=1.27
M$1338 \$1827 A1|B|Y \$1795 VPB|VPWR sky130_fd_pr__pfet_01v8_hvt L=0.15 W=1
+ AS=0.135 AD=0.26 PS=1.27 PD=2.52
M$1339 VPB|VPWR B|C|X S|Y VPB|VPWR sky130_fd_pr__pfet_01v8_hvt L=0.15 W=1
+ AS=0.26 AD=0.135 PS=2.52 PD=1.27
M$1340 S|Y A|B|Y VPB|VPWR VPB|VPWR sky130_fd_pr__pfet_01v8_hvt L=0.15 W=1
+ AS=0.135 AD=0.26 PS=1.27 PD=2.52
M$1341 VPB|VPWR A|A1|B1|C_N|X \$1800 VPB|VPWR sky130_fd_pr__pfet_01v8_hvt
+ L=0.15 W=0.42 AS=0.14575 AD=0.1092 PS=1.335 PD=1.36
M$1342 A|B|Y \$1800 \$1829 VPB|VPWR sky130_fd_pr__pfet_01v8_hvt L=0.15 W=1
+ AS=0.32 AD=0.135 PS=2.64 PD=1.27
M$1343 \$1829 A1|B|Y \$1830 VPB|VPWR sky130_fd_pr__pfet_01v8_hvt L=0.15 W=1
+ AS=0.135 AD=0.135 PS=1.27 PD=1.27
M$1344 \$1830 A|A3|B|Y VPB|VPWR VPB|VPWR sky130_fd_pr__pfet_01v8_hvt L=0.15 W=1
+ AS=0.135 AD=0.14575 PS=1.27 PD=1.335
M$1345 VPB|VPWR S|Y \$1868 VPB|VPWR sky130_fd_pr__pfet_01v8_hvt L=0.15 W=1
+ AS=0.26 AD=0.29 PS=2.52 PD=2.58
M$1346 \$2072 S|Y VPB|VPWR VPB|VPWR sky130_fd_pr__pfet_01v8_hvt L=0.15 W=1
+ AS=0.26 AD=0.3 PS=2.52 PD=1.6
M$1347 VPB|VPWR \$1868 \$2101 VPB|VPWR sky130_fd_pr__pfet_01v8_hvt L=0.15 W=1
+ AS=0.3 AD=0.1975 PS=1.6 PD=1.395
M$1348 \$2101 A1|A2|X A|B|Y VPB|VPWR sky130_fd_pr__pfet_01v8_hvt L=0.15 W=1
+ AS=0.1975 AD=0.1525 PS=1.395 PD=1.305
M$1349 A|B|Y A|A0|X \$2072 VPB|VPWR sky130_fd_pr__pfet_01v8_hvt L=0.15 W=1
+ AS=0.1525 AD=0.28 PS=1.305 PD=2.56
M$1351 VPB|VPWR A1|B|Y \$1831 VPB|VPWR sky130_fd_pr__pfet_01v8_hvt L=0.15 W=1
+ AS=0.26 AD=0.135 PS=2.52 PD=1.27
M$1352 \$1831 A1|A2|X \$1832 VPB|VPWR sky130_fd_pr__pfet_01v8_hvt L=0.15 W=1
+ AS=0.135 AD=0.135 PS=1.27 PD=1.27
M$1353 \$1832 A3|B|X C|SLEEP|Y VPB|VPWR sky130_fd_pr__pfet_01v8_hvt L=0.15 W=1
+ AS=0.135 AD=0.3925 PS=1.27 PD=1.785
M$1354 C|SLEEP|Y A|A1|B1|C_N|X VPB|VPWR VPB|VPWR sky130_fd_pr__pfet_01v8_hvt
+ L=0.15 W=1 AS=0.3925 AD=0.3 PS=1.785 PD=2.6
M$1357 VPB|VPWR B|Y B|C|Y VPB|VPWR sky130_fd_pr__pfet_01v8_hvt L=0.15 W=1
+ AS=0.26 AD=0.135 PS=2.52 PD=1.27
M$1358 B|C|Y A|X VPB|VPWR VPB|VPWR sky130_fd_pr__pfet_01v8_hvt L=0.15 W=1
+ AS=0.135 AD=0.26 PS=1.27 PD=2.52
M$1359 VPB|VPWR \$2056 A|B|Y VPB|VPWR sky130_fd_pr__pfet_01v8_hvt L=0.15 W=1
+ AS=0.36 AD=0.165 PS=2.72 PD=1.33
M$1360 A|B|Y B|C|Y \$2110 VPB|VPWR sky130_fd_pr__pfet_01v8_hvt L=0.15 W=1
+ AS=0.165 AD=0.105 PS=1.33 PD=1.21
M$1361 \$2110 A|X VPB|VPWR VPB|VPWR sky130_fd_pr__pfet_01v8_hvt L=0.15 W=1
+ AS=0.105 AD=0.365 PS=1.21 PD=1.73
M$1362 VPB|VPWR A|X \$2056 VPB|VPWR sky130_fd_pr__pfet_01v8_hvt L=0.15 W=1
+ AS=0.365 AD=0.135 PS=1.73 PD=1.27
M$1363 \$2056 B|C|Y VPB|VPWR VPB|VPWR sky130_fd_pr__pfet_01v8_hvt L=0.15 W=1
+ AS=0.135 AD=0.3 PS=1.27 PD=2.6
M$1366 VPB|VPWR B|C|Y \$2114 VPB|VPWR sky130_fd_pr__pfet_01v8_hvt L=0.15 W=0.42
+ AS=0.2492 AD=0.0441 PS=1.565 PD=0.63
M$1367 \$2114 B|Y \$1873 VPB|VPWR sky130_fd_pr__pfet_01v8_hvt L=0.15 W=0.42
+ AS=0.0441 AD=0.0567 PS=0.63 PD=0.69
M$1368 \$1873 B|Y \$2113 VPB|VPWR sky130_fd_pr__pfet_01v8_hvt L=0.15 W=0.42
+ AS=0.0567 AD=0.0441 PS=0.69 PD=0.63
M$1369 \$2113 A|Y VPB|VPWR VPB|VPWR sky130_fd_pr__pfet_01v8_hvt L=0.15 W=0.42
+ AS=0.0441 AD=0.0567 PS=0.63 PD=0.69
M$1370 VPB|VPWR A|Y \$2115 VPB|VPWR sky130_fd_pr__pfet_01v8_hvt L=0.15 W=0.42
+ AS=0.0567 AD=0.0441 PS=0.69 PD=0.63
M$1371 \$2115 B|C|Y \$1873 VPB|VPWR sky130_fd_pr__pfet_01v8_hvt L=0.15 W=0.42
+ AS=0.0441 AD=0.1092 PS=0.63 PD=1.36
M$1372 B|X \$1873 VPB|VPWR VPB|VPWR sky130_fd_pr__pfet_01v8_hvt L=0.15 W=1
+ AS=0.365 AD=0.2492 PS=2.73 PD=1.565
M$1373 VPB|VPWR A|C|X B|Y VPB|VPWR sky130_fd_pr__pfet_01v8_hvt L=0.15 W=1.68
+ AS=0.3318 AD=0.3486 PS=3.31 PD=3.35
M$1376 A|A1|Y B|Y \$1833 VPB|VPWR sky130_fd_pr__pfet_01v8_hvt L=0.15 W=1
+ AS=0.26 AD=0.105 PS=2.52 PD=1.21
M$1377 \$1833 A|Y VPB|VPWR VPB|VPWR sky130_fd_pr__pfet_01v8_hvt L=0.15 W=1
+ AS=0.105 AD=0.26 PS=1.21 PD=2.52
M$1379 VPB|VPWR A|Y A|B1_N|Y VPB|VPWR sky130_fd_pr__pfet_01v8_hvt L=0.15 W=1
+ AS=0.26 AD=0.135 PS=2.52 PD=1.27
M$1380 A|B1_N|Y A|A2|B|Y VPB|VPWR VPB|VPWR sky130_fd_pr__pfet_01v8_hvt L=0.15
+ W=1 AS=0.135 AD=0.26 PS=1.27 PD=2.52
M$1381 VPB|VPWR A|A1|Y A|Y VPB|VPWR sky130_fd_pr__pfet_01v8_hvt L=0.15 W=3
+ AS=0.655 AD=0.53 PS=6.31 PD=5.06
M$1382 A|Y A|A2|B|X VPB|VPWR VPB|VPWR sky130_fd_pr__pfet_01v8_hvt L=0.15 W=1
+ AS=0.135 AD=0.26 PS=1.27 PD=2.52
M$1383 A|A2|B|X \$1809 \$1810 VPB|VPWR sky130_fd_pr__pfet_01v8_hvt L=0.15 W=1
+ AS=0.3 AD=0.26 PS=2.6 PD=2.52
M$1384 VPB|VPWR B|X \$1810 VPB|VPWR sky130_fd_pr__pfet_01v8_hvt L=0.15 W=1
+ AS=0.26 AD=0.135 PS=2.52 PD=1.27
M$1385 \$1810 A|A2|B|Y VPB|VPWR VPB|VPWR sky130_fd_pr__pfet_01v8_hvt L=0.15 W=1
+ AS=0.135 AD=0.135 PS=1.27 PD=1.27
M$1386 VPB|VPWR A|A2|B|Y \$1835 VPB|VPWR sky130_fd_pr__pfet_01v8_hvt L=0.15 W=1
+ AS=0.135 AD=0.135 PS=1.27 PD=1.27
M$1387 \$1835 B|X \$1809 VPB|VPWR sky130_fd_pr__pfet_01v8_hvt L=0.15 W=1
+ AS=0.135 AD=0.26 PS=1.27 PD=2.52
M$1389 A|B|X \$1877 \$2074 VPB|VPWR sky130_fd_pr__pfet_01v8_hvt L=0.15 W=1
+ AS=0.3 AD=0.26 PS=2.6 PD=2.52
M$1390 VPB|VPWR B|C|X \$2074 VPB|VPWR sky130_fd_pr__pfet_01v8_hvt L=0.15 W=1
+ AS=0.26 AD=0.135 PS=2.52 PD=1.27
M$1391 \$2074 A|Y VPB|VPWR VPB|VPWR sky130_fd_pr__pfet_01v8_hvt L=0.15 W=1
+ AS=0.135 AD=0.135 PS=1.27 PD=1.27
M$1392 VPB|VPWR A|Y \$2116 VPB|VPWR sky130_fd_pr__pfet_01v8_hvt L=0.15 W=1
+ AS=0.135 AD=0.135 PS=1.27 PD=1.27
M$1393 \$2116 B|C|X \$1877 VPB|VPWR sky130_fd_pr__pfet_01v8_hvt L=0.15 W=1
+ AS=0.135 AD=0.26 PS=1.27 PD=2.52
M$1394 B1|X \$1811 \$1837 VPB|VPWR sky130_fd_pr__pfet_01v8_hvt L=0.15 W=1
+ AS=0.26 AD=0.105 PS=2.52 PD=1.21
M$1395 \$1837 B|SLEEP|X VPB|VPWR VPB|VPWR sky130_fd_pr__pfet_01v8_hvt L=0.15
+ W=1 AS=0.105 AD=0.1573 PS=1.21 PD=1.39
M$1396 VPB|VPWR A|B|Y \$1811 VPB|VPWR sky130_fd_pr__pfet_01v8_hvt L=0.15 W=0.42
+ AS=0.1573 AD=0.1092 PS=1.39 PD=1.36
M$1398 VPB|VPWR A|A2|B|Y A|Y VPB|VPWR sky130_fd_pr__pfet_01v8_hvt L=0.15 W=2
+ AS=0.425 AD=0.27 PS=3.85 PD=2.54
M$1399 A|Y B|C|X VPB|VPWR VPB|VPWR sky130_fd_pr__pfet_01v8_hvt L=0.15 W=5
+ AS=0.9465 AD=0.8 PS=8.98 PD=7.6
M$1400 VPB|VPWR \$1813 A|A2|B|Y VPB|VPWR sky130_fd_pr__pfet_01v8_hvt L=0.15 W=1
+ AS=0.36 AD=0.165 PS=2.72 PD=1.33
M$1401 A|A2|B|Y B|SLEEP|X \$1838 VPB|VPWR sky130_fd_pr__pfet_01v8_hvt L=0.15
+ W=1 AS=0.165 AD=0.105 PS=1.33 PD=1.21
M$1402 \$1838 A|B|Y VPB|VPWR VPB|VPWR sky130_fd_pr__pfet_01v8_hvt L=0.15 W=1
+ AS=0.105 AD=0.365 PS=1.21 PD=1.73
M$1403 VPB|VPWR A|B|Y \$1813 VPB|VPWR sky130_fd_pr__pfet_01v8_hvt L=0.15 W=1
+ AS=0.365 AD=0.135 PS=1.73 PD=1.27
M$1404 \$1813 B|SLEEP|X VPB|VPWR VPB|VPWR sky130_fd_pr__pfet_01v8_hvt L=0.15
+ W=1 AS=0.135 AD=0.3 PS=1.27 PD=2.6
M$1406 A|A_N|Y A|Y VPB|VPWR VPB|VPWR sky130_fd_pr__pfet_01v8_hvt L=0.15 W=1
+ AS=0.26 AD=0.165 PS=2.52 PD=1.33
M$1407 VPB|VPWR A|B|Y A|A_N|Y VPB|VPWR sky130_fd_pr__pfet_01v8_hvt L=0.15 W=1
+ AS=0.165 AD=0.135 PS=1.33 PD=1.27
M$1408 A|A_N|Y B|B_N|C|X VPB|VPWR VPB|VPWR sky130_fd_pr__pfet_01v8_hvt L=0.15
+ W=1 AS=0.135 AD=0.26 PS=1.27 PD=2.52
M$1410 B|C|X \$1883 \$2075 VPB|VPWR sky130_fd_pr__pfet_01v8_hvt L=0.15 W=1
+ AS=0.3 AD=0.26 PS=2.6 PD=2.52
M$1411 VPB|VPWR A2|B|Y \$2075 VPB|VPWR sky130_fd_pr__pfet_01v8_hvt L=0.15 W=1
+ AS=0.26 AD=0.135 PS=2.52 PD=1.27
M$1412 \$2075 A|A1|X VPB|VPWR VPB|VPWR sky130_fd_pr__pfet_01v8_hvt L=0.15 W=1
+ AS=0.135 AD=0.135 PS=1.27 PD=1.27
M$1413 VPB|VPWR A|A1|X \$2111 VPB|VPWR sky130_fd_pr__pfet_01v8_hvt L=0.15 W=1
+ AS=0.135 AD=0.135 PS=1.27 PD=1.27
M$1414 \$2111 A2|B|Y \$1883 VPB|VPWR sky130_fd_pr__pfet_01v8_hvt L=0.15 W=1
+ AS=0.135 AD=0.26 PS=1.27 PD=2.52
M$1415 VPB|VPWR \$2060 A2|B|Y VPB|VPWR sky130_fd_pr__pfet_01v8_hvt L=0.15 W=1
+ AS=0.36 AD=0.165 PS=2.72 PD=1.33
M$1416 A2|B|Y B|B_N|C|X \$2109 VPB|VPWR sky130_fd_pr__pfet_01v8_hvt L=0.15 W=1
+ AS=0.165 AD=0.105 PS=1.33 PD=1.21
M$1417 \$2109 A|Y VPB|VPWR VPB|VPWR sky130_fd_pr__pfet_01v8_hvt L=0.15 W=1
+ AS=0.105 AD=0.365 PS=1.21 PD=1.73
M$1418 VPB|VPWR A|Y \$2060 VPB|VPWR sky130_fd_pr__pfet_01v8_hvt L=0.15 W=1
+ AS=0.365 AD=0.135 PS=1.73 PD=1.27
M$1419 \$2060 B|B_N|C|X VPB|VPWR VPB|VPWR sky130_fd_pr__pfet_01v8_hvt L=0.15
+ W=1 AS=0.135 AD=0.3 PS=1.27 PD=2.6
M$1421 \$1885 B|B_N|C|X VPB|VPWR VPB|VPWR sky130_fd_pr__pfet_01v8_hvt L=0.15
+ W=0.42 AS=0.1092 AD=0.1573 PS=1.36 PD=1.39
M$1422 VPB|VPWR A|Y \$2107 VPB|VPWR sky130_fd_pr__pfet_01v8_hvt L=0.15 W=1
+ AS=0.1573 AD=0.105 PS=1.39 PD=1.21
M$1423 \$2107 \$1885 A|C1|Y VPB|VPWR sky130_fd_pr__pfet_01v8_hvt L=0.15 W=1
+ AS=0.105 AD=0.26 PS=1.21 PD=2.52
M$1425 A|Y B|X \$2106 VPB|VPWR sky130_fd_pr__pfet_01v8_hvt L=0.15 W=1 AS=0.26
+ AD=0.105 PS=2.52 PD=1.21
M$1426 \$2106 A|B|Y VPB|VPWR VPB|VPWR sky130_fd_pr__pfet_01v8_hvt L=0.15 W=1
+ AS=0.105 AD=0.26 PS=1.21 PD=2.52
M$1427 B|B_N|C|X \$1888 \$2076 VPB|VPWR sky130_fd_pr__pfet_01v8_hvt L=0.15 W=1
+ AS=0.3 AD=0.26 PS=2.6 PD=2.52
M$1428 VPB|VPWR B|X \$2076 VPB|VPWR sky130_fd_pr__pfet_01v8_hvt L=0.15 W=1
+ AS=0.26 AD=0.135 PS=2.52 PD=1.27
M$1429 \$2076 A|B|Y VPB|VPWR VPB|VPWR sky130_fd_pr__pfet_01v8_hvt L=0.15 W=1
+ AS=0.135 AD=0.135 PS=1.27 PD=1.27
M$1430 VPB|VPWR A|B|Y \$2105 VPB|VPWR sky130_fd_pr__pfet_01v8_hvt L=0.15 W=1
+ AS=0.135 AD=0.135 PS=1.27 PD=1.27
M$1431 \$2105 B|X \$1888 VPB|VPWR sky130_fd_pr__pfet_01v8_hvt L=0.15 W=1
+ AS=0.135 AD=0.26 PS=1.27 PD=2.52
M$1433 VPB|VPWR A|D_N|Y \$1889 VPB|VPWR sky130_fd_pr__pfet_01v8_hvt L=0.15
+ W=0.42 AS=0.14575 AD=0.1092 PS=1.335 PD=1.36
M$1434 VPB|VPWR A|A3|B|Y \$2103 VPB|VPWR sky130_fd_pr__pfet_01v8_hvt L=0.15 W=1
+ AS=0.14575 AD=0.135 PS=1.335 PD=1.27
M$1435 \$2103 A|B|Y \$2104 VPB|VPWR sky130_fd_pr__pfet_01v8_hvt L=0.15 W=1
+ AS=0.135 AD=0.165 PS=1.27 PD=1.33
M$1436 \$2104 B|C|SLEEP|Y \$2102 VPB|VPWR sky130_fd_pr__pfet_01v8_hvt L=0.15
+ W=1 AS=0.165 AD=0.135 PS=1.33 PD=1.27
M$1437 \$2102 \$1889 A|Y VPB|VPWR sky130_fd_pr__pfet_01v8_hvt L=0.15 W=1
+ AS=0.135 AD=0.52 PS=1.27 PD=3.04
M$1441 A|Y A|B|B1|B_N|Y \$2100 VPB|VPWR sky130_fd_pr__pfet_01v8_hvt L=0.15 W=1
+ AS=0.26 AD=0.105 PS=2.52 PD=1.21
M$1442 \$2100 A|C|C1|X VPB|VPWR VPB|VPWR sky130_fd_pr__pfet_01v8_hvt L=0.15 W=1
+ AS=0.105 AD=0.26 PS=1.21 PD=2.52
M$1443 VPB|VPWR A_N|C|Y \$1615 VPB|VPWR sky130_fd_pr__pfet_01v8_hvt L=0.15
+ W=0.42 AS=0.1092 AD=0.1827 PS=1.36 PD=1.71
M$1444 \$2077 A2|B|Y VPB|VPWR VPB|VPWR sky130_fd_pr__pfet_01v8_hvt L=0.15 W=1
+ AS=0.265 AD=0.14 PS=2.53 PD=1.28
M$1445 VPB|VPWR A|A1|B1|Y \$2077 VPB|VPWR sky130_fd_pr__pfet_01v8_hvt L=0.15
+ W=1 AS=0.14 AD=0.14 PS=1.28 PD=1.28
M$1446 \$2077 A|B|B1|B_N|Y \$2099 VPB|VPWR sky130_fd_pr__pfet_01v8_hvt L=0.15
+ W=1 AS=0.14 AD=0.155 PS=1.28 PD=1.31
M$1447 \$2099 A|C|C1|X A|B2|Y VPB|VPWR sky130_fd_pr__pfet_01v8_hvt L=0.15 W=1
+ AS=0.155 AD=0.265 PS=1.31 PD=2.53
M$1450 VPB|VPWR \$2062 B|B1|Y VPB|VPWR sky130_fd_pr__pfet_01v8_hvt L=0.15 W=1
+ AS=0.36 AD=0.165 PS=2.72 PD=1.33
M$1451 B|B1|Y B|X \$2098 VPB|VPWR sky130_fd_pr__pfet_01v8_hvt L=0.15 W=1
+ AS=0.165 AD=0.105 PS=1.33 PD=1.21
M$1452 \$2098 A|A2|Y VPB|VPWR VPB|VPWR sky130_fd_pr__pfet_01v8_hvt L=0.15 W=1
+ AS=0.105 AD=0.365 PS=1.21 PD=1.73
M$1453 VPB|VPWR A|A2|Y \$2062 VPB|VPWR sky130_fd_pr__pfet_01v8_hvt L=0.15 W=1
+ AS=0.365 AD=0.135 PS=1.73 PD=1.27
M$1454 \$2062 B|X VPB|VPWR VPB|VPWR sky130_fd_pr__pfet_01v8_hvt L=0.15 W=1
+ AS=0.135 AD=0.3 PS=1.27 PD=2.6
M$1455 VPB|VPWR \$2065 A2|B|Y VPB|VPWR sky130_fd_pr__pfet_01v8_hvt L=0.15 W=1
+ AS=0.36 AD=0.165 PS=2.72 PD=1.33
M$1456 A2|B|Y B|C|Y \$2097 VPB|VPWR sky130_fd_pr__pfet_01v8_hvt L=0.15 W=1
+ AS=0.165 AD=0.105 PS=1.33 PD=1.21
M$1457 \$2097 A|B|C1|Y VPB|VPWR VPB|VPWR sky130_fd_pr__pfet_01v8_hvt L=0.15 W=1
+ AS=0.105 AD=0.365 PS=1.21 PD=1.73
M$1458 VPB|VPWR A|B|C1|Y \$2065 VPB|VPWR sky130_fd_pr__pfet_01v8_hvt L=0.15 W=1
+ AS=0.365 AD=0.135 PS=1.73 PD=1.27
M$1459 \$2065 B|C|Y VPB|VPWR VPB|VPWR sky130_fd_pr__pfet_01v8_hvt L=0.15 W=1
+ AS=0.135 AD=0.3 PS=1.27 PD=2.6
M$1461 VPB|VPWR A|B1|C|Y \$1842 VPB|VPWR sky130_fd_pr__pfet_01v8_hvt L=0.15 W=1
+ AS=0.26 AD=0.105 PS=2.52 PD=1.21
M$1462 \$1842 B|Y A|B1|Y VPB|VPWR sky130_fd_pr__pfet_01v8_hvt L=0.15 W=1
+ AS=0.105 AD=0.26 PS=1.21 PD=2.52
M$1463 VPB|VPWR \$1817 B|C|Y VPB|VPWR sky130_fd_pr__pfet_01v8_hvt L=0.15 W=1
+ AS=0.36 AD=0.165 PS=2.72 PD=1.33
M$1464 B|C|Y B|Y \$1841 VPB|VPWR sky130_fd_pr__pfet_01v8_hvt L=0.15 W=1
+ AS=0.165 AD=0.105 PS=1.33 PD=1.21
M$1465 \$1841 A|Y VPB|VPWR VPB|VPWR sky130_fd_pr__pfet_01v8_hvt L=0.15 W=1
+ AS=0.105 AD=0.365 PS=1.21 PD=1.73
M$1466 VPB|VPWR A|Y \$1817 VPB|VPWR sky130_fd_pr__pfet_01v8_hvt L=0.15 W=1
+ AS=0.365 AD=0.135 PS=1.73 PD=1.27
M$1467 \$1817 B|Y VPB|VPWR VPB|VPWR sky130_fd_pr__pfet_01v8_hvt L=0.15 W=1
+ AS=0.135 AD=0.3 PS=1.27 PD=2.6
M$1469 B|Y B1|C|X \$2079 VPB|VPWR sky130_fd_pr__pfet_01v8_hvt L=0.15 W=1
+ AS=0.265 AD=0.14 PS=2.53 PD=1.28
M$1470 \$2079 A|A1|A_N|B1|X VPB|VPWR VPB|VPWR sky130_fd_pr__pfet_01v8_hvt
+ L=0.15 W=1 AS=0.14 AD=0.1475 PS=1.28 PD=1.295
M$1471 VPB|VPWR A2|B|Y \$2079 VPB|VPWR sky130_fd_pr__pfet_01v8_hvt L=0.15 W=1
+ AS=0.1475 AD=0.265 PS=1.295 PD=2.53
M$1472 A1|B1|C_N|Y A|A1|A_N|B1|X VPB|VPWR VPB|VPWR sky130_fd_pr__pfet_01v8_hvt
+ L=0.15 W=1 AS=0.26 AD=0.165 PS=2.52 PD=1.33
M$1473 VPB|VPWR A2|B|Y A1|B1|C_N|Y VPB|VPWR sky130_fd_pr__pfet_01v8_hvt L=0.15
+ W=1 AS=0.165 AD=0.135 PS=1.33 PD=1.27
M$1474 A1|B1|C_N|Y B1|C|X VPB|VPWR VPB|VPWR sky130_fd_pr__pfet_01v8_hvt L=0.15
+ W=1 AS=0.135 AD=0.26 PS=1.27 PD=2.52
M$1475 B1|C|X \$1897 \$2080 VPB|VPWR sky130_fd_pr__pfet_01v8_hvt L=0.15 W=1
+ AS=0.3 AD=0.26 PS=2.6 PD=2.52
M$1476 VPB|VPWR \$1820 B|Y VPB|VPWR sky130_fd_pr__pfet_01v8_hvt L=0.15 W=1
+ AS=0.36 AD=0.165 PS=2.72 PD=1.33
M$1477 B|Y A2|B|Y \$1839 VPB|VPWR sky130_fd_pr__pfet_01v8_hvt L=0.15 W=1
+ AS=0.165 AD=0.105 PS=1.33 PD=1.21
M$1478 \$1839 A|X VPB|VPWR VPB|VPWR sky130_fd_pr__pfet_01v8_hvt L=0.15 W=1
+ AS=0.105 AD=0.365 PS=1.21 PD=1.73
M$1479 VPB|VPWR A|X \$1820 VPB|VPWR sky130_fd_pr__pfet_01v8_hvt L=0.15 W=1
+ AS=0.365 AD=0.135 PS=1.73 PD=1.27
M$1480 \$1820 A2|B|Y VPB|VPWR VPB|VPWR sky130_fd_pr__pfet_01v8_hvt L=0.15 W=1
+ AS=0.135 AD=0.3 PS=1.27 PD=2.6
M$1481 VPB|VPWR A|A2|B|Y \$2080 VPB|VPWR sky130_fd_pr__pfet_01v8_hvt L=0.15 W=1
+ AS=0.26 AD=0.135 PS=2.52 PD=1.27
M$1482 \$2080 A|A1|Y VPB|VPWR VPB|VPWR sky130_fd_pr__pfet_01v8_hvt L=0.15 W=1
+ AS=0.135 AD=0.135 PS=1.27 PD=1.27
M$1483 VPB|VPWR A|A1|Y \$2095 VPB|VPWR sky130_fd_pr__pfet_01v8_hvt L=0.15 W=1
+ AS=0.135 AD=0.135 PS=1.27 PD=1.27
M$1484 \$2095 A|A2|B|Y \$1897 VPB|VPWR sky130_fd_pr__pfet_01v8_hvt L=0.15 W=1
+ AS=0.135 AD=0.26 PS=1.27 PD=2.52
M$1486 A|A1|Y A2|B|Y VPB|VPWR VPB|VPWR sky130_fd_pr__pfet_01v8_hvt L=0.15 W=2
+ AS=0.395 AD=0.395 PS=3.79 PD=3.79
M$1488 A|X \$1616 VPB|VPWR VPB|VPWR sky130_fd_pr__pfet_01v8_hvt L=0.15 W=0.64
+ AS=0.1696 AD=0.1841 PS=1.81 PD=1.26
M$1489 VPB|VPWR A1|B|Y \$1616 VPB|VPWR sky130_fd_pr__pfet_01v8_hvt L=0.15
+ W=0.42 AS=0.1841 AD=0.0609 PS=1.26 PD=0.71
M$1490 \$1616 A|S|X VPB|VPWR VPB|VPWR sky130_fd_pr__pfet_01v8_hvt L=0.15 W=0.42
+ AS=0.0609 AD=0.1113 PS=0.71 PD=1.37
M$1491 VPB|VPWR \$2067 A|A2|B|Y VPB|VPWR sky130_fd_pr__pfet_01v8_hvt L=0.15 W=1
+ AS=0.36 AD=0.165 PS=2.72 PD=1.33
M$1492 A|A2|B|Y B|Y \$2093 VPB|VPWR sky130_fd_pr__pfet_01v8_hvt L=0.15 W=1
+ AS=0.165 AD=0.105 PS=1.33 PD=1.21
M$1493 \$2093 A|B|Y VPB|VPWR VPB|VPWR sky130_fd_pr__pfet_01v8_hvt L=0.15 W=1
+ AS=0.105 AD=0.365 PS=1.21 PD=1.73
M$1494 VPB|VPWR A|B|Y \$2067 VPB|VPWR sky130_fd_pr__pfet_01v8_hvt L=0.15 W=1
+ AS=0.365 AD=0.135 PS=1.73 PD=1.27
M$1495 \$2067 B|Y VPB|VPWR VPB|VPWR sky130_fd_pr__pfet_01v8_hvt L=0.15 W=1
+ AS=0.135 AD=0.3 PS=1.27 PD=2.6
M$1498 B|Y B1|Y \$1823 VPB|VPWR sky130_fd_pr__pfet_01v8_hvt L=0.15 W=1 AS=0.265
+ AD=0.14 PS=2.53 PD=1.28
M$1499 \$1823 A|A1|Y VPB|VPWR VPB|VPWR sky130_fd_pr__pfet_01v8_hvt L=0.15 W=1
+ AS=0.14 AD=0.1475 PS=1.28 PD=1.295
M$1500 VPB|VPWR A2|B|X \$1823 VPB|VPWR sky130_fd_pr__pfet_01v8_hvt L=0.15 W=1
+ AS=0.1475 AD=0.265 PS=1.295 PD=2.53
M$1501 A2|C|Y A|A1|C1|Y \$2090 VPB|VPWR sky130_fd_pr__pfet_01v8_hvt L=0.15 W=1
+ AS=0.265 AD=0.155 PS=2.53 PD=1.31
M$1502 \$2090 A|A1|B|B1|Y \$2081 VPB|VPWR sky130_fd_pr__pfet_01v8_hvt L=0.15
+ W=1 AS=0.155 AD=0.14 PS=1.31 PD=1.28
M$1503 \$2081 A|A1|Y VPB|VPWR VPB|VPWR sky130_fd_pr__pfet_01v8_hvt L=0.15 W=1
+ AS=0.14 AD=0.14 PS=1.28 PD=1.28
M$1504 VPB|VPWR A2|B|X \$2081 VPB|VPWR sky130_fd_pr__pfet_01v8_hvt L=0.15 W=1
+ AS=0.14 AD=0.265 PS=1.28 PD=2.53
M$1505 VPB|VPWR A|A1|Y A|B|Y VPB|VPWR sky130_fd_pr__pfet_01v8_hvt L=0.15 W=2
+ AS=0.395 AD=0.395 PS=3.79 PD=3.79
M$1506 A|B|Y A2|B|X VPB|VPWR VPB|VPWR sky130_fd_pr__pfet_01v8_hvt L=0.15 W=2
+ AS=0.395 AD=0.395 PS=3.79 PD=3.79
M$1509 A2|B|B1|C|Y B1|C|Y \$2087 VPB|VPWR sky130_fd_pr__pfet_01v8_hvt L=0.15
+ W=1 AS=0.26 AD=0.135 PS=2.52 PD=1.27
M$1510 \$2087 A|A1|B|Y \$2088 VPB|VPWR sky130_fd_pr__pfet_01v8_hvt L=0.15 W=1
+ AS=0.135 AD=0.135 PS=1.27 PD=1.27
M$1511 \$2088 A|Y VPB|VPWR VPB|VPWR sky130_fd_pr__pfet_01v8_hvt L=0.15 W=1
+ AS=0.135 AD=0.26 PS=1.27 PD=2.52
M$1529 VPB|VPWR B|C|X \$2117 VPB|VPWR sky130_fd_pr__pfet_01v8_hvt L=0.15 W=1
+ AS=0.3 AD=0.135 PS=2.6 PD=1.27
M$1530 \$2117 A|B|Y VPB|VPWR VPB|VPWR sky130_fd_pr__pfet_01v8_hvt L=0.15 W=1
+ AS=0.135 AD=0.365 PS=1.27 PD=1.73
M$1531 VPB|VPWR A|B|Y \$2164 VPB|VPWR sky130_fd_pr__pfet_01v8_hvt L=0.15 W=1
+ AS=0.365 AD=0.105 PS=1.73 PD=1.21
M$1532 \$2164 B|C|X B|Y VPB|VPWR sky130_fd_pr__pfet_01v8_hvt L=0.15 W=1
+ AS=0.105 AD=0.165 PS=1.21 PD=1.33
M$1533 B|Y \$2117 VPB|VPWR VPB|VPWR sky130_fd_pr__pfet_01v8_hvt L=0.15 W=1
+ AS=0.165 AD=0.36 PS=1.33 PD=2.72
M$1538 B|C|X \$2120 VPB|VPWR VPB|VPWR sky130_fd_pr__pfet_01v8_hvt L=0.15 W=1
+ AS=0.28 AD=0.169 PS=2.56 PD=1.365
M$1539 VPB|VPWR C|SLEEP|Y \$2121 VPB|VPWR sky130_fd_pr__pfet_01v8_hvt L=0.15
+ W=0.64 AS=0.169 AD=0.1792 PS=1.365 PD=1.84
M$1541 VPB|VPWR B|C|Y \$2124 VPB|VPWR sky130_fd_pr__pfet_01v8_hvt L=0.15 W=1
+ AS=0.25655 AD=0.26 PS=2.52 PD=2.52
M$1542 \$2122 B|C|Y \$2126 VPB|VPWR sky130_fd_pr__pfet_01v8_hvt L=0.15 W=0.64
+ AS=0.1458 AD=0.246 PS=1.205 PD=1.525
M$1543 \$2122 \$2124 \$2125 VPB|VPWR sky130_fd_pr__pfet_01v8_hvt L=0.15 W=0.84
+ AS=0.1458 AD=0.1715 PS=1.205 PD=1.355
M$1544 \$2125 B|C|Y \$2123 VPB|VPWR sky130_fd_pr__pfet_01v8_hvt L=0.15 W=0.84
+ AS=0.3528 AD=0.2431 PS=2.52 PD=1.445
M$1545 \$2123 \$2124 \$2126 VPB|VPWR sky130_fd_pr__pfet_01v8_hvt L=0.15 W=0.64
+ AS=0.2431 AD=0.246 PS=1.445 PD=1.525
M$1546 \$2125 A|X VPB|VPWR VPB|VPWR sky130_fd_pr__pfet_01v8_hvt L=0.15 W=1
+ AS=0.1715 AD=0.135 PS=1.355 PD=1.27
M$1547 VPB|VPWR \$2125 \$2126 VPB|VPWR sky130_fd_pr__pfet_01v8_hvt L=0.15 W=1
+ AS=0.135 AD=0.285 PS=1.27 PD=2.57
M$1550 VPB|VPWR A|X \$2167 VPB|VPWR sky130_fd_pr__pfet_01v8_hvt L=0.15 W=1
+ AS=0.26 AD=0.105 PS=2.52 PD=1.21
M$1551 \$2167 B|C|Y A|Y VPB|VPWR sky130_fd_pr__pfet_01v8_hvt L=0.15 W=1
+ AS=0.105 AD=0.26 PS=1.21 PD=2.52
M$1552 VPB|VPWR A|Y A|B1|Y VPB|VPWR sky130_fd_pr__pfet_01v8_hvt L=0.15 W=2
+ AS=0.52 AD=0.27 PS=5.04 PD=2.54
M$1553 A|B1|Y A|A2|B|X VPB|VPWR VPB|VPWR sky130_fd_pr__pfet_01v8_hvt L=0.15 W=1
+ AS=0.135 AD=0.26 PS=1.27 PD=2.52
M$1554 A|A2|B|X \$2190 \$2129 VPB|VPWR sky130_fd_pr__pfet_01v8_hvt L=0.15 W=1
+ AS=0.3 AD=0.26 PS=2.6 PD=2.52
M$1555 VPB|VPWR B|X \$2129 VPB|VPWR sky130_fd_pr__pfet_01v8_hvt L=0.15 W=1
+ AS=0.26 AD=0.135 PS=2.52 PD=1.27
M$1556 \$2129 A|A2|B|X VPB|VPWR VPB|VPWR sky130_fd_pr__pfet_01v8_hvt L=0.15 W=1
+ AS=0.135 AD=0.135 PS=1.27 PD=1.27
M$1557 VPB|VPWR A|A2|B|X \$2168 VPB|VPWR sky130_fd_pr__pfet_01v8_hvt L=0.15 W=1
+ AS=0.135 AD=0.135 PS=1.27 PD=1.27
M$1558 \$2168 B|X \$2190 VPB|VPWR sky130_fd_pr__pfet_01v8_hvt L=0.15 W=1
+ AS=0.135 AD=0.26 PS=1.27 PD=2.52
M$1562 A|B|B_N|X \$2191 \$2131 VPB|VPWR sky130_fd_pr__pfet_01v8_hvt L=0.15 W=1
+ AS=0.3 AD=0.26 PS=2.6 PD=2.52
M$1563 \$2073 A|A2|B|X VPB|VPWR VPB|VPWR sky130_fd_pr__pfet_01v8_hvt L=0.15
+ W=0.64 AS=0.1696 AD=0.0896 PS=1.81 PD=0.92
M$1564 VPB|VPWR A|A1|Y \$2073 VPB|VPWR sky130_fd_pr__pfet_01v8_hvt L=0.15
+ W=0.64 AS=0.0896 AD=0.0896 PS=0.92 PD=0.92
M$1565 \$2073 \$1874 B|Y VPB|VPWR sky130_fd_pr__pfet_01v8_hvt L=0.15 W=0.64
+ AS=0.0896 AD=0.1696 PS=0.92 PD=1.81
M$1566 VPB|VPWR B|Y \$2131 VPB|VPWR sky130_fd_pr__pfet_01v8_hvt L=0.15 W=1
+ AS=0.26 AD=0.135 PS=2.52 PD=1.27
M$1567 \$2131 A|B|X VPB|VPWR VPB|VPWR sky130_fd_pr__pfet_01v8_hvt L=0.15 W=1
+ AS=0.135 AD=0.135 PS=1.27 PD=1.27
M$1568 VPB|VPWR A|B|X \$2169 VPB|VPWR sky130_fd_pr__pfet_01v8_hvt L=0.15 W=1
+ AS=0.135 AD=0.135 PS=1.27 PD=1.27
M$1569 \$2169 B|Y \$2191 VPB|VPWR sky130_fd_pr__pfet_01v8_hvt L=0.15 W=1
+ AS=0.135 AD=0.26 PS=1.27 PD=2.52
M$1570 VPB|VPWR A|B1_N|Y \$1874 VPB|VPWR sky130_fd_pr__pfet_01v8_hvt L=0.15
+ W=0.42 AS=0.1113 AD=0.1113 PS=1.37 PD=1.37
M$1571 VPB|VPWR A|Y \$2170 VPB|VPWR sky130_fd_pr__pfet_01v8_hvt L=0.15 W=1
+ AS=0.26 AD=0.105 PS=2.52 PD=1.21
M$1572 \$2170 A|B|X A|Y VPB|VPWR sky130_fd_pr__pfet_01v8_hvt L=0.15 W=1
+ AS=0.105 AD=0.26 PS=1.21 PD=2.52
M$1574 VPB|VPWR A|B1_N|Y \$2171 VPB|VPWR sky130_fd_pr__pfet_01v8_hvt L=0.15 W=1
+ AS=0.26 AD=0.105 PS=2.52 PD=1.21
M$1575 \$2171 A|B|X A|B|B2|Y VPB|VPWR sky130_fd_pr__pfet_01v8_hvt L=0.15 W=1
+ AS=0.105 AD=0.26 PS=1.21 PD=2.52
M$1577 A|Y B1|X \$2134 VPB|VPWR sky130_fd_pr__pfet_01v8_hvt L=0.15 W=1 AS=0.265
+ AD=0.14 PS=2.53 PD=1.28
M$1578 \$2134 A|A1|X VPB|VPWR VPB|VPWR sky130_fd_pr__pfet_01v8_hvt L=0.15 W=1
+ AS=0.14 AD=0.1475 PS=1.28 PD=1.295
M$1579 VPB|VPWR A|A2|B|Y \$2134 VPB|VPWR sky130_fd_pr__pfet_01v8_hvt L=0.15 W=1
+ AS=0.1475 AD=0.265 PS=1.295 PD=2.53
M$1581 \$1879 A|Y VPB|VPWR VPB|VPWR sky130_fd_pr__pfet_01v8_hvt L=0.15 W=0.42
+ AS=0.1092 AD=0.0567 PS=1.36 PD=0.69
M$1582 VPB|VPWR A|B|Y \$1879 VPB|VPWR sky130_fd_pr__pfet_01v8_hvt L=0.15 W=0.42
+ AS=0.0567 AD=0.06615 PS=0.69 PD=0.735
M$1583 VPB|VPWR B|B_N|C|X \$1879 VPB|VPWR sky130_fd_pr__pfet_01v8_hvt L=0.15
+ W=0.42 AS=0.142225 AD=0.06615 PS=1.335 PD=0.735
M$1584 VPB|VPWR \$1879 A|B|X VPB|VPWR sky130_fd_pr__pfet_01v8_hvt L=0.15 W=1
+ AS=0.142225 AD=0.26 PS=1.335 PD=2.52
M$1589 \$2137 A2|B|Y VPB|VPWR VPB|VPWR sky130_fd_pr__pfet_01v8_hvt L=0.15 W=1
+ AS=0.265 AD=0.14 PS=2.53 PD=1.28
M$1590 VPB|VPWR A|A1|X \$2137 VPB|VPWR sky130_fd_pr__pfet_01v8_hvt L=0.15 W=1
+ AS=0.14 AD=0.14 PS=1.28 PD=1.28
M$1591 \$2137 B1|C|Y \$2173 VPB|VPWR sky130_fd_pr__pfet_01v8_hvt L=0.15 W=1
+ AS=0.14 AD=0.155 PS=1.28 PD=1.31
M$1592 \$2173 A|C1|Y A|Y VPB|VPWR sky130_fd_pr__pfet_01v8_hvt L=0.15 W=1
+ AS=0.155 AD=0.265 PS=1.31 PD=2.53
M$1595 VPB|VPWR \$2140 B1|C|Y VPB|VPWR sky130_fd_pr__pfet_01v8_hvt L=0.15 W=1
+ AS=0.36 AD=0.165 PS=2.72 PD=1.33
M$1596 B1|C|Y B|C|SLEEP|Y \$2174 VPB|VPWR sky130_fd_pr__pfet_01v8_hvt L=0.15
+ W=1 AS=0.165 AD=0.105 PS=1.33 PD=1.21
M$1597 \$2174 A|Y VPB|VPWR VPB|VPWR sky130_fd_pr__pfet_01v8_hvt L=0.15 W=1
+ AS=0.105 AD=0.365 PS=1.21 PD=1.73
M$1598 VPB|VPWR A|Y \$2140 VPB|VPWR sky130_fd_pr__pfet_01v8_hvt L=0.15 W=1
+ AS=0.365 AD=0.135 PS=1.73 PD=1.27
M$1599 \$2140 B|C|SLEEP|Y VPB|VPWR VPB|VPWR sky130_fd_pr__pfet_01v8_hvt L=0.15
+ W=1 AS=0.135 AD=0.3 PS=1.27 PD=2.6
M$1602 VPB|VPWR A|B1|Y \$2176 VPB|VPWR sky130_fd_pr__pfet_01v8_hvt L=0.15 W=1
+ AS=0.26 AD=0.135 PS=2.52 PD=1.27
M$1603 \$2176 A|B|Y \$2175 VPB|VPWR sky130_fd_pr__pfet_01v8_hvt L=0.15 W=1
+ AS=0.135 AD=0.135 PS=1.27 PD=1.27
M$1604 \$2175 B|C|SLEEP|Y A|Y VPB|VPWR sky130_fd_pr__pfet_01v8_hvt L=0.15 W=1
+ AS=0.135 AD=0.26 PS=1.27 PD=2.52
M$1607 VPB|VPWR \$2143 A|B|Y VPB|VPWR sky130_fd_pr__pfet_01v8_hvt L=0.15 W=1
+ AS=0.36 AD=0.165 PS=2.72 PD=1.33
M$1608 A|B|Y B|X \$2178 VPB|VPWR sky130_fd_pr__pfet_01v8_hvt L=0.15 W=1
+ AS=0.165 AD=0.105 PS=1.33 PD=1.21
M$1609 \$2178 A|Y VPB|VPWR VPB|VPWR sky130_fd_pr__pfet_01v8_hvt L=0.15 W=1
+ AS=0.105 AD=0.365 PS=1.21 PD=1.73
M$1610 VPB|VPWR A|Y \$2143 VPB|VPWR sky130_fd_pr__pfet_01v8_hvt L=0.15 W=1
+ AS=0.365 AD=0.135 PS=1.73 PD=1.27
M$1611 \$2143 B|X VPB|VPWR VPB|VPWR sky130_fd_pr__pfet_01v8_hvt L=0.15 W=1
+ AS=0.135 AD=0.3 PS=1.27 PD=2.6
M$1613 B|X \$2192 \$2145 VPB|VPWR sky130_fd_pr__pfet_01v8_hvt L=0.15 W=1 AS=0.3
+ AD=0.26 PS=2.6 PD=2.52
M$1614 VPB|VPWR A2|B|Y \$2145 VPB|VPWR sky130_fd_pr__pfet_01v8_hvt L=0.15 W=1
+ AS=0.26 AD=0.135 PS=2.52 PD=1.27
M$1615 \$2145 A|A1|B1|Y VPB|VPWR VPB|VPWR sky130_fd_pr__pfet_01v8_hvt L=0.15
+ W=1 AS=0.135 AD=0.135 PS=1.27 PD=1.27
M$1616 VPB|VPWR A|A1|B1|Y \$2179 VPB|VPWR sky130_fd_pr__pfet_01v8_hvt L=0.15
+ W=1 AS=0.135 AD=0.135 PS=1.27 PD=1.27
M$1617 \$2179 A2|B|Y \$2192 VPB|VPWR sky130_fd_pr__pfet_01v8_hvt L=0.15 W=1
+ AS=0.135 AD=0.26 PS=1.27 PD=2.52
M$1620 VPB|VPWR A|A1|B1|Y \$2181 VPB|VPWR sky130_fd_pr__pfet_01v8_hvt L=0.15
+ W=1 AS=0.26 AD=0.105 PS=2.52 PD=1.21
M$1621 \$2181 A2|B|Y A1|Y VPB|VPWR sky130_fd_pr__pfet_01v8_hvt L=0.15 W=1
+ AS=0.105 AD=0.26 PS=1.21 PD=2.52
M$1624 VPB|VPWR A|B|C1|Y \$2185 VPB|VPWR sky130_fd_pr__pfet_01v8_hvt L=0.15 W=1
+ AS=0.26 AD=0.105 PS=2.52 PD=1.21
M$1625 \$2185 B|C|Y A1|Y VPB|VPWR sky130_fd_pr__pfet_01v8_hvt L=0.15 W=1
+ AS=0.105 AD=0.26 PS=1.21 PD=2.52
M$1627 \$2149 A|A2|Y VPB|VPWR VPB|VPWR sky130_fd_pr__pfet_01v8_hvt L=0.15 W=1
+ AS=0.265 AD=0.1475 PS=2.53 PD=1.295
M$1628 VPB|VPWR A1|Y \$2149 VPB|VPWR sky130_fd_pr__pfet_01v8_hvt L=0.15 W=1
+ AS=0.1475 AD=0.14 PS=1.295 PD=1.28
M$1629 \$2149 A|B1|Y A|Y VPB|VPWR sky130_fd_pr__pfet_01v8_hvt L=0.15 W=1
+ AS=0.14 AD=0.265 PS=1.28 PD=2.53
M$1631 VPB|VPWR A1|B1|C_N|Y \$2151 VPB|VPWR sky130_fd_pr__pfet_01v8_hvt L=0.15
+ W=0.42 AS=0.14575 AD=0.1092 PS=1.335 PD=1.36
M$1632 A|A2|Y \$2151 \$2188 VPB|VPWR sky130_fd_pr__pfet_01v8_hvt L=0.15 W=1
+ AS=0.32 AD=0.135 PS=2.64 PD=1.27
M$1633 \$2188 B|Y \$2187 VPB|VPWR sky130_fd_pr__pfet_01v8_hvt L=0.15 W=1
+ AS=0.135 AD=0.135 PS=1.27 PD=1.27
M$1634 \$2187 A|B1|Y VPB|VPWR VPB|VPWR sky130_fd_pr__pfet_01v8_hvt L=0.15 W=1
+ AS=0.135 AD=0.14575 PS=1.27 PD=1.335
M$1636 VPB|VPWR A1|B1|C_N|Y A|Y VPB|VPWR sky130_fd_pr__pfet_01v8_hvt L=0.15
+ W=0.64 AS=0.1824 AD=0.0896 PS=1.85 PD=0.92
M$1637 A|Y A|A2|B|Y \$2189 VPB|VPWR sky130_fd_pr__pfet_01v8_hvt L=0.15 W=0.64
+ AS=0.0896 AD=0.0768 PS=0.92 PD=0.88
M$1638 \$2189 A|A1|Y VPB|VPWR VPB|VPWR sky130_fd_pr__pfet_01v8_hvt L=0.15
+ W=0.64 AS=0.0768 AD=0.1696 PS=0.88 PD=1.81
M$1639 B|Y B|B1|X \$2154 VPB|VPWR sky130_fd_pr__pfet_01v8_hvt L=0.15 W=1
+ AS=0.265 AD=0.14 PS=2.53 PD=1.28
M$1640 \$2154 A1|B1|C_N|Y VPB|VPWR VPB|VPWR sky130_fd_pr__pfet_01v8_hvt L=0.15
+ W=1 AS=0.14 AD=0.1475 PS=1.28 PD=1.295
M$1641 VPB|VPWR A2|X \$2154 VPB|VPWR sky130_fd_pr__pfet_01v8_hvt L=0.15 W=1
+ AS=0.1475 AD=0.265 PS=1.295 PD=2.53
M$1644 VPB|VPWR A1|B|Y SLEEP|Y VPB|VPWR sky130_fd_pr__pfet_01v8_hvt L=0.15 W=1
+ AS=0.26 AD=0.135 PS=2.52 PD=1.27
M$1645 SLEEP|Y A|Y VPB|VPWR VPB|VPWR sky130_fd_pr__pfet_01v8_hvt L=0.15 W=1
+ AS=0.135 AD=0.26 PS=1.27 PD=2.52
M$1646 VPB|VPWR A|A1|C1|Y \$2186 VPB|VPWR sky130_fd_pr__pfet_01v8_hvt L=0.15
+ W=1 AS=0.26 AD=0.105 PS=2.52 PD=1.21
M$1647 \$2186 B|Y C|Y VPB|VPWR sky130_fd_pr__pfet_01v8_hvt L=0.15 W=1 AS=0.105
+ AD=0.26 PS=1.21 PD=2.52
M$1648 VPB|VPWR A|A1|B|C1|X B|Y VPB|VPWR sky130_fd_pr__pfet_01v8_hvt L=0.15 W=1
+ AS=0.26 AD=0.135 PS=2.52 PD=1.27
M$1649 B|Y A2|B|B1|C|Y VPB|VPWR VPB|VPWR sky130_fd_pr__pfet_01v8_hvt L=0.15 W=1
+ AS=0.135 AD=0.26 PS=1.27 PD=2.52
M$1650 VPB|VPWR A|A1|C1|Y \$2092 VPB|VPWR sky130_fd_pr__pfet_01v8_hvt L=0.15
+ W=0.64 AS=0.1696 AD=0.0768 PS=1.81 PD=0.88
M$1651 \$2092 A2|B|B1|C|Y B|Y VPB|VPWR sky130_fd_pr__pfet_01v8_hvt L=0.15
+ W=0.64 AS=0.0768 AD=0.0896 PS=0.88 PD=0.92
M$1652 B|Y B1|Y VPB|VPWR VPB|VPWR sky130_fd_pr__pfet_01v8_hvt L=0.15 W=0.64
+ AS=0.0896 AD=0.1824 PS=0.92 PD=1.85
M$1655 VPB|VPWR A3|B|Y \$2156 VPB|VPWR sky130_fd_pr__pfet_01v8_hvt L=0.15 W=1
+ AS=0.26 AD=0.135 PS=2.52 PD=1.27
M$1656 \$2156 A|A2|X VPB|VPWR VPB|VPWR sky130_fd_pr__pfet_01v8_hvt L=0.15 W=1
+ AS=0.135 AD=0.1525 PS=1.27 PD=1.305
M$1657 VPB|VPWR A|A1|B|C1|X \$2156 VPB|VPWR sky130_fd_pr__pfet_01v8_hvt L=0.15
+ W=1 AS=0.1525 AD=0.1625 PS=1.305 PD=1.325
M$1658 \$2156 B1|Y B|Y VPB|VPWR sky130_fd_pr__pfet_01v8_hvt L=0.15 W=1
+ AS=0.1625 AD=0.27 PS=1.325 PD=2.54
M$1661 VPB|VPWR A2|B1|SLEEP|Y A3|B|Y VPB|VPWR sky130_fd_pr__pfet_01v8_hvt
+ L=0.15 W=0.64 AS=0.1824 AD=0.0896 PS=1.85 PD=0.92
M$1662 A3|B|Y A2|C|Y \$2091 VPB|VPWR sky130_fd_pr__pfet_01v8_hvt L=0.15 W=0.64
+ AS=0.0896 AD=0.0768 PS=0.92 PD=0.88
M$1663 \$2091 A|A1|B|X VPB|VPWR VPB|VPWR sky130_fd_pr__pfet_01v8_hvt L=0.15
+ W=0.64 AS=0.0768 AD=0.1696 PS=0.88 PD=1.81
M$1664 VPB|VPWR A|A1|C1|Y \$2157 VPB|VPWR sky130_fd_pr__pfet_01v8_hvt L=0.15
+ W=0.42 AS=0.1113 AD=0.0609 PS=1.37 PD=0.71
M$1665 \$2157 A|A1|B|B1|Y VPB|VPWR VPB|VPWR sky130_fd_pr__pfet_01v8_hvt L=0.15
+ W=0.42 AS=0.0609 AD=0.1841 PS=0.71 PD=1.26
M$1666 VPB|VPWR \$2157 A|A1|B|X VPB|VPWR sky130_fd_pr__pfet_01v8_hvt L=0.15
+ W=0.64 AS=0.1841 AD=0.1696 PS=1.26 PD=1.81
M$1672 B1|B2|D|X \$2158 VPB|VPWR VPB|VPWR sky130_fd_pr__pfet_01v8_hvt L=0.15
+ W=1 AS=0.28 AD=0.3275 PS=2.56 PD=1.655
M$1673 VPB|VPWR B1|C|Y \$2158 VPB|VPWR sky130_fd_pr__pfet_01v8_hvt L=0.15 W=1
+ AS=0.3275 AD=0.195 PS=1.655 PD=1.39
M$1674 \$2158 A2|B|X \$2166 VPB|VPWR sky130_fd_pr__pfet_01v8_hvt L=0.15 W=1
+ AS=0.195 AD=0.1525 PS=1.39 PD=1.305
M$1675 \$2166 A|A1|B|Y VPB|VPWR VPB|VPWR sky130_fd_pr__pfet_01v8_hvt L=0.15 W=1
+ AS=0.1525 AD=0.26 PS=1.305 PD=2.52
M$1676 VPB|VPWR A2|B|X \$2159 VPB|VPWR sky130_fd_pr__pfet_01v8_hvt L=0.15 W=1
+ AS=0.3 AD=0.135 PS=2.6 PD=1.27
M$1677 \$2159 A|A1|B|Y VPB|VPWR VPB|VPWR sky130_fd_pr__pfet_01v8_hvt L=0.15 W=1
+ AS=0.135 AD=0.365 PS=1.27 PD=1.73
M$1678 VPB|VPWR A|A1|B|Y \$2163 VPB|VPWR sky130_fd_pr__pfet_01v8_hvt L=0.15 W=1
+ AS=0.365 AD=0.105 PS=1.73 PD=1.21
M$1679 \$2163 A2|B|X A|A1|Y VPB|VPWR sky130_fd_pr__pfet_01v8_hvt L=0.15 W=1
+ AS=0.105 AD=0.165 PS=1.21 PD=1.33
M$1680 A|A1|Y \$2159 VPB|VPWR VPB|VPWR sky130_fd_pr__pfet_01v8_hvt L=0.15 W=1
+ AS=0.165 AD=0.36 PS=1.33 PD=2.72
M$1682 VPB|VPWR A|X B|Y VPB|VPWR sky130_fd_pr__pfet_01v8_hvt L=0.15 W=4.68
+ AS=0.7368 AD=1.1286 PS=7.12 PD=10.91
M$1691 VPB|VPWR B|C|X \$2236 VPB|VPWR sky130_fd_pr__pfet_01v8_hvt L=0.15 W=0.64
+ AS=0.169 AD=0.1792 PS=1.365 PD=1.84
M$1692 B|X \$2235 VPB|VPWR VPB|VPWR sky130_fd_pr__pfet_01v8_hvt L=0.15 W=1
+ AS=0.28 AD=0.169 PS=2.56 PD=1.365
M$1693 \$2235 \$2236 \$2237 VPB|VPWR sky130_fd_pr__pfet_01v8_hvt L=0.15 W=0.84
+ AS=0.15295 AD=0.32235 PS=1.315 PD=2.45
M$1694 \$2235 B|C|X \$2238 VPB|VPWR sky130_fd_pr__pfet_01v8_hvt L=0.15 W=0.84
+ AS=0.15295 AD=0.273 PS=1.315 PD=2.33
M$1695 VPB|VPWR A|B|Y \$2239 VPB|VPWR sky130_fd_pr__pfet_01v8_hvt L=0.15 W=1
+ AS=0.25655 AD=0.26 PS=2.52 PD=2.52
M$1696 \$2237 \$2239 \$2241 VPB|VPWR sky130_fd_pr__pfet_01v8_hvt L=0.15 W=0.64
+ AS=0.2431 AD=0.246 PS=1.445 PD=1.525
M$1697 \$2241 A|B|Y \$2238 VPB|VPWR sky130_fd_pr__pfet_01v8_hvt L=0.15 W=0.64
+ AS=0.246 AD=0.1458 PS=1.525 PD=1.205
M$1698 \$2240 A|B|Y \$2237 VPB|VPWR sky130_fd_pr__pfet_01v8_hvt L=0.15 W=0.84
+ AS=0.3528 AD=0.2431 PS=2.52 PD=1.445
M$1699 \$2240 \$2239 \$2238 VPB|VPWR sky130_fd_pr__pfet_01v8_hvt L=0.15 W=0.84
+ AS=0.1715 AD=0.1458 PS=1.355 PD=1.205
M$1700 \$2240 A|B|X VPB|VPWR VPB|VPWR sky130_fd_pr__pfet_01v8_hvt L=0.15 W=1
+ AS=0.1715 AD=0.135 PS=1.355 PD=1.27
M$1701 VPB|VPWR \$2240 \$2241 VPB|VPWR sky130_fd_pr__pfet_01v8_hvt L=0.15 W=1
+ AS=0.135 AD=0.285 PS=1.27 PD=2.57
M$1704 \$2122 C|SLEEP|Y \$2120 VPB|VPWR sky130_fd_pr__pfet_01v8_hvt L=0.15
+ W=0.84 AS=0.273 AD=0.15295 PS=2.33 PD=1.315
M$1705 \$2120 \$2121 \$2123 VPB|VPWR sky130_fd_pr__pfet_01v8_hvt L=0.15 W=0.84
+ AS=0.15295 AD=0.32235 PS=1.315 PD=2.45
M$1710 \$2243 B|B1|C|X \$2442 VPB|VPWR sky130_fd_pr__pfet_01v8_hvt L=0.15 W=1
+ AS=0.26 AD=0.135 PS=2.52 PD=1.27
M$1711 \$2442 A|B|B2|Y VPB|VPWR VPB|VPWR sky130_fd_pr__pfet_01v8_hvt L=0.15 W=1
+ AS=0.135 AD=0.135 PS=1.27 PD=1.27
M$1712 VPB|VPWR A|B|B2|Y \$2424 VPB|VPWR sky130_fd_pr__pfet_01v8_hvt L=0.15 W=1
+ AS=0.135 AD=0.135 PS=1.27 PD=1.27
M$1713 \$2424 B|B1|C|X VPB|VPWR VPB|VPWR sky130_fd_pr__pfet_01v8_hvt L=0.15 W=1
+ AS=0.135 AD=0.26 PS=1.27 PD=2.52
M$1714 \$2424 \$2243 C|X VPB|VPWR sky130_fd_pr__pfet_01v8_hvt L=0.15 W=1
+ AS=0.26 AD=0.3 PS=2.52 PD=2.6
M$1716 VPB|VPWR A|Y A1|Y VPB|VPWR sky130_fd_pr__pfet_01v8_hvt L=0.15 W=2.68
+ AS=0.4836 AD=0.5918 PS=4.62 PD=5.83
M$1718 VPB|VPWR B|C|SLEEP|Y \$2445 VPB|VPWR sky130_fd_pr__pfet_01v8_hvt L=0.15
+ W=0.42 AS=0.14575 AD=0.0441 PS=1.335 PD=0.63
M$1719 \$2445 A|B|X \$2247 VPB|VPWR sky130_fd_pr__pfet_01v8_hvt L=0.15 W=0.42
+ AS=0.0441 AD=0.1092 PS=0.63 PD=1.36
M$1720 A3|X \$2247 VPB|VPWR VPB|VPWR sky130_fd_pr__pfet_01v8_hvt L=0.15 W=1
+ AS=0.34 AD=0.14575 PS=2.68 PD=1.335
M$1721 VPB|VPWR A|B|X A|A2|Y VPB|VPWR sky130_fd_pr__pfet_01v8_hvt L=0.15 W=1
+ AS=0.26 AD=0.135 PS=2.52 PD=1.27
M$1722 A|A2|Y B|C|SLEEP|Y VPB|VPWR VPB|VPWR sky130_fd_pr__pfet_01v8_hvt L=0.15
+ W=1 AS=0.135 AD=0.26 PS=1.27 PD=2.52
M$1724 VPB|VPWR \$2250 B|C|SLEEP|Y VPB|VPWR sky130_fd_pr__pfet_01v8_hvt L=0.15
+ W=1 AS=0.36 AD=0.165 PS=2.72 PD=1.33
M$1725 B|C|SLEEP|Y B|Y \$2446 VPB|VPWR sky130_fd_pr__pfet_01v8_hvt L=0.15 W=1
+ AS=0.165 AD=0.105 PS=1.33 PD=1.21
M$1726 \$2446 A|A_N|Y VPB|VPWR VPB|VPWR sky130_fd_pr__pfet_01v8_hvt L=0.15 W=1
+ AS=0.105 AD=0.365 PS=1.21 PD=1.73
M$1727 VPB|VPWR A|A_N|Y \$2250 VPB|VPWR sky130_fd_pr__pfet_01v8_hvt L=0.15 W=1
+ AS=0.365 AD=0.135 PS=1.73 PD=1.27
M$1728 \$2250 B|Y VPB|VPWR VPB|VPWR sky130_fd_pr__pfet_01v8_hvt L=0.15 W=1
+ AS=0.135 AD=0.3 PS=1.27 PD=2.6
M$1730 \$2135 A|A1|X VPB|VPWR VPB|VPWR sky130_fd_pr__pfet_01v8_hvt L=0.15
+ W=0.42 AS=0.1092 AD=0.0567 PS=1.36 PD=0.69
M$1731 VPB|VPWR A2|B|Y \$2135 VPB|VPWR sky130_fd_pr__pfet_01v8_hvt L=0.15
+ W=0.42 AS=0.0567 AD=0.06615 PS=0.69 PD=0.735
M$1732 VPB|VPWR B1|C|Y \$2135 VPB|VPWR sky130_fd_pr__pfet_01v8_hvt L=0.15
+ W=0.42 AS=0.142225 AD=0.06615 PS=1.335 PD=0.735
M$1733 VPB|VPWR \$2135 A|B|X VPB|VPWR sky130_fd_pr__pfet_01v8_hvt L=0.15 W=1
+ AS=0.142225 AD=0.26 PS=1.335 PD=2.52
M$1734 B|Y A|B|C|X \$2448 VPB|VPWR sky130_fd_pr__pfet_01v8_hvt L=0.15 W=1
+ AS=0.26 AD=0.135 PS=2.52 PD=1.27
M$1735 \$2448 A|B|X \$2449 VPB|VPWR sky130_fd_pr__pfet_01v8_hvt L=0.15 W=1
+ AS=0.135 AD=0.135 PS=1.27 PD=1.27
M$1736 \$2449 A|Y VPB|VPWR VPB|VPWR sky130_fd_pr__pfet_01v8_hvt L=0.15 W=1
+ AS=0.135 AD=0.26 PS=1.27 PD=2.52
M$1738 \$2254 A|C1|Y VPB|VPWR VPB|VPWR sky130_fd_pr__pfet_01v8_hvt L=0.15
+ W=0.42 AS=0.1092 AD=0.1573 PS=1.36 PD=1.39
M$1739 VPB|VPWR B|C|SLEEP|Y \$2452 VPB|VPWR sky130_fd_pr__pfet_01v8_hvt L=0.15
+ W=1 AS=0.1573 AD=0.105 PS=1.39 PD=1.21
M$1740 \$2452 \$2254 A|B|C|X VPB|VPWR sky130_fd_pr__pfet_01v8_hvt L=0.15 W=1
+ AS=0.105 AD=0.26 PS=1.21 PD=2.52
M$1743 B|X \$2256 \$2425 VPB|VPWR sky130_fd_pr__pfet_01v8_hvt L=0.15 W=1 AS=0.3
+ AD=0.26 PS=2.6 PD=2.52
M$1744 VPB|VPWR B|X \$2425 VPB|VPWR sky130_fd_pr__pfet_01v8_hvt L=0.15 W=1
+ AS=0.26 AD=0.135 PS=2.52 PD=1.27
M$1745 \$2425 A|Y VPB|VPWR VPB|VPWR sky130_fd_pr__pfet_01v8_hvt L=0.15 W=1
+ AS=0.135 AD=0.135 PS=1.27 PD=1.27
M$1746 VPB|VPWR A|Y \$2453 VPB|VPWR sky130_fd_pr__pfet_01v8_hvt L=0.15 W=1
+ AS=0.135 AD=0.135 PS=1.27 PD=1.27
M$1747 \$2453 B|X \$2256 VPB|VPWR sky130_fd_pr__pfet_01v8_hvt L=0.15 W=1
+ AS=0.135 AD=0.26 PS=1.27 PD=2.52
M$1748 VPB|VPWR D1|Y C|Y VPB|VPWR sky130_fd_pr__pfet_01v8_hvt L=0.15 W=1
+ AS=0.265 AD=0.14 PS=2.53 PD=1.28
M$1749 C|Y C1|Y VPB|VPWR VPB|VPWR sky130_fd_pr__pfet_01v8_hvt L=0.15 W=1
+ AS=0.14 AD=0.195 PS=1.28 PD=1.39
M$1750 VPB|VPWR B1|Y C|Y VPB|VPWR sky130_fd_pr__pfet_01v8_hvt L=0.15 W=1
+ AS=0.195 AD=0.2025 PS=1.39 PD=1.405
M$1751 C|Y A2|B|Y \$2451 VPB|VPWR sky130_fd_pr__pfet_01v8_hvt L=0.15 W=1
+ AS=0.2025 AD=0.195 PS=1.405 PD=1.39
M$1752 \$2451 A|A1|Y VPB|VPWR VPB|VPWR sky130_fd_pr__pfet_01v8_hvt L=0.15 W=1
+ AS=0.195 AD=0.265 PS=1.39 PD=2.53
M$1755 VPB|VPWR \$2263 B|C|SLEEP|Y VPB|VPWR sky130_fd_pr__pfet_01v8_hvt L=0.15
+ W=1 AS=0.36 AD=0.165 PS=2.72 PD=1.33
M$1756 B|C|SLEEP|Y B|B1|Y \$2447 VPB|VPWR sky130_fd_pr__pfet_01v8_hvt L=0.15
+ W=1 AS=0.165 AD=0.105 PS=1.33 PD=1.21
M$1757 \$2447 A|B2|Y VPB|VPWR VPB|VPWR sky130_fd_pr__pfet_01v8_hvt L=0.15 W=1
+ AS=0.105 AD=0.365 PS=1.21 PD=1.73
M$1758 VPB|VPWR A|B2|Y \$2263 VPB|VPWR sky130_fd_pr__pfet_01v8_hvt L=0.15 W=1
+ AS=0.365 AD=0.135 PS=1.73 PD=1.27
M$1759 \$2263 B|B1|Y VPB|VPWR VPB|VPWR sky130_fd_pr__pfet_01v8_hvt L=0.15 W=1
+ AS=0.135 AD=0.3 PS=1.27 PD=2.6
M$1760 A2|B|Y A|B2|Y \$2427 VPB|VPWR sky130_fd_pr__pfet_01v8_hvt L=0.15 W=1
+ AS=0.26 AD=0.135 PS=2.52 PD=1.27
M$1761 \$2427 B|B1|Y A2|B|Y VPB|VPWR sky130_fd_pr__pfet_01v8_hvt L=0.15 W=1
+ AS=0.135 AD=0.26 PS=1.27 PD=2.52
M$1762 VPB|VPWR A1|Y \$2427 VPB|VPWR sky130_fd_pr__pfet_01v8_hvt L=0.15 W=1
+ AS=0.26 AD=0.135 PS=2.52 PD=1.27
M$1763 \$2427 A|A2|Y VPB|VPWR VPB|VPWR sky130_fd_pr__pfet_01v8_hvt L=0.15 W=1
+ AS=0.135 AD=0.3 PS=1.27 PD=2.6
M$1764 \$2147 B|C|Y \$2183 VPB|VPWR sky130_fd_pr__pfet_01v8_hvt L=0.15 W=0.42
+ AS=0.1092 AD=0.0441 PS=1.36 PD=0.63
M$1765 \$2183 A|A1|B1|Y VPB|VPWR VPB|VPWR sky130_fd_pr__pfet_01v8_hvt L=0.15
+ W=0.42 AS=0.0441 AD=0.0567 PS=0.63 PD=0.69
M$1766 VPB|VPWR A|A1|B1|Y \$2182 VPB|VPWR sky130_fd_pr__pfet_01v8_hvt L=0.15
+ W=0.42 AS=0.0567 AD=0.0441 PS=0.69 PD=0.63
M$1767 \$2182 A|B|C1|Y \$2147 VPB|VPWR sky130_fd_pr__pfet_01v8_hvt L=0.15
+ W=0.42 AS=0.0441 AD=0.0567 PS=0.63 PD=0.69
M$1768 \$2147 A|B|C1|Y \$2184 VPB|VPWR sky130_fd_pr__pfet_01v8_hvt L=0.15
+ W=0.42 AS=0.0567 AD=0.0441 PS=0.69 PD=0.63
M$1769 VPB|VPWR B|C|Y \$2184 VPB|VPWR sky130_fd_pr__pfet_01v8_hvt L=0.15 W=0.42
+ AS=0.2492 AD=0.0441 PS=1.565 PD=0.63
M$1770 VPB|VPWR \$2147 B|X VPB|VPWR sky130_fd_pr__pfet_01v8_hvt L=0.15 W=1
+ AS=0.2492 AD=0.365 PS=1.565 PD=2.73
M$1774 VPB|VPWR A|Y \$2443 VPB|VPWR sky130_fd_pr__pfet_01v8_hvt L=0.15 W=1
+ AS=0.26 AD=0.105 PS=2.52 PD=1.21
M$1775 \$2443 B|X A|Y VPB|VPWR sky130_fd_pr__pfet_01v8_hvt L=0.15 W=1 AS=0.105
+ AD=0.26 PS=1.21 PD=2.52
M$1778 B|X \$2266 \$2428 VPB|VPWR sky130_fd_pr__pfet_01v8_hvt L=0.15 W=1 AS=0.3
+ AD=0.26 PS=2.6 PD=2.52
M$1779 VPB|VPWR B|B1|X \$2428 VPB|VPWR sky130_fd_pr__pfet_01v8_hvt L=0.15 W=1
+ AS=0.26 AD=0.135 PS=2.52 PD=1.27
M$1780 \$2428 A|Y VPB|VPWR VPB|VPWR sky130_fd_pr__pfet_01v8_hvt L=0.15 W=1
+ AS=0.135 AD=0.135 PS=1.27 PD=1.27
M$1781 VPB|VPWR A|Y \$2441 VPB|VPWR sky130_fd_pr__pfet_01v8_hvt L=0.15 W=1
+ AS=0.135 AD=0.135 PS=1.27 PD=1.27
M$1782 \$2441 B|B1|X \$2266 VPB|VPWR sky130_fd_pr__pfet_01v8_hvt L=0.15 W=1
+ AS=0.135 AD=0.26 PS=1.27 PD=2.52
M$1784 VPB|VPWR SLEEP|Y \$2439 VPB|VPWR sky130_fd_pr__pfet_01v8_hvt L=0.15
+ W=0.42 AS=0.14575 AD=0.0441 PS=1.335 PD=0.63
M$1785 \$2439 A|A2|B|Y \$2267 VPB|VPWR sky130_fd_pr__pfet_01v8_hvt L=0.15
+ W=0.42 AS=0.0441 AD=0.1092 PS=0.63 PD=1.36
M$1786 A2|X \$2267 VPB|VPWR VPB|VPWR sky130_fd_pr__pfet_01v8_hvt L=0.15 W=1
+ AS=0.34 AD=0.14575 PS=2.68 PD=1.335
M$1788 VPB|VPWR A|A2|X A|Y VPB|VPWR sky130_fd_pr__pfet_01v8_hvt L=0.15 W=1
+ AS=0.26 AD=0.135 PS=2.52 PD=1.27
M$1789 A|Y A3|B|Y VPB|VPWR VPB|VPWR sky130_fd_pr__pfet_01v8_hvt L=0.15 W=1
+ AS=0.135 AD=0.26 PS=1.27 PD=2.52
M$1791 VPB|VPWR A2|B1|SLEEP|Y \$2438 VPB|VPWR sky130_fd_pr__pfet_01v8_hvt
+ L=0.15 W=0.42 AS=0.14575 AD=0.0441 PS=1.335 PD=0.63
M$1792 \$2438 A|A1|B|B1|Y \$2268 VPB|VPWR sky130_fd_pr__pfet_01v8_hvt L=0.15
+ W=0.42 AS=0.0441 AD=0.1092 PS=0.63 PD=1.36
M$1793 A|A2|X \$2268 VPB|VPWR VPB|VPWR sky130_fd_pr__pfet_01v8_hvt L=0.15 W=1
+ AS=0.34 AD=0.14575 PS=2.68 PD=1.335
M$1794 B|B1|X \$2269 \$2429 VPB|VPWR sky130_fd_pr__pfet_01v8_hvt L=0.15 W=1
+ AS=0.3 AD=0.26 PS=2.6 PD=2.52
M$1795 VPB|VPWR B|Y \$2429 VPB|VPWR sky130_fd_pr__pfet_01v8_hvt L=0.15 W=1
+ AS=0.26 AD=0.135 PS=2.52 PD=1.27
M$1796 \$2429 A|A1|B|X VPB|VPWR VPB|VPWR sky130_fd_pr__pfet_01v8_hvt L=0.15 W=1
+ AS=0.135 AD=0.135 PS=1.27 PD=1.27
M$1797 VPB|VPWR A|A1|B|X \$2437 VPB|VPWR sky130_fd_pr__pfet_01v8_hvt L=0.15 W=1
+ AS=0.135 AD=0.135 PS=1.27 PD=1.27
M$1798 \$2437 B|Y \$2269 VPB|VPWR sky130_fd_pr__pfet_01v8_hvt L=0.15 W=1
+ AS=0.135 AD=0.26 PS=1.27 PD=2.52
M$1801 VPB|VPWR C|X \$2434 VPB|VPWR sky130_fd_pr__pfet_01v8_hvt L=0.15 W=0.42
+ AS=0.2492 AD=0.0441 PS=1.565 PD=0.63
M$1802 \$2434 B|Y \$2270 VPB|VPWR sky130_fd_pr__pfet_01v8_hvt L=0.15 W=0.42
+ AS=0.0441 AD=0.0567 PS=0.63 PD=0.69
M$1803 \$2270 B|Y \$2433 VPB|VPWR sky130_fd_pr__pfet_01v8_hvt L=0.15 W=0.42
+ AS=0.0567 AD=0.0441 PS=0.69 PD=0.63
M$1804 \$2433 A|Y VPB|VPWR VPB|VPWR sky130_fd_pr__pfet_01v8_hvt L=0.15 W=0.42
+ AS=0.0441 AD=0.0567 PS=0.63 PD=0.69
M$1805 VPB|VPWR A|Y \$2432 VPB|VPWR sky130_fd_pr__pfet_01v8_hvt L=0.15 W=0.42
+ AS=0.0567 AD=0.0441 PS=0.69 PD=0.63
M$1806 \$2432 C|X \$2270 VPB|VPWR sky130_fd_pr__pfet_01v8_hvt L=0.15 W=0.42
+ AS=0.0441 AD=0.1092 PS=0.63 PD=1.36
M$1807 A2|B|X \$2270 VPB|VPWR VPB|VPWR sky130_fd_pr__pfet_01v8_hvt L=0.15 W=1
+ AS=0.365 AD=0.2492 PS=2.73 PD=1.565
M$1810 \$2542 A|FINE_MUX[2] VPB|VPWR VPB|VPWR sky130_fd_pr__pfet_01v8_hvt
+ L=0.15 W=1 AS=0.27 AD=0.1701 PS=2.54 PD=1.36
M$1811 VPB|VPWR \$2542 \$2543 VPB|VPWR sky130_fd_pr__pfet_01v8_hvt L=0.5 W=0.82
+ AS=0.1701 AD=0.2173 PS=1.36 PD=2.17
M$1812 VPB|VPWR \$2543 \$2544 VPB|VPWR sky130_fd_pr__pfet_01v8_hvt L=0.5 W=0.82
+ AS=0.15575 AD=0.2173 PS=1.325 PD=2.17
M$1813 VPB|VPWR \$2544 A|C|X VPB|VPWR sky130_fd_pr__pfet_01v8_hvt L=0.15 W=1
+ AS=0.15575 AD=0.355 PS=1.325 PD=2.71
M$1818 A|Y A2|B|C|X \$2735 VPB|VPWR sky130_fd_pr__pfet_01v8_hvt L=0.15 W=1
+ AS=0.26 AD=0.105 PS=2.52 PD=1.21
M$1819 \$2735 A|Y VPB|VPWR VPB|VPWR sky130_fd_pr__pfet_01v8_hvt L=0.15 W=1
+ AS=0.105 AD=0.26 PS=1.21 PD=2.52
M$1824 A|B|Y B|X VPB|VPWR VPB|VPWR sky130_fd_pr__pfet_01v8_hvt L=0.15 W=2
+ AS=0.395 AD=0.395 PS=3.79 PD=3.79
M$1826 VPB|VPWR A|B|Y B|Y VPB|VPWR sky130_fd_pr__pfet_01v8_hvt L=0.15 W=8.36
+ AS=1.7136 AD=1.6222 PS=16.72 PD=15.55
M$1827 B|Y A|Y VPB|VPWR VPB|VPWR sky130_fd_pr__pfet_01v8_hvt L=0.15 W=6
+ AS=0.935 AD=1.435 PS=8.87 PD=13.87
M$1829 A|Y B|Y VPB|VPWR VPB|VPWR sky130_fd_pr__pfet_01v8_hvt L=0.15 W=14
+ AS=2.52575 AD=2.6325 PS=24.095 PD=24.265
M$1830 VPB|VPWR A|B|Y \$2737 VPB|VPWR sky130_fd_pr__pfet_01v8_hvt L=0.15 W=1
+ AS=0.26 AD=0.105 PS=2.52 PD=1.21
M$1831 \$2737 A|B|Y A|A1_N|Y VPB|VPWR sky130_fd_pr__pfet_01v8_hvt L=0.15 W=1
+ AS=0.105 AD=0.26 PS=1.21 PD=2.52
M$1832 VPB|VPWR A|Y \$2738 VPB|VPWR sky130_fd_pr__pfet_01v8_hvt L=0.15 W=1
+ AS=0.26 AD=0.105 PS=2.52 PD=1.21
M$1833 \$2738 A|B|Y A|B|Y VPB|VPWR sky130_fd_pr__pfet_01v8_hvt L=0.15 W=1
+ AS=0.105 AD=0.26 PS=1.21 PD=2.52
M$1835 VPB|VPWR \$2552 A2_N|B|Y VPB|VPWR sky130_fd_pr__pfet_01v8_hvt L=0.15 W=1
+ AS=0.36 AD=0.165 PS=2.72 PD=1.33
M$1836 A2_N|B|Y B|C|X \$2739 VPB|VPWR sky130_fd_pr__pfet_01v8_hvt L=0.15 W=1
+ AS=0.165 AD=0.105 PS=1.33 PD=1.21
M$1837 \$2739 A|Y VPB|VPWR VPB|VPWR sky130_fd_pr__pfet_01v8_hvt L=0.15 W=1
+ AS=0.105 AD=0.365 PS=1.21 PD=1.73
M$1838 VPB|VPWR A|Y \$2552 VPB|VPWR sky130_fd_pr__pfet_01v8_hvt L=0.15 W=1
+ AS=0.365 AD=0.135 PS=1.73 PD=1.27
M$1839 \$2552 B|C|X VPB|VPWR VPB|VPWR sky130_fd_pr__pfet_01v8_hvt L=0.15 W=1
+ AS=0.135 AD=0.3 PS=1.27 PD=2.6
M$1844 \$2457 C|SLEEP|Y \$2498 VPB|VPWR sky130_fd_pr__pfet_01v8_hvt L=0.15
+ W=0.42 AS=0.1092 AD=0.0441 PS=1.36 PD=0.63
M$1845 \$2498 A|Y VPB|VPWR VPB|VPWR sky130_fd_pr__pfet_01v8_hvt L=0.15 W=0.42
+ AS=0.0441 AD=0.0567 PS=0.63 PD=0.69
M$1846 VPB|VPWR A|Y \$2499 VPB|VPWR sky130_fd_pr__pfet_01v8_hvt L=0.15 W=0.42
+ AS=0.0567 AD=0.0441 PS=0.69 PD=0.63
M$1847 \$2499 A|B|Y \$2457 VPB|VPWR sky130_fd_pr__pfet_01v8_hvt L=0.15 W=0.42
+ AS=0.0441 AD=0.0567 PS=0.63 PD=0.69
M$1848 \$2457 A|B|Y \$2500 VPB|VPWR sky130_fd_pr__pfet_01v8_hvt L=0.15 W=0.42
+ AS=0.0567 AD=0.0441 PS=0.69 PD=0.63
M$1849 VPB|VPWR C|SLEEP|Y \$2500 VPB|VPWR sky130_fd_pr__pfet_01v8_hvt L=0.15
+ W=0.42 AS=0.2492 AD=0.0441 PS=1.565 PD=0.63
M$1850 VPB|VPWR \$2457 B|X VPB|VPWR sky130_fd_pr__pfet_01v8_hvt L=0.15 W=1
+ AS=0.2492 AD=0.365 PS=1.565 PD=2.73
M$1851 VPB|VPWR \$2556 A|B|C|Y VPB|VPWR sky130_fd_pr__pfet_01v8_hvt L=0.15 W=1
+ AS=0.36 AD=0.165 PS=2.72 PD=1.33
M$1852 A|B|C|Y B|X \$2743 VPB|VPWR sky130_fd_pr__pfet_01v8_hvt L=0.15 W=1
+ AS=0.165 AD=0.105 PS=1.33 PD=1.21
M$1853 \$2743 A|A2|B|X VPB|VPWR VPB|VPWR sky130_fd_pr__pfet_01v8_hvt L=0.15 W=1
+ AS=0.105 AD=0.365 PS=1.21 PD=1.73
M$1854 VPB|VPWR A|A2|B|X \$2556 VPB|VPWR sky130_fd_pr__pfet_01v8_hvt L=0.15 W=1
+ AS=0.365 AD=0.135 PS=1.73 PD=1.27
M$1855 \$2556 B|X VPB|VPWR VPB|VPWR sky130_fd_pr__pfet_01v8_hvt L=0.15 W=1
+ AS=0.135 AD=0.3 PS=1.27 PD=2.6
M$1856 \$2459 A|B|Y \$2501 VPB|VPWR sky130_fd_pr__pfet_01v8_hvt L=0.15 W=0.42
+ AS=0.1092 AD=0.0441 PS=1.36 PD=0.63
M$1857 VPB|VPWR C|SLEEP|Y \$2501 VPB|VPWR sky130_fd_pr__pfet_01v8_hvt L=0.15
+ W=0.42 AS=0.14575 AD=0.0441 PS=1.335 PD=0.63
M$1858 VPB|VPWR \$2459 A|A1|X VPB|VPWR sky130_fd_pr__pfet_01v8_hvt L=0.15 W=1
+ AS=0.14575 AD=0.34 PS=1.335 PD=2.68
M$1860 VPB|VPWR A|Y \$2745 VPB|VPWR sky130_fd_pr__pfet_01v8_hvt L=0.15 W=1
+ AS=0.26 AD=0.105 PS=2.52 PD=1.21
M$1861 \$2745 A|A2|B|X A|B1|Y VPB|VPWR sky130_fd_pr__pfet_01v8_hvt L=0.15 W=1
+ AS=0.105 AD=0.26 PS=1.21 PD=2.52
M$1862 VPB|VPWR A|A1|X \$2746 VPB|VPWR sky130_fd_pr__pfet_01v8_hvt L=0.15 W=1
+ AS=0.26 AD=0.105 PS=2.52 PD=1.21
M$1863 \$2746 A|A2|B|X A|Y VPB|VPWR sky130_fd_pr__pfet_01v8_hvt L=0.15 W=1
+ AS=0.105 AD=0.26 PS=1.21 PD=2.52
M$1864 VPB|VPWR A|A1|X \$2502 VPB|VPWR sky130_fd_pr__pfet_01v8_hvt L=0.15
+ W=0.64 AS=0.1696 AD=0.0768 PS=1.81 PD=0.88
M$1865 \$2502 A|A2|B|X B|Y VPB|VPWR sky130_fd_pr__pfet_01v8_hvt L=0.15 W=0.64
+ AS=0.0768 AD=0.0896 PS=0.88 PD=0.92
M$1869 A|Y A|B|B_N|X VPB|VPWR VPB|VPWR sky130_fd_pr__pfet_01v8_hvt L=0.15 W=1
+ AS=0.135 AD=0.26 PS=1.27 PD=2.52
M$1870 VPB|VPWR A|B|B_N|X \$2462 VPB|VPWR sky130_fd_pr__pfet_01v8_hvt L=0.15
+ W=0.42 AS=0.1573 AD=0.1092 PS=1.39 PD=1.36
M$1871 VPB|VPWR A|B1|Y \$2503 VPB|VPWR sky130_fd_pr__pfet_01v8_hvt L=0.15 W=1
+ AS=0.1573 AD=0.105 PS=1.39 PD=1.21
M$1872 \$2503 \$2462 B|Y VPB|VPWR sky130_fd_pr__pfet_01v8_hvt L=0.15 W=1
+ AS=0.105 AD=0.26 PS=1.21 PD=2.52
M$1874 VPB|VPWR B|B1|C|X \$2565 VPB|VPWR sky130_fd_pr__pfet_01v8_hvt L=0.15
+ W=0.64 AS=0.169 AD=0.1792 PS=1.365 PD=1.84
M$1875 A|B|X \$2564 VPB|VPWR VPB|VPWR sky130_fd_pr__pfet_01v8_hvt L=0.15 W=1
+ AS=0.28 AD=0.169 PS=2.56 PD=1.365
M$1876 \$2564 \$2565 \$2566 VPB|VPWR sky130_fd_pr__pfet_01v8_hvt L=0.15 W=0.84
+ AS=0.15295 AD=0.32235 PS=1.315 PD=2.45
M$1877 \$2564 B|B1|C|X \$2567 VPB|VPWR sky130_fd_pr__pfet_01v8_hvt L=0.15
+ W=0.84 AS=0.15295 AD=0.273 PS=1.315 PD=2.33
M$1878 VPB|VPWR A|B|B2|Y \$2568 VPB|VPWR sky130_fd_pr__pfet_01v8_hvt L=0.15 W=1
+ AS=0.25655 AD=0.26 PS=2.52 PD=2.52
M$1879 \$2566 \$2568 \$2570 VPB|VPWR sky130_fd_pr__pfet_01v8_hvt L=0.15 W=0.64
+ AS=0.2431 AD=0.246 PS=1.445 PD=1.525
M$1880 \$2570 A|B|B2|Y \$2567 VPB|VPWR sky130_fd_pr__pfet_01v8_hvt L=0.15
+ W=0.64 AS=0.246 AD=0.1458 PS=1.525 PD=1.205
M$1881 \$2569 A|B|B2|Y \$2566 VPB|VPWR sky130_fd_pr__pfet_01v8_hvt L=0.15
+ W=0.84 AS=0.3528 AD=0.2431 PS=2.52 PD=1.445
M$1882 \$2569 \$2568 \$2567 VPB|VPWR sky130_fd_pr__pfet_01v8_hvt L=0.15 W=0.84
+ AS=0.1715 AD=0.1458 PS=1.355 PD=1.205
M$1883 \$2569 A|Y VPB|VPWR VPB|VPWR sky130_fd_pr__pfet_01v8_hvt L=0.15 W=1
+ AS=0.1715 AD=0.135 PS=1.355 PD=1.27
M$1884 VPB|VPWR \$2569 \$2570 VPB|VPWR sky130_fd_pr__pfet_01v8_hvt L=0.15 W=1
+ AS=0.135 AD=0.285 PS=1.27 PD=2.57
M$1885 \$2464 C|X \$2505 VPB|VPWR sky130_fd_pr__pfet_01v8_hvt L=0.15 W=0.42
+ AS=0.1092 AD=0.0441 PS=1.36 PD=0.63
M$1886 \$2505 A|Y VPB|VPWR VPB|VPWR sky130_fd_pr__pfet_01v8_hvt L=0.15 W=0.42
+ AS=0.0441 AD=0.0567 PS=0.63 PD=0.69
M$1887 VPB|VPWR A|Y \$2504 VPB|VPWR sky130_fd_pr__pfet_01v8_hvt L=0.15 W=0.42
+ AS=0.0567 AD=0.0441 PS=0.69 PD=0.63
M$1888 \$2504 B|Y \$2464 VPB|VPWR sky130_fd_pr__pfet_01v8_hvt L=0.15 W=0.42
+ AS=0.0441 AD=0.0567 PS=0.63 PD=0.69
M$1889 \$2464 B|Y \$2506 VPB|VPWR sky130_fd_pr__pfet_01v8_hvt L=0.15 W=0.42
+ AS=0.0567 AD=0.0441 PS=0.69 PD=0.63
M$1890 VPB|VPWR C|X \$2506 VPB|VPWR sky130_fd_pr__pfet_01v8_hvt L=0.15 W=0.42
+ AS=0.2492 AD=0.0441 PS=1.565 PD=0.63
M$1891 VPB|VPWR \$2464 A2|B|X VPB|VPWR sky130_fd_pr__pfet_01v8_hvt L=0.15 W=1
+ AS=0.2492 AD=0.365 PS=1.565 PD=2.73
M$1893 \$2727 A|B|B2|Y \$2571 VPB|VPWR sky130_fd_pr__pfet_01v8_hvt L=0.15 W=1
+ AS=0.265 AD=0.14 PS=2.53 PD=1.28
M$1894 \$2571 B|B1|C|X \$2727 VPB|VPWR sky130_fd_pr__pfet_01v8_hvt L=0.15 W=1
+ AS=0.14 AD=0.185 PS=1.28 PD=1.37
M$1895 \$2727 A1|Y VPB|VPWR VPB|VPWR sky130_fd_pr__pfet_01v8_hvt L=0.15 W=1
+ AS=0.185 AD=0.225 PS=1.37 PD=1.45
M$1896 VPB|VPWR A|A2|Y \$2727 VPB|VPWR sky130_fd_pr__pfet_01v8_hvt L=0.15 W=1
+ AS=0.225 AD=0.165 PS=1.45 PD=1.33
M$1897 \$2727 A3|X VPB|VPWR VPB|VPWR sky130_fd_pr__pfet_01v8_hvt L=0.15 W=1
+ AS=0.165 AD=0.2425 PS=1.33 PD=1.485
M$1898 VPB|VPWR \$2571 A|B|X VPB|VPWR sky130_fd_pr__pfet_01v8_hvt L=0.15 W=1
+ AS=0.2425 AD=0.33 PS=1.485 PD=2.66
M$1899 B|B1|C|X \$2466 VPB|VPWR VPB|VPWR sky130_fd_pr__pfet_01v8_hvt L=0.15 W=1
+ AS=0.28 AD=0.169 PS=2.56 PD=1.365
M$1900 VPB|VPWR B|C|SLEEP|Y \$2467 VPB|VPWR sky130_fd_pr__pfet_01v8_hvt L=0.15
+ W=0.64 AS=0.169 AD=0.1792 PS=1.365 PD=1.84
M$1901 \$2468 B|C|SLEEP|Y \$2466 VPB|VPWR sky130_fd_pr__pfet_01v8_hvt L=0.15
+ W=0.84 AS=0.273 AD=0.15295 PS=2.33 PD=1.315
M$1902 \$2466 \$2467 \$2469 VPB|VPWR sky130_fd_pr__pfet_01v8_hvt L=0.15 W=0.84
+ AS=0.15295 AD=0.32235 PS=1.315 PD=2.45
M$1903 VPB|VPWR A|B|X \$2470 VPB|VPWR sky130_fd_pr__pfet_01v8_hvt L=0.15 W=1
+ AS=0.25655 AD=0.26 PS=2.52 PD=2.52
M$1904 \$2468 A|B|X \$2472 VPB|VPWR sky130_fd_pr__pfet_01v8_hvt L=0.15 W=0.64
+ AS=0.1458 AD=0.246 PS=1.205 PD=1.525
M$1905 \$2468 \$2470 \$2471 VPB|VPWR sky130_fd_pr__pfet_01v8_hvt L=0.15 W=0.84
+ AS=0.1458 AD=0.1715 PS=1.205 PD=1.355
M$1906 \$2471 A|B|X \$2469 VPB|VPWR sky130_fd_pr__pfet_01v8_hvt L=0.15 W=0.84
+ AS=0.3528 AD=0.2431 PS=2.52 PD=1.445
M$1907 \$2469 \$2470 \$2472 VPB|VPWR sky130_fd_pr__pfet_01v8_hvt L=0.15 W=0.64
+ AS=0.2431 AD=0.246 PS=1.445 PD=1.525
M$1908 \$2471 A|Y VPB|VPWR VPB|VPWR sky130_fd_pr__pfet_01v8_hvt L=0.15 W=1
+ AS=0.1715 AD=0.135 PS=1.355 PD=1.27
M$1909 VPB|VPWR \$2471 \$2472 VPB|VPWR sky130_fd_pr__pfet_01v8_hvt L=0.15 W=1
+ AS=0.135 AD=0.285 PS=1.27 PD=2.57
M$1911 VPB|VPWR A|A2|Y \$2752 VPB|VPWR sky130_fd_pr__pfet_01v8_hvt L=0.15 W=1
+ AS=0.26 AD=0.105 PS=2.52 PD=1.21
M$1912 \$2752 B|Y B|Y VPB|VPWR sky130_fd_pr__pfet_01v8_hvt L=0.15 W=1 AS=0.105
+ AD=0.26 PS=1.21 PD=2.52
M$1913 VPB|VPWR A|A_N|Y \$2473 VPB|VPWR sky130_fd_pr__pfet_01v8_hvt L=0.15
+ W=0.42 AS=0.14575 AD=0.1092 PS=1.335 PD=1.36
M$1915 A|Y \$2473 VPB|VPWR VPB|VPWR sky130_fd_pr__pfet_01v8_hvt L=0.15 W=1
+ AS=0.135 AD=0.265 PS=1.27 PD=2.53
M$1916 VPB|VPWR \$2575 B|Y VPB|VPWR sky130_fd_pr__pfet_01v8_hvt L=0.15 W=1
+ AS=0.36 AD=0.165 PS=2.72 PD=1.33
M$1917 B|Y B|Y \$2751 VPB|VPWR sky130_fd_pr__pfet_01v8_hvt L=0.15 W=1 AS=0.165
+ AD=0.105 PS=1.33 PD=1.21
M$1918 \$2751 A|Y VPB|VPWR VPB|VPWR sky130_fd_pr__pfet_01v8_hvt L=0.15 W=1
+ AS=0.105 AD=0.365 PS=1.21 PD=1.73
M$1919 VPB|VPWR A|Y \$2575 VPB|VPWR sky130_fd_pr__pfet_01v8_hvt L=0.15 W=1
+ AS=0.365 AD=0.135 PS=1.73 PD=1.27
M$1920 \$2575 B|Y VPB|VPWR VPB|VPWR sky130_fd_pr__pfet_01v8_hvt L=0.15 W=1
+ AS=0.135 AD=0.3 PS=1.27 PD=2.6
M$1922 VPB|VPWR A|Y \$2748 VPB|VPWR sky130_fd_pr__pfet_01v8_hvt L=0.15 W=0.42
+ AS=0.14825 AD=0.0693 PS=1.34 PD=0.75
M$1923 \$2748 B|Y \$2747 VPB|VPWR sky130_fd_pr__pfet_01v8_hvt L=0.15 W=0.42
+ AS=0.0693 AD=0.0441 PS=0.75 PD=0.63
M$1924 \$2747 C|Y \$2750 VPB|VPWR sky130_fd_pr__pfet_01v8_hvt L=0.15 W=0.42
+ AS=0.0441 AD=0.0693 PS=0.63 PD=0.75
M$1925 \$2750 D|X \$2577 VPB|VPWR sky130_fd_pr__pfet_01v8_hvt L=0.15 W=0.42
+ AS=0.0693 AD=0.1092 PS=0.75 PD=1.36
M$1926 B1|X \$2577 VPB|VPWR VPB|VPWR sky130_fd_pr__pfet_01v8_hvt L=0.15 W=1
+ AS=0.27 AD=0.14825 PS=2.54 PD=1.34
M$1928 VPB|VPWR \$2476 B|Y VPB|VPWR sky130_fd_pr__pfet_01v8_hvt L=0.15 W=1
+ AS=0.36 AD=0.165 PS=2.72 PD=1.33
M$1929 B|Y B|X \$2510 VPB|VPWR sky130_fd_pr__pfet_01v8_hvt L=0.15 W=1 AS=0.165
+ AD=0.105 PS=1.33 PD=1.21
M$1930 \$2510 A|B|X VPB|VPWR VPB|VPWR sky130_fd_pr__pfet_01v8_hvt L=0.15 W=1
+ AS=0.105 AD=0.365 PS=1.21 PD=1.73
M$1931 VPB|VPWR A|B|X \$2476 VPB|VPWR sky130_fd_pr__pfet_01v8_hvt L=0.15 W=1
+ AS=0.365 AD=0.135 PS=1.73 PD=1.27
M$1932 \$2476 B|X VPB|VPWR VPB|VPWR sky130_fd_pr__pfet_01v8_hvt L=0.15 W=1
+ AS=0.135 AD=0.3 PS=1.27 PD=2.6
M$1935 B|C|X \$2480 \$2479 VPB|VPWR sky130_fd_pr__pfet_01v8_hvt L=0.15 W=1
+ AS=0.3 AD=0.26 PS=2.6 PD=2.52
M$1936 VPB|VPWR B|X \$2479 VPB|VPWR sky130_fd_pr__pfet_01v8_hvt L=0.15 W=1
+ AS=0.26 AD=0.135 PS=2.52 PD=1.27
M$1937 \$2479 A|Y VPB|VPWR VPB|VPWR sky130_fd_pr__pfet_01v8_hvt L=0.15 W=1
+ AS=0.135 AD=0.135 PS=1.27 PD=1.27
M$1938 VPB|VPWR A|Y \$2512 VPB|VPWR sky130_fd_pr__pfet_01v8_hvt L=0.15 W=1
+ AS=0.135 AD=0.135 PS=1.27 PD=1.27
M$1939 \$2512 B|X \$2480 VPB|VPWR sky130_fd_pr__pfet_01v8_hvt L=0.15 W=1
+ AS=0.135 AD=0.26 PS=1.27 PD=2.52
M$1940 VPB|VPWR A|Y C1|Y VPB|VPWR sky130_fd_pr__pfet_01v8_hvt L=0.15 W=3
+ AS=0.78 AD=0.405 PS=7.56 PD=3.81
M$1941 C1|Y B|X VPB|VPWR VPB|VPWR sky130_fd_pr__pfet_01v8_hvt L=0.15 W=2
+ AS=0.27 AD=0.52 PS=2.54 PD=5.04
M$1942 VPB|VPWR B|X B1|Y VPB|VPWR sky130_fd_pr__pfet_01v8_hvt L=0.15 W=1
+ AS=0.26 AD=0.135 PS=2.52 PD=1.27
M$1943 B1|Y A|Y VPB|VPWR VPB|VPWR sky130_fd_pr__pfet_01v8_hvt L=0.15 W=3
+ AS=0.655 AD=0.56 PS=6.31 PD=5.12
M$1944 B|X \$2483 \$2482 VPB|VPWR sky130_fd_pr__pfet_01v8_hvt L=0.15 W=1 AS=0.3
+ AD=0.26 PS=2.6 PD=2.52
M$1945 VPB|VPWR A2|B|Y \$2482 VPB|VPWR sky130_fd_pr__pfet_01v8_hvt L=0.15 W=1
+ AS=0.26 AD=0.135 PS=2.52 PD=1.27
M$1946 \$2482 A|A1|Y VPB|VPWR VPB|VPWR sky130_fd_pr__pfet_01v8_hvt L=0.15 W=1
+ AS=0.135 AD=0.135 PS=1.27 PD=1.27
M$1947 VPB|VPWR A|A1|Y \$2513 VPB|VPWR sky130_fd_pr__pfet_01v8_hvt L=0.15 W=1
+ AS=0.135 AD=0.135 PS=1.27 PD=1.27
M$1948 \$2513 A2|B|Y \$2483 VPB|VPWR sky130_fd_pr__pfet_01v8_hvt L=0.15 W=1
+ AS=0.135 AD=0.26 PS=1.27 PD=2.52
M$1953 VPB|VPWR \$2484 A|A1|Y VPB|VPWR sky130_fd_pr__pfet_01v8_hvt L=0.15 W=1
+ AS=0.36 AD=0.165 PS=2.72 PD=1.33
M$1954 A|A1|Y B|X \$2515 VPB|VPWR sky130_fd_pr__pfet_01v8_hvt L=0.15 W=1
+ AS=0.165 AD=0.105 PS=1.33 PD=1.21
M$1955 \$2515 A|Y VPB|VPWR VPB|VPWR sky130_fd_pr__pfet_01v8_hvt L=0.15 W=1
+ AS=0.105 AD=0.365 PS=1.21 PD=1.73
M$1956 VPB|VPWR A|Y \$2484 VPB|VPWR sky130_fd_pr__pfet_01v8_hvt L=0.15 W=1
+ AS=0.365 AD=0.135 PS=1.73 PD=1.27
M$1957 \$2484 B|X VPB|VPWR VPB|VPWR sky130_fd_pr__pfet_01v8_hvt L=0.15 W=1
+ AS=0.135 AD=0.3 PS=1.27 PD=2.6
M$1959 VPB|VPWR A|Y \$2517 VPB|VPWR sky130_fd_pr__pfet_01v8_hvt L=0.15 W=1
+ AS=0.26 AD=0.135 PS=2.52 PD=1.27
M$1960 \$2517 B|Y \$2516 VPB|VPWR sky130_fd_pr__pfet_01v8_hvt L=0.15 W=1
+ AS=0.135 AD=0.135 PS=1.27 PD=1.27
M$1961 \$2516 C|Y D1|Y VPB|VPWR sky130_fd_pr__pfet_01v8_hvt L=0.15 W=1 AS=0.135
+ AD=0.26 PS=1.27 PD=2.52
M$1967 B1|Y A2|C|Y \$2508 VPB|VPWR sky130_fd_pr__pfet_01v8_hvt L=0.15 W=1
+ AS=0.26 AD=0.135 PS=2.52 PD=1.27
M$1968 \$2508 A|A1|B|X \$2507 VPB|VPWR sky130_fd_pr__pfet_01v8_hvt L=0.15 W=1
+ AS=0.135 AD=0.135 PS=1.27 PD=1.27
M$1969 \$2507 A|A1|B|C1|X VPB|VPWR VPB|VPWR sky130_fd_pr__pfet_01v8_hvt L=0.15
+ W=1 AS=0.135 AD=0.26 PS=1.27 PD=2.52
M$1971 B|C|X \$2485 VPB|VPWR VPB|VPWR sky130_fd_pr__pfet_01v8_hvt L=0.15 W=1
+ AS=0.28 AD=0.169 PS=2.56 PD=1.365
M$1972 VPB|VPWR B|C|X \$2486 VPB|VPWR sky130_fd_pr__pfet_01v8_hvt L=0.15 W=0.64
+ AS=0.169 AD=0.1792 PS=1.365 PD=1.84
M$1973 \$2580 B|C|X \$2734 VPB|VPWR sky130_fd_pr__pfet_01v8_hvt L=0.15 W=1
+ AS=0.26 AD=0.135 PS=2.52 PD=1.27
M$1974 \$2734 A|B|X VPB|VPWR VPB|VPWR sky130_fd_pr__pfet_01v8_hvt L=0.15 W=1
+ AS=0.135 AD=0.135 PS=1.27 PD=1.27
M$1975 VPB|VPWR A|B|X \$2729 VPB|VPWR sky130_fd_pr__pfet_01v8_hvt L=0.15 W=1
+ AS=0.135 AD=0.135 PS=1.27 PD=1.27
M$1976 \$2729 B|C|X VPB|VPWR VPB|VPWR sky130_fd_pr__pfet_01v8_hvt L=0.15 W=1
+ AS=0.135 AD=0.26 PS=1.27 PD=2.52
M$1977 \$2487 B|C|X \$2485 VPB|VPWR sky130_fd_pr__pfet_01v8_hvt L=0.15 W=0.84
+ AS=0.273 AD=0.15295 PS=2.33 PD=1.315
M$1978 \$2485 \$2486 \$2489 VPB|VPWR sky130_fd_pr__pfet_01v8_hvt L=0.15 W=0.84
+ AS=0.15295 AD=0.32235 PS=1.315 PD=2.45
M$1979 VPB|VPWR A|B|X \$2490 VPB|VPWR sky130_fd_pr__pfet_01v8_hvt L=0.15 W=1
+ AS=0.25655 AD=0.26 PS=2.52 PD=2.52
M$1980 \$2729 \$2580 C|X VPB|VPWR sky130_fd_pr__pfet_01v8_hvt L=0.15 W=1
+ AS=0.26 AD=0.3 PS=2.52 PD=2.6
M$1981 \$2487 A|B|X \$2492 VPB|VPWR sky130_fd_pr__pfet_01v8_hvt L=0.15 W=0.64
+ AS=0.1458 AD=0.246 PS=1.205 PD=1.525
M$1982 \$2487 \$2490 \$2491 VPB|VPWR sky130_fd_pr__pfet_01v8_hvt L=0.15 W=0.84
+ AS=0.1458 AD=0.1715 PS=1.205 PD=1.355
M$1983 \$2491 A|B|X \$2489 VPB|VPWR sky130_fd_pr__pfet_01v8_hvt L=0.15 W=0.84
+ AS=0.3528 AD=0.2431 PS=2.52 PD=1.445
M$1984 \$2489 \$2490 \$2492 VPB|VPWR sky130_fd_pr__pfet_01v8_hvt L=0.15 W=0.64
+ AS=0.2431 AD=0.246 PS=1.445 PD=1.525
M$1985 \$2491 A|B|X VPB|VPWR VPB|VPWR sky130_fd_pr__pfet_01v8_hvt L=0.15 W=1
+ AS=0.1715 AD=0.135 PS=1.355 PD=1.27
M$1986 VPB|VPWR \$2491 \$2492 VPB|VPWR sky130_fd_pr__pfet_01v8_hvt L=0.15 W=1
+ AS=0.135 AD=0.285 PS=1.27 PD=2.57
M$1987 A|B|X \$2582 VPB|VPWR VPB|VPWR sky130_fd_pr__pfet_01v8_hvt L=0.15 W=1
+ AS=0.355 AD=0.15575 PS=2.71 PD=1.325
M$1988 VPB|VPWR \$2583 \$2582 VPB|VPWR sky130_fd_pr__pfet_01v8_hvt L=0.5 W=0.82
+ AS=0.15575 AD=0.2173 PS=1.325 PD=2.17
M$1992 VPB|VPWR \$2584 \$2583 VPB|VPWR sky130_fd_pr__pfet_01v8_hvt L=0.5 W=0.82
+ AS=0.1701 AD=0.2173 PS=1.36 PD=2.17
M$1993 VPB|VPWR A|COARSE_MUX[6] \$2584 VPB|VPWR sky130_fd_pr__pfet_01v8_hvt
+ L=0.15 W=1 AS=0.1701 AD=0.27 PS=1.36 PD=2.54
M$1994 VPB|VPWR \$2754 \$2755 VPB|VPWR sky130_fd_pr__pfet_01v8_hvt L=0.5 W=0.82
+ AS=0.1701 AD=0.2173 PS=1.36 PD=2.17
M$1995 \$2754 A|FINE_MUX[0] VPB|VPWR VPB|VPWR sky130_fd_pr__pfet_01v8_hvt
+ L=0.15 W=1 AS=0.27 AD=0.1701 PS=2.54 PD=1.36
M$1996 \$2756 \$2755 VPB|VPWR VPB|VPWR sky130_fd_pr__pfet_01v8_hvt L=0.5 W=0.82
+ AS=0.2173 AD=0.15575 PS=2.17 PD=1.325
M$1997 VPB|VPWR \$2756 A|B|X VPB|VPWR sky130_fd_pr__pfet_01v8_hvt L=0.15 W=1
+ AS=0.15575 AD=0.355 PS=1.325 PD=2.71
M$2006 A1|Y B|X VPB|VPWR VPB|VPWR sky130_fd_pr__pfet_01v8_hvt L=0.15 W=1
+ AS=0.135 AD=0.26 PS=1.27 PD=2.52
M$2008 VPB|VPWR B|C|X B|Y VPB|VPWR sky130_fd_pr__pfet_01v8_hvt L=0.15 W=3
+ AS=0.78 AD=0.405 PS=7.56 PD=3.81
M$2010 VPB|VPWR B|Y B|SLEEP|Y VPB|VPWR sky130_fd_pr__pfet_01v8_hvt L=0.15 W=1
+ AS=0.26 AD=0.135 PS=2.52 PD=1.27
M$2011 B|SLEEP|Y A|C|X VPB|VPWR VPB|VPWR sky130_fd_pr__pfet_01v8_hvt L=0.15 W=1
+ AS=0.135 AD=0.26 PS=1.27 PD=2.52
M$2014 A|X \$2764 \$2763 VPB|VPWR sky130_fd_pr__pfet_01v8_hvt L=0.15 W=1 AS=0.3
+ AD=0.26 PS=2.6 PD=2.52
M$2015 VPB|VPWR B|X \$2763 VPB|VPWR sky130_fd_pr__pfet_01v8_hvt L=0.15 W=1
+ AS=0.26 AD=0.135 PS=2.52 PD=1.27
M$2016 \$2763 A|X VPB|VPWR VPB|VPWR sky130_fd_pr__pfet_01v8_hvt L=0.15 W=1
+ AS=0.135 AD=0.135 PS=1.27 PD=1.27
M$2017 VPB|VPWR A|X \$2803 VPB|VPWR sky130_fd_pr__pfet_01v8_hvt L=0.15 W=1
+ AS=0.135 AD=0.135 PS=1.27 PD=1.27
M$2018 \$2803 B|X \$2764 VPB|VPWR sky130_fd_pr__pfet_01v8_hvt L=0.15 W=1
+ AS=0.135 AD=0.26 PS=1.27 PD=2.52
M$2021 A|A0|B|SLEEP|X \$2767 \$2766 VPB|VPWR sky130_fd_pr__pfet_01v8_hvt L=0.15
+ W=1 AS=0.3 AD=0.26 PS=2.6 PD=2.52
M$2022 VPB|VPWR B|Y \$2766 VPB|VPWR sky130_fd_pr__pfet_01v8_hvt L=0.15 W=1
+ AS=0.26 AD=0.135 PS=2.52 PD=1.27
M$2023 \$2766 A|B|Y VPB|VPWR VPB|VPWR sky130_fd_pr__pfet_01v8_hvt L=0.15 W=1
+ AS=0.135 AD=0.135 PS=1.27 PD=1.27
M$2024 VPB|VPWR A|B|Y \$2804 VPB|VPWR sky130_fd_pr__pfet_01v8_hvt L=0.15 W=1
+ AS=0.135 AD=0.135 PS=1.27 PD=1.27
M$2025 \$2804 B|Y \$2767 VPB|VPWR sky130_fd_pr__pfet_01v8_hvt L=0.15 W=1
+ AS=0.135 AD=0.26 PS=1.27 PD=2.52
M$2027 \$2769 \$2815 \$2770 VPB|VPWR sky130_fd_pr__pfet_01v8_hvt L=0.15 W=0.84
+ AS=0.1715 AD=0.1458 PS=1.355 PD=1.205
M$2028 \$2770 A|B|Y \$2768 VPB|VPWR sky130_fd_pr__pfet_01v8_hvt L=0.15 W=0.64
+ AS=0.1458 AD=0.246 PS=1.205 PD=1.525
M$2029 \$2768 \$2769 VPB|VPWR VPB|VPWR sky130_fd_pr__pfet_01v8_hvt L=0.15 W=1
+ AS=0.285 AD=0.135 PS=2.57 PD=1.27
M$2030 VPB|VPWR A|A1_N|Y \$2769 VPB|VPWR sky130_fd_pr__pfet_01v8_hvt L=0.15 W=1
+ AS=0.135 AD=0.1715 PS=1.27 PD=1.355
M$2031 \$2771 \$2815 \$2768 VPB|VPWR sky130_fd_pr__pfet_01v8_hvt L=0.15 W=0.64
+ AS=0.2431 AD=0.246 PS=1.445 PD=1.525
M$2032 \$2771 A|B|Y \$2769 VPB|VPWR sky130_fd_pr__pfet_01v8_hvt L=0.15 W=0.84
+ AS=0.2431 AD=0.3528 PS=1.445 PD=2.52
M$2033 \$2815 A|B|Y VPB|VPWR VPB|VPWR sky130_fd_pr__pfet_01v8_hvt L=0.15 W=1
+ AS=0.26 AD=0.25655 PS=2.52 PD=2.52
M$2034 VPB|VPWR B|C|X \$2773 VPB|VPWR sky130_fd_pr__pfet_01v8_hvt L=0.15 W=0.64
+ AS=0.169 AD=0.1792 PS=1.365 PD=1.84
M$2035 VPB|VPWR \$2772 A|B|B1|X VPB|VPWR sky130_fd_pr__pfet_01v8_hvt L=0.15 W=1
+ AS=0.169 AD=0.28 PS=1.365 PD=2.56
M$2040 A2|B|X \$2777 \$2776 VPB|VPWR sky130_fd_pr__pfet_01v8_hvt L=0.15 W=1
+ AS=0.3 AD=0.26 PS=2.6 PD=2.52
M$2041 VPB|VPWR B|Y \$2776 VPB|VPWR sky130_fd_pr__pfet_01v8_hvt L=0.15 W=1
+ AS=0.26 AD=0.135 PS=2.52 PD=1.27
M$2042 \$2776 A|B|B_N|X VPB|VPWR VPB|VPWR sky130_fd_pr__pfet_01v8_hvt L=0.15
+ W=1 AS=0.135 AD=0.135 PS=1.27 PD=1.27
M$2043 VPB|VPWR A|B|B_N|X \$2806 VPB|VPWR sky130_fd_pr__pfet_01v8_hvt L=0.15
+ W=1 AS=0.135 AD=0.135 PS=1.27 PD=1.27
M$2044 \$2806 B|Y \$2777 VPB|VPWR sky130_fd_pr__pfet_01v8_hvt L=0.15 W=1
+ AS=0.135 AD=0.26 PS=1.27 PD=2.52
M$2046 \$2778 A|B|X \$2807 VPB|VPWR sky130_fd_pr__pfet_01v8_hvt L=0.15 W=1
+ AS=0.26 AD=0.135 PS=2.52 PD=1.27
M$2047 \$2807 A|Y VPB|VPWR VPB|VPWR sky130_fd_pr__pfet_01v8_hvt L=0.15 W=1
+ AS=0.135 AD=0.135 PS=1.27 PD=1.27
M$2048 VPB|VPWR A|Y \$2779 VPB|VPWR sky130_fd_pr__pfet_01v8_hvt L=0.15 W=1
+ AS=0.135 AD=0.135 PS=1.27 PD=1.27
M$2049 \$2779 A|B|X VPB|VPWR VPB|VPWR sky130_fd_pr__pfet_01v8_hvt L=0.15 W=1
+ AS=0.135 AD=0.26 PS=1.27 PD=2.52
M$2050 VPB|VPWR A|B|X B|C|Y VPB|VPWR sky130_fd_pr__pfet_01v8_hvt L=0.15 W=1.68
+ AS=0.3318 AD=0.3486 PS=3.31 PD=3.35
M$2052 \$2779 \$2778 A2|B|X VPB|VPWR sky130_fd_pr__pfet_01v8_hvt L=0.15 W=1
+ AS=0.26 AD=0.3 PS=2.52 PD=2.6
M$2056 \$2783 A2|B|X VPB|VPWR VPB|VPWR sky130_fd_pr__pfet_01v8_hvt L=0.15 W=1
+ AS=0.265 AD=0.14 PS=2.53 PD=1.28
M$2057 VPB|VPWR A|A1|Y \$2783 VPB|VPWR sky130_fd_pr__pfet_01v8_hvt L=0.15 W=1
+ AS=0.14 AD=0.14 PS=1.28 PD=1.28
M$2058 \$2783 B1|X \$2808 VPB|VPWR sky130_fd_pr__pfet_01v8_hvt L=0.15 W=1
+ AS=0.14 AD=0.155 PS=1.28 PD=1.31
M$2059 \$2808 C1|X B|Y VPB|VPWR sky130_fd_pr__pfet_01v8_hvt L=0.15 W=1 AS=0.155
+ AD=0.265 PS=1.31 PD=2.53
M$2063 VPB|VPWR \$2786 A|SLEEP|Y VPB|VPWR sky130_fd_pr__pfet_01v8_hvt L=0.15
+ W=1 AS=0.36 AD=0.165 PS=2.72 PD=1.33
M$2064 A|SLEEP|Y B|Y \$2811 VPB|VPWR sky130_fd_pr__pfet_01v8_hvt L=0.15 W=1
+ AS=0.165 AD=0.105 PS=1.33 PD=1.21
M$2065 \$2811 A|A2|Y VPB|VPWR VPB|VPWR sky130_fd_pr__pfet_01v8_hvt L=0.15 W=1
+ AS=0.105 AD=0.365 PS=1.21 PD=1.73
M$2066 VPB|VPWR A|A2|Y \$2786 VPB|VPWR sky130_fd_pr__pfet_01v8_hvt L=0.15 W=1
+ AS=0.365 AD=0.135 PS=1.73 PD=1.27
M$2067 \$2786 B|Y VPB|VPWR VPB|VPWR sky130_fd_pr__pfet_01v8_hvt L=0.15 W=1
+ AS=0.135 AD=0.3 PS=1.27 PD=2.6
M$2069 VPB|VPWR A|Y \$2812 VPB|VPWR sky130_fd_pr__pfet_01v8_hvt L=0.15 W=1
+ AS=0.26 AD=0.105 PS=2.52 PD=1.21
M$2070 \$2812 B|Y A|Y VPB|VPWR sky130_fd_pr__pfet_01v8_hvt L=0.15 W=1 AS=0.105
+ AD=0.26 PS=1.21 PD=2.52
M$2073 \$2579 B|C|X \$2741 VPB|VPWR sky130_fd_pr__pfet_01v8_hvt L=0.15 W=0.42
+ AS=0.1092 AD=0.0441 PS=1.36 PD=0.63
M$2074 \$2741 A|B|X VPB|VPWR VPB|VPWR sky130_fd_pr__pfet_01v8_hvt L=0.15 W=0.42
+ AS=0.0441 AD=0.0567 PS=0.63 PD=0.69
M$2075 VPB|VPWR A|B|X \$2742 VPB|VPWR sky130_fd_pr__pfet_01v8_hvt L=0.15 W=0.42
+ AS=0.0567 AD=0.0441 PS=0.69 PD=0.63
M$2076 \$2742 A|B|C|X \$2579 VPB|VPWR sky130_fd_pr__pfet_01v8_hvt L=0.15 W=0.42
+ AS=0.0441 AD=0.0567 PS=0.63 PD=0.69
M$2077 \$2579 A|B|C|X \$2740 VPB|VPWR sky130_fd_pr__pfet_01v8_hvt L=0.15 W=0.42
+ AS=0.0567 AD=0.0441 PS=0.69 PD=0.63
M$2078 VPB|VPWR B|C|X \$2740 VPB|VPWR sky130_fd_pr__pfet_01v8_hvt L=0.15 W=0.42
+ AS=0.2492 AD=0.0441 PS=1.565 PD=0.63
M$2079 VPB|VPWR \$2579 D|X VPB|VPWR sky130_fd_pr__pfet_01v8_hvt L=0.15 W=1
+ AS=0.2492 AD=0.365 PS=1.565 PD=2.73
M$2080 B|X \$2789 \$2788 VPB|VPWR sky130_fd_pr__pfet_01v8_hvt L=0.15 W=1 AS=0.3
+ AD=0.26 PS=2.6 PD=2.52
M$2081 VPB|VPWR B|C|X \$2788 VPB|VPWR sky130_fd_pr__pfet_01v8_hvt L=0.15 W=1
+ AS=0.26 AD=0.135 PS=2.52 PD=1.27
M$2082 \$2788 A|B|C|X VPB|VPWR VPB|VPWR sky130_fd_pr__pfet_01v8_hvt L=0.15 W=1
+ AS=0.135 AD=0.135 PS=1.27 PD=1.27
M$2083 VPB|VPWR A|B|C|X \$2813 VPB|VPWR sky130_fd_pr__pfet_01v8_hvt L=0.15 W=1
+ AS=0.135 AD=0.135 PS=1.27 PD=1.27
M$2084 \$2813 B|C|X \$2789 VPB|VPWR sky130_fd_pr__pfet_01v8_hvt L=0.15 W=1
+ AS=0.135 AD=0.26 PS=1.27 PD=2.52
M$2113 \$2790 A|B1_N|Y VPB|VPWR VPB|VPWR sky130_fd_pr__pfet_01v8_hvt L=0.15
+ W=0.42 AS=0.1113 AD=0.1113 PS=1.37 PD=1.37
M$2114 B1|C|Y \$2790 \$2792 VPB|VPWR sky130_fd_pr__pfet_01v8_hvt L=0.15 W=0.64
+ AS=0.1696 AD=0.0896 PS=1.81 PD=0.92
M$2115 \$2792 A|A1|X VPB|VPWR VPB|VPWR sky130_fd_pr__pfet_01v8_hvt L=0.15
+ W=0.64 AS=0.0896 AD=0.0896 PS=0.92 PD=0.92
M$2116 VPB|VPWR A2|B|X \$2792 VPB|VPWR sky130_fd_pr__pfet_01v8_hvt L=0.15
+ W=0.64 AS=0.0896 AD=0.1696 PS=0.92 PD=1.81
M$2117 VPB|VPWR A2|B|X \$2795 VPB|VPWR sky130_fd_pr__pfet_01v8_hvt L=0.15 W=1
+ AS=0.3 AD=0.135 PS=2.6 PD=1.27
M$2118 \$2795 A|A1|X VPB|VPWR VPB|VPWR sky130_fd_pr__pfet_01v8_hvt L=0.15 W=1
+ AS=0.135 AD=0.365 PS=1.27 PD=1.73
M$2119 VPB|VPWR A|A1|X \$2802 VPB|VPWR sky130_fd_pr__pfet_01v8_hvt L=0.15 W=1
+ AS=0.365 AD=0.105 PS=1.73 PD=1.21
M$2120 \$2802 A2|B|X A|A1|B|Y VPB|VPWR sky130_fd_pr__pfet_01v8_hvt L=0.15 W=1
+ AS=0.105 AD=0.165 PS=1.21 PD=1.33
M$2121 A|A1|B|Y \$2795 VPB|VPWR VPB|VPWR sky130_fd_pr__pfet_01v8_hvt L=0.15 W=1
+ AS=0.165 AD=0.36 PS=1.33 PD=2.72
M$2123 VPB|VPWR \$2797 \$2796 VPB|VPWR sky130_fd_pr__pfet_01v8_hvt L=0.5 W=0.82
+ AS=0.15575 AD=0.2173 PS=1.325 PD=2.17
M$2124 A|B|X \$2796 VPB|VPWR VPB|VPWR sky130_fd_pr__pfet_01v8_hvt L=0.15 W=1
+ AS=0.355 AD=0.15575 PS=2.71 PD=1.325
M$2125 \$2797 \$2798 VPB|VPWR VPB|VPWR sky130_fd_pr__pfet_01v8_hvt L=0.5 W=0.82
+ AS=0.2173 AD=0.1701 PS=2.17 PD=1.36
M$2126 VPB|VPWR A|COARSE_MUX[5] \$2798 VPB|VPWR sky130_fd_pr__pfet_01v8_hvt
+ L=0.15 W=1 AS=0.1701 AD=0.27 PS=1.36 PD=2.54
M$2127 VPB|VPWR A|C|X \$2841 VPB|VPWR sky130_fd_pr__pfet_01v8_hvt L=0.15 W=0.64
+ AS=0.2115 AD=0.1792 PS=1.45 PD=1.84
M$2128 A_N|B|C|X \$2840 VPB|VPWR VPB|VPWR sky130_fd_pr__pfet_01v8_hvt L=0.15
+ W=1 AS=0.28 AD=0.2115 PS=2.56 PD=1.45
M$2129 \$2843 A|C|X \$2840 VPB|VPWR sky130_fd_pr__pfet_01v8_hvt L=0.15 W=0.84
+ AS=0.2688 AD=0.1596 PS=2.32 PD=1.22
M$2130 \$2840 \$2841 \$2842 VPB|VPWR sky130_fd_pr__pfet_01v8_hvt L=0.15 W=0.84
+ AS=0.1596 AD=0.441 PS=1.22 PD=2.73
M$2131 VPB|VPWR A|B|X \$2844 VPB|VPWR sky130_fd_pr__pfet_01v8_hvt L=0.15 W=1
+ AS=0.26 AD=0.2526 PS=2.52 PD=2.52
M$2132 \$2843 \$2844 \$2846 VPB|VPWR sky130_fd_pr__pfet_01v8_hvt L=0.15 W=0.64
+ AS=0.2452 AD=0.246 PS=1.45 PD=1.525
M$2133 \$2846 A|B|X \$2842 VPB|VPWR sky130_fd_pr__pfet_01v8_hvt L=0.15 W=0.64
+ AS=0.246 AD=0.1458 PS=1.525 PD=1.205
M$2134 \$2845 A|B|X \$2843 VPB|VPWR sky130_fd_pr__pfet_01v8_hvt L=0.15 W=0.84
+ AS=0.3536 AD=0.2452 PS=2.53 PD=1.45
M$2135 \$2845 \$2844 \$2842 VPB|VPWR sky130_fd_pr__pfet_01v8_hvt L=0.15 W=0.84
+ AS=0.1715 AD=0.1458 PS=1.355 PD=1.205
M$2136 \$2845 A|X VPB|VPWR VPB|VPWR sky130_fd_pr__pfet_01v8_hvt L=0.15 W=1
+ AS=0.1715 AD=0.135 PS=1.355 PD=1.27
M$2137 VPB|VPWR \$2845 \$2846 VPB|VPWR sky130_fd_pr__pfet_01v8_hvt L=0.15 W=1
+ AS=0.135 AD=0.285 PS=1.27 PD=2.57
M$2138 VPB|VPWR A|X \$3005 VPB|VPWR sky130_fd_pr__pfet_01v8_hvt L=0.15 W=0.42
+ AS=0.14825 AD=0.0693 PS=1.34 PD=0.75
M$2139 \$3005 A|B|X \$3006 VPB|VPWR sky130_fd_pr__pfet_01v8_hvt L=0.15 W=0.42
+ AS=0.0693 AD=0.0441 PS=0.75 PD=0.63
M$2140 \$3006 A|C|X \$2848 VPB|VPWR sky130_fd_pr__pfet_01v8_hvt L=0.15 W=0.42
+ AS=0.0441 AD=0.1092 PS=0.63 PD=1.36
M$2141 A|X \$2848 VPB|VPWR VPB|VPWR sky130_fd_pr__pfet_01v8_hvt L=0.15 W=1
+ AS=0.28 AD=0.14825 PS=2.56 PD=1.34
M$2144 VPB|VPWR A|C|X A|B|Y VPB|VPWR sky130_fd_pr__pfet_01v8_hvt L=0.15 W=1
+ AS=0.26 AD=0.135 PS=2.52 PD=1.27
M$2145 A|B|Y A|B|X VPB|VPWR VPB|VPWR sky130_fd_pr__pfet_01v8_hvt L=0.15 W=1
+ AS=0.135 AD=0.165 PS=1.27 PD=1.33
M$2148 \$2849 A|C|X \$3007 VPB|VPWR sky130_fd_pr__pfet_01v8_hvt L=0.15 W=0.42
+ AS=0.1092 AD=0.0441 PS=1.36 PD=0.63
M$2149 \$3007 A|X VPB|VPWR VPB|VPWR sky130_fd_pr__pfet_01v8_hvt L=0.15 W=0.42
+ AS=0.0441 AD=0.0567 PS=0.63 PD=0.69
M$2150 VPB|VPWR A|X \$3008 VPB|VPWR sky130_fd_pr__pfet_01v8_hvt L=0.15 W=0.42
+ AS=0.0567 AD=0.0441 PS=0.69 PD=0.63
M$2151 \$3008 A|B|X \$2849 VPB|VPWR sky130_fd_pr__pfet_01v8_hvt L=0.15 W=0.42
+ AS=0.0441 AD=0.0567 PS=0.63 PD=0.69
M$2152 \$2849 A|B|X \$3009 VPB|VPWR sky130_fd_pr__pfet_01v8_hvt L=0.15 W=0.42
+ AS=0.0567 AD=0.0441 PS=0.69 PD=0.63
M$2153 VPB|VPWR A|C|X \$3009 VPB|VPWR sky130_fd_pr__pfet_01v8_hvt L=0.15 W=0.42
+ AS=0.2492 AD=0.0441 PS=1.565 PD=0.63
M$2154 VPB|VPWR \$2849 B|X VPB|VPWR sky130_fd_pr__pfet_01v8_hvt L=0.15 W=1
+ AS=0.2492 AD=0.365 PS=1.565 PD=2.73
M$2156 VPB|VPWR \$2850 A|B1|Y VPB|VPWR sky130_fd_pr__pfet_01v8_hvt L=0.15 W=1
+ AS=0.36 AD=0.165 PS=2.72 PD=1.33
M$2157 A|B1|Y B|SLEEP|Y \$3021 VPB|VPWR sky130_fd_pr__pfet_01v8_hvt L=0.15 W=1
+ AS=0.165 AD=0.105 PS=1.33 PD=1.21
M$2158 \$3021 A|X VPB|VPWR VPB|VPWR sky130_fd_pr__pfet_01v8_hvt L=0.15 W=1
+ AS=0.105 AD=0.365 PS=1.21 PD=1.73
M$2159 VPB|VPWR A|X \$2850 VPB|VPWR sky130_fd_pr__pfet_01v8_hvt L=0.15 W=1
+ AS=0.365 AD=0.135 PS=1.73 PD=1.27
M$2160 \$2850 B|SLEEP|Y VPB|VPWR VPB|VPWR sky130_fd_pr__pfet_01v8_hvt L=0.15
+ W=1 AS=0.135 AD=0.3 PS=1.27 PD=2.6
M$2161 \$2852 A|X VPB|VPWR VPB|VPWR sky130_fd_pr__pfet_01v8_hvt L=0.15 W=0.42
+ AS=0.1092 AD=0.1573 PS=1.36 PD=1.39
M$2162 VPB|VPWR B|SLEEP|Y \$3022 VPB|VPWR sky130_fd_pr__pfet_01v8_hvt L=0.15
+ W=1 AS=0.1573 AD=0.105 PS=1.39 PD=1.21
M$2163 \$3022 \$2852 A|A1|X VPB|VPWR sky130_fd_pr__pfet_01v8_hvt L=0.15 W=1
+ AS=0.105 AD=0.26 PS=1.21 PD=2.52
M$2167 \$2772 B|C|X \$2770 VPB|VPWR sky130_fd_pr__pfet_01v8_hvt L=0.15 W=0.84
+ AS=0.15295 AD=0.273 PS=1.315 PD=2.33
M$2168 \$2772 \$2773 \$2771 VPB|VPWR sky130_fd_pr__pfet_01v8_hvt L=0.15 W=0.84
+ AS=0.15295 AD=0.32235 PS=1.315 PD=2.45
M$2169 VPB|VPWR A|A1_N|Y A|Y VPB|VPWR sky130_fd_pr__pfet_01v8_hvt L=0.15 W=1
+ AS=0.26 AD=0.135 PS=2.52 PD=1.27
M$2170 A|Y A2_N|B|Y VPB|VPWR VPB|VPWR sky130_fd_pr__pfet_01v8_hvt L=0.15 W=1
+ AS=0.135 AD=0.26 PS=1.27 PD=2.52
M$2175 VPB|VPWR A|B1|Y A|B|Y VPB|VPWR sky130_fd_pr__pfet_01v8_hvt L=0.15 W=1
+ AS=0.26 AD=0.135 PS=2.52 PD=1.27
M$2176 A|B|Y B|C|Y VPB|VPWR VPB|VPWR sky130_fd_pr__pfet_01v8_hvt L=0.15 W=3
+ AS=0.53 AD=0.5875 PS=5.06 PD=5.175
M$2178 \$2781 A|Y VPB|VPWR VPB|VPWR sky130_fd_pr__pfet_01v8_hvt L=0.15 W=0.42
+ AS=0.1092 AD=0.0567 PS=1.36 PD=0.69
M$2179 VPB|VPWR A|B|B_N|X \$2781 VPB|VPWR sky130_fd_pr__pfet_01v8_hvt L=0.15
+ W=0.42 AS=0.0567 AD=0.06615 PS=0.69 PD=0.735
M$2180 VPB|VPWR B|C|Y \$2781 VPB|VPWR sky130_fd_pr__pfet_01v8_hvt L=0.15 W=0.42
+ AS=0.142225 AD=0.06615 PS=1.335 PD=0.735
M$2181 VPB|VPWR \$2781 A|X VPB|VPWR sky130_fd_pr__pfet_01v8_hvt L=0.15 W=1
+ AS=0.142225 AD=0.26 PS=1.335 PD=2.52
M$2183 A|Y B|X VPB|VPWR VPB|VPWR sky130_fd_pr__pfet_01v8_hvt L=0.15 W=7
+ AS=1.4665 AD=1.07 PS=14.02 PD=10.14
M$2184 B|X \$2858 \$3000 VPB|VPWR sky130_fd_pr__pfet_01v8_hvt L=0.15 W=1 AS=0.3
+ AD=0.26 PS=2.6 PD=2.52
M$2185 VPB|VPWR A2|B|X \$3000 VPB|VPWR sky130_fd_pr__pfet_01v8_hvt L=0.15 W=1
+ AS=0.26 AD=0.135 PS=2.52 PD=1.27
M$2186 \$3000 A|A1|Y VPB|VPWR VPB|VPWR sky130_fd_pr__pfet_01v8_hvt L=0.15 W=1
+ AS=0.135 AD=0.135 PS=1.27 PD=1.27
M$2187 VPB|VPWR A|A1|Y \$3019 VPB|VPWR sky130_fd_pr__pfet_01v8_hvt L=0.15 W=1
+ AS=0.135 AD=0.135 PS=1.27 PD=1.27
M$2188 \$3019 A2|B|X \$2858 VPB|VPWR sky130_fd_pr__pfet_01v8_hvt L=0.15 W=1
+ AS=0.135 AD=0.26 PS=1.27 PD=2.52
M$2189 VPB|VPWR \$2859 A|A1|Y VPB|VPWR sky130_fd_pr__pfet_01v8_hvt L=0.15 W=1
+ AS=0.36 AD=0.165 PS=2.72 PD=1.33
M$2190 A|A1|Y A|B|X \$3017 VPB|VPWR sky130_fd_pr__pfet_01v8_hvt L=0.15 W=1
+ AS=0.165 AD=0.105 PS=1.33 PD=1.21
M$2191 \$3017 A|SLEEP|Y VPB|VPWR VPB|VPWR sky130_fd_pr__pfet_01v8_hvt L=0.15
+ W=1 AS=0.105 AD=0.365 PS=1.21 PD=1.73
M$2192 VPB|VPWR A|SLEEP|Y \$2859 VPB|VPWR sky130_fd_pr__pfet_01v8_hvt L=0.15
+ W=1 AS=0.365 AD=0.135 PS=1.73 PD=1.27
M$2193 \$2859 A|B|X VPB|VPWR VPB|VPWR sky130_fd_pr__pfet_01v8_hvt L=0.15 W=1
+ AS=0.135 AD=0.3 PS=1.27 PD=2.6
M$2194 VPB|VPWR A|B|X \$2862 VPB|VPWR sky130_fd_pr__pfet_01v8_hvt L=0.15 W=0.42
+ AS=0.1573 AD=0.1092 PS=1.39 PD=1.36
M$2195 C1|X \$2862 \$3016 VPB|VPWR sky130_fd_pr__pfet_01v8_hvt L=0.15 W=1
+ AS=0.26 AD=0.105 PS=2.52 PD=1.21
M$2196 \$3016 A|SLEEP|Y VPB|VPWR VPB|VPWR sky130_fd_pr__pfet_01v8_hvt L=0.15
+ W=1 AS=0.105 AD=0.1573 PS=1.21 PD=1.39
M$2215 \$2864 A2|B|C|X \$3013 VPB|VPWR sky130_fd_pr__pfet_01v8_hvt L=0.15 W=1
+ AS=0.26 AD=0.135 PS=2.52 PD=1.27
M$2216 \$3013 A|A1|D|X VPB|VPWR VPB|VPWR sky130_fd_pr__pfet_01v8_hvt L=0.15 W=1
+ AS=0.135 AD=0.135 PS=1.27 PD=1.27
M$2217 VPB|VPWR A|A1|D|X \$3001 VPB|VPWR sky130_fd_pr__pfet_01v8_hvt L=0.15 W=1
+ AS=0.135 AD=0.135 PS=1.27 PD=1.27
M$2218 \$3001 A2|B|C|X VPB|VPWR VPB|VPWR sky130_fd_pr__pfet_01v8_hvt L=0.15 W=1
+ AS=0.135 AD=0.26 PS=1.27 PD=2.52
M$2219 \$3001 \$2864 C|X VPB|VPWR sky130_fd_pr__pfet_01v8_hvt L=0.15 W=1
+ AS=0.26 AD=0.3 PS=2.52 PD=2.6
M$2220 VPB|VPWR C|X \$3004 VPB|VPWR sky130_fd_pr__pfet_01v8_hvt L=0.15 W=0.42
+ AS=0.2492 AD=0.0441 PS=1.565 PD=0.63
M$2221 \$3004 A|B|X \$2867 VPB|VPWR sky130_fd_pr__pfet_01v8_hvt L=0.15 W=0.42
+ AS=0.0441 AD=0.0567 PS=0.63 PD=0.69
M$2222 \$2867 A|B|X \$3003 VPB|VPWR sky130_fd_pr__pfet_01v8_hvt L=0.15 W=0.42
+ AS=0.0567 AD=0.0441 PS=0.69 PD=0.63
M$2223 \$3003 A|B|X VPB|VPWR VPB|VPWR sky130_fd_pr__pfet_01v8_hvt L=0.15 W=0.42
+ AS=0.0441 AD=0.0567 PS=0.63 PD=0.69
M$2224 VPB|VPWR A|B|X \$3002 VPB|VPWR sky130_fd_pr__pfet_01v8_hvt L=0.15 W=0.42
+ AS=0.0567 AD=0.0441 PS=0.69 PD=0.63
M$2225 \$3002 C|X \$2867 VPB|VPWR sky130_fd_pr__pfet_01v8_hvt L=0.15 W=0.42
+ AS=0.0441 AD=0.1092 PS=0.63 PD=1.36
M$2226 A2|B|X \$2867 VPB|VPWR VPB|VPWR sky130_fd_pr__pfet_01v8_hvt L=0.15 W=1
+ AS=0.365 AD=0.2492 PS=2.73 PD=1.565
M$2228 VPB|VPWR \$3024 \$3025 VPB|VPWR sky130_fd_pr__pfet_01v8_hvt L=0.5 W=0.82
+ AS=0.1701 AD=0.2173 PS=1.36 PD=2.17
M$2229 \$3024 A|FINE_MUX[1] VPB|VPWR VPB|VPWR sky130_fd_pr__pfet_01v8_hvt
+ L=0.15 W=1 AS=0.27 AD=0.1701 PS=2.54 PD=1.36
M$2230 \$3026 \$3025 VPB|VPWR VPB|VPWR sky130_fd_pr__pfet_01v8_hvt L=0.5 W=0.82
+ AS=0.2173 AD=0.15575 PS=2.17 PD=1.325
M$2231 VPB|VPWR \$3026 A|X VPB|VPWR sky130_fd_pr__pfet_01v8_hvt L=0.15 W=1
+ AS=0.15575 AD=0.355 PS=1.325 PD=2.71
M$2232 \$3097 A_N|B|C|X VPB|VPWR VPB|VPWR sky130_fd_pr__pfet_01v8_hvt L=0.15
+ W=0.42 AS=0.1092 AD=0.14575 PS=1.36 PD=1.335
M$2233 VPB|VPWR A|B|B1|C1|X A|Y VPB|VPWR sky130_fd_pr__pfet_01v8_hvt L=0.15 W=1
+ AS=0.14575 AD=0.135 PS=1.335 PD=1.27
M$2234 A|Y \$3097 VPB|VPWR VPB|VPWR sky130_fd_pr__pfet_01v8_hvt L=0.15 W=1
+ AS=0.135 AD=0.265 PS=1.27 PD=2.53
M$2238 VPB|VPWR A|X \$3028 VPB|VPWR sky130_fd_pr__pfet_01v8_hvt L=0.15 W=0.42
+ AS=0.1113 AD=0.0609 PS=1.37 PD=0.71
M$2239 \$3028 A|B|Y VPB|VPWR VPB|VPWR sky130_fd_pr__pfet_01v8_hvt L=0.15 W=0.42
+ AS=0.0609 AD=0.1841 PS=0.71 PD=1.26
M$2240 VPB|VPWR \$3028 B|X VPB|VPWR sky130_fd_pr__pfet_01v8_hvt L=0.15 W=0.64
+ AS=0.1841 AD=0.1696 PS=1.26 PD=1.81
M$2241 VPB|VPWR A|Y \$3257 VPB|VPWR sky130_fd_pr__pfet_01v8_hvt L=0.15 W=1
+ AS=0.26 AD=0.105 PS=2.52 PD=1.21
M$2242 \$3257 B|Y A1|Y VPB|VPWR sky130_fd_pr__pfet_01v8_hvt L=0.15 W=1 AS=0.105
+ AD=0.26 PS=1.21 PD=2.52
M$2243 A2|C|X \$3031 \$3030 VPB|VPWR sky130_fd_pr__pfet_01v8_hvt L=0.15 W=1
+ AS=0.3 AD=0.26 PS=2.6 PD=2.52
M$2244 VPB|VPWR A|Y \$3258 VPB|VPWR sky130_fd_pr__pfet_01v8_hvt L=0.15 W=1
+ AS=0.26 AD=0.135 PS=2.52 PD=1.27
M$2245 \$3258 B|Y \$3259 VPB|VPWR sky130_fd_pr__pfet_01v8_hvt L=0.15 W=1
+ AS=0.135 AD=0.135 PS=1.27 PD=1.27
M$2246 \$3259 A2|B|C|X A|B1_N|Y VPB|VPWR sky130_fd_pr__pfet_01v8_hvt L=0.15 W=1
+ AS=0.135 AD=0.26 PS=1.27 PD=2.52
M$2247 VPB|VPWR A2|B|C|X \$3030 VPB|VPWR sky130_fd_pr__pfet_01v8_hvt L=0.15 W=1
+ AS=0.26 AD=0.135 PS=2.52 PD=1.27
M$2248 \$3030 A|B|Y VPB|VPWR VPB|VPWR sky130_fd_pr__pfet_01v8_hvt L=0.15 W=1
+ AS=0.135 AD=0.135 PS=1.27 PD=1.27
M$2249 VPB|VPWR A|B|Y \$3064 VPB|VPWR sky130_fd_pr__pfet_01v8_hvt L=0.15 W=1
+ AS=0.135 AD=0.135 PS=1.27 PD=1.27
M$2250 \$3064 A2|B|C|X \$3031 VPB|VPWR sky130_fd_pr__pfet_01v8_hvt L=0.15 W=1
+ AS=0.135 AD=0.26 PS=1.27 PD=2.52
M$2252 VPB|VPWR A|B|Y \$3065 VPB|VPWR sky130_fd_pr__pfet_01v8_hvt L=0.15 W=1
+ AS=0.26 AD=0.105 PS=2.52 PD=1.21
M$2253 \$3065 A2|B|C|X A|B|Y VPB|VPWR sky130_fd_pr__pfet_01v8_hvt L=0.15 W=1
+ AS=0.105 AD=0.26 PS=1.21 PD=2.52
M$2255 VPB|VPWR B|C|X \$3101 VPB|VPWR sky130_fd_pr__pfet_01v8_hvt L=0.15 W=1
+ AS=0.3 AD=0.135 PS=2.6 PD=1.27
M$2256 \$3101 A|B|Y VPB|VPWR VPB|VPWR sky130_fd_pr__pfet_01v8_hvt L=0.15 W=1
+ AS=0.135 AD=0.365 PS=1.27 PD=1.73
M$2257 VPB|VPWR A|B|Y \$3263 VPB|VPWR sky130_fd_pr__pfet_01v8_hvt L=0.15 W=1
+ AS=0.365 AD=0.105 PS=1.73 PD=1.21
M$2258 \$3263 B|C|X A3|Y VPB|VPWR sky130_fd_pr__pfet_01v8_hvt L=0.15 W=1
+ AS=0.105 AD=0.165 PS=1.21 PD=1.33
M$2259 A3|Y \$3101 VPB|VPWR VPB|VPWR sky130_fd_pr__pfet_01v8_hvt L=0.15 W=1
+ AS=0.165 AD=0.36 PS=1.33 PD=2.72
M$2260 VPB|VPWR A1|Y \$3067 VPB|VPWR sky130_fd_pr__pfet_01v8_hvt L=0.15 W=1
+ AS=0.26 AD=0.135 PS=2.52 PD=1.27
M$2261 \$3067 A2|B|C|X \$3066 VPB|VPWR sky130_fd_pr__pfet_01v8_hvt L=0.15 W=1
+ AS=0.135 AD=0.135 PS=1.27 PD=1.27
M$2262 \$3066 A3|Y B|B_N|Y VPB|VPWR sky130_fd_pr__pfet_01v8_hvt L=0.15 W=1
+ AS=0.135 AD=0.3925 PS=1.27 PD=1.785
M$2263 B|B_N|Y A|B|B1|C1|X VPB|VPWR VPB|VPWR sky130_fd_pr__pfet_01v8_hvt L=0.15
+ W=1 AS=0.3925 AD=0.3 PS=1.785 PD=2.6
M$2266 \$3105 A|C_N|S|Y \$3266 VPB|VPWR sky130_fd_pr__pfet_01v8_hvt L=0.15
+ W=0.42 AS=0.1092 AD=0.0441 PS=1.36 PD=0.63
M$2267 \$3266 A|A0|B|SLEEP|X VPB|VPWR VPB|VPWR sky130_fd_pr__pfet_01v8_hvt
+ L=0.15 W=0.42 AS=0.0441 AD=0.14575 PS=0.63 PD=1.335
M$2268 VPB|VPWR \$3105 A|B1_N|X VPB|VPWR sky130_fd_pr__pfet_01v8_hvt L=0.15 W=1
+ AS=0.14575 AD=0.34 PS=1.335 PD=2.68
M$2269 VPB|VPWR A|A0|B|SLEEP|X A2|B|Y VPB|VPWR sky130_fd_pr__pfet_01v8_hvt
+ L=0.15 W=1.68 AS=0.3318 AD=0.3486 PS=3.31 PD=3.35
M$2272 VPB|VPWR A2|B|Y A|B2|Y VPB|VPWR sky130_fd_pr__pfet_01v8_hvt L=0.15 W=1
+ AS=0.26 AD=0.135 PS=2.52 PD=1.27
M$2273 A|B2|Y A|A1|X VPB|VPWR VPB|VPWR sky130_fd_pr__pfet_01v8_hvt L=0.15 W=1
+ AS=0.135 AD=0.26 PS=1.27 PD=2.52
M$2275 VPB|VPWR A|B|B1|X \$3069 VPB|VPWR sky130_fd_pr__pfet_01v8_hvt L=0.15
+ W=0.42 AS=0.1092 AD=0.0441 PS=1.36 PD=0.63
M$2276 \$3069 A|B2|Y \$3037 VPB|VPWR sky130_fd_pr__pfet_01v8_hvt L=0.15 W=0.42
+ AS=0.0441 AD=0.0672 PS=0.63 PD=0.74
M$2277 VPB|VPWR \$3038 \$3037 VPB|VPWR sky130_fd_pr__pfet_01v8_hvt L=0.15
+ W=0.42 AS=0.20925 AD=0.0672 PS=1.345 PD=0.74
M$2278 VPB|VPWR A2_N|B|Y \$3038 VPB|VPWR sky130_fd_pr__pfet_01v8_hvt L=0.15
+ W=0.42 AS=0.20925 AD=0.129 PS=1.345 PD=1.18
M$2279 VPB|VPWR A|A1_N|Y \$3038 VPB|VPWR sky130_fd_pr__pfet_01v8_hvt L=0.15
+ W=0.42 AS=0.14575 AD=0.129 PS=1.335 PD=1.18
M$2280 VPB|VPWR \$3037 B|X VPB|VPWR sky130_fd_pr__pfet_01v8_hvt L=0.15 W=1
+ AS=0.14575 AD=0.26 PS=1.335 PD=2.52
M$2281 B|X \$3111 \$3253 VPB|VPWR sky130_fd_pr__pfet_01v8_hvt L=0.15 W=1 AS=0.3
+ AD=0.26 PS=2.6 PD=2.52
M$2282 VPB|VPWR B|X \$3253 VPB|VPWR sky130_fd_pr__pfet_01v8_hvt L=0.15 W=1
+ AS=0.26 AD=0.135 PS=2.52 PD=1.27
M$2283 \$3253 A|B|C|Y VPB|VPWR VPB|VPWR sky130_fd_pr__pfet_01v8_hvt L=0.15 W=1
+ AS=0.135 AD=0.135 PS=1.27 PD=1.27
M$2284 VPB|VPWR A|B|C|Y \$3268 VPB|VPWR sky130_fd_pr__pfet_01v8_hvt L=0.15 W=1
+ AS=0.135 AD=0.135 PS=1.27 PD=1.27
M$2285 \$3268 B|X \$3111 VPB|VPWR sky130_fd_pr__pfet_01v8_hvt L=0.15 W=1
+ AS=0.135 AD=0.26 PS=1.27 PD=2.52
M$2286 \$3112 A|B|C|Y \$3269 VPB|VPWR sky130_fd_pr__pfet_01v8_hvt L=0.15 W=0.42
+ AS=0.1092 AD=0.0441 PS=1.36 PD=0.63
M$2287 \$3269 A|B|B1|X \$3271 VPB|VPWR sky130_fd_pr__pfet_01v8_hvt L=0.15
+ W=0.42 AS=0.0441 AD=0.0693 PS=0.63 PD=0.75
M$2288 \$3271 A|B2|Y VPB|VPWR VPB|VPWR sky130_fd_pr__pfet_01v8_hvt L=0.15
+ W=0.42 AS=0.0693 AD=0.14825 PS=0.75 PD=1.34
M$2289 VPB|VPWR \$3112 A|X VPB|VPWR sky130_fd_pr__pfet_01v8_hvt L=0.15 W=1
+ AS=0.14825 AD=0.28 PS=1.34 PD=2.56
M$2291 VPB|VPWR A|Y \$3070 VPB|VPWR sky130_fd_pr__pfet_01v8_hvt L=0.15 W=1
+ AS=0.26 AD=0.105 PS=2.52 PD=1.21
M$2292 \$3070 A|B|C|Y A|A1|Y VPB|VPWR sky130_fd_pr__pfet_01v8_hvt L=0.15 W=1
+ AS=0.105 AD=0.26 PS=1.21 PD=2.52
M$2293 VPB|VPWR A|Y \$3071 VPB|VPWR sky130_fd_pr__pfet_01v8_hvt L=0.15 W=1
+ AS=0.26 AD=0.135 PS=2.52 PD=1.27
M$2294 \$3071 A|B|C|Y \$3072 VPB|VPWR sky130_fd_pr__pfet_01v8_hvt L=0.15 W=1
+ AS=0.135 AD=0.135 PS=1.27 PD=1.27
M$2295 \$3072 B|C|Y A|A1|Y VPB|VPWR sky130_fd_pr__pfet_01v8_hvt L=0.15 W=1
+ AS=0.135 AD=0.26 PS=1.27 PD=2.52
M$2296 B|C|X \$3115 \$3254 VPB|VPWR sky130_fd_pr__pfet_01v8_hvt L=0.15 W=1
+ AS=0.3 AD=0.26 PS=2.6 PD=2.52
M$2297 VPB|VPWR B|C|Y \$3254 VPB|VPWR sky130_fd_pr__pfet_01v8_hvt L=0.15 W=1
+ AS=0.26 AD=0.135 PS=2.52 PD=1.27
M$2298 \$3254 A|A1|Y VPB|VPWR VPB|VPWR sky130_fd_pr__pfet_01v8_hvt L=0.15 W=1
+ AS=0.135 AD=0.135 PS=1.27 PD=1.27
M$2299 VPB|VPWR A|A1|Y \$3272 VPB|VPWR sky130_fd_pr__pfet_01v8_hvt L=0.15 W=1
+ AS=0.135 AD=0.135 PS=1.27 PD=1.27
M$2300 \$3272 B|C|Y \$3115 VPB|VPWR sky130_fd_pr__pfet_01v8_hvt L=0.15 W=1
+ AS=0.135 AD=0.26 PS=1.27 PD=2.52
M$2301 VPB|VPWR \$3043 B|C|Y VPB|VPWR sky130_fd_pr__pfet_01v8_hvt L=0.15 W=1
+ AS=0.36 AD=0.165 PS=2.72 PD=1.33
M$2302 B|C|Y A2|B|X \$3073 VPB|VPWR sky130_fd_pr__pfet_01v8_hvt L=0.15 W=1
+ AS=0.165 AD=0.105 PS=1.33 PD=1.21
M$2303 \$3073 A|B1|Y VPB|VPWR VPB|VPWR sky130_fd_pr__pfet_01v8_hvt L=0.15 W=1
+ AS=0.105 AD=0.365 PS=1.21 PD=1.73
M$2304 VPB|VPWR A|B1|Y \$3043 VPB|VPWR sky130_fd_pr__pfet_01v8_hvt L=0.15 W=1
+ AS=0.365 AD=0.135 PS=1.73 PD=1.27
M$2305 \$3043 A2|B|X VPB|VPWR VPB|VPWR sky130_fd_pr__pfet_01v8_hvt L=0.15 W=1
+ AS=0.135 AD=0.3 PS=1.27 PD=2.6
M$2306 \$3044 A2|B|X VPB|VPWR VPB|VPWR sky130_fd_pr__pfet_01v8_hvt L=0.15 W=1
+ AS=0.265 AD=0.1475 PS=2.53 PD=1.295
M$2307 VPB|VPWR A|A1|Y \$3044 VPB|VPWR sky130_fd_pr__pfet_01v8_hvt L=0.15 W=1
+ AS=0.1475 AD=0.14 PS=1.295 PD=1.28
M$2308 \$3044 A|B1|Y A|Y VPB|VPWR sky130_fd_pr__pfet_01v8_hvt L=0.15 W=1
+ AS=0.14 AD=0.265 PS=1.28 PD=2.53
M$2312 VPB|VPWR A3|Y \$3249 VPB|VPWR sky130_fd_pr__pfet_01v8_hvt L=0.15 W=1
+ AS=0.26 AD=0.1375 PS=2.52 PD=1.275
M$2313 \$3249 A2|B|X VPB|VPWR VPB|VPWR sky130_fd_pr__pfet_01v8_hvt L=0.15 W=1
+ AS=0.1375 AD=0.14 PS=1.275 PD=1.28
M$2314 VPB|VPWR A|A1|Y \$3249 VPB|VPWR sky130_fd_pr__pfet_01v8_hvt L=0.15 W=1
+ AS=0.14 AD=0.165 PS=1.28 PD=1.33
M$2315 \$3249 B1|Y \$3275 VPB|VPWR sky130_fd_pr__pfet_01v8_hvt L=0.15 W=1
+ AS=0.165 AD=0.1725 PS=1.33 PD=1.345
M$2316 \$3275 C1|Y C1|Y VPB|VPWR sky130_fd_pr__pfet_01v8_hvt L=0.15 W=1
+ AS=0.1725 AD=0.26 PS=1.345 PD=2.52
M$2317 VPB|VPWR A|B|Y A3|Y VPB|VPWR sky130_fd_pr__pfet_01v8_hvt L=0.15 W=2
+ AS=0.395 AD=0.395 PS=3.79 PD=3.79
M$2318 A3|Y B|C|Y VPB|VPWR VPB|VPWR sky130_fd_pr__pfet_01v8_hvt L=0.15 W=1
+ AS=0.135 AD=0.26 PS=1.27 PD=2.52
M$2320 VPB|VPWR A|B|Y \$3274 VPB|VPWR sky130_fd_pr__pfet_01v8_hvt L=0.15 W=1
+ AS=0.26 AD=0.105 PS=2.52 PD=1.21
M$2321 \$3274 B|C|Y B1|Y VPB|VPWR sky130_fd_pr__pfet_01v8_hvt L=0.15 W=1
+ AS=0.105 AD=0.26 PS=1.21 PD=2.52
M$2322 VPB|VPWR \$3048 B|C|Y VPB|VPWR sky130_fd_pr__pfet_01v8_hvt L=0.15 W=1
+ AS=0.36 AD=0.165 PS=2.72 PD=1.33
M$2323 B|C|Y B|X \$3075 VPB|VPWR sky130_fd_pr__pfet_01v8_hvt L=0.15 W=1
+ AS=0.165 AD=0.105 PS=1.33 PD=1.21
M$2324 \$3075 A|X VPB|VPWR VPB|VPWR sky130_fd_pr__pfet_01v8_hvt L=0.15 W=1
+ AS=0.105 AD=0.365 PS=1.21 PD=1.73
M$2325 VPB|VPWR A|X \$3048 VPB|VPWR sky130_fd_pr__pfet_01v8_hvt L=0.15 W=1
+ AS=0.365 AD=0.135 PS=1.73 PD=1.27
M$2326 \$3048 B|X VPB|VPWR VPB|VPWR sky130_fd_pr__pfet_01v8_hvt L=0.15 W=1
+ AS=0.135 AD=0.3 PS=1.27 PD=2.6
M$2328 C1|Y B|Y VPB|VPWR VPB|VPWR sky130_fd_pr__pfet_01v8_hvt L=0.15 W=1
+ AS=0.135 AD=0.26 PS=1.27 PD=2.52
M$2347 B|C|X \$3050 VPB|VPWR VPB|VPWR sky130_fd_pr__pfet_01v8_hvt L=0.15 W=1
+ AS=0.28 AD=0.169 PS=2.56 PD=1.365
M$2348 VPB|VPWR A2|B|C|X \$3051 VPB|VPWR sky130_fd_pr__pfet_01v8_hvt L=0.15
+ W=0.64 AS=0.169 AD=0.1792 PS=1.365 PD=1.84
M$2349 \$3052 A2|B|C|X \$3050 VPB|VPWR sky130_fd_pr__pfet_01v8_hvt L=0.15
+ W=0.84 AS=0.273 AD=0.15295 PS=2.33 PD=1.315
M$2350 \$3050 \$3051 \$3053 VPB|VPWR sky130_fd_pr__pfet_01v8_hvt L=0.15 W=0.84
+ AS=0.15295 AD=0.32235 PS=1.315 PD=2.45
M$2351 VPB|VPWR A|B|X \$3054 VPB|VPWR sky130_fd_pr__pfet_01v8_hvt L=0.15 W=1
+ AS=0.25655 AD=0.26 PS=2.52 PD=2.52
M$2352 \$3119 A|B1_N|Y VPB|VPWR VPB|VPWR sky130_fd_pr__pfet_01v8_hvt L=0.15
+ W=0.42 AS=0.1092 AD=0.1573 PS=1.36 PD=1.39
M$2353 VPB|VPWR SLEEP|Y \$3261 VPB|VPWR sky130_fd_pr__pfet_01v8_hvt L=0.15 W=1
+ AS=0.1573 AD=0.105 PS=1.39 PD=1.21
M$2354 \$3261 \$3119 A|A1|X VPB|VPWR sky130_fd_pr__pfet_01v8_hvt L=0.15 W=1
+ AS=0.105 AD=0.26 PS=1.21 PD=2.52
M$2355 \$3052 A|B|X \$3057 VPB|VPWR sky130_fd_pr__pfet_01v8_hvt L=0.15 W=0.64
+ AS=0.1458 AD=0.246 PS=1.205 PD=1.525
M$2356 \$3052 \$3054 \$3055 VPB|VPWR sky130_fd_pr__pfet_01v8_hvt L=0.15 W=0.84
+ AS=0.1458 AD=0.1715 PS=1.205 PD=1.355
M$2357 \$3055 A|B|X \$3053 VPB|VPWR sky130_fd_pr__pfet_01v8_hvt L=0.15 W=0.84
+ AS=0.3528 AD=0.2431 PS=2.52 PD=1.445
M$2358 \$3053 \$3054 \$3057 VPB|VPWR sky130_fd_pr__pfet_01v8_hvt L=0.15 W=0.64
+ AS=0.2431 AD=0.246 PS=1.445 PD=1.525
M$2359 \$3055 A|A1|D|X VPB|VPWR VPB|VPWR sky130_fd_pr__pfet_01v8_hvt L=0.15 W=1
+ AS=0.1715 AD=0.135 PS=1.355 PD=1.27
M$2360 VPB|VPWR \$3055 \$3057 VPB|VPWR sky130_fd_pr__pfet_01v8_hvt L=0.15 W=1
+ AS=0.135 AD=0.285 PS=1.27 PD=2.57
M$2361 \$3250 A2|B|C|X VPB|VPWR VPB|VPWR sky130_fd_pr__pfet_01v8_hvt L=0.15 W=1
+ AS=0.265 AD=0.1475 PS=2.53 PD=1.295
M$2362 VPB|VPWR A|A1|D|X \$3250 VPB|VPWR sky130_fd_pr__pfet_01v8_hvt L=0.15 W=1
+ AS=0.1475 AD=0.14 PS=1.295 PD=1.28
M$2363 \$3250 B1|X SLEEP|Y VPB|VPWR sky130_fd_pr__pfet_01v8_hvt L=0.15 W=1
+ AS=0.14 AD=0.265 PS=1.28 PD=2.53
M$2364 A|X \$3122 VPB|VPWR VPB|VPWR sky130_fd_pr__pfet_01v8_hvt L=0.15 W=1
+ AS=0.355 AD=0.15575 PS=2.71 PD=1.325
M$2365 VPB|VPWR \$3123 \$3122 VPB|VPWR sky130_fd_pr__pfet_01v8_hvt L=0.5 W=0.82
+ AS=0.15575 AD=0.2173 PS=1.325 PD=2.17
M$2366 VPB|VPWR \$3059 \$3058 VPB|VPWR sky130_fd_pr__pfet_01v8_hvt L=0.5 W=0.82
+ AS=0.15575 AD=0.2173 PS=1.325 PD=2.17
M$2367 A|A1|D|X \$3058 VPB|VPWR VPB|VPWR sky130_fd_pr__pfet_01v8_hvt L=0.15 W=1
+ AS=0.355 AD=0.15575 PS=2.71 PD=1.325
M$2368 \$3059 \$3060 VPB|VPWR VPB|VPWR sky130_fd_pr__pfet_01v8_hvt L=0.5 W=0.82
+ AS=0.2173 AD=0.1701 PS=2.17 PD=1.36
M$2369 VPB|VPWR A|COARSE_MUX[3] \$3060 VPB|VPWR sky130_fd_pr__pfet_01v8_hvt
+ L=0.15 W=1 AS=0.1701 AD=0.27 PS=1.36 PD=2.54
M$2370 VPB|VPWR \$3124 \$3123 VPB|VPWR sky130_fd_pr__pfet_01v8_hvt L=0.5 W=0.82
+ AS=0.1701 AD=0.2173 PS=1.36 PD=2.17
M$2371 VPB|VPWR A|COARSE_MUX[1] \$3124 VPB|VPWR sky130_fd_pr__pfet_01v8_hvt
+ L=0.15 W=1 AS=0.1701 AD=0.27 PS=1.36 PD=2.54
M$2377 VPB|VPWR A1|Y \$3265 VPB|VPWR sky130_fd_pr__pfet_01v8_hvt L=0.15 W=0.64
+ AS=0.1792 AD=0.0864 PS=1.84 PD=0.91
M$2378 \$3265 A2|B|C|X \$3264 VPB|VPWR sky130_fd_pr__pfet_01v8_hvt L=0.15
+ W=0.64 AS=0.0864 AD=0.0864 PS=0.91 PD=0.91
M$2379 \$3264 A3|Y A|C_N|S|Y VPB|VPWR sky130_fd_pr__pfet_01v8_hvt L=0.15 W=0.64
+ AS=0.0864 AD=0.144 PS=0.91 PD=1.09
M$2380 A|C_N|S|Y A|B1|Y VPB|VPWR VPB|VPWR sky130_fd_pr__pfet_01v8_hvt L=0.15
+ W=0.64 AS=0.144 AD=0.1184 PS=1.09 PD=1.01
M$2381 VPB|VPWR A|B|B1|C1|X A|C_N|S|Y VPB|VPWR sky130_fd_pr__pfet_01v8_hvt
+ L=0.15 W=0.64 AS=0.1184 AD=0.1984 PS=1.01 PD=1.9
M$2383 \$3107 A|B1_N|X VPB|VPWR VPB|VPWR sky130_fd_pr__pfet_01v8_hvt L=0.15
+ W=0.42 AS=0.1113 AD=0.1113 PS=1.37 PD=1.37
M$2384 B|Y \$3107 \$3252 VPB|VPWR sky130_fd_pr__pfet_01v8_hvt L=0.15 W=0.64
+ AS=0.1696 AD=0.0896 PS=1.81 PD=0.92
M$2385 \$3252 A|A1|X VPB|VPWR VPB|VPWR sky130_fd_pr__pfet_01v8_hvt L=0.15
+ W=0.64 AS=0.0896 AD=0.0896 PS=0.92 PD=0.92
M$2386 VPB|VPWR A2|B|Y \$3252 VPB|VPWR sky130_fd_pr__pfet_01v8_hvt L=0.15
+ W=0.64 AS=0.0896 AD=0.1696 PS=0.92 PD=1.81
M$2414 VPB|VPWR B|X \$3277 VPB|VPWR sky130_fd_pr__pfet_01v8_hvt L=0.15 W=1
+ AS=0.3 AD=0.135 PS=2.6 PD=1.27
M$2415 \$3277 A|Y VPB|VPWR VPB|VPWR sky130_fd_pr__pfet_01v8_hvt L=0.15 W=1
+ AS=0.135 AD=0.365 PS=1.27 PD=1.73
M$2416 VPB|VPWR A|Y \$3319 VPB|VPWR sky130_fd_pr__pfet_01v8_hvt L=0.15 W=1
+ AS=0.365 AD=0.105 PS=1.73 PD=1.21
M$2417 \$3319 B|X A2|B|C|Y VPB|VPWR sky130_fd_pr__pfet_01v8_hvt L=0.15 W=1
+ AS=0.105 AD=0.165 PS=1.21 PD=1.33
M$2418 A2|B|C|Y \$3277 VPB|VPWR VPB|VPWR sky130_fd_pr__pfet_01v8_hvt L=0.15 W=1
+ AS=0.165 AD=0.36 PS=1.33 PD=2.72
M$2420 VPB|VPWR A|B1_N|Y \$3280 VPB|VPWR sky130_fd_pr__pfet_01v8_hvt L=0.15
+ W=0.42 AS=0.17825 AD=0.1092 PS=1.4 PD=1.36
M$2421 VPB|VPWR A1|Y \$3320 VPB|VPWR sky130_fd_pr__pfet_01v8_hvt L=0.15 W=1
+ AS=0.28 AD=0.1275 PS=2.56 PD=1.255
M$2422 \$3320 A2|C|X B|Y VPB|VPWR sky130_fd_pr__pfet_01v8_hvt L=0.15 W=1
+ AS=0.1275 AD=0.1525 PS=1.255 PD=1.305
M$2423 B|Y \$3280 VPB|VPWR VPB|VPWR sky130_fd_pr__pfet_01v8_hvt L=0.15 W=1
+ AS=0.1525 AD=0.17825 PS=1.305 PD=1.4
M$2425 A0|A1|X \$3282 VPB|VPWR VPB|VPWR sky130_fd_pr__pfet_01v8_hvt L=0.15 W=1
+ AS=0.28 AD=0.169 PS=2.56 PD=1.365
M$2426 VPB|VPWR B|C|X \$3283 VPB|VPWR sky130_fd_pr__pfet_01v8_hvt L=0.15 W=0.64
+ AS=0.169 AD=0.1792 PS=1.365 PD=1.84
M$2427 \$3284 B|C|X \$3282 VPB|VPWR sky130_fd_pr__pfet_01v8_hvt L=0.15 W=0.84
+ AS=0.273 AD=0.15295 PS=2.33 PD=1.315
M$2428 \$3282 \$3283 \$3285 VPB|VPWR sky130_fd_pr__pfet_01v8_hvt L=0.15 W=0.84
+ AS=0.15295 AD=0.32235 PS=1.315 PD=2.45
M$2429 VPB|VPWR A|B|Y \$3286 VPB|VPWR sky130_fd_pr__pfet_01v8_hvt L=0.15 W=1
+ AS=0.25655 AD=0.26 PS=2.52 PD=2.52
M$2430 \$3284 A|B|Y \$3288 VPB|VPWR sky130_fd_pr__pfet_01v8_hvt L=0.15 W=0.64
+ AS=0.1458 AD=0.246 PS=1.205 PD=1.525
M$2431 \$3284 \$3286 \$3287 VPB|VPWR sky130_fd_pr__pfet_01v8_hvt L=0.15 W=0.84
+ AS=0.1458 AD=0.1715 PS=1.205 PD=1.355
M$2432 \$3287 A|B|Y \$3285 VPB|VPWR sky130_fd_pr__pfet_01v8_hvt L=0.15 W=0.84
+ AS=0.3528 AD=0.2431 PS=2.52 PD=1.445
M$2433 \$3285 \$3286 \$3288 VPB|VPWR sky130_fd_pr__pfet_01v8_hvt L=0.15 W=0.64
+ AS=0.2431 AD=0.246 PS=1.445 PD=1.525
M$2434 \$3287 A|B1_N|Y VPB|VPWR VPB|VPWR sky130_fd_pr__pfet_01v8_hvt L=0.15 W=1
+ AS=0.1715 AD=0.135 PS=1.355 PD=1.27
M$2435 VPB|VPWR \$3287 \$3288 VPB|VPWR sky130_fd_pr__pfet_01v8_hvt L=0.15 W=1
+ AS=0.135 AD=0.285 PS=1.27 PD=2.57
M$2438 VPB|VPWR \$3290 A1|B|Y VPB|VPWR sky130_fd_pr__pfet_01v8_hvt L=0.15 W=1
+ AS=0.36 AD=0.165 PS=2.72 PD=1.33
M$2439 A1|B|Y A|A0|B|SLEEP|X \$3321 VPB|VPWR sky130_fd_pr__pfet_01v8_hvt L=0.15
+ W=1 AS=0.165 AD=0.105 PS=1.33 PD=1.21
M$2440 \$3321 A|A1|X VPB|VPWR VPB|VPWR sky130_fd_pr__pfet_01v8_hvt L=0.15 W=1
+ AS=0.105 AD=0.365 PS=1.21 PD=1.73
M$2441 VPB|VPWR A|A1|X \$3290 VPB|VPWR sky130_fd_pr__pfet_01v8_hvt L=0.15 W=1
+ AS=0.365 AD=0.135 PS=1.73 PD=1.27
M$2442 \$3290 A|A0|B|SLEEP|X VPB|VPWR VPB|VPWR sky130_fd_pr__pfet_01v8_hvt
+ L=0.15 W=1 AS=0.135 AD=0.3 PS=1.27 PD=2.6
M$2443 VPB|VPWR \$3292 B|Y VPB|VPWR sky130_fd_pr__pfet_01v8_hvt L=0.15 W=1
+ AS=0.36 AD=0.165 PS=2.72 PD=1.33
M$2444 B|Y B|Y \$3322 VPB|VPWR sky130_fd_pr__pfet_01v8_hvt L=0.15 W=1 AS=0.165
+ AD=0.105 PS=1.33 PD=1.21
M$2445 \$3322 A|B|B1|X VPB|VPWR VPB|VPWR sky130_fd_pr__pfet_01v8_hvt L=0.15 W=1
+ AS=0.105 AD=0.365 PS=1.21 PD=1.73
M$2446 VPB|VPWR A|B|B1|X \$3292 VPB|VPWR sky130_fd_pr__pfet_01v8_hvt L=0.15 W=1
+ AS=0.365 AD=0.135 PS=1.73 PD=1.27
M$2447 \$3292 B|Y VPB|VPWR VPB|VPWR sky130_fd_pr__pfet_01v8_hvt L=0.15 W=1
+ AS=0.135 AD=0.3 PS=1.27 PD=2.6
M$2448 VPB|VPWR A|B1_N|X \$3324 VPB|VPWR sky130_fd_pr__pfet_01v8_hvt L=0.15 W=1
+ AS=0.26 AD=0.105 PS=2.52 PD=1.21
M$2449 \$3324 A|B|B1|X A|Y VPB|VPWR sky130_fd_pr__pfet_01v8_hvt L=0.15 W=1
+ AS=0.105 AD=0.26 PS=1.21 PD=2.52
M$2453 B|X \$3297 \$3298 VPB|VPWR sky130_fd_pr__pfet_01v8_hvt L=0.15 W=1 AS=0.3
+ AD=0.26 PS=2.6 PD=2.52
M$2454 VPB|VPWR A2|B|X \$3298 VPB|VPWR sky130_fd_pr__pfet_01v8_hvt L=0.15 W=1
+ AS=0.26 AD=0.135 PS=2.52 PD=1.27
M$2455 \$3298 A|Y VPB|VPWR VPB|VPWR sky130_fd_pr__pfet_01v8_hvt L=0.15 W=1
+ AS=0.135 AD=0.135 PS=1.27 PD=1.27
M$2456 VPB|VPWR A|Y \$3329 VPB|VPWR sky130_fd_pr__pfet_01v8_hvt L=0.15 W=1
+ AS=0.135 AD=0.135 PS=1.27 PD=1.27
M$2457 \$3329 A2|B|X \$3297 VPB|VPWR sky130_fd_pr__pfet_01v8_hvt L=0.15 W=1
+ AS=0.135 AD=0.26 PS=1.27 PD=2.52
M$2459 \$3300 \$3336 \$3301 VPB|VPWR sky130_fd_pr__pfet_01v8_hvt L=0.15 W=0.84
+ AS=0.1715 AD=0.1458 PS=1.355 PD=1.205
M$2460 \$3301 A|B|Y \$3299 VPB|VPWR sky130_fd_pr__pfet_01v8_hvt L=0.15 W=0.64
+ AS=0.1458 AD=0.246 PS=1.205 PD=1.525
M$2461 \$3299 \$3300 VPB|VPWR VPB|VPWR sky130_fd_pr__pfet_01v8_hvt L=0.15 W=1
+ AS=0.285 AD=0.135 PS=2.57 PD=1.27
M$2462 VPB|VPWR A|Y \$3300 VPB|VPWR sky130_fd_pr__pfet_01v8_hvt L=0.15 W=1
+ AS=0.135 AD=0.1715 PS=1.27 PD=1.355
M$2463 \$3302 \$3336 \$3299 VPB|VPWR sky130_fd_pr__pfet_01v8_hvt L=0.15 W=0.64
+ AS=0.2431 AD=0.246 PS=1.445 PD=1.525
M$2464 \$3302 A|B|Y \$3300 VPB|VPWR sky130_fd_pr__pfet_01v8_hvt L=0.15 W=0.84
+ AS=0.2431 AD=0.3528 PS=1.445 PD=2.52
M$2465 \$3336 A|B|Y VPB|VPWR VPB|VPWR sky130_fd_pr__pfet_01v8_hvt L=0.15 W=1
+ AS=0.26 AD=0.25655 PS=2.52 PD=2.52
M$2466 \$3304 B|C|Y \$3301 VPB|VPWR sky130_fd_pr__pfet_01v8_hvt L=0.15 W=0.84
+ AS=0.15295 AD=0.273 PS=1.315 PD=2.33
M$2467 \$3304 \$3303 \$3302 VPB|VPWR sky130_fd_pr__pfet_01v8_hvt L=0.15 W=0.84
+ AS=0.15295 AD=0.32235 PS=1.315 PD=2.45
M$2468 VPB|VPWR B|C|Y \$3303 VPB|VPWR sky130_fd_pr__pfet_01v8_hvt L=0.15 W=0.64
+ AS=0.169 AD=0.1792 PS=1.365 PD=1.84
M$2469 VPB|VPWR \$3304 A|B|SLEEP|X VPB|VPWR sky130_fd_pr__pfet_01v8_hvt L=0.15
+ W=1 AS=0.169 AD=0.28 PS=1.365 PD=2.56
M$2489 VPB|VPWR \$3306 \$3307 VPB|VPWR sky130_fd_pr__pfet_01v8_hvt L=0.5 W=0.82
+ AS=0.1701 AD=0.2173 PS=1.36 PD=2.17
M$2490 \$3306 A|COARSE_MUX[4] VPB|VPWR VPB|VPWR sky130_fd_pr__pfet_01v8_hvt
+ L=0.15 W=1 AS=0.27 AD=0.1701 PS=2.54 PD=1.36
M$2491 \$3308 \$3307 VPB|VPWR VPB|VPWR sky130_fd_pr__pfet_01v8_hvt L=0.5 W=0.82
+ AS=0.2173 AD=0.15575 PS=2.17 PD=1.325
M$2492 VPB|VPWR \$3308 A|B|X VPB|VPWR sky130_fd_pr__pfet_01v8_hvt L=0.15 W=1
+ AS=0.15575 AD=0.355 PS=1.325 PD=2.71
M$2493 A2|B|C|X \$3310 VPB|VPWR VPB|VPWR sky130_fd_pr__pfet_01v8_hvt L=0.15 W=1
+ AS=0.28 AD=0.2115 PS=2.56 PD=1.45
M$2494 VPB|VPWR C|X \$3311 VPB|VPWR sky130_fd_pr__pfet_01v8_hvt L=0.15 W=0.64
+ AS=0.2115 AD=0.1792 PS=1.45 PD=1.84
M$2495 \$3312 C|X \$3310 VPB|VPWR sky130_fd_pr__pfet_01v8_hvt L=0.15 W=0.84
+ AS=0.2688 AD=0.1596 PS=2.32 PD=1.22
M$2496 \$3310 \$3311 \$3313 VPB|VPWR sky130_fd_pr__pfet_01v8_hvt L=0.15 W=0.84
+ AS=0.1596 AD=0.441 PS=1.22 PD=2.73
M$2497 VPB|VPWR B|X \$3314 VPB|VPWR sky130_fd_pr__pfet_01v8_hvt L=0.15 W=1
+ AS=0.26 AD=0.2526 PS=2.52 PD=2.52
M$2498 \$3313 B|X \$3316 VPB|VPWR sky130_fd_pr__pfet_01v8_hvt L=0.15 W=0.64
+ AS=0.1458 AD=0.246 PS=1.205 PD=1.525
M$2499 \$3313 \$3314 \$3315 VPB|VPWR sky130_fd_pr__pfet_01v8_hvt L=0.15 W=0.84
+ AS=0.1458 AD=0.1715 PS=1.205 PD=1.355
M$2500 \$3315 B|X \$3312 VPB|VPWR sky130_fd_pr__pfet_01v8_hvt L=0.15 W=0.84
+ AS=0.3536 AD=0.2452 PS=2.53 PD=1.45
M$2501 \$3312 \$3314 \$3316 VPB|VPWR sky130_fd_pr__pfet_01v8_hvt L=0.15 W=0.64
+ AS=0.2452 AD=0.246 PS=1.45 PD=1.525
M$2502 \$3315 A|X VPB|VPWR VPB|VPWR sky130_fd_pr__pfet_01v8_hvt L=0.15 W=1
+ AS=0.1715 AD=0.135 PS=1.355 PD=1.27
M$2503 VPB|VPWR \$3315 \$3316 VPB|VPWR sky130_fd_pr__pfet_01v8_hvt L=0.15 W=1
+ AS=0.135 AD=0.285 PS=1.27 PD=2.57
M$2505 VPB|VPWR A_N|B|C|X \$3350 VPB|VPWR sky130_fd_pr__pfet_01v8_hvt L=0.15
+ W=1 AS=0.3 AD=0.135 PS=2.6 PD=1.27
M$2506 \$3350 A|B|B1|C1|X VPB|VPWR VPB|VPWR sky130_fd_pr__pfet_01v8_hvt L=0.15
+ W=1 AS=0.135 AD=0.365 PS=1.27 PD=1.73
M$2507 VPB|VPWR A|B|B1|C1|X \$3507 VPB|VPWR sky130_fd_pr__pfet_01v8_hvt L=0.15
+ W=1 AS=0.365 AD=0.105 PS=1.73 PD=1.21
M$2508 \$3507 A_N|B|C|X A|B|Y VPB|VPWR sky130_fd_pr__pfet_01v8_hvt L=0.15 W=1
+ AS=0.105 AD=0.165 PS=1.21 PD=1.33
M$2509 A|B|Y \$3350 VPB|VPWR VPB|VPWR sky130_fd_pr__pfet_01v8_hvt L=0.15 W=1
+ AS=0.165 AD=0.36 PS=1.33 PD=2.72
M$2511 A2|Y A|B|Y VPB|VPWR VPB|VPWR sky130_fd_pr__pfet_01v8_hvt L=0.15 W=1
+ AS=0.26 AD=0.165 PS=2.52 PD=1.33
M$2512 VPB|VPWR B|X A2|Y VPB|VPWR sky130_fd_pr__pfet_01v8_hvt L=0.15 W=2 AS=0.3
+ AD=0.395 PS=2.6 PD=3.79
M$2513 A2|Y A2|C|X VPB|VPWR VPB|VPWR sky130_fd_pr__pfet_01v8_hvt L=0.15 W=1
+ AS=0.135 AD=0.26 PS=1.27 PD=2.52
M$2515 A1|X \$3356 \$3491 VPB|VPWR sky130_fd_pr__pfet_01v8_hvt L=0.15 W=1
+ AS=0.3 AD=0.26 PS=2.6 PD=2.52
M$2516 VPB|VPWR B|C|X \$3491 VPB|VPWR sky130_fd_pr__pfet_01v8_hvt L=0.15 W=1
+ AS=0.26 AD=0.135 PS=2.52 PD=1.27
M$2517 \$3491 A|B|Y VPB|VPWR VPB|VPWR sky130_fd_pr__pfet_01v8_hvt L=0.15 W=1
+ AS=0.135 AD=0.135 PS=1.27 PD=1.27
M$2518 VPB|VPWR A|B|Y \$3509 VPB|VPWR sky130_fd_pr__pfet_01v8_hvt L=0.15 W=1
+ AS=0.135 AD=0.135 PS=1.27 PD=1.27
M$2519 \$3509 B|C|X \$3356 VPB|VPWR sky130_fd_pr__pfet_01v8_hvt L=0.15 W=1
+ AS=0.135 AD=0.26 PS=1.27 PD=2.52
M$2522 VPB|VPWR A|C_N|S|Y \$3502 VPB|VPWR sky130_fd_pr__pfet_01v8_hvt L=0.15
+ W=0.42 AS=0.15835 AD=0.07665 PS=1.395 PD=0.785
M$2523 \$3502 A|A0|B|SLEEP|X \$3357 VPB|VPWR sky130_fd_pr__pfet_01v8_hvt L=0.15
+ W=0.42 AS=0.07665 AD=0.1932 PS=0.785 PD=1.34
M$2524 \$3357 A1|B|Y \$3503 VPB|VPWR sky130_fd_pr__pfet_01v8_hvt L=0.15 W=0.42
+ AS=0.1932 AD=0.0441 PS=1.34 PD=0.63
M$2525 \$3503 \$3358 VPB|VPWR VPB|VPWR sky130_fd_pr__pfet_01v8_hvt L=0.15
+ W=0.42 AS=0.0441 AD=0.0693 PS=0.63 PD=0.75
M$2526 VPB|VPWR A|C_N|S|Y \$3358 VPB|VPWR sky130_fd_pr__pfet_01v8_hvt L=0.15
+ W=0.42 AS=0.0693 AD=0.1176 PS=0.75 PD=1.4
M$2527 A2|X \$3357 VPB|VPWR VPB|VPWR sky130_fd_pr__pfet_01v8_hvt L=0.15 W=1
+ AS=0.26 AD=0.15835 PS=2.52 PD=1.395
M$2529 B|C|X \$3359 \$3494 VPB|VPWR sky130_fd_pr__pfet_01v8_hvt L=0.15 W=1
+ AS=0.3 AD=0.26 PS=2.6 PD=2.52
M$2530 VPB|VPWR B|X \$3494 VPB|VPWR sky130_fd_pr__pfet_01v8_hvt L=0.15 W=1
+ AS=0.26 AD=0.135 PS=2.52 PD=1.27
M$2531 \$3494 A|Y VPB|VPWR VPB|VPWR sky130_fd_pr__pfet_01v8_hvt L=0.15 W=1
+ AS=0.135 AD=0.135 PS=1.27 PD=1.27
M$2532 VPB|VPWR A|Y \$3508 VPB|VPWR sky130_fd_pr__pfet_01v8_hvt L=0.15 W=1
+ AS=0.135 AD=0.135 PS=1.27 PD=1.27
M$2533 \$3508 B|X \$3359 VPB|VPWR sky130_fd_pr__pfet_01v8_hvt L=0.15 W=1
+ AS=0.135 AD=0.26 PS=1.27 PD=2.52
M$2534 VPB|VPWR B|X B|Y VPB|VPWR sky130_fd_pr__pfet_01v8_hvt L=0.15 W=1 AS=0.26
+ AD=0.135 PS=2.52 PD=1.27
M$2536 VPB|VPWR B|C|X \$3363 VPB|VPWR sky130_fd_pr__pfet_01v8_hvt L=0.15 W=0.64
+ AS=0.169 AD=0.1792 PS=1.365 PD=1.84
M$2537 B|X \$3362 VPB|VPWR VPB|VPWR sky130_fd_pr__pfet_01v8_hvt L=0.15 W=1
+ AS=0.28 AD=0.169 PS=2.56 PD=1.365
M$2538 \$3362 \$3363 \$3364 VPB|VPWR sky130_fd_pr__pfet_01v8_hvt L=0.15 W=0.84
+ AS=0.15295 AD=0.32235 PS=1.315 PD=2.45
M$2539 \$3362 B|C|X \$3365 VPB|VPWR sky130_fd_pr__pfet_01v8_hvt L=0.15 W=0.84
+ AS=0.15295 AD=0.273 PS=1.315 PD=2.33
M$2540 VPB|VPWR B|Y \$3366 VPB|VPWR sky130_fd_pr__pfet_01v8_hvt L=0.15 W=1
+ AS=0.25655 AD=0.26 PS=2.52 PD=2.52
M$2541 \$3364 \$3366 \$3368 VPB|VPWR sky130_fd_pr__pfet_01v8_hvt L=0.15 W=0.64
+ AS=0.2431 AD=0.246 PS=1.445 PD=1.525
M$2542 \$3368 B|Y \$3365 VPB|VPWR sky130_fd_pr__pfet_01v8_hvt L=0.15 W=0.64
+ AS=0.246 AD=0.1458 PS=1.525 PD=1.205
M$2543 \$3367 B|Y \$3364 VPB|VPWR sky130_fd_pr__pfet_01v8_hvt L=0.15 W=0.84
+ AS=0.3528 AD=0.2431 PS=2.52 PD=1.445
M$2544 \$3367 \$3366 \$3365 VPB|VPWR sky130_fd_pr__pfet_01v8_hvt L=0.15 W=0.84
+ AS=0.1715 AD=0.1458 PS=1.355 PD=1.205
M$2545 \$3367 A|X VPB|VPWR VPB|VPWR sky130_fd_pr__pfet_01v8_hvt L=0.15 W=1
+ AS=0.1715 AD=0.135 PS=1.355 PD=1.27
M$2546 VPB|VPWR \$3367 \$3368 VPB|VPWR sky130_fd_pr__pfet_01v8_hvt L=0.15 W=1
+ AS=0.135 AD=0.285 PS=1.27 PD=2.57
M$2547 \$3294 B|C|X \$3325 VPB|VPWR sky130_fd_pr__pfet_01v8_hvt L=0.15 W=0.42
+ AS=0.1092 AD=0.0441 PS=1.36 PD=0.63
M$2548 \$3325 A|X VPB|VPWR VPB|VPWR sky130_fd_pr__pfet_01v8_hvt L=0.15 W=0.42
+ AS=0.0441 AD=0.0567 PS=0.63 PD=0.69
M$2549 VPB|VPWR A|X \$3326 VPB|VPWR sky130_fd_pr__pfet_01v8_hvt L=0.15 W=0.42
+ AS=0.0567 AD=0.0441 PS=0.69 PD=0.63
M$2550 \$3326 B|Y \$3294 VPB|VPWR sky130_fd_pr__pfet_01v8_hvt L=0.15 W=0.42
+ AS=0.0441 AD=0.0567 PS=0.63 PD=0.69
M$2551 \$3294 B|Y \$3327 VPB|VPWR sky130_fd_pr__pfet_01v8_hvt L=0.15 W=0.42
+ AS=0.0567 AD=0.0441 PS=0.69 PD=0.63
M$2552 VPB|VPWR B|C|X \$3327 VPB|VPWR sky130_fd_pr__pfet_01v8_hvt L=0.15 W=0.42
+ AS=0.2492 AD=0.0441 PS=1.565 PD=0.63
M$2553 VPB|VPWR \$3294 A|X VPB|VPWR sky130_fd_pr__pfet_01v8_hvt L=0.15 W=1
+ AS=0.2492 AD=0.365 PS=1.565 PD=2.73
M$2576 VPB|VPWR A|A1|D|X A|B1_N|Y VPB|VPWR sky130_fd_pr__pfet_01v8_hvt L=0.15
+ W=1 AS=0.26 AD=0.135 PS=2.52 PD=1.27
M$2577 A|B1_N|Y C|X VPB|VPWR VPB|VPWR sky130_fd_pr__pfet_01v8_hvt L=0.15 W=1
+ AS=0.135 AD=0.135 PS=1.27 PD=1.27
M$2578 VPB|VPWR B|X A|B1_N|Y VPB|VPWR sky130_fd_pr__pfet_01v8_hvt L=0.15 W=1
+ AS=0.135 AD=0.165 PS=1.27 PD=1.33
M$2579 A|B1_N|Y A|X VPB|VPWR VPB|VPWR sky130_fd_pr__pfet_01v8_hvt L=0.15 W=1
+ AS=0.165 AD=0.3 PS=1.33 PD=2.6
M$2580 VPB|VPWR C|X \$3499 VPB|VPWR sky130_fd_pr__pfet_01v8_hvt L=0.15 W=0.42
+ AS=0.2492 AD=0.0441 PS=1.565 PD=0.63
M$2581 \$3499 B|X \$3371 VPB|VPWR sky130_fd_pr__pfet_01v8_hvt L=0.15 W=0.42
+ AS=0.0441 AD=0.0567 PS=0.63 PD=0.69
M$2582 \$3371 B|X \$3498 VPB|VPWR sky130_fd_pr__pfet_01v8_hvt L=0.15 W=0.42
+ AS=0.0567 AD=0.0441 PS=0.69 PD=0.63
M$2583 \$3498 A|X VPB|VPWR VPB|VPWR sky130_fd_pr__pfet_01v8_hvt L=0.15 W=0.42
+ AS=0.0441 AD=0.0567 PS=0.63 PD=0.69
M$2584 VPB|VPWR A|X \$3497 VPB|VPWR sky130_fd_pr__pfet_01v8_hvt L=0.15 W=0.42
+ AS=0.0567 AD=0.0441 PS=0.69 PD=0.63
M$2585 \$3497 C|X \$3371 VPB|VPWR sky130_fd_pr__pfet_01v8_hvt L=0.15 W=0.42
+ AS=0.0441 AD=0.1092 PS=0.63 PD=1.36
M$2586 B1|X \$3371 VPB|VPWR VPB|VPWR sky130_fd_pr__pfet_01v8_hvt L=0.15 W=1
+ AS=0.365 AD=0.2492 PS=2.73 PD=1.565
M$2588 \$3561 A|FINE_MUX[3] VPB|VPWR VPB|VPWR sky130_fd_pr__pfet_01v8_hvt
+ L=0.15 W=1 AS=0.27 AD=0.1701 PS=2.54 PD=1.36
M$2589 VPB|VPWR \$3561 \$3562 VPB|VPWR sky130_fd_pr__pfet_01v8_hvt L=0.5 W=0.82
+ AS=0.1701 AD=0.2173 PS=1.36 PD=2.17
M$2590 A|B|X \$3511 VPB|VPWR VPB|VPWR sky130_fd_pr__pfet_01v8_hvt L=0.15 W=1
+ AS=0.28 AD=0.169 PS=2.56 PD=1.365
M$2591 VPB|VPWR A_N|B|C|X \$3512 VPB|VPWR sky130_fd_pr__pfet_01v8_hvt L=0.15
+ W=0.64 AS=0.169 AD=0.1792 PS=1.365 PD=1.84
M$2592 \$3513 A_N|B|C|X \$3511 VPB|VPWR sky130_fd_pr__pfet_01v8_hvt L=0.15
+ W=0.84 AS=0.273 AD=0.15295 PS=2.33 PD=1.315
M$2593 \$3511 \$3512 \$3514 VPB|VPWR sky130_fd_pr__pfet_01v8_hvt L=0.15 W=0.84
+ AS=0.15295 AD=0.32235 PS=1.315 PD=2.45
M$2594 VPB|VPWR \$3562 \$3563 VPB|VPWR sky130_fd_pr__pfet_01v8_hvt L=0.5 W=0.82
+ AS=0.15575 AD=0.2173 PS=1.325 PD=2.17
M$2595 VPB|VPWR \$3563 A|B|B1|C1|X VPB|VPWR sky130_fd_pr__pfet_01v8_hvt L=0.15
+ W=1 AS=0.15575 AD=0.355 PS=1.325 PD=2.71
M$2596 VPB|VPWR A|B|B1|X \$3515 VPB|VPWR sky130_fd_pr__pfet_01v8_hvt L=0.15 W=1
+ AS=0.25655 AD=0.26 PS=2.52 PD=2.52
M$2597 \$3513 A|B|B1|X \$3517 VPB|VPWR sky130_fd_pr__pfet_01v8_hvt L=0.15
+ W=0.64 AS=0.1458 AD=0.246 PS=1.205 PD=1.525
M$2598 \$3513 \$3515 \$3516 VPB|VPWR sky130_fd_pr__pfet_01v8_hvt L=0.15 W=0.84
+ AS=0.1458 AD=0.1715 PS=1.205 PD=1.355
M$2599 \$3516 A|B|B1|X \$3514 VPB|VPWR sky130_fd_pr__pfet_01v8_hvt L=0.15
+ W=0.84 AS=0.3528 AD=0.2431 PS=2.52 PD=1.445
M$2600 \$3514 \$3515 \$3517 VPB|VPWR sky130_fd_pr__pfet_01v8_hvt L=0.15 W=0.64
+ AS=0.2431 AD=0.246 PS=1.445 PD=1.525
M$2601 \$3516 A|B|B1|C1|X VPB|VPWR VPB|VPWR sky130_fd_pr__pfet_01v8_hvt L=0.15
+ W=1 AS=0.1715 AD=0.135 PS=1.355 PD=1.27
M$2602 VPB|VPWR \$3516 \$3517 VPB|VPWR sky130_fd_pr__pfet_01v8_hvt L=0.15 W=1
+ AS=0.135 AD=0.285 PS=1.27 PD=2.57
M$2603 VPB|VPWR A|B|B1|X \$3353 VPB|VPWR sky130_fd_pr__pfet_01v8_hvt L=0.15
+ W=0.42 AS=0.1113 AD=0.0609 PS=1.37 PD=0.71
M$2604 VPB|VPWR A|B|Y \$3353 VPB|VPWR sky130_fd_pr__pfet_01v8_hvt L=0.15 W=0.42
+ AS=0.1841 AD=0.0609 PS=1.26 PD=0.71
M$2605 VPB|VPWR \$3353 A|A1|X VPB|VPWR sky130_fd_pr__pfet_01v8_hvt L=0.15
+ W=0.64 AS=0.1841 AD=0.1696 PS=1.26 PD=1.81
M$2606 VPB|VPWR A|A1|X A|B1|Y VPB|VPWR sky130_fd_pr__pfet_01v8_hvt L=0.15 W=1
+ AS=0.26 AD=0.135 PS=2.52 PD=1.27
M$2607 A|B1|Y B|X VPB|VPWR VPB|VPWR sky130_fd_pr__pfet_01v8_hvt L=0.15 W=1
+ AS=0.135 AD=0.26 PS=1.27 PD=2.52
M$2609 VPB|VPWR A|B|B1|X A|C|Y VPB|VPWR sky130_fd_pr__pfet_01v8_hvt L=0.15
+ W=0.64 AS=0.1824 AD=0.0896 PS=1.85 PD=0.92
M$2610 A|C|Y A2|Y \$3537 VPB|VPWR sky130_fd_pr__pfet_01v8_hvt L=0.15 W=0.64
+ AS=0.0896 AD=0.0768 PS=0.92 PD=0.88
M$2611 \$3537 A0|A1|X VPB|VPWR VPB|VPWR sky130_fd_pr__pfet_01v8_hvt L=0.15
+ W=0.64 AS=0.0768 AD=0.1696 PS=0.88 PD=1.81
M$2612 VPB|VPWR A|B1|Y \$3691 VPB|VPWR sky130_fd_pr__pfet_01v8_hvt L=0.15 W=1
+ AS=0.26 AD=0.105 PS=2.52 PD=1.21
M$2613 \$3691 B|Y S|Y VPB|VPWR sky130_fd_pr__pfet_01v8_hvt L=0.15 W=1 AS=0.105
+ AD=0.26 PS=1.21 PD=2.52
M$2615 \$3684 A0|A1|X A|B|SLEEP|Y VPB|VPWR sky130_fd_pr__pfet_01v8_hvt L=0.15
+ W=1 AS=0.28 AD=0.1525 PS=2.56 PD=1.305
M$2616 A|B|SLEEP|Y A1|X \$3692 VPB|VPWR sky130_fd_pr__pfet_01v8_hvt L=0.15 W=1
+ AS=0.1525 AD=0.1975 PS=1.305 PD=1.395
M$2617 \$3692 \$3570 VPB|VPWR VPB|VPWR sky130_fd_pr__pfet_01v8_hvt L=0.15 W=1
+ AS=0.1975 AD=0.3 PS=1.395 PD=1.6
M$2618 VPB|VPWR S|Y \$3684 VPB|VPWR sky130_fd_pr__pfet_01v8_hvt L=0.15 W=1
+ AS=0.3 AD=0.26 PS=1.6 PD=2.52
M$2619 \$3570 S|Y VPB|VPWR VPB|VPWR sky130_fd_pr__pfet_01v8_hvt L=0.15 W=1
+ AS=0.29 AD=0.26 PS=2.58 PD=2.52
M$2621 VPB|VPWR A|C|Y \$3572 VPB|VPWR sky130_fd_pr__pfet_01v8_hvt L=0.15 W=0.64
+ AS=0.169 AD=0.1792 PS=1.365 PD=1.84
M$2622 A|X \$3571 VPB|VPWR VPB|VPWR sky130_fd_pr__pfet_01v8_hvt L=0.15 W=1
+ AS=0.28 AD=0.169 PS=2.56 PD=1.365
M$2623 \$3571 \$3572 \$3573 VPB|VPWR sky130_fd_pr__pfet_01v8_hvt L=0.15 W=0.84
+ AS=0.15295 AD=0.32235 PS=1.315 PD=2.45
M$2624 \$3571 A|C|Y \$3574 VPB|VPWR sky130_fd_pr__pfet_01v8_hvt L=0.15 W=0.84
+ AS=0.15295 AD=0.273 PS=1.315 PD=2.33
M$2625 VPB|VPWR B|B_N|Y \$3575 VPB|VPWR sky130_fd_pr__pfet_01v8_hvt L=0.15 W=1
+ AS=0.25655 AD=0.26 PS=2.52 PD=2.52
M$2626 B|Y \$3521 \$3538 VPB|VPWR sky130_fd_pr__pfet_01v8_hvt L=0.15 W=1
+ AS=0.26 AD=0.105 PS=2.52 PD=1.21
M$2627 \$3538 A|B1|Y VPB|VPWR VPB|VPWR sky130_fd_pr__pfet_01v8_hvt L=0.15 W=1
+ AS=0.105 AD=0.1573 PS=1.21 PD=1.39
M$2628 VPB|VPWR B|B_N|Y \$3521 VPB|VPWR sky130_fd_pr__pfet_01v8_hvt L=0.15
+ W=0.42 AS=0.1573 AD=0.1092 PS=1.39 PD=1.36
M$2629 \$3573 \$3575 \$3577 VPB|VPWR sky130_fd_pr__pfet_01v8_hvt L=0.15 W=0.64
+ AS=0.2431 AD=0.246 PS=1.445 PD=1.525
M$2630 \$3577 B|B_N|Y \$3574 VPB|VPWR sky130_fd_pr__pfet_01v8_hvt L=0.15 W=0.64
+ AS=0.246 AD=0.1458 PS=1.525 PD=1.205
M$2631 \$3576 B|B_N|Y \$3573 VPB|VPWR sky130_fd_pr__pfet_01v8_hvt L=0.15 W=0.84
+ AS=0.3528 AD=0.2431 PS=2.52 PD=1.445
M$2632 \$3576 \$3575 \$3574 VPB|VPWR sky130_fd_pr__pfet_01v8_hvt L=0.15 W=0.84
+ AS=0.1715 AD=0.1458 PS=1.355 PD=1.205
M$2633 \$3576 A|B1|Y VPB|VPWR VPB|VPWR sky130_fd_pr__pfet_01v8_hvt L=0.15 W=1
+ AS=0.1715 AD=0.135 PS=1.355 PD=1.27
M$2634 VPB|VPWR \$3576 \$3577 VPB|VPWR sky130_fd_pr__pfet_01v8_hvt L=0.15 W=1
+ AS=0.135 AD=0.285 PS=1.27 PD=2.57
M$2635 VPB|VPWR A|C_N|S|Y \$3522 VPB|VPWR sky130_fd_pr__pfet_01v8_hvt L=0.15
+ W=0.42 AS=0.14575 AD=0.1092 PS=1.335 PD=1.36
M$2636 VPB|VPWR A|C|Y \$3539 VPB|VPWR sky130_fd_pr__pfet_01v8_hvt L=0.15 W=1
+ AS=0.14575 AD=0.135 PS=1.335 PD=1.27
M$2637 \$3539 B|Y \$3540 VPB|VPWR sky130_fd_pr__pfet_01v8_hvt L=0.15 W=1
+ AS=0.135 AD=0.135 PS=1.27 PD=1.27
M$2638 \$3540 \$3522 A|A1|Y VPB|VPWR sky130_fd_pr__pfet_01v8_hvt L=0.15 W=1
+ AS=0.135 AD=0.32 PS=1.27 PD=2.64
M$2640 VPB|VPWR A|A1|Y A|B1|Y VPB|VPWR sky130_fd_pr__pfet_01v8_hvt L=0.15 W=1
+ AS=0.26 AD=0.135 PS=2.52 PD=1.27
M$2641 A|B1|Y A1|B|Y VPB|VPWR VPB|VPWR sky130_fd_pr__pfet_01v8_hvt L=0.15 W=2
+ AS=0.28075 AD=0.395 PS=2.605 PD=3.79
M$2645 A|B|X \$3525 \$3526 VPB|VPWR sky130_fd_pr__pfet_01v8_hvt L=0.15 W=1
+ AS=0.3 AD=0.26 PS=2.6 PD=2.52
M$2646 VPB|VPWR B|C|X \$3526 VPB|VPWR sky130_fd_pr__pfet_01v8_hvt L=0.15 W=1
+ AS=0.26 AD=0.135 PS=2.52 PD=1.27
M$2647 \$3526 A|X VPB|VPWR VPB|VPWR sky130_fd_pr__pfet_01v8_hvt L=0.15 W=1
+ AS=0.135 AD=0.135 PS=1.27 PD=1.27
M$2648 VPB|VPWR A|X \$3542 VPB|VPWR sky130_fd_pr__pfet_01v8_hvt L=0.15 W=1
+ AS=0.135 AD=0.135 PS=1.27 PD=1.27
M$2649 \$3542 B|C|X \$3525 VPB|VPWR sky130_fd_pr__pfet_01v8_hvt L=0.15 W=1
+ AS=0.135 AD=0.26 PS=1.27 PD=2.52
M$2651 VPB|VPWR A|X \$3543 VPB|VPWR sky130_fd_pr__pfet_01v8_hvt L=0.15 W=1
+ AS=0.26 AD=0.105 PS=2.52 PD=1.21
M$2652 \$3543 B|X B1|Y VPB|VPWR sky130_fd_pr__pfet_01v8_hvt L=0.15 W=1 AS=0.105
+ AD=0.26 PS=1.21 PD=2.52
M$2653 B|X \$3529 \$3530 VPB|VPWR sky130_fd_pr__pfet_01v8_hvt L=0.15 W=1 AS=0.3
+ AD=0.26 PS=2.6 PD=2.52
M$2654 A|A_N|B|Y B1|Y \$3686 VPB|VPWR sky130_fd_pr__pfet_01v8_hvt L=0.15 W=1
+ AS=0.265 AD=0.14 PS=2.53 PD=1.28
M$2655 \$3686 A|A1|A2|B|C|X VPB|VPWR VPB|VPWR sky130_fd_pr__pfet_01v8_hvt
+ L=0.15 W=1 AS=0.14 AD=0.1475 PS=1.28 PD=1.295
M$2656 VPB|VPWR A2|Y \$3686 VPB|VPWR sky130_fd_pr__pfet_01v8_hvt L=0.15 W=1
+ AS=0.1475 AD=0.265 PS=1.295 PD=2.53
M$2657 VPB|VPWR B|X \$3530 VPB|VPWR sky130_fd_pr__pfet_01v8_hvt L=0.15 W=1
+ AS=0.26 AD=0.135 PS=2.52 PD=1.27
M$2658 \$3530 A|X VPB|VPWR VPB|VPWR sky130_fd_pr__pfet_01v8_hvt L=0.15 W=1
+ AS=0.135 AD=0.135 PS=1.27 PD=1.27
M$2659 VPB|VPWR A|X \$3545 VPB|VPWR sky130_fd_pr__pfet_01v8_hvt L=0.15 W=1
+ AS=0.135 AD=0.135 PS=1.27 PD=1.27
M$2660 \$3545 B|X \$3529 VPB|VPWR sky130_fd_pr__pfet_01v8_hvt L=0.15 W=1
+ AS=0.135 AD=0.26 PS=1.27 PD=2.52
M$2661 VPB|VPWR A|X A2|Y VPB|VPWR sky130_fd_pr__pfet_01v8_hvt L=0.15 W=1
+ AS=0.26 AD=0.135 PS=2.52 PD=1.27
M$2684 VPB|VPWR \$3532 \$3531 VPB|VPWR sky130_fd_pr__pfet_01v8_hvt L=0.5 W=0.82
+ AS=0.15575 AD=0.2173 PS=1.325 PD=2.17
M$2685 B|X \$3531 VPB|VPWR VPB|VPWR sky130_fd_pr__pfet_01v8_hvt L=0.15 W=1
+ AS=0.355 AD=0.15575 PS=2.71 PD=1.325
M$2686 C|X \$3580 VPB|VPWR VPB|VPWR sky130_fd_pr__pfet_01v8_hvt L=0.15 W=1
+ AS=0.355 AD=0.15575 PS=2.71 PD=1.325
M$2687 VPB|VPWR \$3581 \$3580 VPB|VPWR sky130_fd_pr__pfet_01v8_hvt L=0.5 W=0.82
+ AS=0.15575 AD=0.2173 PS=1.325 PD=2.17
M$2688 \$3532 \$3533 VPB|VPWR VPB|VPWR sky130_fd_pr__pfet_01v8_hvt L=0.5 W=0.82
+ AS=0.2173 AD=0.1701 PS=2.17 PD=1.36
M$2689 VPB|VPWR A|COARSE_MUX[0] \$3533 VPB|VPWR sky130_fd_pr__pfet_01v8_hvt
+ L=0.15 W=1 AS=0.1701 AD=0.27 PS=1.36 PD=2.54
M$2690 VPB|VPWR \$3582 \$3581 VPB|VPWR sky130_fd_pr__pfet_01v8_hvt L=0.5 W=0.82
+ AS=0.1701 AD=0.2173 PS=1.36 PD=2.17
M$2691 VPB|VPWR A|COARSE_MUX[2] \$3582 VPB|VPWR sky130_fd_pr__pfet_01v8_hvt
+ L=0.15 W=1 AS=0.1701 AD=0.27 PS=1.36 PD=2.54
M$2723 VPB|VPWR \$3697 \$3698 VPB|VPWR sky130_fd_pr__pfet_01v8_hvt L=0.5 W=0.82
+ AS=0.1701 AD=0.2173 PS=1.36 PD=2.17
M$2724 \$3697 A|FINE_MUX[4] VPB|VPWR VPB|VPWR sky130_fd_pr__pfet_01v8_hvt
+ L=0.15 W=1 AS=0.27 AD=0.1701 PS=2.54 PD=1.36
M$2725 \$3699 \$3698 VPB|VPWR VPB|VPWR sky130_fd_pr__pfet_01v8_hvt L=0.5 W=0.82
+ AS=0.2173 AD=0.15575 PS=2.17 PD=1.325
M$2726 VPB|VPWR \$3699 A|B|B1|X VPB|VPWR sky130_fd_pr__pfet_01v8_hvt L=0.15 W=1
+ AS=0.15575 AD=0.355 PS=1.325 PD=2.71
M$2728 VPB|VPWR A|B1|Y B1|SLEEP|Y VPB|VPWR sky130_fd_pr__pfet_01v8_hvt L=0.15
+ W=0.64 AS=0.1824 AD=0.0896 PS=1.85 PD=0.92
M$2729 B1|SLEEP|Y A2|B|C|Y \$3689 VPB|VPWR sky130_fd_pr__pfet_01v8_hvt L=0.15
+ W=0.64 AS=0.0896 AD=0.0768 PS=0.92 PD=0.88
M$2730 \$3689 A|A1|X VPB|VPWR VPB|VPWR sky130_fd_pr__pfet_01v8_hvt L=0.15
+ W=0.64 AS=0.0768 AD=0.1696 PS=0.88 PD=1.81
M$2731 VPB|VPWR A|B|X B|Y VPB|VPWR sky130_fd_pr__pfet_01v8_hvt L=0.15 W=4.68
+ AS=0.8786 AD=0.9868 PS=8.41 PD=9.62
M$2732 B|Y A2|B|C|Y VPB|VPWR VPB|VPWR sky130_fd_pr__pfet_01v8_hvt L=0.15 W=1
+ AS=0.135 AD=0.26 PS=1.27 PD=2.52
M$2735 VPB|VPWR B|Y \$3701 VPB|VPWR sky130_fd_pr__pfet_01v8_hvt L=0.15 W=1
+ AS=0.3 AD=0.135 PS=2.6 PD=1.27
M$2736 \$3701 A|B1|Y VPB|VPWR VPB|VPWR sky130_fd_pr__pfet_01v8_hvt L=0.15 W=1
+ AS=0.135 AD=0.365 PS=1.27 PD=1.73
M$2737 VPB|VPWR A|B1|Y \$3720 VPB|VPWR sky130_fd_pr__pfet_01v8_hvt L=0.15 W=1
+ AS=0.365 AD=0.105 PS=1.73 PD=1.21
M$2738 \$3720 B|Y A|A2|B|Y VPB|VPWR sky130_fd_pr__pfet_01v8_hvt L=0.15 W=1
+ AS=0.105 AD=0.165 PS=1.21 PD=1.33
M$2739 A|A2|B|Y \$3701 VPB|VPWR VPB|VPWR sky130_fd_pr__pfet_01v8_hvt L=0.15 W=1
+ AS=0.165 AD=0.36 PS=1.33 PD=2.72
M$2742 VPB|VPWR A|A1|Y \$3721 VPB|VPWR sky130_fd_pr__pfet_01v8_hvt L=0.15
+ W=0.64 AS=0.1696 AD=0.0768 PS=1.81 PD=0.88
M$2743 \$3721 A2|X A|C|Y VPB|VPWR sky130_fd_pr__pfet_01v8_hvt L=0.15 W=0.64
+ AS=0.0768 AD=0.0896 PS=0.88 PD=0.92
M$2744 A|C|Y A|B1|Y VPB|VPWR VPB|VPWR sky130_fd_pr__pfet_01v8_hvt L=0.15 W=0.64
+ AS=0.0896 AD=0.1824 PS=0.92 PD=1.85
M$2745 VPB|VPWR A|A1|Y \$3722 VPB|VPWR sky130_fd_pr__pfet_01v8_hvt L=0.15 W=1
+ AS=0.265 AD=0.105 PS=2.53 PD=1.21
M$2746 \$3722 A2|X A|Y VPB|VPWR sky130_fd_pr__pfet_01v8_hvt L=0.15 W=1 AS=0.105
+ AD=0.195 PS=1.21 PD=1.39
M$2747 A|Y A|B1|Y VPB|VPWR VPB|VPWR sky130_fd_pr__pfet_01v8_hvt L=0.15 W=2.68
+ AS=0.5436 AD=0.5268 PS=4.74 PD=4.7
M$2748 VPB|VPWR B|C1|Y A|Y VPB|VPWR sky130_fd_pr__pfet_01v8_hvt L=0.15 W=1
+ AS=0.195 AD=0.635 PS=1.39 PD=3.27
M$2750 B|X \$3707 \$3708 VPB|VPWR sky130_fd_pr__pfet_01v8_hvt L=0.15 W=1 AS=0.3
+ AD=0.26 PS=2.6 PD=2.52
M$2751 VPB|VPWR B|Y \$3708 VPB|VPWR sky130_fd_pr__pfet_01v8_hvt L=0.15 W=1
+ AS=0.26 AD=0.135 PS=2.52 PD=1.27
M$2752 \$3708 A|B1|Y VPB|VPWR VPB|VPWR sky130_fd_pr__pfet_01v8_hvt L=0.15 W=1
+ AS=0.135 AD=0.135 PS=1.27 PD=1.27
M$2753 VPB|VPWR A|B1|Y \$3723 VPB|VPWR sky130_fd_pr__pfet_01v8_hvt L=0.15 W=1
+ AS=0.135 AD=0.135 PS=1.27 PD=1.27
M$2754 \$3723 B|Y \$3707 VPB|VPWR sky130_fd_pr__pfet_01v8_hvt L=0.15 W=1
+ AS=0.135 AD=0.26 PS=1.27 PD=2.52
M$2755 VPB|VPWR A|B1|Y \$3725 VPB|VPWR sky130_fd_pr__pfet_01v8_hvt L=0.15 W=1
+ AS=0.26 AD=0.105 PS=2.52 PD=1.21
M$2756 \$3725 B|Y A|Y VPB|VPWR sky130_fd_pr__pfet_01v8_hvt L=0.15 W=1 AS=0.105
+ AD=0.26 PS=1.21 PD=2.52
M$2758 VPB|VPWR A|Y \$3710 VPB|VPWR sky130_fd_pr__pfet_01v8_hvt L=0.15 W=0.42
+ AS=0.1113 AD=0.0609 PS=1.37 PD=0.71
M$2759 \$3710 B|C|X VPB|VPWR VPB|VPWR sky130_fd_pr__pfet_01v8_hvt L=0.15 W=0.42
+ AS=0.0609 AD=0.1841 PS=0.71 PD=1.26
M$2760 VPB|VPWR \$3710 A|X VPB|VPWR sky130_fd_pr__pfet_01v8_hvt L=0.15 W=0.64
+ AS=0.1841 AD=0.1696 PS=1.26 PD=1.81
M$2762 A|A1|B|Y B|C|X \$3727 VPB|VPWR sky130_fd_pr__pfet_01v8_hvt L=0.15 W=1
+ AS=0.26 AD=0.135 PS=2.52 PD=1.27
M$2763 \$3727 B|X \$3726 VPB|VPWR sky130_fd_pr__pfet_01v8_hvt L=0.15 W=1
+ AS=0.135 AD=0.135 PS=1.27 PD=1.27
M$2764 \$3726 A|X VPB|VPWR VPB|VPWR sky130_fd_pr__pfet_01v8_hvt L=0.15 W=1
+ AS=0.135 AD=0.26 PS=1.27 PD=2.52
M$2765 VPB|VPWR A|X \$3713 VPB|VPWR sky130_fd_pr__pfet_01v8_hvt L=0.15 W=0.42
+ AS=0.1113 AD=0.0609 PS=1.37 PD=0.71
M$2766 \$3713 A|B|X VPB|VPWR VPB|VPWR sky130_fd_pr__pfet_01v8_hvt L=0.15 W=0.42
+ AS=0.0609 AD=0.1841 PS=0.71 PD=1.26
M$2767 VPB|VPWR \$3713 A|A1|A2|B|C|X VPB|VPWR sky130_fd_pr__pfet_01v8_hvt
+ L=0.15 W=0.64 AS=0.1841 AD=0.1696 PS=1.26 PD=1.81
M$2769 VPB|VPWR B|X \$3714 VPB|VPWR sky130_fd_pr__pfet_01v8_hvt L=0.15 W=1
+ AS=0.3 AD=0.135 PS=2.6 PD=1.27
M$2770 \$3714 A|A1|A2|B|C|X VPB|VPWR VPB|VPWR sky130_fd_pr__pfet_01v8_hvt
+ L=0.15 W=1 AS=0.135 AD=0.365 PS=1.27 PD=1.73
M$2771 VPB|VPWR A|A1|A2|B|C|X \$3729 VPB|VPWR sky130_fd_pr__pfet_01v8_hvt
+ L=0.15 W=1 AS=0.365 AD=0.105 PS=1.73 PD=1.21
M$2772 \$3729 B|X B|C|Y VPB|VPWR sky130_fd_pr__pfet_01v8_hvt L=0.15 W=1
+ AS=0.105 AD=0.165 PS=1.21 PD=1.33
M$2773 B|C|Y \$3714 VPB|VPWR VPB|VPWR sky130_fd_pr__pfet_01v8_hvt L=0.15 W=1
+ AS=0.165 AD=0.36 PS=1.33 PD=2.72
M$2775 VPB|VPWR A|A_N|B|Y \$3716 VPB|VPWR sky130_fd_pr__pfet_01v8_hvt L=0.15
+ W=1 AS=0.3 AD=0.135 PS=2.6 PD=1.27
M$2776 \$3716 A|B|SLEEP|X VPB|VPWR VPB|VPWR sky130_fd_pr__pfet_01v8_hvt L=0.15
+ W=1 AS=0.135 AD=0.365 PS=1.27 PD=1.73
M$2777 VPB|VPWR A|B|SLEEP|X \$3730 VPB|VPWR sky130_fd_pr__pfet_01v8_hvt L=0.15
+ W=1 AS=0.365 AD=0.105 PS=1.73 PD=1.21
M$2778 \$3730 A|A_N|B|Y A|Y VPB|VPWR sky130_fd_pr__pfet_01v8_hvt L=0.15 W=1
+ AS=0.105 AD=0.165 PS=1.21 PD=1.33
M$2779 A|Y \$3716 VPB|VPWR VPB|VPWR sky130_fd_pr__pfet_01v8_hvt L=0.15 W=1
+ AS=0.165 AD=0.36 PS=1.33 PD=2.72
M$2803 VPB|VPWR \$3918 \$3919 VPB|VPWR sky130_fd_pr__pfet_01v8_hvt L=0.5 W=0.82
+ AS=0.1701 AD=0.2173 PS=1.36 PD=2.17
M$2804 \$3918 A|FINE_MUX[5] VPB|VPWR VPB|VPWR sky130_fd_pr__pfet_01v8_hvt
+ L=0.15 W=1 AS=0.27 AD=0.1701 PS=2.54 PD=1.36
M$2805 \$3920 \$3919 VPB|VPWR VPB|VPWR sky130_fd_pr__pfet_01v8_hvt L=0.5 W=0.82
+ AS=0.2173 AD=0.15575 PS=2.17 PD=1.325
M$2806 VPB|VPWR \$3920 A|X VPB|VPWR sky130_fd_pr__pfet_01v8_hvt L=0.15 W=1
+ AS=0.15575 AD=0.355 PS=1.325 PD=2.71
M$2807 VPB|VPWR A|B|X C1|Y VPB|VPWR sky130_fd_pr__pfet_01v8_hvt L=0.15 W=1
+ AS=0.26 AD=0.135 PS=2.52 PD=1.27
M$2808 C1|Y A|X VPB|VPWR VPB|VPWR sky130_fd_pr__pfet_01v8_hvt L=0.15 W=2 AS=0.3
+ AD=0.56 PS=2.6 PD=5.12
M$2809 VPB|VPWR \$3922 A|A2|B|Y VPB|VPWR sky130_fd_pr__pfet_01v8_hvt L=0.15 W=1
+ AS=0.36 AD=0.165 PS=2.72 PD=1.33
M$2810 A|A2|B|Y A|B|X \$3939 VPB|VPWR sky130_fd_pr__pfet_01v8_hvt L=0.15 W=1
+ AS=0.165 AD=0.105 PS=1.33 PD=1.21
M$2811 \$3939 A|X VPB|VPWR VPB|VPWR sky130_fd_pr__pfet_01v8_hvt L=0.15 W=1
+ AS=0.105 AD=0.365 PS=1.21 PD=1.73
M$2812 VPB|VPWR A|X \$3922 VPB|VPWR sky130_fd_pr__pfet_01v8_hvt L=0.15 W=1
+ AS=0.365 AD=0.135 PS=1.73 PD=1.27
M$2813 \$3922 A|B|X VPB|VPWR VPB|VPWR sky130_fd_pr__pfet_01v8_hvt L=0.15 W=1
+ AS=0.135 AD=0.3 PS=1.27 PD=2.6
M$2814 A|C|Y A|X VPB|VPWR VPB|VPWR sky130_fd_pr__pfet_01v8_hvt L=0.15 W=1
+ AS=0.26 AD=0.165 PS=2.52 PD=1.33
M$2815 VPB|VPWR A|B|X A|C|Y VPB|VPWR sky130_fd_pr__pfet_01v8_hvt L=0.15 W=2
+ AS=0.3 AD=0.395 PS=2.6 PD=3.79
M$2816 A|C|Y A2|B|C|Y VPB|VPWR VPB|VPWR sky130_fd_pr__pfet_01v8_hvt L=0.15 W=1
+ AS=0.135 AD=0.26 PS=1.27 PD=2.52
M$2820 B|Y B|Y \$3914 VPB|VPWR sky130_fd_pr__pfet_01v8_hvt L=0.15 W=1 AS=0.26
+ AD=0.105 PS=2.52 PD=1.21
M$2821 \$3914 A|A2|B|Y VPB|VPWR VPB|VPWR sky130_fd_pr__pfet_01v8_hvt L=0.15 W=1
+ AS=0.105 AD=0.26 PS=1.21 PD=2.52
M$2822 VPB|VPWR A|C|Y \$3916 VPB|VPWR sky130_fd_pr__pfet_01v8_hvt L=0.15 W=1
+ AS=0.26 AD=0.105 PS=2.52 PD=1.21
M$2823 \$3916 B|Y A|Y VPB|VPWR sky130_fd_pr__pfet_01v8_hvt L=0.15 W=1 AS=0.105
+ AD=0.26 PS=1.21 PD=2.52
M$2824 VPB|VPWR A|B|SLEEP|Y \$3923 VPB|VPWR sky130_fd_pr__pfet_01v8_hvt L=0.15
+ W=1 AS=0.3 AD=0.135 PS=2.6 PD=1.27
M$2825 \$3923 A|Y VPB|VPWR VPB|VPWR sky130_fd_pr__pfet_01v8_hvt L=0.15 W=1
+ AS=0.135 AD=0.365 PS=1.27 PD=1.73
M$2826 VPB|VPWR A|Y \$3940 VPB|VPWR sky130_fd_pr__pfet_01v8_hvt L=0.15 W=1
+ AS=0.365 AD=0.105 PS=1.73 PD=1.21
M$2827 \$3940 A|B|SLEEP|Y A2|A3|Y VPB|VPWR sky130_fd_pr__pfet_01v8_hvt L=0.15
+ W=1 AS=0.105 AD=0.165 PS=1.21 PD=1.33
M$2828 A2|A3|Y \$3923 VPB|VPWR VPB|VPWR sky130_fd_pr__pfet_01v8_hvt L=0.15 W=1
+ AS=0.165 AD=0.36 PS=1.33 PD=2.72
M$2830 B|Y A|B|SLEEP|Y VPB|VPWR VPB|VPWR sky130_fd_pr__pfet_01v8_hvt L=0.15 W=1
+ AS=0.135 AD=0.26 PS=1.27 PD=2.52
M$2835 VPB|VPWR A|X \$3924 VPB|VPWR sky130_fd_pr__pfet_01v8_hvt L=0.15 W=0.42
+ AS=0.1113 AD=0.0609 PS=1.37 PD=0.71
M$2836 \$3924 B|Y VPB|VPWR VPB|VPWR sky130_fd_pr__pfet_01v8_hvt L=0.15 W=0.42
+ AS=0.0609 AD=0.1841 PS=0.71 PD=1.26
M$2837 VPB|VPWR \$3924 B|X VPB|VPWR sky130_fd_pr__pfet_01v8_hvt L=0.15 W=0.64
+ AS=0.1841 AD=0.1696 PS=1.26 PD=1.81
M$2839 VPB|VPWR A|X \$3941 VPB|VPWR sky130_fd_pr__pfet_01v8_hvt L=0.15 W=1
+ AS=0.26 AD=0.105 PS=2.52 PD=1.21
M$2840 \$3941 B|Y A|Y VPB|VPWR sky130_fd_pr__pfet_01v8_hvt L=0.15 W=1 AS=0.105
+ AD=0.26 PS=1.21 PD=2.52
M$2842 \$3761 A|C|Y \$3906 VPB|VPWR sky130_fd_pr__pfet_01v8_hvt L=0.15 W=0.42
+ AS=0.1092 AD=0.0441 PS=1.36 PD=0.63
M$2843 \$3906 B|Y \$3907 VPB|VPWR sky130_fd_pr__pfet_01v8_hvt L=0.15 W=0.42
+ AS=0.0441 AD=0.0693 PS=0.63 PD=0.75
M$2844 \$3907 A|X VPB|VPWR VPB|VPWR sky130_fd_pr__pfet_01v8_hvt L=0.15 W=0.42
+ AS=0.0693 AD=0.14825 PS=0.75 PD=1.34
M$2845 VPB|VPWR \$3761 A|X VPB|VPWR sky130_fd_pr__pfet_01v8_hvt L=0.15 W=1
+ AS=0.14825 AD=0.28 PS=1.34 PD=2.56
M$2848 VPB|VPWR A|X \$3915 VPB|VPWR sky130_fd_pr__pfet_01v8_hvt L=0.15 W=1
+ AS=0.26 AD=0.105 PS=2.52 PD=1.21
M$2849 \$3915 B|Y A|B1|Y VPB|VPWR sky130_fd_pr__pfet_01v8_hvt L=0.15 W=1
+ AS=0.105 AD=0.26 PS=1.21 PD=2.52
M$2850 VPB|VPWR B|X \$3764 VPB|VPWR sky130_fd_pr__pfet_01v8_hvt L=0.15 W=1
+ AS=0.3 AD=0.135 PS=2.6 PD=1.27
M$2851 \$3764 A|X VPB|VPWR VPB|VPWR sky130_fd_pr__pfet_01v8_hvt L=0.15 W=1
+ AS=0.135 AD=0.365 PS=1.27 PD=1.73
M$2852 VPB|VPWR A|X \$3913 VPB|VPWR sky130_fd_pr__pfet_01v8_hvt L=0.15 W=1
+ AS=0.365 AD=0.105 PS=1.73 PD=1.21
M$2853 \$3913 B|X A2|B|C|Y VPB|VPWR sky130_fd_pr__pfet_01v8_hvt L=0.15 W=1
+ AS=0.105 AD=0.165 PS=1.21 PD=1.33
M$2854 A2|B|C|Y \$3764 VPB|VPWR VPB|VPWR sky130_fd_pr__pfet_01v8_hvt L=0.15 W=1
+ AS=0.165 AD=0.36 PS=1.33 PD=2.72
M$2855 VPB|VPWR A|Y A|A1|Y VPB|VPWR sky130_fd_pr__pfet_01v8_hvt L=0.15 W=3.36
+ AS=0.6804 AD=0.6804 PS=6.66 PD=6.66
M$2857 \$3927 A2|B|C|Y VPB|VPWR VPB|VPWR sky130_fd_pr__pfet_01v8_hvt L=0.15 W=1
+ AS=0.265 AD=0.1475 PS=2.53 PD=1.295
M$2858 VPB|VPWR A|A1|Y \$3927 VPB|VPWR sky130_fd_pr__pfet_01v8_hvt L=0.15 W=1
+ AS=0.1475 AD=0.14 PS=1.295 PD=1.28
M$2859 \$3927 A|B1|Y B|Y VPB|VPWR sky130_fd_pr__pfet_01v8_hvt L=0.15 W=1
+ AS=0.14 AD=0.265 PS=1.28 PD=2.53
M$2860 A|X \$3767 \$3900 VPB|VPWR sky130_fd_pr__pfet_01v8_hvt L=0.15 W=1 AS=0.3
+ AD=0.26 PS=2.6 PD=2.52
M$2861 VPB|VPWR B|C|X \$3900 VPB|VPWR sky130_fd_pr__pfet_01v8_hvt L=0.15 W=1
+ AS=0.26 AD=0.135 PS=2.52 PD=1.27
M$2862 \$3900 A|Y VPB|VPWR VPB|VPWR sky130_fd_pr__pfet_01v8_hvt L=0.15 W=1
+ AS=0.135 AD=0.135 PS=1.27 PD=1.27
M$2863 VPB|VPWR A|Y \$3912 VPB|VPWR sky130_fd_pr__pfet_01v8_hvt L=0.15 W=1
+ AS=0.135 AD=0.135 PS=1.27 PD=1.27
M$2864 \$3912 B|C|X \$3767 VPB|VPWR sky130_fd_pr__pfet_01v8_hvt L=0.15 W=1
+ AS=0.135 AD=0.26 PS=1.27 PD=2.52
M$2865 A|B|B1|Y A|A1|Y VPB|VPWR VPB|VPWR sky130_fd_pr__pfet_01v8_hvt L=0.15 W=1
+ AS=0.26 AD=0.165 PS=2.52 PD=1.33
M$2866 VPB|VPWR A2|B|C|Y A|B|B1|Y VPB|VPWR sky130_fd_pr__pfet_01v8_hvt L=0.15
+ W=1 AS=0.165 AD=0.135 PS=1.33 PD=1.27
M$2867 A|B|B1|Y B|C|X VPB|VPWR VPB|VPWR sky130_fd_pr__pfet_01v8_hvt L=0.15 W=1
+ AS=0.135 AD=0.26 PS=1.27 PD=2.52
M$2869 VPB|VPWR A|B1|Y \$3768 VPB|VPWR sky130_fd_pr__pfet_01v8_hvt L=0.15
+ W=0.42 AS=0.1113 AD=0.0609 PS=1.37 PD=0.71
M$2870 VPB|VPWR B|C|X \$3768 VPB|VPWR sky130_fd_pr__pfet_01v8_hvt L=0.15 W=0.42
+ AS=0.1841 AD=0.0609 PS=1.26 PD=0.71
M$2871 VPB|VPWR \$3768 B|C|X VPB|VPWR sky130_fd_pr__pfet_01v8_hvt L=0.15 W=0.64
+ AS=0.1841 AD=0.1696 PS=1.26 PD=1.81
M$2873 VPB|VPWR A|B|X \$3769 VPB|VPWR sky130_fd_pr__pfet_01v8_hvt L=0.15 W=0.42
+ AS=0.1113 AD=0.0609 PS=1.37 PD=0.71
M$2874 VPB|VPWR B|C|X \$3769 VPB|VPWR sky130_fd_pr__pfet_01v8_hvt L=0.15 W=0.42
+ AS=0.1841 AD=0.0609 PS=1.26 PD=0.71
M$2875 VPB|VPWR \$3769 A|A3|C|D|X VPB|VPWR sky130_fd_pr__pfet_01v8_hvt L=0.15
+ W=0.64 AS=0.1841 AD=0.1696 PS=1.26 PD=1.81
M$2878 VPB|VPWR A|A3|C|D|X A|Y VPB|VPWR sky130_fd_pr__pfet_01v8_hvt L=0.15
+ W=1.68 AS=0.3318 AD=0.3486 PS=3.31 PD=3.35
M$2882 \$3771 A|A_N|B|Y VPB|VPWR VPB|VPWR sky130_fd_pr__pfet_01v8_hvt L=0.15
+ W=0.42 AS=0.1092 AD=0.14575 PS=1.36 PD=1.335
M$2883 VPB|VPWR A|B|SLEEP|X D1|Y VPB|VPWR sky130_fd_pr__pfet_01v8_hvt L=0.15
+ W=1 AS=0.14575 AD=0.135 PS=1.335 PD=1.27
M$2884 D1|Y \$3771 VPB|VPWR VPB|VPWR sky130_fd_pr__pfet_01v8_hvt L=0.15 W=1
+ AS=0.135 AD=0.265 PS=1.27 PD=2.53
M$2886 VPB|VPWR D1|Y D|Y VPB|VPWR sky130_fd_pr__pfet_01v8_hvt L=0.15 W=1
+ AS=0.265 AD=0.14 PS=2.53 PD=1.28
M$2887 D|Y C1|Y VPB|VPWR VPB|VPWR sky130_fd_pr__pfet_01v8_hvt L=0.15 W=1
+ AS=0.14 AD=0.195 PS=1.28 PD=1.39
M$2888 VPB|VPWR B1|Y D|Y VPB|VPWR sky130_fd_pr__pfet_01v8_hvt L=0.15 W=1
+ AS=0.195 AD=0.2025 PS=1.39 PD=1.405
M$2889 D|Y A2|B|X \$3911 VPB|VPWR sky130_fd_pr__pfet_01v8_hvt L=0.15 W=1
+ AS=0.2025 AD=0.195 PS=1.405 PD=1.39
M$2890 \$3911 A1|X VPB|VPWR VPB|VPWR sky130_fd_pr__pfet_01v8_hvt L=0.15 W=1
+ AS=0.195 AD=0.265 PS=1.39 PD=2.53
M$2891 VPB|VPWR \$3936 B|Y VPB|VPWR sky130_fd_pr__pfet_01v8_hvt L=0.15 W=1
+ AS=0.36 AD=0.165 PS=2.72 PD=1.33
M$2892 B|Y A2|B|X \$3950 VPB|VPWR sky130_fd_pr__pfet_01v8_hvt L=0.15 W=1
+ AS=0.165 AD=0.105 PS=1.33 PD=1.21
M$2893 \$3950 A|Y VPB|VPWR VPB|VPWR sky130_fd_pr__pfet_01v8_hvt L=0.15 W=1
+ AS=0.105 AD=0.365 PS=1.21 PD=1.73
M$2894 VPB|VPWR A|Y \$3936 VPB|VPWR sky130_fd_pr__pfet_01v8_hvt L=0.15 W=1
+ AS=0.365 AD=0.135 PS=1.73 PD=1.27
M$2895 \$3936 A2|B|X VPB|VPWR VPB|VPWR sky130_fd_pr__pfet_01v8_hvt L=0.15 W=1
+ AS=0.135 AD=0.3 PS=1.27 PD=2.6
M$2896 \$3777 A|A_N|B|Y VPB|VPWR VPB|VPWR sky130_fd_pr__pfet_01v8_hvt L=0.15
+ W=0.42 AS=0.1092 AD=0.1573 PS=1.36 PD=1.39
M$2897 VPB|VPWR A|B|SLEEP|X \$3910 VPB|VPWR sky130_fd_pr__pfet_01v8_hvt L=0.15
+ W=1 AS=0.1573 AD=0.105 PS=1.39 PD=1.21
M$2898 \$3910 \$3777 A1|X VPB|VPWR sky130_fd_pr__pfet_01v8_hvt L=0.15 W=1
+ AS=0.105 AD=0.26 PS=1.21 PD=2.52
M$2943 VPB|VPWR A1|Y \$4120 VPB|VPWR sky130_fd_pr__pfet_01v8_hvt L=0.15 W=1
+ AS=0.265 AD=0.105 PS=2.53 PD=1.21
M$2944 \$4120 A|A2|B|Y B|Y VPB|VPWR sky130_fd_pr__pfet_01v8_hvt L=0.15 W=1
+ AS=0.105 AD=0.195 PS=1.21 PD=1.39
M$2945 B|Y B1|SLEEP|Y VPB|VPWR VPB|VPWR sky130_fd_pr__pfet_01v8_hvt L=0.15 W=1
+ AS=0.195 AD=0.195 PS=1.39 PD=1.39
M$2946 VPB|VPWR C1|Y B|Y VPB|VPWR sky130_fd_pr__pfet_01v8_hvt L=0.15 W=1
+ AS=0.195 AD=0.635 PS=1.39 PD=3.27
M$2947 \$3977 A|A2|B|Y \$4116 VPB|VPWR sky130_fd_pr__pfet_01v8_hvt L=0.15
+ W=0.42 AS=0.1092 AD=0.0441 PS=1.36 PD=0.63
M$2948 \$4116 B1|SLEEP|Y VPB|VPWR VPB|VPWR sky130_fd_pr__pfet_01v8_hvt L=0.15
+ W=0.42 AS=0.0441 AD=0.14575 PS=0.63 PD=1.335
M$2949 VPB|VPWR \$3977 A|A1|X VPB|VPWR sky130_fd_pr__pfet_01v8_hvt L=0.15 W=1
+ AS=0.14575 AD=0.34 PS=1.335 PD=2.68
M$2951 B|B_N|C|X \$3980 \$4112 VPB|VPWR sky130_fd_pr__pfet_01v8_hvt L=0.15 W=1
+ AS=0.3 AD=0.26 PS=2.6 PD=2.52
M$2952 VPB|VPWR A|A2|B|Y \$4112 VPB|VPWR sky130_fd_pr__pfet_01v8_hvt L=0.15 W=1
+ AS=0.26 AD=0.135 PS=2.52 PD=1.27
M$2953 \$4112 A|C|Y VPB|VPWR VPB|VPWR sky130_fd_pr__pfet_01v8_hvt L=0.15 W=1
+ AS=0.135 AD=0.135 PS=1.27 PD=1.27
M$2954 VPB|VPWR A|C|Y \$4125 VPB|VPWR sky130_fd_pr__pfet_01v8_hvt L=0.15 W=1
+ AS=0.135 AD=0.135 PS=1.27 PD=1.27
M$2955 \$4125 A|A2|B|Y \$3980 VPB|VPWR sky130_fd_pr__pfet_01v8_hvt L=0.15 W=1
+ AS=0.135 AD=0.26 PS=1.27 PD=2.52
M$2956 VPB|VPWR A|A1|X \$4126 VPB|VPWR sky130_fd_pr__pfet_01v8_hvt L=0.15 W=1
+ AS=0.26 AD=0.135 PS=2.52 PD=1.27
M$2957 \$4126 A|A2|B|Y \$4127 VPB|VPWR sky130_fd_pr__pfet_01v8_hvt L=0.15 W=1
+ AS=0.135 AD=0.135 PS=1.27 PD=1.27
M$2958 \$4127 A2|A3|Y C|Y VPB|VPWR sky130_fd_pr__pfet_01v8_hvt L=0.15 W=1
+ AS=0.135 AD=0.3925 PS=1.27 PD=1.785
M$2959 C|Y A|B1|X VPB|VPWR VPB|VPWR sky130_fd_pr__pfet_01v8_hvt L=0.15 W=2
+ AS=0.5275 AD=0.56 PS=3.055 PD=5.12
M$2961 VPB|VPWR C|Y \$3984 VPB|VPWR sky130_fd_pr__pfet_01v8_hvt L=0.15 W=0.64
+ AS=0.169 AD=0.1792 PS=1.365 PD=1.84
M$2962 B|C|X \$3983 VPB|VPWR VPB|VPWR sky130_fd_pr__pfet_01v8_hvt L=0.15 W=1
+ AS=0.28 AD=0.169 PS=2.56 PD=1.365
M$2963 \$3983 \$3984 \$3985 VPB|VPWR sky130_fd_pr__pfet_01v8_hvt L=0.15 W=0.84
+ AS=0.15295 AD=0.32235 PS=1.315 PD=2.45
M$2964 \$3983 C|Y \$4114 VPB|VPWR sky130_fd_pr__pfet_01v8_hvt L=0.15 W=0.84
+ AS=0.15295 AD=0.273 PS=1.315 PD=2.33
M$2965 VPB|VPWR B|Y \$3986 VPB|VPWR sky130_fd_pr__pfet_01v8_hvt L=0.15 W=1
+ AS=0.25655 AD=0.26 PS=2.52 PD=2.52
M$2966 \$3985 \$3986 \$3988 VPB|VPWR sky130_fd_pr__pfet_01v8_hvt L=0.15 W=0.64
+ AS=0.2431 AD=0.246 PS=1.445 PD=1.525
M$2967 \$3988 B|Y \$4114 VPB|VPWR sky130_fd_pr__pfet_01v8_hvt L=0.15 W=0.64
+ AS=0.246 AD=0.1458 PS=1.525 PD=1.205
M$2968 \$3987 B|Y \$3985 VPB|VPWR sky130_fd_pr__pfet_01v8_hvt L=0.15 W=0.84
+ AS=0.3528 AD=0.2431 PS=2.52 PD=1.445
M$2969 \$3987 \$3986 \$4114 VPB|VPWR sky130_fd_pr__pfet_01v8_hvt L=0.15 W=0.84
+ AS=0.1715 AD=0.1458 PS=1.355 PD=1.205
M$2970 \$3987 A|X VPB|VPWR VPB|VPWR sky130_fd_pr__pfet_01v8_hvt L=0.15 W=1
+ AS=0.1715 AD=0.135 PS=1.355 PD=1.27
M$2971 VPB|VPWR \$3987 \$3988 VPB|VPWR sky130_fd_pr__pfet_01v8_hvt L=0.15 W=1
+ AS=0.135 AD=0.285 PS=1.27 PD=2.57
M$2972 VPB|VPWR A|Y \$4134 VPB|VPWR sky130_fd_pr__pfet_01v8_hvt L=0.15 W=1
+ AS=0.26 AD=0.105 PS=2.52 PD=1.21
M$2973 \$4134 B|C1|Y B|Y VPB|VPWR sky130_fd_pr__pfet_01v8_hvt L=0.15 W=1
+ AS=0.105 AD=0.26 PS=1.21 PD=2.52
M$2976 VPB|VPWR B|Y \$3991 VPB|VPWR sky130_fd_pr__pfet_01v8_hvt L=0.15 W=1
+ AS=0.3 AD=0.135 PS=2.6 PD=1.27
M$2977 \$3991 A|X VPB|VPWR VPB|VPWR sky130_fd_pr__pfet_01v8_hvt L=0.15 W=1
+ AS=0.135 AD=0.365 PS=1.27 PD=1.73
M$2978 VPB|VPWR A|X \$4133 VPB|VPWR sky130_fd_pr__pfet_01v8_hvt L=0.15 W=1
+ AS=0.365 AD=0.105 PS=1.73 PD=1.21
M$2979 \$4133 B|Y B|C|Y VPB|VPWR sky130_fd_pr__pfet_01v8_hvt L=0.15 W=1
+ AS=0.105 AD=0.165 PS=1.21 PD=1.33
M$2980 B|C|Y \$3991 VPB|VPWR VPB|VPWR sky130_fd_pr__pfet_01v8_hvt L=0.15 W=1
+ AS=0.165 AD=0.36 PS=1.33 PD=2.72
M$2983 VPB|VPWR A|A1|B|Y \$4132 VPB|VPWR sky130_fd_pr__pfet_01v8_hvt L=0.15 W=1
+ AS=0.26 AD=0.135 PS=2.52 PD=1.27
M$2984 \$4132 A|A1|A2|B|C|X \$4131 VPB|VPWR sky130_fd_pr__pfet_01v8_hvt L=0.15
+ W=1 AS=0.135 AD=0.135 PS=1.27 PD=1.27
M$2985 \$4131 A|A3|C|D|X C|Y VPB|VPWR sky130_fd_pr__pfet_01v8_hvt L=0.15 W=1
+ AS=0.135 AD=0.26 PS=1.27 PD=2.52
M$2986 VPB|VPWR A|B|B1|Y \$3994 VPB|VPWR sky130_fd_pr__pfet_01v8_hvt L=0.15 W=1
+ AS=0.345 AD=0.2125 PS=2.69 PD=1.425
M$2987 \$3994 A|A3|C|D|X \$4128 VPB|VPWR sky130_fd_pr__pfet_01v8_hvt L=0.15 W=1
+ AS=0.2125 AD=0.165 PS=1.425 PD=1.33
M$2988 \$4128 A|A1|A2|B|C|X \$4129 VPB|VPWR sky130_fd_pr__pfet_01v8_hvt L=0.15
+ W=1 AS=0.165 AD=0.135 PS=1.33 PD=1.27
M$2989 \$4129 A|A1|B|Y VPB|VPWR VPB|VPWR sky130_fd_pr__pfet_01v8_hvt L=0.15 W=1
+ AS=0.135 AD=0.195 PS=1.27 PD=1.39
M$2990 VPB|VPWR \$3994 A2|C|X VPB|VPWR sky130_fd_pr__pfet_01v8_hvt L=0.15 W=1
+ AS=0.195 AD=0.36 PS=1.39 PD=2.72
M$2991 \$3930 A|A3|C|D|X \$3944 VPB|VPWR sky130_fd_pr__pfet_01v8_hvt L=0.15
+ W=0.42 AS=0.1092 AD=0.0693 PS=1.36 PD=0.75
M$2992 \$3944 A|A1|A2|B|C|X \$3945 VPB|VPWR sky130_fd_pr__pfet_01v8_hvt L=0.15
+ W=0.42 AS=0.0693 AD=0.0441 PS=0.75 PD=0.63
M$2993 \$3945 A|A1|B|Y \$3946 VPB|VPWR sky130_fd_pr__pfet_01v8_hvt L=0.15
+ W=0.42 AS=0.0441 AD=0.0693 PS=0.63 PD=0.75
M$2994 VPB|VPWR A|B|B1|Y \$3946 VPB|VPWR sky130_fd_pr__pfet_01v8_hvt L=0.15
+ W=0.42 AS=0.14825 AD=0.0693 PS=1.34 PD=0.75
M$2995 VPB|VPWR \$3930 B|B1|D_N|X VPB|VPWR sky130_fd_pr__pfet_01v8_hvt L=0.15
+ W=1 AS=0.14825 AD=0.27 PS=1.34 PD=2.54
M$2997 VPB|VPWR \$3998 A|B|Y VPB|VPWR sky130_fd_pr__pfet_01v8_hvt L=0.15 W=1
+ AS=0.36 AD=0.165 PS=2.72 PD=1.33
M$2998 A|B|Y B|C|Y \$4124 VPB|VPWR sky130_fd_pr__pfet_01v8_hvt L=0.15 W=1
+ AS=0.165 AD=0.105 PS=1.33 PD=1.21
M$2999 \$4124 A|Y VPB|VPWR VPB|VPWR sky130_fd_pr__pfet_01v8_hvt L=0.15 W=1
+ AS=0.105 AD=0.365 PS=1.21 PD=1.73
M$3000 VPB|VPWR A|Y \$3998 VPB|VPWR sky130_fd_pr__pfet_01v8_hvt L=0.15 W=1
+ AS=0.365 AD=0.135 PS=1.73 PD=1.27
M$3001 \$3998 B|C|Y VPB|VPWR VPB|VPWR sky130_fd_pr__pfet_01v8_hvt L=0.15 W=1
+ AS=0.135 AD=0.3 PS=1.27 PD=2.6
M$3002 \$3933 B|C|Y \$3947 VPB|VPWR sky130_fd_pr__pfet_01v8_hvt L=0.15 W=0.42
+ AS=0.1092 AD=0.0441 PS=1.36 PD=0.63
M$3003 \$3947 A|Y VPB|VPWR VPB|VPWR sky130_fd_pr__pfet_01v8_hvt L=0.15 W=0.42
+ AS=0.0441 AD=0.0567 PS=0.63 PD=0.69
M$3004 VPB|VPWR A|Y \$3948 VPB|VPWR sky130_fd_pr__pfet_01v8_hvt L=0.15 W=0.42
+ AS=0.0567 AD=0.0441 PS=0.69 PD=0.63
M$3005 \$3948 B|B1|D_N|X \$3933 VPB|VPWR sky130_fd_pr__pfet_01v8_hvt L=0.15
+ W=0.42 AS=0.0441 AD=0.0567 PS=0.63 PD=0.69
M$3006 \$3933 B|B1|D_N|X \$3949 VPB|VPWR sky130_fd_pr__pfet_01v8_hvt L=0.15
+ W=0.42 AS=0.0567 AD=0.0441 PS=0.69 PD=0.63
M$3007 VPB|VPWR B|C|Y \$3949 VPB|VPWR sky130_fd_pr__pfet_01v8_hvt L=0.15 W=0.42
+ AS=0.2492 AD=0.0441 PS=1.565 PD=0.63
M$3008 VPB|VPWR \$3933 A2|B|X VPB|VPWR sky130_fd_pr__pfet_01v8_hvt L=0.15 W=1
+ AS=0.2492 AD=0.365 PS=1.565 PD=2.73
M$3034 \$4178 A|FINE_MUX[6] VPB|VPWR VPB|VPWR sky130_fd_pr__pfet_01v8_hvt
+ L=0.15 W=1 AS=0.27 AD=0.1701 PS=2.54 PD=1.36
M$3035 VPB|VPWR \$4178 \$4179 VPB|VPWR sky130_fd_pr__pfet_01v8_hvt L=0.5 W=0.82
+ AS=0.1701 AD=0.2173 PS=1.36 PD=2.17
M$3036 VPB|VPWR A|B1|X A1|Y VPB|VPWR sky130_fd_pr__pfet_01v8_hvt L=0.15 W=1.68
+ AS=0.3486 AD=0.3318 PS=3.35 PD=3.31
M$3038 VPB|VPWR \$4179 \$4180 VPB|VPWR sky130_fd_pr__pfet_01v8_hvt L=0.5 W=0.82
+ AS=0.15575 AD=0.2173 PS=1.325 PD=2.17
M$3039 VPB|VPWR \$4180 A|B1|X VPB|VPWR sky130_fd_pr__pfet_01v8_hvt L=0.15 W=1
+ AS=0.15575 AD=0.355 PS=1.325 PD=2.71
M$3040 VPB|VPWR \$4182 A|B|C|Y VPB|VPWR sky130_fd_pr__pfet_01v8_hvt L=0.15 W=1
+ AS=0.36 AD=0.165 PS=2.72 PD=1.33
M$3041 A|B|C|Y A|A2|B|Y \$4317 VPB|VPWR sky130_fd_pr__pfet_01v8_hvt L=0.15 W=1
+ AS=0.165 AD=0.105 PS=1.33 PD=1.21
M$3042 \$4317 A|B1|X VPB|VPWR VPB|VPWR sky130_fd_pr__pfet_01v8_hvt L=0.15 W=1
+ AS=0.105 AD=0.365 PS=1.21 PD=1.73
M$3043 VPB|VPWR A|B1|X \$4182 VPB|VPWR sky130_fd_pr__pfet_01v8_hvt L=0.15 W=1
+ AS=0.365 AD=0.135 PS=1.73 PD=1.27
M$3044 \$4182 A|A2|B|Y VPB|VPWR VPB|VPWR sky130_fd_pr__pfet_01v8_hvt L=0.15 W=1
+ AS=0.135 AD=0.3 PS=1.27 PD=2.6
M$3047 VPB|VPWR A|Y A|Y VPB|VPWR sky130_fd_pr__pfet_01v8_hvt L=0.15 W=6 AS=1.12
+ AD=1.34 PS=10.24 PD=12.68
M$3049 VPB|VPWR \$4185 A|B|C|D|Y VPB|VPWR sky130_fd_pr__pfet_01v8_hvt L=0.15
+ W=1 AS=0.36 AD=0.165 PS=2.72 PD=1.33
M$3050 A|B|C|D|Y B|B_N|C|X \$4319 VPB|VPWR sky130_fd_pr__pfet_01v8_hvt L=0.15
+ W=1 AS=0.165 AD=0.105 PS=1.33 PD=1.21
M$3051 \$4319 A|Y VPB|VPWR VPB|VPWR sky130_fd_pr__pfet_01v8_hvt L=0.15 W=1
+ AS=0.105 AD=0.365 PS=1.21 PD=1.73
M$3052 VPB|VPWR A|Y \$4185 VPB|VPWR sky130_fd_pr__pfet_01v8_hvt L=0.15 W=1
+ AS=0.365 AD=0.135 PS=1.73 PD=1.27
M$3053 \$4185 B|B_N|C|X VPB|VPWR VPB|VPWR sky130_fd_pr__pfet_01v8_hvt L=0.15
+ W=1 AS=0.135 AD=0.3 PS=1.27 PD=2.6
M$3054 VPB|VPWR A|A1|X B|Y VPB|VPWR sky130_fd_pr__pfet_01v8_hvt L=0.15 W=2.68
+ AS=0.5918 AD=0.4836 PS=5.83 PD=4.62
M$3058 \$4187 B|B_N|C|X VPB|VPWR VPB|VPWR sky130_fd_pr__pfet_01v8_hvt L=0.15
+ W=0.42 AS=0.1092 AD=0.1573 PS=1.36 PD=1.39
M$3059 VPB|VPWR A|Y \$4320 VPB|VPWR sky130_fd_pr__pfet_01v8_hvt L=0.15 W=1
+ AS=0.1573 AD=0.105 PS=1.39 PD=1.21
M$3060 \$4320 \$4187 A|A1|Y VPB|VPWR sky130_fd_pr__pfet_01v8_hvt L=0.15 W=1
+ AS=0.105 AD=0.26 PS=1.21 PD=2.52
M$3061 VPB|VPWR B|B_N|C|X A|A1|Y VPB|VPWR sky130_fd_pr__pfet_01v8_hvt L=0.15
+ W=1 AS=0.26 AD=0.135 PS=2.52 PD=1.27
M$3062 A|A1|Y B|Y VPB|VPWR VPB|VPWR sky130_fd_pr__pfet_01v8_hvt L=0.15 W=4
+ AS=0.79 AD=0.6 PS=7.58 PD=5.2
M$3063 VPB|VPWR A|B1|X A|A1|Y VPB|VPWR sky130_fd_pr__pfet_01v8_hvt L=0.15
+ W=4.68 AS=0.7836 AD=1.1118 PS=7.22 PD=10.87
M$3065 \$4189 A|A1|Y \$4321 VPB|VPWR sky130_fd_pr__pfet_01v8_hvt L=0.15 W=0.42
+ AS=0.1092 AD=0.0441 PS=1.36 PD=0.63
M$3066 \$4321 A|B|SLEEP|Y VPB|VPWR VPB|VPWR sky130_fd_pr__pfet_01v8_hvt L=0.15
+ W=0.42 AS=0.0441 AD=0.14575 PS=0.63 PD=1.335
M$3067 VPB|VPWR \$4189 B1|X VPB|VPWR sky130_fd_pr__pfet_01v8_hvt L=0.15 W=1
+ AS=0.14575 AD=0.34 PS=1.335 PD=2.68
M$3069 B|C1|Y C|Y \$4149 VPB|VPWR sky130_fd_pr__pfet_01v8_hvt L=0.15 W=1
+ AS=0.26 AD=0.135 PS=2.52 PD=1.27
M$3070 \$4149 B|X \$4150 VPB|VPWR sky130_fd_pr__pfet_01v8_hvt L=0.15 W=1
+ AS=0.135 AD=0.135 PS=1.27 PD=1.27
M$3071 \$4150 A|Y VPB|VPWR VPB|VPWR sky130_fd_pr__pfet_01v8_hvt L=0.15 W=1
+ AS=0.135 AD=0.26 PS=1.27 PD=2.52
M$3072 VPB|VPWR B|Y \$4138 VPB|VPWR sky130_fd_pr__pfet_01v8_hvt L=0.15 W=1
+ AS=0.3 AD=0.135 PS=2.6 PD=1.27
M$3073 \$4138 A|C|Y VPB|VPWR VPB|VPWR sky130_fd_pr__pfet_01v8_hvt L=0.15 W=1
+ AS=0.135 AD=0.365 PS=1.27 PD=1.73
M$3074 VPB|VPWR A|C|Y \$4151 VPB|VPWR sky130_fd_pr__pfet_01v8_hvt L=0.15 W=1
+ AS=0.365 AD=0.105 PS=1.73 PD=1.21
M$3075 \$4151 B|Y B|Y VPB|VPWR sky130_fd_pr__pfet_01v8_hvt L=0.15 W=1 AS=0.105
+ AD=0.165 PS=1.21 PD=1.33
M$3076 B|Y \$4138 VPB|VPWR VPB|VPWR sky130_fd_pr__pfet_01v8_hvt L=0.15 W=1
+ AS=0.165 AD=0.36 PS=1.33 PD=2.72
M$3078 VPB|VPWR A2|B|C|Y \$4193 VPB|VPWR sky130_fd_pr__pfet_01v8_hvt L=0.15
+ W=0.64 AS=0.169 AD=0.1792 PS=1.365 PD=1.84
M$3079 B|C|X \$4192 VPB|VPWR VPB|VPWR sky130_fd_pr__pfet_01v8_hvt L=0.15 W=1
+ AS=0.28 AD=0.169 PS=2.56 PD=1.365
M$3080 \$4192 \$4193 \$4194 VPB|VPWR sky130_fd_pr__pfet_01v8_hvt L=0.15 W=0.84
+ AS=0.15295 AD=0.32235 PS=1.315 PD=2.45
M$3081 \$4192 A2|B|C|Y \$4195 VPB|VPWR sky130_fd_pr__pfet_01v8_hvt L=0.15
+ W=0.84 AS=0.15295 AD=0.273 PS=1.315 PD=2.33
M$3082 VPB|VPWR A|B|Y \$4196 VPB|VPWR sky130_fd_pr__pfet_01v8_hvt L=0.15 W=1
+ AS=0.25655 AD=0.26 PS=2.52 PD=2.52
M$3084 \$4194 \$4196 \$4198 VPB|VPWR sky130_fd_pr__pfet_01v8_hvt L=0.15 W=0.64
+ AS=0.2431 AD=0.246 PS=1.445 PD=1.525
M$3085 \$4198 A|B|Y \$4195 VPB|VPWR sky130_fd_pr__pfet_01v8_hvt L=0.15 W=0.64
+ AS=0.246 AD=0.1458 PS=1.525 PD=1.205
M$3086 \$4197 A|B|Y \$4194 VPB|VPWR sky130_fd_pr__pfet_01v8_hvt L=0.15 W=0.84
+ AS=0.3528 AD=0.2431 PS=2.52 PD=1.445
M$3087 \$4197 \$4196 \$4195 VPB|VPWR sky130_fd_pr__pfet_01v8_hvt L=0.15 W=0.84
+ AS=0.1715 AD=0.1458 PS=1.355 PD=1.205
M$3088 \$4197 A|Y VPB|VPWR VPB|VPWR sky130_fd_pr__pfet_01v8_hvt L=0.15 W=1
+ AS=0.1715 AD=0.135 PS=1.355 PD=1.27
M$3089 VPB|VPWR \$4197 \$4198 VPB|VPWR sky130_fd_pr__pfet_01v8_hvt L=0.15 W=1
+ AS=0.135 AD=0.285 PS=1.27 PD=2.57
M$3090 VPB|VPWR A2|B|C|Y \$4140 VPB|VPWR sky130_fd_pr__pfet_01v8_hvt L=0.15 W=1
+ AS=0.3 AD=0.135 PS=2.6 PD=1.27
M$3091 \$4140 A|Y VPB|VPWR VPB|VPWR sky130_fd_pr__pfet_01v8_hvt L=0.15 W=1
+ AS=0.135 AD=0.365 PS=1.27 PD=1.73
M$3092 VPB|VPWR A|Y \$4153 VPB|VPWR sky130_fd_pr__pfet_01v8_hvt L=0.15 W=1
+ AS=0.365 AD=0.105 PS=1.73 PD=1.21
M$3093 \$4153 A2|B|C|Y B|Y VPB|VPWR sky130_fd_pr__pfet_01v8_hvt L=0.15 W=1
+ AS=0.105 AD=0.165 PS=1.21 PD=1.33
M$3094 B|Y \$4140 VPB|VPWR VPB|VPWR sky130_fd_pr__pfet_01v8_hvt L=0.15 W=1
+ AS=0.165 AD=0.36 PS=1.33 PD=2.72
M$3095 VPB|VPWR B|C|Y A|A1|Y VPB|VPWR sky130_fd_pr__pfet_01v8_hvt L=0.15 W=1
+ AS=0.26 AD=0.135 PS=2.52 PD=1.27
M$3097 VPB|VPWR A|B|Y A|A1|Y VPB|VPWR sky130_fd_pr__pfet_01v8_hvt L=0.15 W=2
+ AS=0.425 AD=0.425 PS=3.85 PD=3.85
M$3101 VPB|VPWR C|Y \$4203 VPB|VPWR sky130_fd_pr__pfet_01v8_hvt L=0.15 W=0.64
+ AS=0.2115 AD=0.1792 PS=1.45 PD=1.84
M$3102 A|B|C|X \$4202 VPB|VPWR VPB|VPWR sky130_fd_pr__pfet_01v8_hvt L=0.15 W=1
+ AS=0.28 AD=0.2115 PS=2.56 PD=1.45
M$3104 VPB|VPWR A|B|B1|Y \$4206 VPB|VPWR sky130_fd_pr__pfet_01v8_hvt L=0.15 W=1
+ AS=0.26 AD=0.2526 PS=2.52 PD=2.52
M$3105 \$4205 \$4206 \$4208 VPB|VPWR sky130_fd_pr__pfet_01v8_hvt L=0.15 W=0.64
+ AS=0.2452 AD=0.246 PS=1.45 PD=1.525
M$3106 \$4208 A|B|B1|Y \$4204 VPB|VPWR sky130_fd_pr__pfet_01v8_hvt L=0.15
+ W=0.64 AS=0.246 AD=0.1458 PS=1.525 PD=1.205
M$3107 \$4207 A|B|B1|Y \$4205 VPB|VPWR sky130_fd_pr__pfet_01v8_hvt L=0.15
+ W=0.84 AS=0.3536 AD=0.2452 PS=2.53 PD=1.45
M$3108 \$4207 \$4206 \$4204 VPB|VPWR sky130_fd_pr__pfet_01v8_hvt L=0.15 W=0.84
+ AS=0.1715 AD=0.1458 PS=1.355 PD=1.205
M$3109 \$4207 A|A1|Y VPB|VPWR VPB|VPWR sky130_fd_pr__pfet_01v8_hvt L=0.15 W=1
+ AS=0.1715 AD=0.135 PS=1.355 PD=1.27
M$3110 VPB|VPWR \$4207 \$4208 VPB|VPWR sky130_fd_pr__pfet_01v8_hvt L=0.15 W=1
+ AS=0.135 AD=0.285 PS=1.27 PD=2.57
M$3111 VPB|VPWR B|B1|D_N|X \$4142 VPB|VPWR sky130_fd_pr__pfet_01v8_hvt L=0.15
+ W=0.42 AS=0.14575 AD=0.1092 PS=1.335 PD=1.36
M$3112 VPB|VPWR A|A1|Y \$4155 VPB|VPWR sky130_fd_pr__pfet_01v8_hvt L=0.15 W=1
+ AS=0.14575 AD=0.135 PS=1.335 PD=1.27
M$3113 \$4155 A|B|Y \$4157 VPB|VPWR sky130_fd_pr__pfet_01v8_hvt L=0.15 W=1
+ AS=0.135 AD=0.165 PS=1.27 PD=1.33
M$3114 \$4157 A2|C|X \$4156 VPB|VPWR sky130_fd_pr__pfet_01v8_hvt L=0.15 W=1
+ AS=0.165 AD=0.135 PS=1.33 PD=1.27
M$3115 \$4156 \$4142 A|Y VPB|VPWR sky130_fd_pr__pfet_01v8_hvt L=0.15 W=1
+ AS=0.135 AD=0.52 PS=1.27 PD=3.04
M$3117 A|X \$4145 \$4146 VPB|VPWR sky130_fd_pr__pfet_01v8_hvt L=0.15 W=1 AS=0.3
+ AD=0.26 PS=2.6 PD=2.52
M$3118 VPB|VPWR B|Y \$4146 VPB|VPWR sky130_fd_pr__pfet_01v8_hvt L=0.15 W=1
+ AS=0.26 AD=0.135 PS=2.52 PD=1.27
M$3119 \$4146 A|Y VPB|VPWR VPB|VPWR sky130_fd_pr__pfet_01v8_hvt L=0.15 W=1
+ AS=0.135 AD=0.135 PS=1.27 PD=1.27
M$3120 VPB|VPWR A|Y \$4158 VPB|VPWR sky130_fd_pr__pfet_01v8_hvt L=0.15 W=1
+ AS=0.135 AD=0.135 PS=1.27 PD=1.27
M$3121 \$4158 B|Y \$4145 VPB|VPWR sky130_fd_pr__pfet_01v8_hvt L=0.15 W=1
+ AS=0.135 AD=0.26 PS=1.27 PD=2.52
M$3150 \$4205 C|Y \$4202 VPB|VPWR sky130_fd_pr__pfet_01v8_hvt L=0.15 W=0.84
+ AS=0.2688 AD=0.1596 PS=2.32 PD=1.22
M$3151 \$4202 \$4203 \$4204 VPB|VPWR sky130_fd_pr__pfet_01v8_hvt L=0.15 W=0.84
+ AS=0.1596 AD=0.441 PS=1.22 PD=2.73
M$3176 \$4370 A|B|C|Y \$4506 VPB|VPWR sky130_fd_pr__pfet_01v8_hvt L=0.15 W=1
+ AS=0.26 AD=0.135 PS=2.52 PD=1.27
M$3177 \$4506 A|X VPB|VPWR VPB|VPWR sky130_fd_pr__pfet_01v8_hvt L=0.15 W=1
+ AS=0.135 AD=0.135 PS=1.27 PD=1.27
M$3178 VPB|VPWR A|X \$4500 VPB|VPWR sky130_fd_pr__pfet_01v8_hvt L=0.15 W=1
+ AS=0.135 AD=0.135 PS=1.27 PD=1.27
M$3179 \$4500 A|B|C|Y VPB|VPWR VPB|VPWR sky130_fd_pr__pfet_01v8_hvt L=0.15 W=1
+ AS=0.135 AD=0.26 PS=1.27 PD=2.52
M$3180 \$4500 \$4370 A|B|X VPB|VPWR sky130_fd_pr__pfet_01v8_hvt L=0.15 W=1
+ AS=0.26 AD=0.3 PS=2.52 PD=2.6
M$3181 C1|Y A|B|C|Y VPB|VPWR VPB|VPWR sky130_fd_pr__pfet_01v8_hvt L=0.15 W=4
+ AS=0.695 AD=0.6 PS=6.39 PD=5.2
M$3183 C1|Y A|B|C|D|Y VPB|VPWR VPB|VPWR sky130_fd_pr__pfet_01v8_hvt L=0.15 W=2
+ AS=0.395 AD=0.395 PS=3.79 PD=3.79
M$3189 VPB|VPWR A|A1|Y \$4329 VPB|VPWR sky130_fd_pr__pfet_01v8_hvt L=0.15
+ W=0.42 AS=0.1113 AD=0.0609 PS=1.37 PD=0.71
M$3190 \$4329 A|B|SLEEP|Y VPB|VPWR VPB|VPWR sky130_fd_pr__pfet_01v8_hvt L=0.15
+ W=0.42 AS=0.0609 AD=0.1841 PS=0.71 PD=1.26
M$3191 VPB|VPWR \$4329 B1|X VPB|VPWR sky130_fd_pr__pfet_01v8_hvt L=0.15 W=0.64
+ AS=0.1841 AD=0.1696 PS=1.26 PD=1.81
M$3192 VPB|VPWR A|X A|A_N|Y VPB|VPWR sky130_fd_pr__pfet_01v8_hvt L=0.15 W=2
+ AS=0.52 AD=0.3 PS=5.04 PD=2.6
M$3193 A|A_N|Y B|X VPB|VPWR VPB|VPWR sky130_fd_pr__pfet_01v8_hvt L=0.15 W=1
+ AS=0.135 AD=0.26 PS=1.27 PD=2.52
M$3194 \$4330 C1|Y \$4344 VPB|VPWR sky130_fd_pr__pfet_01v8_hvt L=0.15 W=1
+ AS=0.265 AD=0.155 PS=2.53 PD=1.31
M$3195 \$4344 B1|X \$4332 VPB|VPWR sky130_fd_pr__pfet_01v8_hvt L=0.15 W=1
+ AS=0.155 AD=0.14 PS=1.31 PD=1.28
M$3196 \$4332 A|A1|Y VPB|VPWR VPB|VPWR sky130_fd_pr__pfet_01v8_hvt L=0.15 W=1
+ AS=0.14 AD=0.14 PS=1.28 PD=1.28
M$3197 VPB|VPWR A2|A3|Y \$4332 VPB|VPWR sky130_fd_pr__pfet_01v8_hvt L=0.15 W=1
+ AS=0.14 AD=0.265 PS=1.28 PD=2.53
M$3198 A2|B|X \$4372 VPB|VPWR VPB|VPWR sky130_fd_pr__pfet_01v8_hvt L=0.15 W=1
+ AS=0.265 AD=0.265 PS=2.53 PD=2.53
M$3199 \$4502 A2|A3|Y VPB|VPWR VPB|VPWR sky130_fd_pr__pfet_01v8_hvt L=0.15 W=1
+ AS=0.265 AD=0.14 PS=2.53 PD=1.28
M$3200 VPB|VPWR A|A1|Y \$4502 VPB|VPWR sky130_fd_pr__pfet_01v8_hvt L=0.15 W=1
+ AS=0.14 AD=0.14 PS=1.28 PD=1.28
M$3201 \$4502 B1|X \$4508 VPB|VPWR sky130_fd_pr__pfet_01v8_hvt L=0.15 W=1
+ AS=0.14 AD=0.155 PS=1.28 PD=1.31
M$3202 \$4508 C1|Y \$4372 VPB|VPWR sky130_fd_pr__pfet_01v8_hvt L=0.15 W=1
+ AS=0.155 AD=0.265 PS=1.31 PD=2.53
M$3203 VPB|VPWR \$4330 B|X VPB|VPWR sky130_fd_pr__pfet_01v8_hvt L=0.15 W=1
+ AS=0.265 AD=0.265 PS=2.53 PD=2.53
M$3204 VPB|VPWR A|A1|Y \$4345 VPB|VPWR sky130_fd_pr__pfet_01v8_hvt L=0.15 W=1
+ AS=0.265 AD=0.105 PS=2.53 PD=1.21
M$3205 \$4345 A2|A3|Y A|A1|Y VPB|VPWR sky130_fd_pr__pfet_01v8_hvt L=0.15 W=1
+ AS=0.105 AD=0.195 PS=1.21 PD=1.39
M$3206 A|A1|Y B1|X VPB|VPWR VPB|VPWR sky130_fd_pr__pfet_01v8_hvt L=0.15 W=1
+ AS=0.195 AD=0.195 PS=1.39 PD=1.39
M$3207 VPB|VPWR C1|Y A|A1|Y VPB|VPWR sky130_fd_pr__pfet_01v8_hvt L=0.15 W=1
+ AS=0.195 AD=0.635 PS=1.39 PD=3.27
M$3209 VPB|VPWR B|C|X \$4374 VPB|VPWR sky130_fd_pr__pfet_01v8_hvt L=0.15 W=1
+ AS=0.3 AD=0.135 PS=2.6 PD=1.27
M$3210 \$4374 A|A_N|Y VPB|VPWR VPB|VPWR sky130_fd_pr__pfet_01v8_hvt L=0.15 W=1
+ AS=0.135 AD=0.365 PS=1.27 PD=1.73
M$3211 VPB|VPWR A|A_N|Y \$4510 VPB|VPWR sky130_fd_pr__pfet_01v8_hvt L=0.15 W=1
+ AS=0.365 AD=0.105 PS=1.73 PD=1.21
M$3212 \$4510 B|C|X B|Y VPB|VPWR sky130_fd_pr__pfet_01v8_hvt L=0.15 W=1
+ AS=0.105 AD=0.165 PS=1.21 PD=1.33
M$3213 B|Y \$4374 VPB|VPWR VPB|VPWR sky130_fd_pr__pfet_01v8_hvt L=0.15 W=1
+ AS=0.165 AD=0.36 PS=1.33 PD=2.72
M$3214 VPB|VPWR A|A_N|Y \$4335 VPB|VPWR sky130_fd_pr__pfet_01v8_hvt L=0.15
+ W=0.42 AS=0.14575 AD=0.1092 PS=1.335 PD=1.36
M$3216 A|Y \$4335 VPB|VPWR VPB|VPWR sky130_fd_pr__pfet_01v8_hvt L=0.15 W=1
+ AS=0.135 AD=0.265 PS=1.27 PD=2.53
M$3218 \$4378 B|Y \$4511 VPB|VPWR sky130_fd_pr__pfet_01v8_hvt L=0.15 W=1
+ AS=0.26 AD=0.135 PS=2.52 PD=1.27
M$3219 \$4511 A|Y VPB|VPWR VPB|VPWR sky130_fd_pr__pfet_01v8_hvt L=0.15 W=1
+ AS=0.135 AD=0.135 PS=1.27 PD=1.27
M$3220 VPB|VPWR A|Y \$4503 VPB|VPWR sky130_fd_pr__pfet_01v8_hvt L=0.15 W=1
+ AS=0.135 AD=0.135 PS=1.27 PD=1.27
M$3221 \$4503 B|Y VPB|VPWR VPB|VPWR sky130_fd_pr__pfet_01v8_hvt L=0.15 W=1
+ AS=0.135 AD=0.26 PS=1.27 PD=2.52
M$3222 VPB|VPWR A|Y \$4346 VPB|VPWR sky130_fd_pr__pfet_01v8_hvt L=0.15 W=1
+ AS=0.26 AD=0.105 PS=2.52 PD=1.21
M$3223 \$4346 B|Y A|B|Y VPB|VPWR sky130_fd_pr__pfet_01v8_hvt L=0.15 W=1
+ AS=0.105 AD=0.26 PS=1.21 PD=2.52
M$3224 \$4503 \$4378 A|B|X VPB|VPWR sky130_fd_pr__pfet_01v8_hvt L=0.15 W=1
+ AS=0.26 AD=0.3 PS=2.52 PD=2.6
M$3227 VPB|VPWR B|C|Y \$4337 VPB|VPWR sky130_fd_pr__pfet_01v8_hvt L=0.15 W=1
+ AS=0.3 AD=0.135 PS=2.6 PD=1.27
M$3228 \$4337 A|Y VPB|VPWR VPB|VPWR sky130_fd_pr__pfet_01v8_hvt L=0.15 W=1
+ AS=0.135 AD=0.365 PS=1.27 PD=1.73
M$3229 VPB|VPWR A|Y \$4348 VPB|VPWR sky130_fd_pr__pfet_01v8_hvt L=0.15 W=1
+ AS=0.365 AD=0.105 PS=1.73 PD=1.21
M$3230 \$4348 B|C|Y B|Y VPB|VPWR sky130_fd_pr__pfet_01v8_hvt L=0.15 W=1
+ AS=0.105 AD=0.165 PS=1.21 PD=1.33
M$3231 B|Y \$4337 VPB|VPWR VPB|VPWR sky130_fd_pr__pfet_01v8_hvt L=0.15 W=1
+ AS=0.165 AD=0.36 PS=1.33 PD=2.72
M$3232 \$4381 A|A_N|Y VPB|VPWR VPB|VPWR sky130_fd_pr__pfet_01v8_hvt L=0.15
+ W=0.42 AS=0.1092 AD=0.14575 PS=1.36 PD=1.335
M$3233 VPB|VPWR B|Y A_N|B1_N|Y VPB|VPWR sky130_fd_pr__pfet_01v8_hvt L=0.15 W=1
+ AS=0.14575 AD=0.135 PS=1.335 PD=1.27
M$3234 A_N|B1_N|Y \$4381 VPB|VPWR VPB|VPWR sky130_fd_pr__pfet_01v8_hvt L=0.15
+ W=1 AS=0.135 AD=0.265 PS=1.27 PD=2.53
M$3237 VPB|VPWR A2|B|Y A|Y VPB|VPWR sky130_fd_pr__pfet_01v8_hvt L=0.15 W=1
+ AS=0.165 AD=0.135 PS=1.33 PD=1.27
M$3238 A|Y A|B|C|X VPB|VPWR VPB|VPWR sky130_fd_pr__pfet_01v8_hvt L=0.15 W=1
+ AS=0.135 AD=0.26 PS=1.27 PD=2.52
M$3240 \$4339 B|Y \$4350 VPB|VPWR sky130_fd_pr__pfet_01v8_hvt L=0.15 W=1
+ AS=0.26 AD=0.135 PS=2.52 PD=1.27
M$3241 \$4350 A|B|Y VPB|VPWR VPB|VPWR sky130_fd_pr__pfet_01v8_hvt L=0.15 W=1
+ AS=0.135 AD=0.135 PS=1.27 PD=1.27
M$3242 VPB|VPWR A|B|Y \$4340 VPB|VPWR sky130_fd_pr__pfet_01v8_hvt L=0.15 W=1
+ AS=0.135 AD=0.135 PS=1.27 PD=1.27
M$3243 \$4340 B|Y VPB|VPWR VPB|VPWR sky130_fd_pr__pfet_01v8_hvt L=0.15 W=1
+ AS=0.135 AD=0.26 PS=1.27 PD=2.52
M$3244 VPB|VPWR A|A1|Y \$4324 VPB|VPWR sky130_fd_pr__pfet_01v8_hvt L=0.15
+ W=0.64 AS=0.1696 AD=0.0768 PS=1.81 PD=0.88
M$3245 \$4324 A2|C|X B|Y VPB|VPWR sky130_fd_pr__pfet_01v8_hvt L=0.15 W=0.64
+ AS=0.0768 AD=0.0896 PS=0.88 PD=0.92
M$3246 B|Y B|B1|D_N|X VPB|VPWR VPB|VPWR sky130_fd_pr__pfet_01v8_hvt L=0.15
+ W=0.64 AS=0.0896 AD=0.1824 PS=0.92 PD=1.85
M$3247 \$4340 \$4339 C|X VPB|VPWR sky130_fd_pr__pfet_01v8_hvt L=0.15 W=1
+ AS=0.26 AD=0.3 PS=2.52 PD=2.6
M$3303 VPB|VPWR A|Y A|B|C|Y VPB|VPWR sky130_fd_pr__pfet_01v8_hvt L=0.15 W=1.68
+ AS=0.3486 AD=0.3318 PS=3.35 PD=3.31
M$3308 A|X \$4524 VPB|VPWR VPB|VPWR sky130_fd_pr__pfet_01v8_hvt L=0.15 W=1
+ AS=0.28 AD=0.169 PS=2.56 PD=1.365
M$3309 VPB|VPWR B|C|X \$4525 VPB|VPWR sky130_fd_pr__pfet_01v8_hvt L=0.15 W=0.64
+ AS=0.169 AD=0.1792 PS=1.365 PD=1.84
M$3310 VPB|VPWR A|B|Y \$4528 VPB|VPWR sky130_fd_pr__pfet_01v8_hvt L=0.15 W=1
+ AS=0.25655 AD=0.26 PS=2.52 PD=2.52
M$3311 \$4526 A|B|Y \$4530 VPB|VPWR sky130_fd_pr__pfet_01v8_hvt L=0.15 W=0.64
+ AS=0.1458 AD=0.246 PS=1.205 PD=1.525
M$3312 \$4526 \$4528 \$4529 VPB|VPWR sky130_fd_pr__pfet_01v8_hvt L=0.15 W=0.84
+ AS=0.1458 AD=0.1715 PS=1.205 PD=1.355
M$3313 \$4529 A|B|Y \$4527 VPB|VPWR sky130_fd_pr__pfet_01v8_hvt L=0.15 W=0.84
+ AS=0.3528 AD=0.2431 PS=2.52 PD=1.445
M$3314 \$4527 \$4528 \$4530 VPB|VPWR sky130_fd_pr__pfet_01v8_hvt L=0.15 W=0.64
+ AS=0.2431 AD=0.246 PS=1.445 PD=1.525
M$3315 \$4529 A|A_N|Y VPB|VPWR VPB|VPWR sky130_fd_pr__pfet_01v8_hvt L=0.15 W=1
+ AS=0.1715 AD=0.135 PS=1.355 PD=1.27
M$3316 VPB|VPWR \$4529 \$4530 VPB|VPWR sky130_fd_pr__pfet_01v8_hvt L=0.15 W=1
+ AS=0.135 AD=0.285 PS=1.27 PD=2.57
M$3319 VPB|VPWR A|B|X A|A_N|Y VPB|VPWR sky130_fd_pr__pfet_01v8_hvt L=0.15 W=3
+ AS=0.465 AD=0.56 PS=3.93 PD=5.12
M$3320 A|A_N|Y B|C|X VPB|VPWR VPB|VPWR sky130_fd_pr__pfet_01v8_hvt L=0.15 W=2
+ AS=0.395 AD=0.395 PS=3.79 PD=3.79
M$3323 VPB|VPWR B|Y \$4531 VPB|VPWR sky130_fd_pr__pfet_01v8_hvt L=0.15 W=1
+ AS=0.3 AD=0.135 PS=2.6 PD=1.27
M$3324 \$4531 A|A_N|Y VPB|VPWR VPB|VPWR sky130_fd_pr__pfet_01v8_hvt L=0.15 W=1
+ AS=0.135 AD=0.365 PS=1.27 PD=1.73
M$3325 VPB|VPWR A|A_N|Y \$4550 VPB|VPWR sky130_fd_pr__pfet_01v8_hvt L=0.15 W=1
+ AS=0.365 AD=0.105 PS=1.73 PD=1.21
M$3326 \$4550 B|Y A2|B|Y VPB|VPWR sky130_fd_pr__pfet_01v8_hvt L=0.15 W=1
+ AS=0.105 AD=0.165 PS=1.21 PD=1.33
M$3327 A2|B|Y \$4531 VPB|VPWR VPB|VPWR sky130_fd_pr__pfet_01v8_hvt L=0.15 W=1
+ AS=0.165 AD=0.36 PS=1.33 PD=2.72
M$3329 \$4532 A2|B|Y VPB|VPWR VPB|VPWR sky130_fd_pr__pfet_01v8_hvt L=0.15
+ W=0.64 AS=0.1696 AD=0.0896 PS=1.81 PD=0.92
M$3330 VPB|VPWR A|A1|X \$4532 VPB|VPWR sky130_fd_pr__pfet_01v8_hvt L=0.15
+ W=0.64 AS=0.0896 AD=0.0896 PS=0.92 PD=0.92
M$3331 \$4532 \$4555 B|Y VPB|VPWR sky130_fd_pr__pfet_01v8_hvt L=0.15 W=0.64
+ AS=0.0896 AD=0.1696 PS=0.92 PD=1.81
M$3332 VPB|VPWR A_N|B1_N|Y \$4555 VPB|VPWR sky130_fd_pr__pfet_01v8_hvt L=0.15
+ W=0.42 AS=0.1113 AD=0.1113 PS=1.37 PD=1.37
M$3333 VPB|VPWR A_N|B1_N|Y \$4534 VPB|VPWR sky130_fd_pr__pfet_01v8_hvt L=0.15
+ W=0.42 AS=0.14575 AD=0.1092 PS=1.335 PD=1.36
M$3335 B|Y \$4534 VPB|VPWR VPB|VPWR sky130_fd_pr__pfet_01v8_hvt L=0.15 W=1
+ AS=0.135 AD=0.265 PS=1.27 PD=2.53
M$3337 \$4537 \$4538 \$4539 VPB|VPWR sky130_fd_pr__pfet_01v8_hvt L=0.15 W=0.84
+ AS=0.1715 AD=0.1458 PS=1.355 PD=1.205
M$3338 \$4539 B|Y \$4536 VPB|VPWR sky130_fd_pr__pfet_01v8_hvt L=0.15 W=0.64
+ AS=0.1458 AD=0.246 PS=1.205 PD=1.525
M$3339 \$4536 \$4537 VPB|VPWR VPB|VPWR sky130_fd_pr__pfet_01v8_hvt L=0.15 W=1
+ AS=0.285 AD=0.135 PS=2.57 PD=1.27
M$3340 VPB|VPWR A|Y \$4537 VPB|VPWR sky130_fd_pr__pfet_01v8_hvt L=0.15 W=1
+ AS=0.135 AD=0.1715 PS=1.27 PD=1.355
M$3341 \$4540 \$4538 \$4536 VPB|VPWR sky130_fd_pr__pfet_01v8_hvt L=0.15 W=0.64
+ AS=0.2452 AD=0.246 PS=1.45 PD=1.525
M$3342 \$4540 B|Y \$4537 VPB|VPWR sky130_fd_pr__pfet_01v8_hvt L=0.15 W=0.84
+ AS=0.2452 AD=0.3536 PS=1.45 PD=2.53
M$3343 \$4386 C|X \$4513 VPB|VPWR sky130_fd_pr__pfet_01v8_hvt L=0.15 W=0.42
+ AS=0.1092 AD=0.0441 PS=1.36 PD=0.63
M$3344 \$4513 A|Y VPB|VPWR VPB|VPWR sky130_fd_pr__pfet_01v8_hvt L=0.15 W=0.42
+ AS=0.0441 AD=0.0567 PS=0.63 PD=0.69
M$3345 VPB|VPWR A|Y \$4515 VPB|VPWR sky130_fd_pr__pfet_01v8_hvt L=0.15 W=0.42
+ AS=0.0567 AD=0.0441 PS=0.69 PD=0.63
M$3346 \$4515 B|Y \$4386 VPB|VPWR sky130_fd_pr__pfet_01v8_hvt L=0.15 W=0.42
+ AS=0.0441 AD=0.0567 PS=0.63 PD=0.69
M$3347 \$4386 B|Y \$4514 VPB|VPWR sky130_fd_pr__pfet_01v8_hvt L=0.15 W=0.42
+ AS=0.0567 AD=0.0441 PS=0.69 PD=0.63
M$3348 VPB|VPWR C|X \$4514 VPB|VPWR sky130_fd_pr__pfet_01v8_hvt L=0.15 W=0.42
+ AS=0.2492 AD=0.0441 PS=1.565 PD=0.63
M$3349 VPB|VPWR \$4386 B|SLEEP|X VPB|VPWR sky130_fd_pr__pfet_01v8_hvt L=0.15
+ W=1 AS=0.2492 AD=0.365 PS=1.565 PD=2.73
M$3350 \$4538 B|Y VPB|VPWR VPB|VPWR sky130_fd_pr__pfet_01v8_hvt L=0.15 W=1
+ AS=0.2526 AD=0.26 PS=2.52 PD=2.52
M$3351 VPB|VPWR C|X \$4541 VPB|VPWR sky130_fd_pr__pfet_01v8_hvt L=0.15 W=0.64
+ AS=0.2115 AD=0.1792 PS=1.45 PD=1.84
M$3352 VPB|VPWR \$4542 A|A_N|X VPB|VPWR sky130_fd_pr__pfet_01v8_hvt L=0.15 W=1
+ AS=0.2115 AD=0.28 PS=1.45 PD=2.56
M$3375 \$4573 A|FINE_MUX[7] VPB|VPWR VPB|VPWR sky130_fd_pr__pfet_01v8_hvt
+ L=0.15 W=1 AS=0.27 AD=0.1701 PS=2.54 PD=1.36
M$3376 VPB|VPWR \$4573 \$4574 VPB|VPWR sky130_fd_pr__pfet_01v8_hvt L=0.5 W=0.82
+ AS=0.1701 AD=0.2173 PS=1.36 PD=2.17
M$3377 \$4519 A|B|C|Y \$4546 VPB|VPWR sky130_fd_pr__pfet_01v8_hvt L=0.15 W=0.42
+ AS=0.1092 AD=0.0441 PS=1.36 PD=0.63
M$3378 \$4546 A|X VPB|VPWR VPB|VPWR sky130_fd_pr__pfet_01v8_hvt L=0.15 W=0.42
+ AS=0.0441 AD=0.0567 PS=0.63 PD=0.69
M$3379 VPB|VPWR A|X \$4547 VPB|VPWR sky130_fd_pr__pfet_01v8_hvt L=0.15 W=0.42
+ AS=0.0567 AD=0.0441 PS=0.69 PD=0.63
M$3380 \$4547 A|B|X \$4519 VPB|VPWR sky130_fd_pr__pfet_01v8_hvt L=0.15 W=0.42
+ AS=0.0441 AD=0.0567 PS=0.63 PD=0.69
M$3381 \$4519 A|B|X \$4548 VPB|VPWR sky130_fd_pr__pfet_01v8_hvt L=0.15 W=0.42
+ AS=0.0567 AD=0.0441 PS=0.69 PD=0.63
M$3382 VPB|VPWR A|B|C|Y \$4548 VPB|VPWR sky130_fd_pr__pfet_01v8_hvt L=0.15
+ W=0.42 AS=0.2492 AD=0.0441 PS=1.565 PD=0.63
M$3383 VPB|VPWR \$4519 B|X VPB|VPWR sky130_fd_pr__pfet_01v8_hvt L=0.15 W=1
+ AS=0.2492 AD=0.365 PS=1.565 PD=2.73
M$3384 VPB|VPWR \$4574 \$4575 VPB|VPWR sky130_fd_pr__pfet_01v8_hvt L=0.5 W=0.82
+ AS=0.15575 AD=0.2173 PS=1.325 PD=2.17
M$3385 VPB|VPWR \$4575 A|X VPB|VPWR sky130_fd_pr__pfet_01v8_hvt L=0.15 W=1
+ AS=0.15575 AD=0.355 PS=1.325 PD=2.71
M$3387 \$4576 B|X \$4720 VPB|VPWR sky130_fd_pr__pfet_01v8_hvt L=0.15 W=1
+ AS=0.26 AD=0.135 PS=2.52 PD=1.27
M$3388 \$4720 A|Y VPB|VPWR VPB|VPWR sky130_fd_pr__pfet_01v8_hvt L=0.15 W=1
+ AS=0.135 AD=0.135 PS=1.27 PD=1.27
M$3389 VPB|VPWR A|Y \$4709 VPB|VPWR sky130_fd_pr__pfet_01v8_hvt L=0.15 W=1
+ AS=0.135 AD=0.135 PS=1.27 PD=1.27
M$3390 \$4709 B|X VPB|VPWR VPB|VPWR sky130_fd_pr__pfet_01v8_hvt L=0.15 W=1
+ AS=0.135 AD=0.26 PS=1.27 PD=2.52
M$3391 \$4521 A|B|X VPB|VPWR VPB|VPWR sky130_fd_pr__pfet_01v8_hvt L=0.15 W=0.42
+ AS=0.1092 AD=0.0567 PS=1.36 PD=0.69
M$3392 VPB|VPWR A|B|C|Y \$4521 VPB|VPWR sky130_fd_pr__pfet_01v8_hvt L=0.15
+ W=0.42 AS=0.0567 AD=0.06615 PS=0.69 PD=0.735
M$3393 VPB|VPWR A|B|C|D|Y \$4521 VPB|VPWR sky130_fd_pr__pfet_01v8_hvt L=0.15
+ W=0.42 AS=0.142225 AD=0.06615 PS=1.335 PD=0.735
M$3394 VPB|VPWR \$4521 A3|B|X VPB|VPWR sky130_fd_pr__pfet_01v8_hvt L=0.15 W=1
+ AS=0.142225 AD=0.26 PS=1.335 PD=2.52
M$3395 \$4709 \$4576 A|A_N|X VPB|VPWR sky130_fd_pr__pfet_01v8_hvt L=0.15 W=1
+ AS=0.26 AD=0.3 PS=2.52 PD=2.6
M$3396 \$4578 A|A_N|X VPB|VPWR VPB|VPWR sky130_fd_pr__pfet_01v8_hvt L=0.15
+ W=0.42 AS=0.1092 AD=0.14575 PS=1.36 PD=1.335
M$3397 VPB|VPWR A|B|C|D|Y A2|B|SLEEP|Y VPB|VPWR sky130_fd_pr__pfet_01v8_hvt
+ L=0.15 W=1 AS=0.14575 AD=0.135 PS=1.335 PD=1.27
M$3398 A2|B|SLEEP|Y \$4578 VPB|VPWR VPB|VPWR sky130_fd_pr__pfet_01v8_hvt L=0.15
+ W=1 AS=0.135 AD=0.265 PS=1.27 PD=2.53
M$3403 VPB|VPWR A3|B|X \$4710 VPB|VPWR sky130_fd_pr__pfet_01v8_hvt L=0.15 W=1
+ AS=0.26 AD=0.135 PS=2.52 PD=1.27
M$3404 \$4710 A2|B|X VPB|VPWR VPB|VPWR sky130_fd_pr__pfet_01v8_hvt L=0.15 W=1
+ AS=0.135 AD=0.1525 PS=1.27 PD=1.305
M$3405 VPB|VPWR A|A1|Y \$4710 VPB|VPWR sky130_fd_pr__pfet_01v8_hvt L=0.15 W=1
+ AS=0.1525 AD=0.1625 PS=1.305 PD=1.325
M$3406 \$4710 B1|Y A|B|Y VPB|VPWR sky130_fd_pr__pfet_01v8_hvt L=0.15 W=1
+ AS=0.1625 AD=0.27 PS=1.325 PD=2.54
M$3408 \$4526 B|C|X \$4524 VPB|VPWR sky130_fd_pr__pfet_01v8_hvt L=0.15 W=0.84
+ AS=0.273 AD=0.15295 PS=2.33 PD=1.315
M$3409 \$4524 \$4525 \$4527 VPB|VPWR sky130_fd_pr__pfet_01v8_hvt L=0.15 W=0.84
+ AS=0.15295 AD=0.32235 PS=1.315 PD=2.45
M$3412 \$4586 A|B|X VPB|VPWR VPB|VPWR sky130_fd_pr__pfet_01v8_hvt L=0.15 W=0.84
+ AS=0.1659 AD=0.12285 PS=2.05 PD=1.425
M$3414 VPB|VPWR B|C|X \$4586 VPB|VPWR sky130_fd_pr__pfet_01v8_hvt L=0.15 W=0.42
+ AS=0.142225 AD=0.06615 PS=1.335 PD=0.735
M$3415 VPB|VPWR \$4586 A|A1|X VPB|VPWR sky130_fd_pr__pfet_01v8_hvt L=0.15 W=1
+ AS=0.142225 AD=0.26 PS=1.335 PD=2.52
M$3418 VPB|VPWR A2|B|Y \$4587 VPB|VPWR sky130_fd_pr__pfet_01v8_hvt L=0.15 W=1
+ AS=0.3 AD=0.135 PS=2.6 PD=1.27
M$3419 \$4587 A|A1|X VPB|VPWR VPB|VPWR sky130_fd_pr__pfet_01v8_hvt L=0.15 W=1
+ AS=0.135 AD=0.365 PS=1.27 PD=1.73
M$3420 VPB|VPWR A|A1|X \$4723 VPB|VPWR sky130_fd_pr__pfet_01v8_hvt L=0.15 W=1
+ AS=0.365 AD=0.105 PS=1.73 PD=1.21
M$3421 \$4723 A2|B|Y A|Y VPB|VPWR sky130_fd_pr__pfet_01v8_hvt L=0.15 W=1
+ AS=0.105 AD=0.165 PS=1.21 PD=1.33
M$3422 A|Y \$4587 VPB|VPWR VPB|VPWR sky130_fd_pr__pfet_01v8_hvt L=0.15 W=1
+ AS=0.165 AD=0.36 PS=1.33 PD=2.72
M$3423 VPB|VPWR B|Y \$4589 VPB|VPWR sky130_fd_pr__pfet_01v8_hvt L=0.15 W=1
+ AS=0.3 AD=0.135 PS=2.6 PD=1.27
M$3424 \$4589 A|B|C|X VPB|VPWR VPB|VPWR sky130_fd_pr__pfet_01v8_hvt L=0.15 W=1
+ AS=0.135 AD=0.365 PS=1.27 PD=1.73
M$3425 VPB|VPWR A|B|C|X \$4722 VPB|VPWR sky130_fd_pr__pfet_01v8_hvt L=0.15 W=1
+ AS=0.365 AD=0.105 PS=1.73 PD=1.21
M$3426 \$4722 B|Y B|C|Y VPB|VPWR sky130_fd_pr__pfet_01v8_hvt L=0.15 W=1
+ AS=0.105 AD=0.165 PS=1.21 PD=1.33
M$3427 B|C|Y \$4589 VPB|VPWR VPB|VPWR sky130_fd_pr__pfet_01v8_hvt L=0.15 W=1
+ AS=0.165 AD=0.36 PS=1.33 PD=2.72
M$3430 \$4539 \$4541 \$4542 VPB|VPWR sky130_fd_pr__pfet_01v8_hvt L=0.15 W=0.84
+ AS=0.441 AD=0.1596 PS=2.73 PD=1.22
M$3431 \$4542 C|X \$4540 VPB|VPWR sky130_fd_pr__pfet_01v8_hvt L=0.15 W=0.84
+ AS=0.1596 AD=0.2688 PS=1.22 PD=2.32
M$3433 VPB|VPWR \$4593 B|B_N|Y VPB|VPWR sky130_fd_pr__pfet_01v8_hvt L=0.15 W=1
+ AS=0.36 AD=0.165 PS=2.72 PD=1.33
M$3434 B|B_N|Y B|SLEEP|X \$4721 VPB|VPWR sky130_fd_pr__pfet_01v8_hvt L=0.15 W=1
+ AS=0.165 AD=0.105 PS=1.33 PD=1.21
M$3435 \$4721 A|X VPB|VPWR VPB|VPWR sky130_fd_pr__pfet_01v8_hvt L=0.15 W=1
+ AS=0.105 AD=0.365 PS=1.21 PD=1.73
M$3436 VPB|VPWR A|X \$4593 VPB|VPWR sky130_fd_pr__pfet_01v8_hvt L=0.15 W=1
+ AS=0.365 AD=0.135 PS=1.73 PD=1.27
M$3437 \$4593 B|SLEEP|X VPB|VPWR VPB|VPWR sky130_fd_pr__pfet_01v8_hvt L=0.15
+ W=1 AS=0.135 AD=0.3 PS=1.27 PD=2.6
M$3460 VPB|VPWR A|REF \$4595 VPB|VPWR sky130_fd_pr__pfet_01v8_hvt L=0.15 W=0.64
+ AS=0.149 AD=0.1664 PS=1.325 PD=1.8
M$3461 VPB|VPWR \$4595 A|X VPB|VPWR sky130_fd_pr__pfet_01v8_hvt L=0.15 W=2
+ AS=0.4 AD=0.284 PS=3.8 PD=2.595
M$3464 VPB|VPWR \$4724 \$4725 VPB|VPWR sky130_fd_pr__pfet_01v8_hvt L=0.5 W=0.82
+ AS=0.1701 AD=0.2173 PS=1.36 PD=2.17
M$3465 \$4724 A|FINE_MUX[8] VPB|VPWR VPB|VPWR sky130_fd_pr__pfet_01v8_hvt
+ L=0.15 W=1 AS=0.27 AD=0.1701 PS=2.54 PD=1.36
M$3466 \$4726 \$4725 VPB|VPWR VPB|VPWR sky130_fd_pr__pfet_01v8_hvt L=0.5 W=0.82
+ AS=0.2173 AD=0.15575 PS=2.17 PD=1.325
M$3467 VPB|VPWR \$4726 A|B|X VPB|VPWR sky130_fd_pr__pfet_01v8_hvt L=0.15 W=1
+ AS=0.15575 AD=0.355 PS=1.325 PD=2.71
M$3469 \$4730 B|X \$4754 VPB|VPWR sky130_fd_pr__pfet_01v8_hvt L=0.15 W=1
+ AS=0.26 AD=0.135 PS=2.52 PD=1.27
M$3470 \$4754 A|B|C|D|Y VPB|VPWR VPB|VPWR sky130_fd_pr__pfet_01v8_hvt L=0.15
+ W=1 AS=0.135 AD=0.135 PS=1.27 PD=1.27
M$3471 VPB|VPWR A|B|C|D|Y \$4731 VPB|VPWR sky130_fd_pr__pfet_01v8_hvt L=0.15
+ W=1 AS=0.135 AD=0.135 PS=1.27 PD=1.27
M$3472 \$4731 B|X VPB|VPWR VPB|VPWR sky130_fd_pr__pfet_01v8_hvt L=0.15 W=1
+ AS=0.135 AD=0.26 PS=1.27 PD=2.52
M$3473 \$4731 \$4730 B|D|X VPB|VPWR sky130_fd_pr__pfet_01v8_hvt L=0.15 W=1
+ AS=0.26 AD=0.3 PS=2.52 PD=2.6
M$3475 VPB|VPWR A3|B|X B|Y VPB|VPWR sky130_fd_pr__pfet_01v8_hvt L=0.15 W=1
+ AS=0.26 AD=0.135 PS=2.52 PD=1.27
M$3478 VPB|VPWR A|B|X B1|Y VPB|VPWR sky130_fd_pr__pfet_01v8_hvt L=0.15 W=1.68
+ AS=0.3318 AD=0.3486 PS=3.31 PD=3.35
M$3482 VPB|VPWR A|B|Y \$4584 VPB|VPWR sky130_fd_pr__pfet_01v8_hvt L=0.15 W=0.42
+ AS=0.1113 AD=0.0609 PS=1.37 PD=0.71
M$3483 VPB|VPWR B|Y \$4584 VPB|VPWR sky130_fd_pr__pfet_01v8_hvt L=0.15 W=0.42
+ AS=0.1841 AD=0.0609 PS=1.26 PD=0.71
M$3484 VPB|VPWR \$4584 A|X VPB|VPWR sky130_fd_pr__pfet_01v8_hvt L=0.15 W=0.64
+ AS=0.1841 AD=0.1696 PS=1.26 PD=1.81
M$3485 VPB|VPWR A|X \$4755 VPB|VPWR sky130_fd_pr__pfet_01v8_hvt L=0.15 W=1
+ AS=0.26 AD=0.105 PS=2.52 PD=1.21
M$3486 \$4755 A|B|X B|C|SLEEP|Y VPB|VPWR sky130_fd_pr__pfet_01v8_hvt L=0.15 W=1
+ AS=0.105 AD=0.26 PS=1.21 PD=2.52
M$3488 A|B|X \$4736 VPB|VPWR VPB|VPWR sky130_fd_pr__pfet_01v8_hvt L=0.15 W=1
+ AS=0.28 AD=0.169 PS=2.56 PD=1.365
M$3489 VPB|VPWR B|C|Y \$4737 VPB|VPWR sky130_fd_pr__pfet_01v8_hvt L=0.15 W=0.64
+ AS=0.169 AD=0.1792 PS=1.365 PD=1.84
M$3490 \$4738 B|C|Y \$4736 VPB|VPWR sky130_fd_pr__pfet_01v8_hvt L=0.15 W=0.84
+ AS=0.273 AD=0.15295 PS=2.33 PD=1.315
M$3491 \$4736 \$4737 \$4739 VPB|VPWR sky130_fd_pr__pfet_01v8_hvt L=0.15 W=0.84
+ AS=0.15295 AD=0.32235 PS=1.315 PD=2.45
M$3492 VPB|VPWR A2|B|Y \$4740 VPB|VPWR sky130_fd_pr__pfet_01v8_hvt L=0.15 W=1
+ AS=0.25655 AD=0.26 PS=2.52 PD=2.52
M$3493 \$4738 A2|B|Y \$4742 VPB|VPWR sky130_fd_pr__pfet_01v8_hvt L=0.15 W=0.64
+ AS=0.1458 AD=0.246 PS=1.205 PD=1.525
M$3494 \$4738 \$4740 \$4741 VPB|VPWR sky130_fd_pr__pfet_01v8_hvt L=0.15 W=0.84
+ AS=0.1458 AD=0.1715 PS=1.205 PD=1.355
M$3495 \$4741 A2|B|Y \$4739 VPB|VPWR sky130_fd_pr__pfet_01v8_hvt L=0.15 W=0.84
+ AS=0.3528 AD=0.2431 PS=2.52 PD=1.445
M$3496 \$4739 \$4740 \$4742 VPB|VPWR sky130_fd_pr__pfet_01v8_hvt L=0.15 W=0.64
+ AS=0.2431 AD=0.246 PS=1.445 PD=1.525
M$3497 \$4741 A|A1|X VPB|VPWR VPB|VPWR sky130_fd_pr__pfet_01v8_hvt L=0.15 W=1
+ AS=0.1715 AD=0.135 PS=1.355 PD=1.27
M$3498 VPB|VPWR \$4741 \$4742 VPB|VPWR sky130_fd_pr__pfet_01v8_hvt L=0.15 W=1
+ AS=0.135 AD=0.285 PS=1.27 PD=2.57
M$3502 VPB|VPWR A|X \$4743 VPB|VPWR sky130_fd_pr__pfet_01v8_hvt L=0.15 W=0.42
+ AS=0.1573 AD=0.1092 PS=1.39 PD=1.36
M$3503 VPB|VPWR B|SLEEP|X \$4758 VPB|VPWR sky130_fd_pr__pfet_01v8_hvt L=0.15
+ W=1 AS=0.1573 AD=0.105 PS=1.39 PD=1.21
M$3504 \$4758 \$4743 A|X VPB|VPWR sky130_fd_pr__pfet_01v8_hvt L=0.15 W=1
+ AS=0.105 AD=0.26 PS=1.21 PD=2.52
M$3526 VPB|VPWR A|B|Y \$4746 VPB|VPWR sky130_fd_pr__pfet_01v8_hvt L=0.15 W=0.64
+ AS=0.149 AD=0.1664 PS=1.325 PD=1.8
M$3527 VPB|VPWR \$4746 A|X VPB|VPWR sky130_fd_pr__pfet_01v8_hvt L=0.15 W=2
+ AS=0.4 AD=0.284 PS=3.8 PD=2.595
M$3529 VPB|VPWR A|X \$4748 VPB|VPWR sky130_fd_pr__pfet_01v8_hvt L=0.15 W=0.64
+ AS=0.149 AD=0.1664 PS=1.325 PD=1.8
M$3530 VPB|VPWR \$4748 A|X VPB|VPWR sky130_fd_pr__pfet_01v8_hvt L=0.15 W=2
+ AS=0.284 AD=0.4 PS=2.595 PD=3.8
M$3533 \$4775 A|FINE_MUX[9] VPB|VPWR VPB|VPWR sky130_fd_pr__pfet_01v8_hvt
+ L=0.15 W=1 AS=0.27 AD=0.1701 PS=2.54 PD=1.36
M$3534 VPB|VPWR \$4775 \$4776 VPB|VPWR sky130_fd_pr__pfet_01v8_hvt L=0.5 W=0.82
+ AS=0.1701 AD=0.2173 PS=1.36 PD=2.17
M$3535 VPB|VPWR \$4776 \$4777 VPB|VPWR sky130_fd_pr__pfet_01v8_hvt L=0.5 W=0.82
+ AS=0.15575 AD=0.2173 PS=1.325 PD=2.17
M$3536 VPB|VPWR \$4777 A|B1|X VPB|VPWR sky130_fd_pr__pfet_01v8_hvt L=0.15 W=1
+ AS=0.15575 AD=0.355 PS=1.325 PD=2.71
M$3537 VPB|VPWR \$4779 A|A1|B|Y VPB|VPWR sky130_fd_pr__pfet_01v8_hvt L=0.15 W=1
+ AS=0.36 AD=0.165 PS=2.72 PD=1.33
M$3538 A|A1|B|Y A|B|X \$4927 VPB|VPWR sky130_fd_pr__pfet_01v8_hvt L=0.15 W=1
+ AS=0.165 AD=0.105 PS=1.33 PD=1.21
M$3539 \$4927 A|B|X VPB|VPWR VPB|VPWR sky130_fd_pr__pfet_01v8_hvt L=0.15 W=1
+ AS=0.105 AD=0.365 PS=1.21 PD=1.73
M$3540 VPB|VPWR A|B|X \$4779 VPB|VPWR sky130_fd_pr__pfet_01v8_hvt L=0.15 W=2
+ AS=0.5 AD=0.435 PS=3 PD=3.87
M$3542 \$4728 B|C|Y \$4752 VPB|VPWR sky130_fd_pr__pfet_01v8_hvt L=0.15 W=0.42
+ AS=0.1092 AD=0.0441 PS=1.36 PD=0.63
M$3543 \$4752 A|B|C|Y VPB|VPWR VPB|VPWR sky130_fd_pr__pfet_01v8_hvt L=0.15
+ W=0.42 AS=0.0441 AD=0.0567 PS=0.63 PD=0.69
M$3544 VPB|VPWR A|B|C|Y \$4751 VPB|VPWR sky130_fd_pr__pfet_01v8_hvt L=0.15
+ W=0.42 AS=0.0567 AD=0.0441 PS=0.69 PD=0.63
M$3545 \$4751 B|X \$4728 VPB|VPWR sky130_fd_pr__pfet_01v8_hvt L=0.15 W=0.42
+ AS=0.0441 AD=0.0567 PS=0.63 PD=0.69
M$3546 \$4728 B|X \$4753 VPB|VPWR sky130_fd_pr__pfet_01v8_hvt L=0.15 W=0.42
+ AS=0.0567 AD=0.0441 PS=0.69 PD=0.63
M$3547 VPB|VPWR B|C|Y \$4753 VPB|VPWR sky130_fd_pr__pfet_01v8_hvt L=0.15 W=0.42
+ AS=0.2492 AD=0.0441 PS=1.565 PD=0.63
M$3548 VPB|VPWR \$4728 B|X VPB|VPWR sky130_fd_pr__pfet_01v8_hvt L=0.15 W=1
+ AS=0.2492 AD=0.365 PS=1.565 PD=2.73
M$3549 VPB|VPWR B|C|Y \$4781 VPB|VPWR sky130_fd_pr__pfet_01v8_hvt L=0.15 W=1
+ AS=0.3 AD=0.135 PS=2.6 PD=1.27
M$3550 \$4781 A|A_N|X VPB|VPWR VPB|VPWR sky130_fd_pr__pfet_01v8_hvt L=0.15 W=1
+ AS=0.135 AD=0.365 PS=1.27 PD=1.73
M$3551 VPB|VPWR A|A_N|X \$4932 VPB|VPWR sky130_fd_pr__pfet_01v8_hvt L=0.15 W=1
+ AS=0.365 AD=0.105 PS=1.73 PD=1.21
M$3552 \$4932 B|C|Y A|A1|C|Y VPB|VPWR sky130_fd_pr__pfet_01v8_hvt L=0.15 W=1
+ AS=0.105 AD=0.165 PS=1.21 PD=1.33
M$3553 A|A1|C|Y \$4781 VPB|VPWR VPB|VPWR sky130_fd_pr__pfet_01v8_hvt L=0.15 W=1
+ AS=0.165 AD=0.36 PS=1.33 PD=2.72
M$3555 VPB|VPWR \$4785 A2|A3|Y VPB|VPWR sky130_fd_pr__pfet_01v8_hvt L=0.15 W=1
+ AS=0.36 AD=0.165 PS=2.72 PD=1.33
M$3556 A2|A3|Y B|Y \$4936 VPB|VPWR sky130_fd_pr__pfet_01v8_hvt L=0.15 W=1
+ AS=0.165 AD=0.105 PS=1.33 PD=1.21
M$3557 \$4936 A|B|Y VPB|VPWR VPB|VPWR sky130_fd_pr__pfet_01v8_hvt L=0.15 W=1
+ AS=0.105 AD=0.365 PS=1.21 PD=1.73
M$3558 VPB|VPWR A|B|Y \$4785 VPB|VPWR sky130_fd_pr__pfet_01v8_hvt L=0.15 W=1
+ AS=0.365 AD=0.135 PS=1.73 PD=1.27
M$3559 \$4785 B|Y VPB|VPWR VPB|VPWR sky130_fd_pr__pfet_01v8_hvt L=0.15 W=1
+ AS=0.135 AD=0.3 PS=1.27 PD=2.6
M$3562 VPB|VPWR A|B|X \$4788 VPB|VPWR sky130_fd_pr__pfet_01v8_hvt L=0.15 W=0.42
+ AS=0.1573 AD=0.1092 PS=1.39 PD=1.36
M$3563 A|X \$4788 \$4935 VPB|VPWR sky130_fd_pr__pfet_01v8_hvt L=0.15 W=1
+ AS=0.26 AD=0.105 PS=2.52 PD=1.21
M$3564 \$4935 B|C|SLEEP|Y VPB|VPWR VPB|VPWR sky130_fd_pr__pfet_01v8_hvt L=0.15
+ W=1 AS=0.105 AD=0.1573 PS=1.21 PD=1.39
M$3565 VPB|VPWR B|C|X \$4789 VPB|VPWR sky130_fd_pr__pfet_01v8_hvt L=0.15 W=1
+ AS=0.3 AD=0.135 PS=2.6 PD=1.27
M$3566 \$4789 A|X VPB|VPWR VPB|VPWR sky130_fd_pr__pfet_01v8_hvt L=0.15 W=1
+ AS=0.135 AD=0.365 PS=1.27 PD=1.73
M$3567 VPB|VPWR A|X \$4934 VPB|VPWR sky130_fd_pr__pfet_01v8_hvt L=0.15 W=1
+ AS=0.365 AD=0.105 PS=1.73 PD=1.21
M$3568 \$4934 B|C|X B|Y VPB|VPWR sky130_fd_pr__pfet_01v8_hvt L=0.15 W=1
+ AS=0.105 AD=0.165 PS=1.21 PD=1.33
M$3569 B|Y \$4789 VPB|VPWR VPB|VPWR sky130_fd_pr__pfet_01v8_hvt L=0.15 W=1
+ AS=0.165 AD=0.36 PS=1.33 PD=2.72
M$3572 A|Y B|C|Y \$4933 VPB|VPWR sky130_fd_pr__pfet_01v8_hvt L=0.15 W=1 AS=0.26
+ AD=0.105 PS=2.52 PD=1.21
M$3573 \$4933 A|Y VPB|VPWR VPB|VPWR sky130_fd_pr__pfet_01v8_hvt L=0.15 W=1
+ AS=0.105 AD=0.26 PS=1.21 PD=2.52
M$3576 \$4793 A|A_N|X VPB|VPWR VPB|VPWR sky130_fd_pr__pfet_01v8_hvt L=0.15
+ W=0.42 AS=0.1092 AD=0.14575 PS=1.36 PD=1.335
M$3578 A|Y \$4793 VPB|VPWR VPB|VPWR sky130_fd_pr__pfet_01v8_hvt L=0.15 W=1
+ AS=0.135 AD=0.265 PS=1.27 PD=2.53
M$3580 \$4795 B|B_N|Y VPB|VPWR VPB|VPWR sky130_fd_pr__pfet_01v8_hvt L=0.15
+ W=0.42 AS=0.1092 AD=0.1573 PS=1.36 PD=1.39
M$3581 VPB|VPWR A|Y \$4931 VPB|VPWR sky130_fd_pr__pfet_01v8_hvt L=0.15 W=1
+ AS=0.1573 AD=0.105 PS=1.39 PD=1.21
M$3582 \$4931 \$4795 B|Y VPB|VPWR sky130_fd_pr__pfet_01v8_hvt L=0.15 W=1
+ AS=0.105 AD=0.26 PS=1.21 PD=2.52
M$3583 C1|Y D|Y \$4929 VPB|VPWR sky130_fd_pr__pfet_01v8_hvt L=0.15 W=1 AS=0.26
+ AD=0.13 PS=2.52 PD=1.26
M$3584 \$4929 C|X \$4930 VPB|VPWR sky130_fd_pr__pfet_01v8_hvt L=0.15 W=1
+ AS=0.13 AD=0.19 PS=1.26 PD=1.38
M$3585 \$4930 B|Y \$4928 VPB|VPWR sky130_fd_pr__pfet_01v8_hvt L=0.15 W=1
+ AS=0.19 AD=0.135 PS=1.38 PD=1.27
M$3586 \$4928 A|X VPB|VPWR VPB|VPWR sky130_fd_pr__pfet_01v8_hvt L=0.15 W=1
+ AS=0.135 AD=0.26 PS=1.27 PD=2.52
M$3608 VPB|VPWR A|X \$4800 VPB|VPWR sky130_fd_pr__pfet_01v8_hvt L=0.15 W=0.64
+ AS=0.149 AD=0.1664 PS=1.325 PD=1.8
M$3609 VPB|VPWR \$4800 A|X VPB|VPWR sky130_fd_pr__pfet_01v8_hvt L=0.15 W=2
+ AS=0.4 AD=0.284 PS=3.8 PD=2.595
M$3611 VPB|VPWR A|B|Y A|B|Y VPB|VPWR sky130_fd_pr__pfet_01v8_hvt L=0.15 W=5
+ AS=0.81075 AD=0.8 PS=7.665 PD=7.6
M$3613 VPB|VPWR A|Q A|B|Y VPB|VPWR sky130_fd_pr__pfet_01v8_hvt L=0.15 W=2
+ AS=0.27 AD=0.395 PS=2.54 PD=3.79
M$3615 \$4806 A|X VPB|VPWR VPB|VPWR sky130_fd_pr__pfet_01v8_hvt L=0.15 W=1
+ AS=0.27 AD=0.1701 PS=2.54 PD=1.36
M$3616 VPB|VPWR \$4806 \$4807 VPB|VPWR sky130_fd_pr__pfet_01v8_hvt L=0.5 W=0.82
+ AS=0.1701 AD=0.2173 PS=1.36 PD=2.17
M$3617 VPB|VPWR \$4807 \$4808 VPB|VPWR sky130_fd_pr__pfet_01v8_hvt L=0.5 W=0.82
+ AS=0.15575 AD=0.2173 PS=1.325 PD=2.17
M$3618 VPB|VPWR \$4808 OUT|X VPB|VPWR sky130_fd_pr__pfet_01v8_hvt L=0.15 W=1
+ AS=0.15575 AD=0.355 PS=1.325 PD=2.71
M$3624 VPB|VPWR A|B1|X \$4939 VPB|VPWR sky130_fd_pr__pfet_01v8_hvt L=0.15 W=1
+ AS=0.345 AD=0.2125 PS=2.69 PD=1.425
M$3625 \$4939 A2|A3|Y \$4970 VPB|VPWR sky130_fd_pr__pfet_01v8_hvt L=0.15 W=1
+ AS=0.2125 AD=0.165 PS=1.425 PD=1.33
M$3626 \$4970 A2|B|SLEEP|Y \$4971 VPB|VPWR sky130_fd_pr__pfet_01v8_hvt L=0.15
+ W=1 AS=0.165 AD=0.135 PS=1.33 PD=1.27
M$3627 \$4971 A|A1|B|Y VPB|VPWR VPB|VPWR sky130_fd_pr__pfet_01v8_hvt L=0.15 W=1
+ AS=0.135 AD=0.195 PS=1.27 PD=1.39
M$3628 VPB|VPWR \$4939 B|X VPB|VPWR sky130_fd_pr__pfet_01v8_hvt L=0.15 W=1
+ AS=0.195 AD=0.36 PS=1.39 PD=2.72
M$3631 VPB|VPWR A|X \$4972 VPB|VPWR sky130_fd_pr__pfet_01v8_hvt L=0.15 W=1
+ AS=0.26 AD=0.105 PS=2.52 PD=1.21
M$3632 \$4972 B|X B|Y VPB|VPWR sky130_fd_pr__pfet_01v8_hvt L=0.15 W=1 AS=0.105
+ AD=0.26 PS=1.21 PD=2.52
M$3633 VPB|VPWR A|X \$4787 VPB|VPWR sky130_fd_pr__pfet_01v8_hvt L=0.15 W=0.42
+ AS=0.1113 AD=0.0609 PS=1.37 PD=0.71
M$3634 VPB|VPWR B|X \$4787 VPB|VPWR sky130_fd_pr__pfet_01v8_hvt L=0.15 W=0.42
+ AS=0.1841 AD=0.0609 PS=1.26 PD=0.71
M$3635 VPB|VPWR \$4787 A|B|X VPB|VPWR sky130_fd_pr__pfet_01v8_hvt L=0.15 W=0.64
+ AS=0.1841 AD=0.1696 PS=1.26 PD=1.81
M$3636 VPB|VPWR C|C_N|X \$4942 VPB|VPWR sky130_fd_pr__pfet_01v8_hvt L=0.15
+ W=0.42 AS=0.14575 AD=0.1092 PS=1.335 PD=1.36
M$3637 VPB|VPWR A|B|X \$4974 VPB|VPWR sky130_fd_pr__pfet_01v8_hvt L=0.15 W=1
+ AS=0.14575 AD=0.135 PS=1.335 PD=1.27
M$3638 \$4974 B|Y \$4973 VPB|VPWR sky130_fd_pr__pfet_01v8_hvt L=0.15 W=1
+ AS=0.135 AD=0.135 PS=1.27 PD=1.27
M$3639 \$4973 \$4942 A|Y VPB|VPWR sky130_fd_pr__pfet_01v8_hvt L=0.15 W=1
+ AS=0.135 AD=0.32 PS=1.27 PD=2.64
M$3641 B|X \$4946 VPB|VPWR VPB|VPWR sky130_fd_pr__pfet_01v8_hvt L=0.15 W=1
+ AS=0.28 AD=0.169 PS=2.56 PD=1.365
M$3642 VPB|VPWR B|C|SLEEP|Y \$4947 VPB|VPWR sky130_fd_pr__pfet_01v8_hvt L=0.15
+ W=0.64 AS=0.169 AD=0.1792 PS=1.365 PD=1.84
M$3643 VPB|VPWR A|B|X \$4950 VPB|VPWR sky130_fd_pr__pfet_01v8_hvt L=0.15 W=1
+ AS=0.25655 AD=0.26 PS=2.52 PD=2.52
M$3644 \$4948 A|B|X \$4952 VPB|VPWR sky130_fd_pr__pfet_01v8_hvt L=0.15 W=0.64
+ AS=0.1458 AD=0.246 PS=1.205 PD=1.525
M$3645 \$4948 \$4950 \$4951 VPB|VPWR sky130_fd_pr__pfet_01v8_hvt L=0.15 W=0.84
+ AS=0.1458 AD=0.1715 PS=1.205 PD=1.355
M$3646 \$4951 A|B|X \$4949 VPB|VPWR sky130_fd_pr__pfet_01v8_hvt L=0.15 W=0.84
+ AS=0.3528 AD=0.2431 PS=2.52 PD=1.445
M$3647 \$4949 \$4950 \$4952 VPB|VPWR sky130_fd_pr__pfet_01v8_hvt L=0.15 W=0.64
+ AS=0.2431 AD=0.246 PS=1.445 PD=1.525
M$3648 \$4951 A|Y VPB|VPWR VPB|VPWR sky130_fd_pr__pfet_01v8_hvt L=0.15 W=1
+ AS=0.1715 AD=0.135 PS=1.355 PD=1.27
M$3649 VPB|VPWR \$4951 \$4952 VPB|VPWR sky130_fd_pr__pfet_01v8_hvt L=0.15 W=1
+ AS=0.135 AD=0.285 PS=1.27 PD=2.57
M$3653 B|X \$4956 \$4957 VPB|VPWR sky130_fd_pr__pfet_01v8_hvt L=0.15 W=1 AS=0.3
+ AD=0.26 PS=2.6 PD=2.52
M$3654 VPB|VPWR B|X \$4957 VPB|VPWR sky130_fd_pr__pfet_01v8_hvt L=0.15 W=1
+ AS=0.26 AD=0.135 PS=2.52 PD=1.27
M$3655 \$4957 A|A_N|X VPB|VPWR VPB|VPWR sky130_fd_pr__pfet_01v8_hvt L=0.15 W=1
+ AS=0.135 AD=0.135 PS=1.27 PD=1.27
M$3656 VPB|VPWR A|A_N|X \$4979 VPB|VPWR sky130_fd_pr__pfet_01v8_hvt L=0.15 W=1
+ AS=0.135 AD=0.135 PS=1.27 PD=1.27
M$3657 \$4979 B|X \$4956 VPB|VPWR sky130_fd_pr__pfet_01v8_hvt L=0.15 W=1
+ AS=0.135 AD=0.26 PS=1.27 PD=2.52
M$3659 VPB|VPWR B|B_N|Y \$4958 VPB|VPWR sky130_fd_pr__pfet_01v8_hvt L=0.15 W=1
+ AS=0.3 AD=0.135 PS=2.6 PD=1.27
M$3660 \$4958 A|Y VPB|VPWR VPB|VPWR sky130_fd_pr__pfet_01v8_hvt L=0.15 W=1
+ AS=0.135 AD=0.365 PS=1.27 PD=1.73
M$3661 VPB|VPWR A|Y \$4981 VPB|VPWR sky130_fd_pr__pfet_01v8_hvt L=0.15 W=1
+ AS=0.365 AD=0.105 PS=1.73 PD=1.21
M$3662 \$4981 B|B_N|Y A|Y VPB|VPWR sky130_fd_pr__pfet_01v8_hvt L=0.15 W=1
+ AS=0.105 AD=0.165 PS=1.21 PD=1.33
M$3663 A|Y \$4958 VPB|VPWR VPB|VPWR sky130_fd_pr__pfet_01v8_hvt L=0.15 W=1
+ AS=0.165 AD=0.36 PS=1.33 PD=2.72
M$3684 VPB|VPWR A|B|Y \$4960 VPB|VPWR sky130_fd_pr__pfet_01v8_hvt L=0.15 W=0.64
+ AS=0.149 AD=0.1664 PS=1.325 PD=1.8
M$3685 VPB|VPWR \$4960 A|X VPB|VPWR sky130_fd_pr__pfet_01v8_hvt L=0.15 W=2
+ AS=0.4 AD=0.284 PS=3.8 PD=2.595
M$3687 VPB|VPWR \$4961 \$4962 VPB|VPWR sky130_fd_pr__pfet_01v8_hvt L=0.5 W=0.82
+ AS=0.1701 AD=0.2173 PS=1.36 PD=2.17
M$3688 \$4961 A|X VPB|VPWR VPB|VPWR sky130_fd_pr__pfet_01v8_hvt L=0.15 W=1
+ AS=0.27 AD=0.1701 PS=2.54 PD=1.36
M$3689 \$4963 \$4962 VPB|VPWR VPB|VPWR sky130_fd_pr__pfet_01v8_hvt L=0.5 W=0.82
+ AS=0.2173 AD=0.15575 PS=2.17 PD=1.325
M$3690 VPB|VPWR \$4963 INJ_EDGE|X VPB|VPWR sky130_fd_pr__pfet_01v8_hvt L=0.15
+ W=1 AS=0.15575 AD=0.355 PS=1.325 PD=2.71
M$3691 VPB|VPWR \$4964 \$4965 VPB|VPWR sky130_fd_pr__pfet_01v8_hvt L=0.5 W=0.82
+ AS=0.1701 AD=0.2173 PS=1.36 PD=2.17
M$3692 \$4964 A|X VPB|VPWR VPB|VPWR sky130_fd_pr__pfet_01v8_hvt L=0.15 W=1
+ AS=0.27 AD=0.1701 PS=2.54 PD=1.36
M$3693 \$4966 \$4965 VPB|VPWR VPB|VPWR sky130_fd_pr__pfet_01v8_hvt L=0.5 W=0.82
+ AS=0.2173 AD=0.15575 PS=2.17 PD=1.325
M$3694 VPB|VPWR \$4966 SS_BBPD[1]|X VPB|VPWR sky130_fd_pr__pfet_01v8_hvt L=0.15
+ W=1 AS=0.15575 AD=0.355 PS=1.325 PD=2.71
M$3696 A|A1|B|X \$4999 \$5148 VPB|VPWR sky130_fd_pr__pfet_01v8_hvt L=0.15 W=1
+ AS=0.3 AD=0.26 PS=2.6 PD=2.52
M$3697 VPB|VPWR A|A1|B|Y \$5148 VPB|VPWR sky130_fd_pr__pfet_01v8_hvt L=0.15 W=1
+ AS=0.26 AD=0.135 PS=2.52 PD=1.27
M$3698 \$5148 A|B1|X VPB|VPWR VPB|VPWR sky130_fd_pr__pfet_01v8_hvt L=0.15 W=1
+ AS=0.135 AD=0.135 PS=1.27 PD=1.27
M$3699 VPB|VPWR A|B1|X \$5156 VPB|VPWR sky130_fd_pr__pfet_01v8_hvt L=0.15 W=1
+ AS=0.135 AD=0.135 PS=1.27 PD=1.27
M$3700 \$5156 A|A1|B|Y \$4999 VPB|VPWR sky130_fd_pr__pfet_01v8_hvt L=0.15 W=1
+ AS=0.135 AD=0.26 PS=1.27 PD=2.52
M$3701 VPB|VPWR A|B|Y B|C|Y VPB|VPWR sky130_fd_pr__pfet_01v8_hvt L=0.15 W=1
+ AS=0.26 AD=0.135 PS=2.52 PD=1.27
M$3702 B|C|Y A|Y VPB|VPWR VPB|VPWR sky130_fd_pr__pfet_01v8_hvt L=0.15 W=2
+ AS=0.3 AD=0.52 PS=2.6 PD=5.04
M$3704 VPB|VPWR A|Y \$5158 VPB|VPWR sky130_fd_pr__pfet_01v8_hvt L=0.15 W=1
+ AS=0.26 AD=0.105 PS=2.52 PD=1.21
M$3705 \$5158 A2|B|SLEEP|Y A|A1|Y VPB|VPWR sky130_fd_pr__pfet_01v8_hvt L=0.15
+ W=1 AS=0.105 AD=0.26 PS=1.21 PD=2.52
M$3707 \$5149 A2|A3|Y VPB|VPWR VPB|VPWR sky130_fd_pr__pfet_01v8_hvt L=0.15 W=1
+ AS=0.265 AD=0.14 PS=2.53 PD=1.28
M$3708 VPB|VPWR A|A1|Y \$5149 VPB|VPWR sky130_fd_pr__pfet_01v8_hvt L=0.15 W=1
+ AS=0.14 AD=0.14 PS=1.28 PD=1.28
M$3709 \$5149 B1|C1|X \$5160 VPB|VPWR sky130_fd_pr__pfet_01v8_hvt L=0.15 W=1
+ AS=0.14 AD=0.155 PS=1.28 PD=1.31
M$3710 \$5160 B1|C1|Y A2|B|SLEEP|Y VPB|VPWR sky130_fd_pr__pfet_01v8_hvt L=0.15
+ W=1 AS=0.155 AD=0.265 PS=1.31 PD=2.53
M$3711 \$5006 \$5008 \$5009 VPB|VPWR sky130_fd_pr__pfet_01v8_hvt L=0.15 W=0.64
+ AS=0.246 AD=0.2452 PS=1.525 PD=1.45
M$3712 \$5006 B|X \$5010 VPB|VPWR sky130_fd_pr__pfet_01v8_hvt L=0.15 W=0.64
+ AS=0.246 AD=0.1458 PS=1.525 PD=1.205
M$3713 \$5009 B|X \$5007 VPB|VPWR sky130_fd_pr__pfet_01v8_hvt L=0.15 W=0.84
+ AS=0.2452 AD=0.3536 PS=1.45 PD=2.53
M$3714 \$5006 \$5007 VPB|VPWR VPB|VPWR sky130_fd_pr__pfet_01v8_hvt L=0.15 W=1
+ AS=0.285 AD=0.135 PS=2.57 PD=1.27
M$3715 VPB|VPWR A|X \$5007 VPB|VPWR sky130_fd_pr__pfet_01v8_hvt L=0.15 W=1
+ AS=0.135 AD=0.1715 PS=1.27 PD=1.355
M$3716 \$5007 \$5008 \$5010 VPB|VPWR sky130_fd_pr__pfet_01v8_hvt L=0.15 W=0.84
+ AS=0.1715 AD=0.1458 PS=1.355 PD=1.205
M$3717 \$5008 B|X VPB|VPWR VPB|VPWR sky130_fd_pr__pfet_01v8_hvt L=0.15 W=1
+ AS=0.2526 AD=0.26 PS=2.52 PD=2.52
M$3718 \$5011 C|C_N|X VPB|VPWR VPB|VPWR sky130_fd_pr__pfet_01v8_hvt L=0.15
+ W=0.64 AS=0.1792 AD=0.2115 PS=1.84 PD=1.45
M$3719 VPB|VPWR \$5012 B|B_N|X VPB|VPWR sky130_fd_pr__pfet_01v8_hvt L=0.15 W=1
+ AS=0.2115 AD=0.28 PS=1.45 PD=2.56
M$3721 \$4948 B|C|SLEEP|Y \$4946 VPB|VPWR sky130_fd_pr__pfet_01v8_hvt L=0.15
+ W=0.84 AS=0.273 AD=0.15295 PS=2.33 PD=1.315
M$3722 \$4946 \$4947 \$4949 VPB|VPWR sky130_fd_pr__pfet_01v8_hvt L=0.15 W=0.84
+ AS=0.15295 AD=0.32235 PS=1.315 PD=2.45
M$3723 VPB|VPWR B|C|SLEEP|Y \$5014 VPB|VPWR sky130_fd_pr__pfet_01v8_hvt L=0.15
+ W=1 AS=0.3 AD=0.135 PS=2.6 PD=1.27
M$3724 \$5014 A|B|X VPB|VPWR VPB|VPWR sky130_fd_pr__pfet_01v8_hvt L=0.15 W=1
+ AS=0.135 AD=0.365 PS=1.27 PD=1.73
M$3725 VPB|VPWR A|B|X \$5164 VPB|VPWR sky130_fd_pr__pfet_01v8_hvt L=0.15 W=1
+ AS=0.365 AD=0.105 PS=1.73 PD=1.21
M$3726 \$5164 B|C|SLEEP|Y B|C|Y VPB|VPWR sky130_fd_pr__pfet_01v8_hvt L=0.15 W=1
+ AS=0.105 AD=0.165 PS=1.21 PD=1.33
M$3727 B|C|Y \$5014 VPB|VPWR VPB|VPWR sky130_fd_pr__pfet_01v8_hvt L=0.15 W=1
+ AS=0.165 AD=0.36 PS=1.33 PD=2.72
M$3728 VPB|VPWR B|C|X B|C|Y VPB|VPWR sky130_fd_pr__pfet_01v8_hvt L=0.15 W=1
+ AS=0.26 AD=0.135 PS=2.52 PD=1.27
M$3729 B|C|Y B|C|Y VPB|VPWR VPB|VPWR sky130_fd_pr__pfet_01v8_hvt L=0.15 W=1
+ AS=0.135 AD=0.165 PS=1.27 PD=1.33
M$3732 VPB|VPWR C|X \$5020 VPB|VPWR sky130_fd_pr__pfet_01v8_hvt L=0.15 W=0.64
+ AS=0.2115 AD=0.1792 PS=1.45 PD=1.84
M$3733 B|C|D_N|X \$5018 VPB|VPWR VPB|VPWR sky130_fd_pr__pfet_01v8_hvt L=0.15
+ W=1 AS=0.28 AD=0.2115 PS=2.56 PD=1.45
M$3734 VPB|VPWR B|C|Y \$5023 VPB|VPWR sky130_fd_pr__pfet_01v8_hvt L=0.15 W=1
+ AS=0.26 AD=0.2526 PS=2.52 PD=2.52
M$3735 \$5022 \$5023 \$5025 VPB|VPWR sky130_fd_pr__pfet_01v8_hvt L=0.15 W=0.64
+ AS=0.2452 AD=0.246 PS=1.45 PD=1.525
M$3736 \$5025 B|C|Y \$5021 VPB|VPWR sky130_fd_pr__pfet_01v8_hvt L=0.15 W=0.64
+ AS=0.246 AD=0.1458 PS=1.525 PD=1.205
M$3737 \$5024 B|C|Y \$5022 VPB|VPWR sky130_fd_pr__pfet_01v8_hvt L=0.15 W=0.84
+ AS=0.3536 AD=0.2452 PS=2.53 PD=1.45
M$3738 \$5024 \$5023 \$5021 VPB|VPWR sky130_fd_pr__pfet_01v8_hvt L=0.15 W=0.84
+ AS=0.1715 AD=0.1458 PS=1.355 PD=1.205
M$3739 \$5024 A|Y VPB|VPWR VPB|VPWR sky130_fd_pr__pfet_01v8_hvt L=0.15 W=1
+ AS=0.1715 AD=0.135 PS=1.355 PD=1.27
M$3740 VPB|VPWR \$5024 \$5025 VPB|VPWR sky130_fd_pr__pfet_01v8_hvt L=0.15 W=1
+ AS=0.135 AD=0.285 PS=1.27 PD=2.57
M$3741 \$4953 B|C|Y \$4976 VPB|VPWR sky130_fd_pr__pfet_01v8_hvt L=0.15 W=0.42
+ AS=0.1092 AD=0.0441 PS=1.36 PD=0.63
M$3742 \$4976 A|Y VPB|VPWR VPB|VPWR sky130_fd_pr__pfet_01v8_hvt L=0.15 W=0.42
+ AS=0.0441 AD=0.0567 PS=0.63 PD=0.69
M$3743 VPB|VPWR A|Y \$4977 VPB|VPWR sky130_fd_pr__pfet_01v8_hvt L=0.15 W=0.42
+ AS=0.0567 AD=0.0441 PS=0.69 PD=0.63
M$3744 \$4977 A|B|X \$4953 VPB|VPWR sky130_fd_pr__pfet_01v8_hvt L=0.15 W=0.42
+ AS=0.0441 AD=0.0567 PS=0.63 PD=0.69
M$3745 \$4953 A|B|X \$4978 VPB|VPWR sky130_fd_pr__pfet_01v8_hvt L=0.15 W=0.42
+ AS=0.0567 AD=0.0441 PS=0.69 PD=0.63
M$3746 VPB|VPWR B|C|Y \$4978 VPB|VPWR sky130_fd_pr__pfet_01v8_hvt L=0.15 W=0.42
+ AS=0.2492 AD=0.0441 PS=1.565 PD=0.63
M$3747 VPB|VPWR \$4953 B|X VPB|VPWR sky130_fd_pr__pfet_01v8_hvt L=0.15 W=1
+ AS=0.2492 AD=0.365 PS=1.565 PD=2.73
M$3750 VPB|VPWR A|Y \$5029 VPB|VPWR sky130_fd_pr__pfet_01v8_hvt L=0.15 W=0.42
+ AS=0.1573 AD=0.1092 PS=1.39 PD=1.36
M$3751 C|X \$5029 \$5161 VPB|VPWR sky130_fd_pr__pfet_01v8_hvt L=0.15 W=1
+ AS=0.26 AD=0.105 PS=2.52 PD=1.21
M$3752 \$5161 B|SLEEP|X VPB|VPWR VPB|VPWR sky130_fd_pr__pfet_01v8_hvt L=0.15
+ W=1 AS=0.105 AD=0.1573 PS=1.21 PD=1.39
M$3774 VPB|VPWR A|Q \$5030 VPB|VPWR sky130_fd_pr__pfet_01v8_hvt L=0.15 W=0.64
+ AS=0.149 AD=0.1664 PS=1.325 PD=1.8
M$3775 VPB|VPWR \$5030 A|X VPB|VPWR sky130_fd_pr__pfet_01v8_hvt L=0.15 W=2
+ AS=0.284 AD=0.4 PS=2.595 PD=3.8
M$3777 VPB|VPWR A|REF A|B|Y VPB|VPWR sky130_fd_pr__pfet_01v8_hvt L=0.15 W=2
+ AS=0.395 AD=0.27 PS=3.79 PD=2.54
M$3781 \$5032 A|X VPB|VPWR VPB|VPWR sky130_fd_pr__pfet_01v8_hvt L=0.15 W=1
+ AS=0.27 AD=0.1701 PS=2.54 PD=1.36
M$3782 VPB|VPWR \$5032 \$5033 VPB|VPWR sky130_fd_pr__pfet_01v8_hvt L=0.5 W=0.82
+ AS=0.1701 AD=0.2173 PS=1.36 PD=2.17
M$3783 VPB|VPWR \$5033 \$5034 VPB|VPWR sky130_fd_pr__pfet_01v8_hvt L=0.5 W=0.82
+ AS=0.15575 AD=0.2173 PS=1.325 PD=2.17
M$3784 VPB|VPWR \$5034 SS_BBPD[0]|X VPB|VPWR sky130_fd_pr__pfet_01v8_hvt L=0.15
+ W=1 AS=0.15575 AD=0.355 PS=1.325 PD=2.71
M$3786 VPB|VPWR A|A1|B|X B|Y VPB|VPWR sky130_fd_pr__pfet_01v8_hvt L=0.15
+ W=10.08 AS=1.9908 AD=2.0916 PS=19.86 PD=20.1
M$3788 VPB|VPWR A|A1|B|Y B|Y VPB|VPWR sky130_fd_pr__pfet_01v8_hvt L=0.15 W=6.72
+ AS=1.3272 AD=1.3944 PS=13.24 PD=13.4
M$3791 A|B|Y A|B1|X VPB|VPWR VPB|VPWR sky130_fd_pr__pfet_01v8_hvt L=0.15 W=3
+ AS=0.405 AD=0.78 PS=3.81 PD=7.56
M$3792 VPB|VPWR A|B1|X \$5167 VPB|VPWR sky130_fd_pr__pfet_01v8_hvt L=0.15 W=1
+ AS=0.345 AD=0.2125 PS=2.69 PD=1.425
M$3793 \$5167 A3|X \$5205 VPB|VPWR sky130_fd_pr__pfet_01v8_hvt L=0.15 W=1
+ AS=0.2125 AD=0.165 PS=1.425 PD=1.33
M$3794 \$5205 A2|B|SLEEP|Y \$5204 VPB|VPWR sky130_fd_pr__pfet_01v8_hvt L=0.15
+ W=1 AS=0.165 AD=0.135 PS=1.33 PD=1.27
M$3795 \$5204 A|A1|B|X VPB|VPWR VPB|VPWR sky130_fd_pr__pfet_01v8_hvt L=0.15 W=1
+ AS=0.135 AD=0.195 PS=1.27 PD=1.39
M$3796 VPB|VPWR \$5167 C|C_N|X VPB|VPWR sky130_fd_pr__pfet_01v8_hvt L=0.15 W=1
+ AS=0.195 AD=0.36 PS=1.39 PD=2.72
M$3797 A3|X \$5170 VPB|VPWR VPB|VPWR sky130_fd_pr__pfet_01v8_hvt L=0.15 W=1
+ AS=0.26 AD=0.26 PS=2.52 PD=2.52
M$3798 \$5170 B1|C1|Y \$5171 VPB|VPWR sky130_fd_pr__pfet_01v8_hvt L=0.15 W=1
+ AS=0.26 AD=0.1375 PS=2.52 PD=1.275
M$3799 \$5171 A|A1|Y VPB|VPWR VPB|VPWR sky130_fd_pr__pfet_01v8_hvt L=0.15 W=1
+ AS=0.1375 AD=0.14 PS=1.275 PD=1.28
M$3800 VPB|VPWR A2|A3|Y \$5171 VPB|VPWR sky130_fd_pr__pfet_01v8_hvt L=0.15 W=1
+ AS=0.14 AD=0.265 PS=1.28 PD=2.53
M$3801 \$5172 B1|C1|X VPB|VPWR VPB|VPWR sky130_fd_pr__pfet_01v8_hvt L=0.15 W=1
+ AS=0.3 AD=0.175 PS=2.6 PD=1.35
M$3802 VPB|VPWR B1|Y \$5172 VPB|VPWR sky130_fd_pr__pfet_01v8_hvt L=0.15 W=1
+ AS=0.175 AD=0.22 PS=1.35 PD=1.44
M$3803 \$5172 A2|A3|Y \$5208 VPB|VPWR sky130_fd_pr__pfet_01v8_hvt L=0.15 W=1
+ AS=0.22 AD=0.1625 PS=1.44 PD=1.325
M$3804 \$5208 A|A1|Y VPB|VPWR VPB|VPWR sky130_fd_pr__pfet_01v8_hvt L=0.15 W=1
+ AS=0.1625 AD=0.26 PS=1.325 PD=2.52
M$3805 VPB|VPWR \$5172 A|A1|X VPB|VPWR sky130_fd_pr__pfet_01v8_hvt L=0.15 W=1
+ AS=0.26 AD=0.26 PS=2.52 PD=2.52
M$3806 B1|C1|Y A|B|Y \$5209 VPB|VPWR sky130_fd_pr__pfet_01v8_hvt L=0.15 W=1
+ AS=0.26 AD=0.105 PS=2.52 PD=1.21
M$3807 \$5209 A|A1|Y VPB|VPWR VPB|VPWR sky130_fd_pr__pfet_01v8_hvt L=0.15 W=1
+ AS=0.105 AD=0.26 PS=1.21 PD=2.52
M$3809 \$5010 \$5011 \$5012 VPB|VPWR sky130_fd_pr__pfet_01v8_hvt L=0.15 W=0.84
+ AS=0.441 AD=0.1596 PS=2.73 PD=1.22
M$3810 \$5012 C|C_N|X \$5009 VPB|VPWR sky130_fd_pr__pfet_01v8_hvt L=0.15 W=0.84
+ AS=0.1596 AD=0.2688 PS=1.22 PD=2.32
M$3814 VPB|VPWR A|B|X \$5178 VPB|VPWR sky130_fd_pr__pfet_01v8_hvt L=0.15 W=0.42
+ AS=0.1113 AD=0.0609 PS=1.37 PD=0.71
M$3815 \$5178 B|C|Y VPB|VPWR VPB|VPWR sky130_fd_pr__pfet_01v8_hvt L=0.15 W=0.42
+ AS=0.0609 AD=0.1841 PS=0.71 PD=1.26
M$3816 VPB|VPWR \$5178 A|B|X VPB|VPWR sky130_fd_pr__pfet_01v8_hvt L=0.15 W=0.64
+ AS=0.1841 AD=0.1696 PS=1.26 PD=1.81
M$3817 \$5022 C|X \$5018 VPB|VPWR sky130_fd_pr__pfet_01v8_hvt L=0.15 W=0.84
+ AS=0.2688 AD=0.1596 PS=2.32 PD=1.22
M$3818 \$5018 \$5020 \$5021 VPB|VPWR sky130_fd_pr__pfet_01v8_hvt L=0.15 W=0.84
+ AS=0.1596 AD=0.441 PS=1.22 PD=2.73
M$3819 B|Y B|Y \$5217 VPB|VPWR sky130_fd_pr__pfet_01v8_hvt L=0.15 W=1 AS=0.26
+ AD=0.105 PS=2.52 PD=1.21
M$3820 \$5217 A|B|X VPB|VPWR VPB|VPWR sky130_fd_pr__pfet_01v8_hvt L=0.15 W=1
+ AS=0.105 AD=0.26 PS=1.21 PD=2.52
M$3821 \$5182 B|C|Y \$5218 VPB|VPWR sky130_fd_pr__pfet_01v8_hvt L=0.15 W=1
+ AS=0.26 AD=0.135 PS=2.52 PD=1.27
M$3822 \$5218 A|Y VPB|VPWR VPB|VPWR sky130_fd_pr__pfet_01v8_hvt L=0.15 W=1
+ AS=0.135 AD=0.135 PS=1.27 PD=1.27
M$3823 VPB|VPWR A|Y \$5183 VPB|VPWR sky130_fd_pr__pfet_01v8_hvt L=0.15 W=1
+ AS=0.135 AD=0.135 PS=1.27 PD=1.27
M$3824 \$5183 B|C|Y VPB|VPWR VPB|VPWR sky130_fd_pr__pfet_01v8_hvt L=0.15 W=1
+ AS=0.135 AD=0.26 PS=1.27 PD=2.52
M$3825 \$5183 \$5182 C|X VPB|VPWR sky130_fd_pr__pfet_01v8_hvt L=0.15 W=1
+ AS=0.26 AD=0.3 PS=2.52 PD=2.6
M$3826 VPB|VPWR C|X A|Y VPB|VPWR sky130_fd_pr__pfet_01v8_hvt L=0.15 W=1 AS=0.26
+ AD=0.135 PS=2.52 PD=1.27
M$3829 \$5187 \$5226 \$5188 VPB|VPWR sky130_fd_pr__pfet_01v8_hvt L=0.15 W=0.84
+ AS=0.1715 AD=0.1458 PS=1.355 PD=1.205
M$3830 \$5188 B|X \$5186 VPB|VPWR sky130_fd_pr__pfet_01v8_hvt L=0.15 W=0.64
+ AS=0.1458 AD=0.246 PS=1.205 PD=1.525
M$3831 \$5186 \$5187 VPB|VPWR VPB|VPWR sky130_fd_pr__pfet_01v8_hvt L=0.15 W=1
+ AS=0.285 AD=0.135 PS=2.57 PD=1.27
M$3832 VPB|VPWR A|Y \$5187 VPB|VPWR sky130_fd_pr__pfet_01v8_hvt L=0.15 W=1
+ AS=0.135 AD=0.1715 PS=1.27 PD=1.355
M$3833 \$5189 \$5226 \$5186 VPB|VPWR sky130_fd_pr__pfet_01v8_hvt L=0.15 W=0.64
+ AS=0.2431 AD=0.246 PS=1.445 PD=1.525
M$3834 \$5189 B|X \$5187 VPB|VPWR sky130_fd_pr__pfet_01v8_hvt L=0.15 W=0.84
+ AS=0.2431 AD=0.3528 PS=1.445 PD=2.52
M$3835 \$5026 C|Y \$5150 VPB|VPWR sky130_fd_pr__pfet_01v8_hvt L=0.15 W=0.42
+ AS=0.1092 AD=0.0441 PS=1.36 PD=0.63
M$3836 \$5150 A|Y VPB|VPWR VPB|VPWR sky130_fd_pr__pfet_01v8_hvt L=0.15 W=0.42
+ AS=0.0441 AD=0.0567 PS=0.63 PD=0.69
M$3837 VPB|VPWR A|Y \$5151 VPB|VPWR sky130_fd_pr__pfet_01v8_hvt L=0.15 W=0.42
+ AS=0.0567 AD=0.0441 PS=0.69 PD=0.63
M$3838 \$5151 B|X \$5026 VPB|VPWR sky130_fd_pr__pfet_01v8_hvt L=0.15 W=0.42
+ AS=0.0441 AD=0.0567 PS=0.63 PD=0.69
M$3839 \$5026 B|X \$5152 VPB|VPWR sky130_fd_pr__pfet_01v8_hvt L=0.15 W=0.42
+ AS=0.0567 AD=0.0441 PS=0.69 PD=0.63
M$3840 VPB|VPWR C|Y \$5152 VPB|VPWR sky130_fd_pr__pfet_01v8_hvt L=0.15 W=0.42
+ AS=0.2492 AD=0.0441 PS=1.565 PD=0.63
M$3841 VPB|VPWR \$5026 B|SLEEP|X VPB|VPWR sky130_fd_pr__pfet_01v8_hvt L=0.15
+ W=1 AS=0.2492 AD=0.365 PS=1.565 PD=2.73
M$3842 \$5226 B|X VPB|VPWR VPB|VPWR sky130_fd_pr__pfet_01v8_hvt L=0.15 W=1
+ AS=0.26 AD=0.25655 PS=2.52 PD=2.52
M$3843 VPB|VPWR C|Y \$5191 VPB|VPWR sky130_fd_pr__pfet_01v8_hvt L=0.15 W=0.64
+ AS=0.169 AD=0.1792 PS=1.365 PD=1.84
M$3844 VPB|VPWR \$5190 A|B|X VPB|VPWR sky130_fd_pr__pfet_01v8_hvt L=0.15 W=1
+ AS=0.169 AD=0.28 PS=1.365 PD=2.56
M$3845 VPB|VPWR B|SLEEP|X \$5192 VPB|VPWR sky130_fd_pr__pfet_01v8_hvt L=0.15
+ W=1 AS=0.3 AD=0.135 PS=2.6 PD=1.27
M$3846 \$5192 A|Y VPB|VPWR VPB|VPWR sky130_fd_pr__pfet_01v8_hvt L=0.15 W=1
+ AS=0.135 AD=0.365 PS=1.27 PD=1.73
M$3847 VPB|VPWR A|Y \$5220 VPB|VPWR sky130_fd_pr__pfet_01v8_hvt L=0.15 W=1
+ AS=0.365 AD=0.105 PS=1.73 PD=1.21
M$3848 \$5220 B|SLEEP|X A1|B|C|Y VPB|VPWR sky130_fd_pr__pfet_01v8_hvt L=0.15
+ W=1 AS=0.105 AD=0.165 PS=1.21 PD=1.33
M$3849 A1|B|C|Y \$5192 VPB|VPWR VPB|VPWR sky130_fd_pr__pfet_01v8_hvt L=0.15 W=1
+ AS=0.165 AD=0.36 PS=1.33 PD=2.72
M$3870 VPB|VPWR D|X \$5196 VPB|VPWR sky130_fd_pr__pfet_01v8_hvt L=0.15 W=0.42
+ AS=0.1092 AD=0.0651 PS=1.36 PD=0.73
M$3871 \$5196 \$5194 \$5197 VPB|VPWR sky130_fd_pr__pfet_01v8_hvt L=0.15 W=0.42
+ AS=0.0651 AD=0.07245 PS=0.73 PD=0.765
M$3872 \$5197 \$5193 \$5198 VPB|VPWR sky130_fd_pr__pfet_01v8_hvt L=0.15 W=0.42
+ AS=0.07245 AD=0.1155 PS=0.765 PD=0.97
M$3873 \$5198 \$5199 VPB|VPWR VPB|VPWR sky130_fd_pr__pfet_01v8_hvt L=0.15
+ W=0.42 AS=0.1155 AD=0.07035 PS=0.97 PD=0.755
M$3874 VPB|VPWR RESET_B|X \$5198 VPB|VPWR sky130_fd_pr__pfet_01v8_hvt L=0.15
+ W=0.42 AS=0.07035 AD=0.1092 PS=0.755 PD=1.36
M$3875 \$5199 \$5193 \$5200 VPB|VPWR sky130_fd_pr__pfet_01v8_hvt L=0.15 W=0.42
+ AS=0.12915 AD=0.0588 PS=1.185 PD=0.7
M$3876 \$5200 \$5194 \$5206 VPB|VPWR sky130_fd_pr__pfet_01v8_hvt L=0.15 W=0.42
+ AS=0.0588 AD=0.0567 PS=0.7 PD=0.69
M$3877 \$5206 \$5201 VPB|VPWR VPB|VPWR sky130_fd_pr__pfet_01v8_hvt L=0.15
+ W=0.42 AS=0.0567 AD=0.0819 PS=0.69 PD=0.81
M$3878 VPB|VPWR RESET_B|X \$5201 VPB|VPWR sky130_fd_pr__pfet_01v8_hvt L=0.15
+ W=0.42 AS=0.0819 AD=0.0567 PS=0.81 PD=0.69
M$3879 \$5201 \$5200 VPB|VPWR VPB|VPWR sky130_fd_pr__pfet_01v8_hvt L=0.15
+ W=0.42 AS=0.0567 AD=0.1134 PS=0.69 PD=1.38
M$3880 VPB|VPWR \$5197 \$5199 VPB|VPWR sky130_fd_pr__pfet_01v8_hvt L=0.15
+ W=0.84 AS=0.2184 AD=0.12915 PS=2.2 PD=1.185
M$3881 VPB|VPWR \$5201 A|Q VPB|VPWR sky130_fd_pr__pfet_01v8_hvt L=0.15 W=1
+ AS=0.3012 AD=0.26 PS=2.66 PD=2.52
M$3882 \$5255 A|FINE_MUX[10] VPB|VPWR VPB|VPWR sky130_fd_pr__pfet_01v8_hvt
+ L=0.15 W=1 AS=0.27 AD=0.1701 PS=2.54 PD=1.36
M$3883 VPB|VPWR \$5255 \$5256 VPB|VPWR sky130_fd_pr__pfet_01v8_hvt L=0.5 W=0.82
+ AS=0.1701 AD=0.2173 PS=1.36 PD=2.17
M$3884 VPB|VPWR \$5256 \$5257 VPB|VPWR sky130_fd_pr__pfet_01v8_hvt L=0.5 W=0.82
+ AS=0.15575 AD=0.2173 PS=1.325 PD=2.17
M$3885 VPB|VPWR \$5257 A|B1|X VPB|VPWR sky130_fd_pr__pfet_01v8_hvt L=0.15 W=1
+ AS=0.15575 AD=0.355 PS=1.325 PD=2.71
M$3886 \$5258 A|A1|B|X \$5425 VPB|VPWR sky130_fd_pr__pfet_01v8_hvt L=0.15 W=1
+ AS=0.26 AD=0.135 PS=2.52 PD=1.27
M$3887 \$5425 A|B1|X VPB|VPWR VPB|VPWR sky130_fd_pr__pfet_01v8_hvt L=0.15 W=1
+ AS=0.135 AD=0.135 PS=1.27 PD=1.27
M$3888 VPB|VPWR A|B1|X \$5412 VPB|VPWR sky130_fd_pr__pfet_01v8_hvt L=0.15 W=1
+ AS=0.135 AD=0.135 PS=1.27 PD=1.27
M$3889 \$5412 A|A1|B|X VPB|VPWR VPB|VPWR sky130_fd_pr__pfet_01v8_hvt L=0.15 W=1
+ AS=0.135 AD=0.26 PS=1.27 PD=2.52
M$3890 \$5412 \$5258 A|A1|B|X VPB|VPWR sky130_fd_pr__pfet_01v8_hvt L=0.15 W=1
+ AS=0.26 AD=0.3 PS=2.52 PD=2.6
M$3892 \$5169 A|B|Y \$5207 VPB|VPWR sky130_fd_pr__pfet_01v8_hvt L=0.15 W=0.42
+ AS=0.1092 AD=0.0441 PS=1.36 PD=0.63
M$3893 VPB|VPWR A2|B|SLEEP|Y \$5207 VPB|VPWR sky130_fd_pr__pfet_01v8_hvt L=0.15
+ W=0.42 AS=0.14575 AD=0.0441 PS=1.335 PD=0.63
M$3894 VPB|VPWR \$5169 B1|C1|X VPB|VPWR sky130_fd_pr__pfet_01v8_hvt L=0.15 W=1
+ AS=0.14575 AD=0.34 PS=1.335 PD=2.68
M$3896 VPB|VPWR A|A1|Y A|A1|Y VPB|VPWR sky130_fd_pr__pfet_01v8_hvt L=0.15
+ W=1.68 AS=0.3486 AD=0.3318 PS=3.35 PD=3.31
M$3898 VPB|VPWR A|A1|Y B1|Y VPB|VPWR sky130_fd_pr__pfet_01v8_hvt L=0.15 W=2
+ AS=0.395 AD=0.395 PS=3.79 PD=3.79
M$3899 B1|Y A|B|Y VPB|VPWR VPB|VPWR sky130_fd_pr__pfet_01v8_hvt L=0.15 W=2
+ AS=0.27 AD=0.425 PS=2.54 PD=3.85
M$3902 \$5174 B|C|Y \$5210 VPB|VPWR sky130_fd_pr__pfet_01v8_hvt L=0.15 W=0.42
+ AS=0.1092 AD=0.0441 PS=1.36 PD=0.63
M$3903 \$5210 A|Y VPB|VPWR VPB|VPWR sky130_fd_pr__pfet_01v8_hvt L=0.15 W=0.42
+ AS=0.0441 AD=0.0567 PS=0.63 PD=0.69
M$3904 VPB|VPWR A|Y \$5211 VPB|VPWR sky130_fd_pr__pfet_01v8_hvt L=0.15 W=0.42
+ AS=0.0567 AD=0.0441 PS=0.69 PD=0.63
M$3905 \$5211 A|B|Y \$5174 VPB|VPWR sky130_fd_pr__pfet_01v8_hvt L=0.15 W=0.42
+ AS=0.0441 AD=0.0567 PS=0.63 PD=0.69
M$3906 \$5174 A|B|Y \$5212 VPB|VPWR sky130_fd_pr__pfet_01v8_hvt L=0.15 W=0.42
+ AS=0.0567 AD=0.0441 PS=0.69 PD=0.63
M$3907 VPB|VPWR B|C|Y \$5212 VPB|VPWR sky130_fd_pr__pfet_01v8_hvt L=0.15 W=0.42
+ AS=0.2492 AD=0.0441 PS=1.565 PD=0.63
M$3908 VPB|VPWR \$5174 A|X VPB|VPWR sky130_fd_pr__pfet_01v8_hvt L=0.15 W=1
+ AS=0.2492 AD=0.365 PS=1.565 PD=2.73
M$3911 VPB|VPWR A|Y \$5430 VPB|VPWR sky130_fd_pr__pfet_01v8_hvt L=0.15 W=1
+ AS=0.26 AD=0.105 PS=2.52 PD=1.21
M$3912 \$5430 B|Y B|C|Y VPB|VPWR sky130_fd_pr__pfet_01v8_hvt L=0.15 W=1
+ AS=0.105 AD=0.26 PS=1.21 PD=2.52
M$3913 \$5262 B|Y \$5431 VPB|VPWR sky130_fd_pr__pfet_01v8_hvt L=0.15 W=1
+ AS=0.26 AD=0.135 PS=2.52 PD=1.27
M$3914 \$5431 A|X VPB|VPWR VPB|VPWR sky130_fd_pr__pfet_01v8_hvt L=0.15 W=1
+ AS=0.135 AD=0.135 PS=1.27 PD=1.27
M$3915 VPB|VPWR A|X \$5413 VPB|VPWR sky130_fd_pr__pfet_01v8_hvt L=0.15 W=1
+ AS=0.135 AD=0.135 PS=1.27 PD=1.27
M$3916 \$5413 B|Y VPB|VPWR VPB|VPWR sky130_fd_pr__pfet_01v8_hvt L=0.15 W=1
+ AS=0.135 AD=0.26 PS=1.27 PD=2.52
M$3917 \$5413 \$5262 B|X VPB|VPWR sky130_fd_pr__pfet_01v8_hvt L=0.15 W=1
+ AS=0.26 AD=0.3 PS=2.52 PD=2.6
M$3919 \$5177 B|C|Y \$5214 VPB|VPWR sky130_fd_pr__pfet_01v8_hvt L=0.15 W=0.42
+ AS=0.1092 AD=0.0441 PS=1.36 PD=0.63
M$3920 \$5214 A|Y VPB|VPWR VPB|VPWR sky130_fd_pr__pfet_01v8_hvt L=0.15 W=0.42
+ AS=0.0441 AD=0.0567 PS=0.63 PD=0.69
M$3921 VPB|VPWR A|Y \$5215 VPB|VPWR sky130_fd_pr__pfet_01v8_hvt L=0.15 W=0.42
+ AS=0.0567 AD=0.0441 PS=0.69 PD=0.63
M$3922 \$5215 A|B|X \$5177 VPB|VPWR sky130_fd_pr__pfet_01v8_hvt L=0.15 W=0.42
+ AS=0.0441 AD=0.0567 PS=0.63 PD=0.69
M$3923 \$5177 A|B|X \$5216 VPB|VPWR sky130_fd_pr__pfet_01v8_hvt L=0.15 W=0.42
+ AS=0.0567 AD=0.0441 PS=0.69 PD=0.63
M$3924 VPB|VPWR B|C|Y \$5216 VPB|VPWR sky130_fd_pr__pfet_01v8_hvt L=0.15 W=0.42
+ AS=0.2492 AD=0.0441 PS=1.565 PD=0.63
M$3925 VPB|VPWR \$5177 C|X VPB|VPWR sky130_fd_pr__pfet_01v8_hvt L=0.15 W=1
+ AS=0.2492 AD=0.365 PS=1.565 PD=2.73
M$3927 VPB|VPWR A|B|X \$5434 VPB|VPWR sky130_fd_pr__pfet_01v8_hvt L=0.15 W=1
+ AS=0.26 AD=0.105 PS=2.52 PD=1.21
M$3928 \$5434 B|C|Y B|Y VPB|VPWR sky130_fd_pr__pfet_01v8_hvt L=0.15 W=1
+ AS=0.105 AD=0.26 PS=1.21 PD=2.52
M$3931 \$5190 C|Y \$5188 VPB|VPWR sky130_fd_pr__pfet_01v8_hvt L=0.15 W=0.84
+ AS=0.15295 AD=0.273 PS=1.315 PD=2.33
M$3932 \$5190 \$5191 \$5189 VPB|VPWR sky130_fd_pr__pfet_01v8_hvt L=0.15 W=0.84
+ AS=0.15295 AD=0.32235 PS=1.315 PD=2.45
M$3948 VPB|VPWR \$5270 \$5414 VPB|VPWR sky130_fd_pr__pfet_01v8_hvt L=0.15
+ W=0.84 AS=0.2184 AD=0.12915 PS=2.2 PD=1.185
M$3949 \$5414 \$5266 \$5271 VPB|VPWR sky130_fd_pr__pfet_01v8_hvt L=0.15 W=0.42
+ AS=0.12915 AD=0.0588 PS=1.185 PD=0.7
M$3950 \$5271 \$5267 \$5429 VPB|VPWR sky130_fd_pr__pfet_01v8_hvt L=0.15 W=0.42
+ AS=0.0588 AD=0.0567 PS=0.7 PD=0.69
M$3951 \$5429 \$5272 VPB|VPWR VPB|VPWR sky130_fd_pr__pfet_01v8_hvt L=0.15
+ W=0.42 AS=0.0567 AD=0.0819 PS=0.69 PD=0.81
M$3952 VPB|VPWR RESET_B|X \$5272 VPB|VPWR sky130_fd_pr__pfet_01v8_hvt L=0.15
+ W=0.42 AS=0.0819 AD=0.0567 PS=0.81 PD=0.69
M$3953 \$5272 \$5271 VPB|VPWR VPB|VPWR sky130_fd_pr__pfet_01v8_hvt L=0.15
+ W=0.42 AS=0.0567 AD=0.1134 PS=0.69 PD=1.38
M$3954 VPB|VPWR \$5272 A|C1|Q VPB|VPWR sky130_fd_pr__pfet_01v8_hvt L=0.15 W=1
+ AS=0.3012 AD=0.26 PS=2.66 PD=2.52
M$3957 VPB|VPWR \$5277 \$5416 VPB|VPWR sky130_fd_pr__pfet_01v8_hvt L=0.15
+ W=0.84 AS=0.2184 AD=0.12915 PS=2.2 PD=1.185
M$3958 \$5416 \$5274 \$5278 VPB|VPWR sky130_fd_pr__pfet_01v8_hvt L=0.15 W=0.42
+ AS=0.12915 AD=0.0588 PS=1.185 PD=0.7
M$3959 \$5278 \$5275 \$5427 VPB|VPWR sky130_fd_pr__pfet_01v8_hvt L=0.15 W=0.42
+ AS=0.0588 AD=0.0567 PS=0.7 PD=0.69
M$3960 \$5427 \$5279 VPB|VPWR VPB|VPWR sky130_fd_pr__pfet_01v8_hvt L=0.15
+ W=0.42 AS=0.0567 AD=0.0819 PS=0.69 PD=0.81
M$3961 VPB|VPWR RESET_B|X \$5279 VPB|VPWR sky130_fd_pr__pfet_01v8_hvt L=0.15
+ W=0.42 AS=0.0819 AD=0.0567 PS=0.81 PD=0.69
M$3962 \$5279 \$5278 VPB|VPWR VPB|VPWR sky130_fd_pr__pfet_01v8_hvt L=0.15
+ W=0.42 AS=0.0567 AD=0.1134 PS=0.69 PD=1.38
M$3963 VPB|VPWR \$5279 A|Q VPB|VPWR sky130_fd_pr__pfet_01v8_hvt L=0.15 W=1
+ AS=0.3012 AD=0.26 PS=2.66 PD=2.52
M$3965 \$5282 B_N|Y VPB|VPWR VPB|VPWR sky130_fd_pr__pfet_01v8_hvt L=0.15 W=0.42
+ AS=0.1092 AD=0.1573 PS=1.36 PD=1.39
M$3966 VPB|VPWR A|B|Y \$5426 VPB|VPWR sky130_fd_pr__pfet_01v8_hvt L=0.15 W=1
+ AS=0.1573 AD=0.105 PS=1.39 PD=1.21
M$3967 \$5426 \$5282 D|Y VPB|VPWR sky130_fd_pr__pfet_01v8_hvt L=0.15 W=1
+ AS=0.105 AD=0.26 PS=1.21 PD=2.52
M$3969 VPB|VPWR A|Q B|B1|Y VPB|VPWR sky130_fd_pr__pfet_01v8_hvt L=0.15 W=1.68
+ AS=0.3486 AD=0.3318 PS=3.35 PD=3.31
M$3972 \$5286 A|B|Y \$5424 VPB|VPWR sky130_fd_pr__pfet_01v8_hvt L=0.15 W=1
+ AS=0.26 AD=0.135 PS=2.52 PD=1.27
M$3973 \$5424 A|Q VPB|VPWR VPB|VPWR sky130_fd_pr__pfet_01v8_hvt L=0.15 W=1
+ AS=0.135 AD=0.135 PS=1.27 PD=1.27
M$3974 VPB|VPWR A|Q \$5418 VPB|VPWR sky130_fd_pr__pfet_01v8_hvt L=0.15 W=1
+ AS=0.135 AD=0.135 PS=1.27 PD=1.27
M$3975 \$5418 A|B|Y VPB|VPWR VPB|VPWR sky130_fd_pr__pfet_01v8_hvt L=0.15 W=1
+ AS=0.135 AD=0.26 PS=1.27 PD=2.52
M$3976 \$5193 CLK|TICK VPB|VPWR VPB|VPWR sky130_fd_pr__pfet_01v8_hvt L=0.15
+ W=0.64 AS=0.1664 AD=0.0864 PS=1.8 PD=0.91
M$3977 VPB|VPWR \$5193 \$5194 VPB|VPWR sky130_fd_pr__pfet_01v8_hvt L=0.15
+ W=0.64 AS=0.0864 AD=0.1664 PS=0.91 PD=1.8
M$3978 \$5418 \$5286 D|X VPB|VPWR sky130_fd_pr__pfet_01v8_hvt L=0.15 W=1
+ AS=0.26 AD=0.3 PS=2.52 PD=2.6
M$3980 \$5287 A|Q VPB|VPWR VPB|VPWR sky130_fd_pr__pfet_01v8_hvt L=0.15 W=1
+ AS=0.27 AD=0.1701 PS=2.54 PD=1.36
M$3981 VPB|VPWR \$5287 \$5288 VPB|VPWR sky130_fd_pr__pfet_01v8_hvt L=0.5 W=0.82
+ AS=0.1701 AD=0.2173 PS=1.36 PD=2.17
M$3982 VPB|VPWR \$5288 \$5289 VPB|VPWR sky130_fd_pr__pfet_01v8_hvt L=0.5 W=0.82
+ AS=0.15575 AD=0.2173 PS=1.325 PD=2.17
M$3983 VPB|VPWR \$5289 MID_OUT|X VPB|VPWR sky130_fd_pr__pfet_01v8_hvt L=0.15
+ W=1 AS=0.15575 AD=0.355 PS=1.325 PD=2.71
M$3989 VPB|VPWR B|B_N|X \$5436 VPB|VPWR sky130_fd_pr__pfet_01v8_hvt L=0.15
+ W=0.42 AS=0.1573 AD=0.1092 PS=1.39 PD=1.36
M$3990 VPB|VPWR A|Y \$5480 VPB|VPWR sky130_fd_pr__pfet_01v8_hvt L=0.15 W=1
+ AS=0.1573 AD=0.105 PS=1.39 PD=1.21
M$3991 \$5480 \$5436 A|B|Y VPB|VPWR sky130_fd_pr__pfet_01v8_hvt L=0.15 W=1
+ AS=0.105 AD=0.26 PS=1.21 PD=2.52
M$3993 VPB|VPWR B|X \$5438 VPB|VPWR sky130_fd_pr__pfet_01v8_hvt L=0.15 W=1
+ AS=0.3 AD=0.135 PS=2.6 PD=1.27
M$3994 \$5438 A|B|Y VPB|VPWR VPB|VPWR sky130_fd_pr__pfet_01v8_hvt L=0.15 W=1
+ AS=0.135 AD=0.365 PS=1.27 PD=1.73
M$3995 VPB|VPWR A|B|Y \$5481 VPB|VPWR sky130_fd_pr__pfet_01v8_hvt L=0.15 W=1
+ AS=0.365 AD=0.105 PS=1.73 PD=1.21
M$3996 \$5481 B|X A|C|Y VPB|VPWR sky130_fd_pr__pfet_01v8_hvt L=0.15 W=1
+ AS=0.105 AD=0.165 PS=1.21 PD=1.33
M$3997 A|C|Y \$5438 VPB|VPWR VPB|VPWR sky130_fd_pr__pfet_01v8_hvt L=0.15 W=1
+ AS=0.165 AD=0.36 PS=1.33 PD=2.72
M$4000 VPB|VPWR A|Y \$5482 VPB|VPWR sky130_fd_pr__pfet_01v8_hvt L=0.15 W=1
+ AS=0.26 AD=0.105 PS=2.52 PD=1.21
M$4001 \$5482 B|X A|Y VPB|VPWR sky130_fd_pr__pfet_01v8_hvt L=0.15 W=1 AS=0.105
+ AD=0.26 PS=1.21 PD=2.52
M$4003 \$5441 \$5495 \$5442 VPB|VPWR sky130_fd_pr__pfet_01v8_hvt L=0.15 W=0.84
+ AS=0.1715 AD=0.1458 PS=1.355 PD=1.205
M$4004 \$5442 A|B|X \$5440 VPB|VPWR sky130_fd_pr__pfet_01v8_hvt L=0.15 W=0.64
+ AS=0.1458 AD=0.246 PS=1.205 PD=1.525
M$4005 \$5440 \$5441 VPB|VPWR VPB|VPWR sky130_fd_pr__pfet_01v8_hvt L=0.15 W=1
+ AS=0.285 AD=0.135 PS=2.57 PD=1.27
M$4006 VPB|VPWR A|Y \$5441 VPB|VPWR sky130_fd_pr__pfet_01v8_hvt L=0.15 W=1
+ AS=0.135 AD=0.1715 PS=1.27 PD=1.355
M$4007 \$5443 \$5495 \$5440 VPB|VPWR sky130_fd_pr__pfet_01v8_hvt L=0.15 W=0.64
+ AS=0.2431 AD=0.246 PS=1.445 PD=1.525
M$4008 \$5443 A|B|X \$5441 VPB|VPWR sky130_fd_pr__pfet_01v8_hvt L=0.15 W=0.84
+ AS=0.2431 AD=0.3528 PS=1.445 PD=2.52
M$4009 \$5495 A|B|X VPB|VPWR VPB|VPWR sky130_fd_pr__pfet_01v8_hvt L=0.15 W=1
+ AS=0.26 AD=0.25655 PS=2.52 PD=2.52
M$4010 VPB|VPWR B|C|Y \$5445 VPB|VPWR sky130_fd_pr__pfet_01v8_hvt L=0.15 W=0.64
+ AS=0.169 AD=0.1792 PS=1.365 PD=1.84
M$4011 VPB|VPWR \$5444 A|C|X VPB|VPWR sky130_fd_pr__pfet_01v8_hvt L=0.15 W=1
+ AS=0.169 AD=0.28 PS=1.365 PD=2.56
M$4012 VPB|VPWR A|Y C|Y VPB|VPWR sky130_fd_pr__pfet_01v8_hvt L=0.15 W=1 AS=0.26
+ AD=0.135 PS=2.52 PD=1.27
M$4013 C|Y B|C|D_N|X VPB|VPWR VPB|VPWR sky130_fd_pr__pfet_01v8_hvt L=0.15 W=1
+ AS=0.135 AD=0.26 PS=1.27 PD=2.52
M$4016 \$5447 A1|B|C|Y \$5485 VPB|VPWR sky130_fd_pr__pfet_01v8_hvt L=0.15 W=1
+ AS=0.26 AD=0.135 PS=2.52 PD=1.27
M$4017 \$5485 A|C|Y VPB|VPWR VPB|VPWR sky130_fd_pr__pfet_01v8_hvt L=0.15 W=1
+ AS=0.135 AD=0.135 PS=1.27 PD=1.27
M$4018 VPB|VPWR A|C|Y \$5448 VPB|VPWR sky130_fd_pr__pfet_01v8_hvt L=0.15 W=1
+ AS=0.135 AD=0.135 PS=1.27 PD=1.27
M$4019 \$5448 A1|B|C|Y VPB|VPWR VPB|VPWR sky130_fd_pr__pfet_01v8_hvt L=0.15 W=1
+ AS=0.135 AD=0.26 PS=1.27 PD=2.52
M$4020 \$5448 \$5447 A0|A2|X VPB|VPWR sky130_fd_pr__pfet_01v8_hvt L=0.15 W=1
+ AS=0.26 AD=0.3 PS=2.52 PD=2.6
M$4034 A|B1|Q \$5451 VPB|VPWR VPB|VPWR sky130_fd_pr__pfet_01v8_hvt L=0.15 W=1
+ AS=0.26 AD=0.3012 PS=2.52 PD=2.66
M$4035 VPB|VPWR \$5452 \$5451 VPB|VPWR sky130_fd_pr__pfet_01v8_hvt L=0.15
+ W=0.42 AS=0.1134 AD=0.0567 PS=1.38 PD=0.69
M$4036 \$5451 RESET_B|X VPB|VPWR VPB|VPWR sky130_fd_pr__pfet_01v8_hvt L=0.15
+ W=0.42 AS=0.0567 AD=0.0819 PS=0.69 PD=0.81
M$4037 VPB|VPWR \$5451 \$5490 VPB|VPWR sky130_fd_pr__pfet_01v8_hvt L=0.15
+ W=0.42 AS=0.0819 AD=0.0567 PS=0.81 PD=0.69
M$4038 \$5490 \$5453 \$5452 VPB|VPWR sky130_fd_pr__pfet_01v8_hvt L=0.15 W=0.42
+ AS=0.0567 AD=0.0588 PS=0.69 PD=0.7
M$4039 \$5452 \$5454 \$5455 VPB|VPWR sky130_fd_pr__pfet_01v8_hvt L=0.15 W=0.42
+ AS=0.0588 AD=0.12915 PS=0.7 PD=1.185
M$4040 \$5455 \$5457 VPB|VPWR VPB|VPWR sky130_fd_pr__pfet_01v8_hvt L=0.15
+ W=0.84 AS=0.12915 AD=0.2184 PS=1.185 PD=2.2
M$4041 \$5456 RESET_B|X VPB|VPWR VPB|VPWR sky130_fd_pr__pfet_01v8_hvt L=0.15
+ W=0.42 AS=0.1092 AD=0.07035 PS=1.36 PD=0.755
M$4042 VPB|VPWR \$5455 \$5456 VPB|VPWR sky130_fd_pr__pfet_01v8_hvt L=0.15
+ W=0.42 AS=0.07035 AD=0.1155 PS=0.755 PD=0.97
M$4043 \$5456 \$5454 \$5457 VPB|VPWR sky130_fd_pr__pfet_01v8_hvt L=0.15 W=0.42
+ AS=0.1155 AD=0.07245 PS=0.97 PD=0.765
M$4044 \$5457 \$5453 \$5458 VPB|VPWR sky130_fd_pr__pfet_01v8_hvt L=0.15 W=0.42
+ AS=0.07245 AD=0.0651 PS=0.765 PD=0.73
M$4045 \$5458 D|X VPB|VPWR VPB|VPWR sky130_fd_pr__pfet_01v8_hvt L=0.15 W=0.42
+ AS=0.0651 AD=0.1092 PS=0.73 PD=1.36
M$4046 \$5266 CLK|TICK VPB|VPWR VPB|VPWR sky130_fd_pr__pfet_01v8_hvt L=0.15
+ W=0.64 AS=0.1664 AD=0.0864 PS=1.8 PD=0.91
M$4047 VPB|VPWR \$5266 \$5267 VPB|VPWR sky130_fd_pr__pfet_01v8_hvt L=0.15
+ W=0.64 AS=0.0864 AD=0.1664 PS=0.91 PD=1.8
M$4048 VPB|VPWR D|Y \$5269 VPB|VPWR sky130_fd_pr__pfet_01v8_hvt L=0.15 W=0.42
+ AS=0.1092 AD=0.0651 PS=1.36 PD=0.73
M$4049 \$5269 \$5267 \$5270 VPB|VPWR sky130_fd_pr__pfet_01v8_hvt L=0.15 W=0.42
+ AS=0.0651 AD=0.07245 PS=0.73 PD=0.765
M$4050 \$5270 \$5266 \$5419 VPB|VPWR sky130_fd_pr__pfet_01v8_hvt L=0.15 W=0.42
+ AS=0.07245 AD=0.1155 PS=0.765 PD=0.97
M$4051 \$5419 \$5414 VPB|VPWR VPB|VPWR sky130_fd_pr__pfet_01v8_hvt L=0.15
+ W=0.42 AS=0.1155 AD=0.07035 PS=0.97 PD=0.755
M$4052 VPB|VPWR RESET_B|X \$5419 VPB|VPWR sky130_fd_pr__pfet_01v8_hvt L=0.15
+ W=0.42 AS=0.07035 AD=0.1092 PS=0.755 PD=1.36
M$4053 VPB|VPWR \$5459 D|Y VPB|VPWR sky130_fd_pr__pfet_01v8_hvt L=0.15 W=1
+ AS=0.36 AD=0.165 PS=2.72 PD=1.33
M$4054 D|Y B|Y \$5491 VPB|VPWR sky130_fd_pr__pfet_01v8_hvt L=0.15 W=1 AS=0.165
+ AD=0.105 PS=1.33 PD=1.21
M$4055 \$5491 A|C1|Q VPB|VPWR VPB|VPWR sky130_fd_pr__pfet_01v8_hvt L=0.15 W=1
+ AS=0.105 AD=0.365 PS=1.21 PD=1.73
M$4056 VPB|VPWR A|C1|Q \$5459 VPB|VPWR sky130_fd_pr__pfet_01v8_hvt L=0.15 W=1
+ AS=0.365 AD=0.135 PS=1.73 PD=1.27
M$4057 \$5459 B|Y VPB|VPWR VPB|VPWR sky130_fd_pr__pfet_01v8_hvt L=0.15 W=1
+ AS=0.135 AD=0.3 PS=1.27 PD=2.6
M$4059 VPB|VPWR B|Y \$5461 VPB|VPWR sky130_fd_pr__pfet_01v8_hvt L=0.15 W=1
+ AS=0.3 AD=0.135 PS=2.6 PD=1.27
M$4060 \$5461 A|D1|Q VPB|VPWR VPB|VPWR sky130_fd_pr__pfet_01v8_hvt L=0.15 W=1
+ AS=0.135 AD=0.365 PS=1.27 PD=1.73
M$4061 VPB|VPWR A|D1|Q \$5493 VPB|VPWR sky130_fd_pr__pfet_01v8_hvt L=0.15 W=1
+ AS=0.365 AD=0.105 PS=1.73 PD=1.21
M$4062 \$5493 B|Y D|Y VPB|VPWR sky130_fd_pr__pfet_01v8_hvt L=0.15 W=1 AS=0.105
+ AD=0.165 PS=1.21 PD=1.33
M$4063 D|Y \$5461 VPB|VPWR VPB|VPWR sky130_fd_pr__pfet_01v8_hvt L=0.15 W=1
+ AS=0.165 AD=0.36 PS=1.33 PD=2.72
M$4065 \$5274 CLK|TICK VPB|VPWR VPB|VPWR sky130_fd_pr__pfet_01v8_hvt L=0.15
+ W=0.64 AS=0.1664 AD=0.0864 PS=1.8 PD=0.91
M$4066 VPB|VPWR \$5274 \$5275 VPB|VPWR sky130_fd_pr__pfet_01v8_hvt L=0.15
+ W=0.64 AS=0.0864 AD=0.1664 PS=0.91 PD=1.8
M$4067 VPB|VPWR \$5463 D|Y VPB|VPWR sky130_fd_pr__pfet_01v8_hvt L=0.15 W=1
+ AS=0.36 AD=0.165 PS=2.72 PD=1.33
M$4068 D|Y A2|B|C|Y \$5492 VPB|VPWR sky130_fd_pr__pfet_01v8_hvt L=0.15 W=1
+ AS=0.165 AD=0.105 PS=1.33 PD=1.21
M$4069 \$5492 A|Q VPB|VPWR VPB|VPWR sky130_fd_pr__pfet_01v8_hvt L=0.15 W=1
+ AS=0.105 AD=0.365 PS=1.21 PD=1.73
M$4070 VPB|VPWR A|Q \$5463 VPB|VPWR sky130_fd_pr__pfet_01v8_hvt L=0.15 W=1
+ AS=0.365 AD=0.135 PS=1.73 PD=1.27
M$4071 \$5463 A2|B|C|Y VPB|VPWR VPB|VPWR sky130_fd_pr__pfet_01v8_hvt L=0.15 W=1
+ AS=0.135 AD=0.3 PS=1.27 PD=2.6
M$4072 VPB|VPWR D|Y \$5276 VPB|VPWR sky130_fd_pr__pfet_01v8_hvt L=0.15 W=0.42
+ AS=0.1092 AD=0.0651 PS=1.36 PD=0.73
M$4073 \$5276 \$5275 \$5277 VPB|VPWR sky130_fd_pr__pfet_01v8_hvt L=0.15 W=0.42
+ AS=0.0651 AD=0.07245 PS=0.73 PD=0.765
M$4074 \$5277 \$5274 \$5420 VPB|VPWR sky130_fd_pr__pfet_01v8_hvt L=0.15 W=0.42
+ AS=0.07245 AD=0.1155 PS=0.765 PD=0.97
M$4075 \$5420 \$5416 VPB|VPWR VPB|VPWR sky130_fd_pr__pfet_01v8_hvt L=0.15
+ W=0.42 AS=0.1155 AD=0.07035 PS=0.97 PD=0.755
M$4076 VPB|VPWR RESET_B|X \$5420 VPB|VPWR sky130_fd_pr__pfet_01v8_hvt L=0.15
+ W=0.42 AS=0.07035 AD=0.1092 PS=0.755 PD=1.36
M$4078 VPB|VPWR A|Q A|A1|Y VPB|VPWR sky130_fd_pr__pfet_01v8_hvt L=0.15 W=1.68
+ AS=0.3318 AD=0.3486 PS=3.31 PD=3.35
M$4080 VPB|VPWR A|A1|Y \$5487 VPB|VPWR sky130_fd_pr__pfet_01v8_hvt L=0.15
+ W=0.64 AS=0.1696 AD=0.0768 PS=1.81 PD=0.88
M$4081 \$5487 A2|B|C|Y B_N|Y VPB|VPWR sky130_fd_pr__pfet_01v8_hvt L=0.15 W=0.64
+ AS=0.0768 AD=0.0896 PS=0.88 PD=0.92
M$4082 B_N|Y B|B1|Y VPB|VPWR VPB|VPWR sky130_fd_pr__pfet_01v8_hvt L=0.15 W=0.64
+ AS=0.0896 AD=0.1824 PS=0.92 PD=1.85
M$4083 VPB|VPWR D|Y \$5468 VPB|VPWR sky130_fd_pr__pfet_01v8_hvt L=0.15 W=0.42
+ AS=0.1092 AD=0.0651 PS=1.36 PD=0.73
M$4084 \$5468 \$5467 \$5469 VPB|VPWR sky130_fd_pr__pfet_01v8_hvt L=0.15 W=0.42
+ AS=0.0651 AD=0.07245 PS=0.73 PD=0.765
M$4085 \$5469 \$5466 \$5470 VPB|VPWR sky130_fd_pr__pfet_01v8_hvt L=0.15 W=0.42
+ AS=0.07245 AD=0.1155 PS=0.765 PD=0.97
M$4086 \$5470 \$5471 VPB|VPWR VPB|VPWR sky130_fd_pr__pfet_01v8_hvt L=0.15
+ W=0.42 AS=0.1155 AD=0.07035 PS=0.97 PD=0.755
M$4087 VPB|VPWR RESET_B|X \$5470 VPB|VPWR sky130_fd_pr__pfet_01v8_hvt L=0.15
+ W=0.42 AS=0.07035 AD=0.1092 PS=0.755 PD=1.36
M$4088 \$5471 \$5466 \$5472 VPB|VPWR sky130_fd_pr__pfet_01v8_hvt L=0.15 W=0.42
+ AS=0.12915 AD=0.0588 PS=1.185 PD=0.7
M$4089 \$5472 \$5467 \$5484 VPB|VPWR sky130_fd_pr__pfet_01v8_hvt L=0.15 W=0.42
+ AS=0.0588 AD=0.0567 PS=0.7 PD=0.69
M$4090 \$5484 \$5473 VPB|VPWR VPB|VPWR sky130_fd_pr__pfet_01v8_hvt L=0.15
+ W=0.42 AS=0.0567 AD=0.0819 PS=0.69 PD=0.81
M$4091 VPB|VPWR RESET_B|X \$5473 VPB|VPWR sky130_fd_pr__pfet_01v8_hvt L=0.15
+ W=0.42 AS=0.0819 AD=0.0567 PS=0.81 PD=0.69
M$4092 \$5473 \$5472 VPB|VPWR VPB|VPWR sky130_fd_pr__pfet_01v8_hvt L=0.15
+ W=0.42 AS=0.0567 AD=0.1134 PS=0.69 PD=1.38
M$4093 VPB|VPWR \$5469 \$5471 VPB|VPWR sky130_fd_pr__pfet_01v8_hvt L=0.15
+ W=0.84 AS=0.2184 AD=0.12915 PS=2.2 PD=1.185
M$4094 VPB|VPWR \$5473 A|Q VPB|VPWR sky130_fd_pr__pfet_01v8_hvt L=0.15 W=1
+ AS=0.3012 AD=0.26 PS=2.66 PD=2.52
M$4096 VPB|VPWR \$5475 \$5474 VPB|VPWR sky130_fd_pr__pfet_01v8_hvt L=0.5 W=0.82
+ AS=0.15575 AD=0.2173 PS=1.325 PD=2.17
M$4097 RESET_B|X \$5474 VPB|VPWR VPB|VPWR sky130_fd_pr__pfet_01v8_hvt L=0.15
+ W=1 AS=0.355 AD=0.15575 PS=2.71 PD=1.325
M$4098 \$5475 \$5477 VPB|VPWR VPB|VPWR sky130_fd_pr__pfet_01v8_hvt L=0.5 W=0.82
+ AS=0.2173 AD=0.1701 PS=2.17 PD=1.36
M$4099 VPB|VPWR A|DCO_EN \$5477 VPB|VPWR sky130_fd_pr__pfet_01v8_hvt L=0.15 W=1
+ AS=0.1701 AD=0.27 PS=1.36 PD=2.54
M$4102 VPB|VPWR A|A1|B|X \$5698 VPB|VPWR sky130_fd_pr__pfet_01v8_hvt L=0.15 W=1
+ AS=0.26 AD=0.135 PS=2.52 PD=1.27
M$4103 \$5698 A1|A2|X \$5700 VPB|VPWR sky130_fd_pr__pfet_01v8_hvt L=0.15 W=1
+ AS=0.135 AD=0.135 PS=1.27 PD=1.27
M$4104 \$5700 A3|SLEEP|Y A|Y VPB|VPWR sky130_fd_pr__pfet_01v8_hvt L=0.15 W=1
+ AS=0.135 AD=0.3925 PS=1.27 PD=1.785
M$4107 VPB|VPWR A2|B|SLEEP|Y \$5702 VPB|VPWR sky130_fd_pr__pfet_01v8_hvt L=0.15
+ W=0.42 AS=0.14575 AD=0.0441 PS=1.335 PD=0.63
M$4108 \$5702 A|A1|X \$5526 VPB|VPWR sky130_fd_pr__pfet_01v8_hvt L=0.15 W=0.42
+ AS=0.0441 AD=0.1092 PS=0.63 PD=1.36
M$4109 A1|A2|X \$5526 VPB|VPWR VPB|VPWR sky130_fd_pr__pfet_01v8_hvt L=0.15 W=1
+ AS=0.34 AD=0.14575 PS=2.68 PD=1.335
M$4110 \$5527 B1|C|Y \$5705 VPB|VPWR sky130_fd_pr__pfet_01v8_hvt L=0.15 W=0.42
+ AS=0.1092 AD=0.0441 PS=1.36 PD=0.63
M$4111 \$5705 A2|B|SLEEP|Y \$5704 VPB|VPWR sky130_fd_pr__pfet_01v8_hvt L=0.15
+ W=0.42 AS=0.0441 AD=0.0693 PS=0.63 PD=0.75
M$4112 \$5704 A|A1|X VPB|VPWR VPB|VPWR sky130_fd_pr__pfet_01v8_hvt L=0.15
+ W=0.42 AS=0.0693 AD=0.14825 PS=0.75 PD=1.34
M$4113 VPB|VPWR \$5527 A2|B|X VPB|VPWR sky130_fd_pr__pfet_01v8_hvt L=0.15 W=1
+ AS=0.14825 AD=0.28 PS=1.34 PD=2.56
M$4115 VPB|VPWR B|B_N|X \$5529 VPB|VPWR sky130_fd_pr__pfet_01v8_hvt L=0.15 W=1
+ AS=0.3 AD=0.135 PS=2.6 PD=1.27
M$4116 \$5529 A|Y VPB|VPWR VPB|VPWR sky130_fd_pr__pfet_01v8_hvt L=0.15 W=1
+ AS=0.135 AD=0.365 PS=1.27 PD=1.73
M$4117 VPB|VPWR A|Y \$5706 VPB|VPWR sky130_fd_pr__pfet_01v8_hvt L=0.15 W=1
+ AS=0.365 AD=0.105 PS=1.73 PD=1.21
M$4118 \$5706 B|B_N|X A|Y VPB|VPWR sky130_fd_pr__pfet_01v8_hvt L=0.15 W=1
+ AS=0.105 AD=0.165 PS=1.21 PD=1.33
M$4119 A|Y \$5529 VPB|VPWR VPB|VPWR sky130_fd_pr__pfet_01v8_hvt L=0.15 W=1
+ AS=0.165 AD=0.36 PS=1.33 PD=2.72
M$4124 VPB|VPWR B|X \$5534 VPB|VPWR sky130_fd_pr__pfet_01v8_hvt L=0.15 W=1
+ AS=0.3 AD=0.135 PS=2.6 PD=1.27
M$4125 \$5534 A|Y VPB|VPWR VPB|VPWR sky130_fd_pr__pfet_01v8_hvt L=0.15 W=1
+ AS=0.135 AD=0.365 PS=1.27 PD=1.73
M$4126 VPB|VPWR A|Y \$5708 VPB|VPWR sky130_fd_pr__pfet_01v8_hvt L=0.15 W=1
+ AS=0.365 AD=0.105 PS=1.73 PD=1.21
M$4127 \$5708 B|X A|B|Y VPB|VPWR sky130_fd_pr__pfet_01v8_hvt L=0.15 W=1
+ AS=0.105 AD=0.165 PS=1.21 PD=1.33
M$4128 A|B|Y \$5534 VPB|VPWR VPB|VPWR sky130_fd_pr__pfet_01v8_hvt L=0.15 W=1
+ AS=0.165 AD=0.36 PS=1.33 PD=2.72
M$4131 \$5444 B|C|Y \$5442 VPB|VPWR sky130_fd_pr__pfet_01v8_hvt L=0.15 W=0.84
+ AS=0.15295 AD=0.273 PS=1.315 PD=2.33
M$4132 \$5444 \$5445 \$5443 VPB|VPWR sky130_fd_pr__pfet_01v8_hvt L=0.15 W=0.84
+ AS=0.15295 AD=0.32235 PS=1.315 PD=2.45
M$4134 VPB|VPWR B|C|Y A|C|Y VPB|VPWR sky130_fd_pr__pfet_01v8_hvt L=0.15 W=1
+ AS=0.26 AD=0.135 PS=2.52 PD=1.27
M$4136 D1|Y A|B|X VPB|VPWR VPB|VPWR sky130_fd_pr__pfet_01v8_hvt L=0.15 W=1
+ AS=0.26 AD=0.165 PS=2.52 PD=1.33
M$4137 VPB|VPWR B|C|Y D1|Y VPB|VPWR sky130_fd_pr__pfet_01v8_hvt L=0.15 W=1
+ AS=0.165 AD=0.135 PS=1.33 PD=1.27
M$4138 D1|Y A1|B|C|Y VPB|VPWR VPB|VPWR sky130_fd_pr__pfet_01v8_hvt L=0.15 W=1
+ AS=0.135 AD=0.26 PS=1.27 PD=2.52
M$4139 VPB|VPWR D1|Y B1|Y VPB|VPWR sky130_fd_pr__pfet_01v8_hvt L=0.15 W=1
+ AS=0.265 AD=0.14 PS=2.53 PD=1.28
M$4140 B1|Y C1|Y VPB|VPWR VPB|VPWR sky130_fd_pr__pfet_01v8_hvt L=0.15 W=2
+ AS=0.335 AD=0.83 PS=2.67 PD=4.66
M$4141 VPB|VPWR B1|Y B1|Y VPB|VPWR sky130_fd_pr__pfet_01v8_hvt L=0.15 W=2
+ AS=0.39 AD=0.3975 PS=2.78 PD=2.795
M$4142 B1|Y A0|A2|X \$5713 VPB|VPWR sky130_fd_pr__pfet_01v8_hvt L=0.15 W=1
+ AS=0.2025 AD=0.195 PS=1.405 PD=1.39
M$4143 \$5713 A1|B1|Y VPB|VPWR VPB|VPWR sky130_fd_pr__pfet_01v8_hvt L=0.15 W=1
+ AS=0.195 AD=0.265 PS=1.39 PD=2.53
M$4144 VPB|VPWR A1|B|C|Y B1|Y VPB|VPWR sky130_fd_pr__pfet_01v8_hvt L=0.15 W=1
+ AS=0.26 AD=0.135 PS=2.52 PD=1.27
M$4145 B1|Y A|S|X VPB|VPWR VPB|VPWR sky130_fd_pr__pfet_01v8_hvt L=0.15 W=1
+ AS=0.135 AD=0.26 PS=1.27 PD=2.52
M$4158 VPB|VPWR A|B1|Q \$5545 VPB|VPWR sky130_fd_pr__pfet_01v8_hvt L=0.15
+ W=0.42 AS=0.1092 AD=0.0735 PS=1.36 PD=0.77
M$4159 \$5545 A1|B|Y VPB|VPWR VPB|VPWR sky130_fd_pr__pfet_01v8_hvt L=0.15
+ W=0.42 AS=0.0735 AD=0.0777 PS=0.77 PD=0.79
M$4160 VPB|VPWR A2|C|Y \$5545 VPB|VPWR sky130_fd_pr__pfet_01v8_hvt L=0.15
+ W=0.42 AS=0.0777 AD=0.0588 PS=0.79 PD=0.7
M$4161 VPB|VPWR A3|D|Y \$5545 VPB|VPWR sky130_fd_pr__pfet_01v8_hvt L=0.15
+ W=0.42 AS=0.31245 AD=0.0588 PS=1.68 PD=0.7
M$4162 VPB|VPWR \$5545 A|A1|X VPB|VPWR sky130_fd_pr__pfet_01v8_hvt L=0.15 W=1
+ AS=0.31245 AD=0.26 PS=1.68 PD=2.52
M$4164 \$5548 A2|B|X \$5714 VPB|VPWR sky130_fd_pr__pfet_01v8_hvt L=0.15 W=1
+ AS=0.26 AD=0.135 PS=2.52 PD=1.27
M$4165 \$5714 A|Y VPB|VPWR VPB|VPWR sky130_fd_pr__pfet_01v8_hvt L=0.15 W=1
+ AS=0.135 AD=0.135 PS=1.27 PD=1.27
M$4166 VPB|VPWR A|Y \$5693 VPB|VPWR sky130_fd_pr__pfet_01v8_hvt L=0.15 W=1
+ AS=0.135 AD=0.135 PS=1.27 PD=1.27
M$4167 \$5693 A2|B|X VPB|VPWR VPB|VPWR sky130_fd_pr__pfet_01v8_hvt L=0.15 W=1
+ AS=0.135 AD=0.26 PS=1.27 PD=2.52
M$4168 \$5693 \$5548 D|X VPB|VPWR sky130_fd_pr__pfet_01v8_hvt L=0.15 W=1
+ AS=0.26 AD=0.3 PS=2.52 PD=2.6
M$4170 VPB|VPWR A|A1|X \$5711 VPB|VPWR sky130_fd_pr__pfet_01v8_hvt L=0.15
+ W=0.64 AS=0.1696 AD=0.0768 PS=1.81 PD=0.88
M$4171 \$5711 A2|B|X B|Y VPB|VPWR sky130_fd_pr__pfet_01v8_hvt L=0.15 W=0.64
+ AS=0.0768 AD=0.0896 PS=0.88 PD=0.92
M$4172 B|Y B1|B_N|X VPB|VPWR VPB|VPWR sky130_fd_pr__pfet_01v8_hvt L=0.15 W=1.64
+ AS=0.2846 AD=0.3774 PS=2.31 PD=3.24
M$4173 \$5453 \$5454 VPB|VPWR VPB|VPWR sky130_fd_pr__pfet_01v8_hvt L=0.15
+ W=0.64 AS=0.1664 AD=0.0864 PS=1.8 PD=0.91
M$4174 VPB|VPWR CLK|TICK \$5454 VPB|VPWR sky130_fd_pr__pfet_01v8_hvt L=0.15
+ W=0.64 AS=0.0864 AD=0.1664 PS=0.91 PD=1.8
M$4176 VPB|VPWR A|A1|X \$5709 VPB|VPWR sky130_fd_pr__pfet_01v8_hvt L=0.15 W=1
+ AS=0.265 AD=0.195 PS=2.53 PD=1.39
M$4177 \$5709 A2|B|X A2|B|C|Y VPB|VPWR sky130_fd_pr__pfet_01v8_hvt L=0.15 W=1
+ AS=0.195 AD=0.2025 PS=1.39 PD=1.405
M$4178 A2|B|C|Y B1|B_N|X VPB|VPWR VPB|VPWR sky130_fd_pr__pfet_01v8_hvt L=0.15
+ W=1 AS=0.2025 AD=0.195 PS=1.405 PD=1.39
M$4179 VPB|VPWR A|C1|Q A2|B|C|Y VPB|VPWR sky130_fd_pr__pfet_01v8_hvt L=0.15 W=1
+ AS=0.195 AD=0.14 PS=1.39 PD=1.28
M$4180 A2|B|C|Y A|D1|Q VPB|VPWR VPB|VPWR sky130_fd_pr__pfet_01v8_hvt L=0.15 W=1
+ AS=0.14 AD=0.265 PS=1.28 PD=2.53
M$4181 A|D1|Q \$5553 VPB|VPWR VPB|VPWR sky130_fd_pr__pfet_01v8_hvt L=0.15 W=1
+ AS=0.26 AD=0.3012 PS=2.52 PD=2.66
M$4182 VPB|VPWR \$5692 \$5553 VPB|VPWR sky130_fd_pr__pfet_01v8_hvt L=0.15
+ W=0.42 AS=0.1134 AD=0.0567 PS=1.38 PD=0.69
M$4183 \$5553 RESET_B|X VPB|VPWR VPB|VPWR sky130_fd_pr__pfet_01v8_hvt L=0.15
+ W=0.42 AS=0.0567 AD=0.0819 PS=0.69 PD=0.81
M$4184 VPB|VPWR \$5553 \$5707 VPB|VPWR sky130_fd_pr__pfet_01v8_hvt L=0.15
+ W=0.42 AS=0.0819 AD=0.0567 PS=0.81 PD=0.69
M$4185 \$5707 \$5555 \$5692 VPB|VPWR sky130_fd_pr__pfet_01v8_hvt L=0.15 W=0.42
+ AS=0.0567 AD=0.0588 PS=0.69 PD=0.7
M$4186 \$5556 \$5554 \$5692 VPB|VPWR sky130_fd_pr__pfet_01v8_hvt L=0.15 W=0.42
+ AS=0.12915 AD=0.0588 PS=1.185 PD=0.7
M$4187 \$5556 \$5557 VPB|VPWR VPB|VPWR sky130_fd_pr__pfet_01v8_hvt L=0.15
+ W=0.84 AS=0.12915 AD=0.2184 PS=1.185 PD=2.2
M$4188 \$5694 RESET_B|X VPB|VPWR VPB|VPWR sky130_fd_pr__pfet_01v8_hvt L=0.15
+ W=0.42 AS=0.1092 AD=0.07035 PS=1.36 PD=0.755
M$4189 VPB|VPWR \$5556 \$5694 VPB|VPWR sky130_fd_pr__pfet_01v8_hvt L=0.15
+ W=0.42 AS=0.07035 AD=0.1155 PS=0.755 PD=0.97
M$4190 \$5694 \$5554 \$5557 VPB|VPWR sky130_fd_pr__pfet_01v8_hvt L=0.15 W=0.42
+ AS=0.1155 AD=0.07245 PS=0.97 PD=0.765
M$4191 \$5557 \$5555 \$5558 VPB|VPWR sky130_fd_pr__pfet_01v8_hvt L=0.15 W=0.42
+ AS=0.07245 AD=0.0651 PS=0.765 PD=0.73
M$4192 \$5558 D|Y VPB|VPWR VPB|VPWR sky130_fd_pr__pfet_01v8_hvt L=0.15 W=0.42
+ AS=0.0651 AD=0.1092 PS=0.73 PD=1.36
M$4193 \$5555 \$5554 VPB|VPWR VPB|VPWR sky130_fd_pr__pfet_01v8_hvt L=0.15
+ W=0.64 AS=0.1664 AD=0.0864 PS=1.8 PD=0.91
M$4194 VPB|VPWR CLK|TICK \$5554 VPB|VPWR sky130_fd_pr__pfet_01v8_hvt L=0.15
+ W=0.64 AS=0.0864 AD=0.1664 PS=0.91 PD=1.8
M$4197 \$5466 CLK|TICK VPB|VPWR VPB|VPWR sky130_fd_pr__pfet_01v8_hvt L=0.15
+ W=0.64 AS=0.1664 AD=0.0864 PS=1.8 PD=0.91
M$4198 VPB|VPWR \$5466 \$5467 VPB|VPWR sky130_fd_pr__pfet_01v8_hvt L=0.15
+ W=0.64 AS=0.0864 AD=0.1664 PS=0.91 PD=1.8
M$4199 VPB|VPWR A|A1|Y \$5699 VPB|VPWR sky130_fd_pr__pfet_01v8_hvt L=0.15 W=1
+ AS=0.26 AD=0.135 PS=2.52 PD=1.27
M$4200 \$5699 B|B1|Y \$5701 VPB|VPWR sky130_fd_pr__pfet_01v8_hvt L=0.15 W=1
+ AS=0.135 AD=0.135 PS=1.27 PD=1.27
M$4201 \$5701 A2|B|C|Y A|B|Y VPB|VPWR sky130_fd_pr__pfet_01v8_hvt L=0.15 W=1
+ AS=0.135 AD=0.26 PS=1.27 PD=2.52
M$4205 \$5784 A|FINE_MUX[12] VPB|VPWR VPB|VPWR sky130_fd_pr__pfet_01v8_hvt
+ L=0.15 W=1 AS=0.27 AD=0.1701 PS=2.54 PD=1.36
M$4206 VPB|VPWR \$5784 \$5785 VPB|VPWR sky130_fd_pr__pfet_01v8_hvt L=0.5 W=0.82
+ AS=0.1701 AD=0.2173 PS=1.36 PD=2.17
M$4207 VPB|VPWR \$5718 \$5719 VPB|VPWR sky130_fd_pr__pfet_01v8_hvt L=0.5 W=0.82
+ AS=0.1701 AD=0.2173 PS=1.36 PD=2.17
M$4208 \$5718 A|FINE_MUX[11] VPB|VPWR VPB|VPWR sky130_fd_pr__pfet_01v8_hvt
+ L=0.15 W=1 AS=0.27 AD=0.1701 PS=2.54 PD=1.36
M$4209 \$5720 \$5719 VPB|VPWR VPB|VPWR sky130_fd_pr__pfet_01v8_hvt L=0.5 W=0.82
+ AS=0.2173 AD=0.15575 PS=2.17 PD=1.325
M$4210 VPB|VPWR \$5720 A|B1|X VPB|VPWR sky130_fd_pr__pfet_01v8_hvt L=0.15 W=1
+ AS=0.15575 AD=0.355 PS=1.325 PD=2.71
M$4211 VPB|VPWR \$5785 \$5786 VPB|VPWR sky130_fd_pr__pfet_01v8_hvt L=0.5 W=0.82
+ AS=0.15575 AD=0.2173 PS=1.325 PD=2.17
M$4212 VPB|VPWR \$5786 A|B|B1|X VPB|VPWR sky130_fd_pr__pfet_01v8_hvt L=0.15 W=1
+ AS=0.15575 AD=0.355 PS=1.325 PD=2.71
M$4214 VPB|VPWR A|A1|B|X B|C|Y VPB|VPWR sky130_fd_pr__pfet_01v8_hvt L=0.15
+ W=1.68 AS=0.3486 AD=0.3318 PS=3.35 PD=3.31
M$4216 \$5723 A|A1|B|X \$5748 VPB|VPWR sky130_fd_pr__pfet_01v8_hvt L=0.15 W=1
+ AS=0.26 AD=0.135 PS=2.52 PD=1.27
M$4217 \$5748 A|B1|X VPB|VPWR VPB|VPWR sky130_fd_pr__pfet_01v8_hvt L=0.15 W=1
+ AS=0.135 AD=0.135 PS=1.27 PD=1.27
M$4218 VPB|VPWR A|B1|X \$5724 VPB|VPWR sky130_fd_pr__pfet_01v8_hvt L=0.15 W=1
+ AS=0.135 AD=0.135 PS=1.27 PD=1.27
M$4219 \$5724 A|A1|B|X VPB|VPWR VPB|VPWR sky130_fd_pr__pfet_01v8_hvt L=0.15 W=1
+ AS=0.135 AD=0.26 PS=1.27 PD=2.52
M$4220 \$5724 \$5723 A|B|X VPB|VPWR sky130_fd_pr__pfet_01v8_hvt L=0.15 W=1
+ AS=0.26 AD=0.3 PS=2.52 PD=2.6
M$4221 VPB|VPWR B|D|X B1|C|Y VPB|VPWR sky130_fd_pr__pfet_01v8_hvt L=0.15 W=1
+ AS=0.26 AD=0.135 PS=2.52 PD=1.27
M$4222 B1|C|Y A|A1|C|Y VPB|VPWR VPB|VPWR sky130_fd_pr__pfet_01v8_hvt L=0.15 W=1
+ AS=0.135 AD=0.135 PS=1.27 PD=1.27
M$4223 VPB|VPWR B|C|Y B1|C|Y VPB|VPWR sky130_fd_pr__pfet_01v8_hvt L=0.15 W=1
+ AS=0.135 AD=0.165 PS=1.27 PD=1.33
M$4224 B1|C|Y A|B1|X VPB|VPWR VPB|VPWR sky130_fd_pr__pfet_01v8_hvt L=0.15 W=1
+ AS=0.165 AD=0.3 PS=1.33 PD=2.6
M$4225 \$5789 A|B|X \$5945 VPB|VPWR sky130_fd_pr__pfet_01v8_hvt L=0.15 W=0.42
+ AS=0.1092 AD=0.0441 PS=1.36 PD=0.63
M$4226 \$5945 A3|SLEEP|Y VPB|VPWR VPB|VPWR sky130_fd_pr__pfet_01v8_hvt L=0.15
+ W=0.42 AS=0.0441 AD=0.14575 PS=0.63 PD=1.335
M$4227 VPB|VPWR \$5789 A2|SLEEP|X VPB|VPWR sky130_fd_pr__pfet_01v8_hvt L=0.15
+ W=1 AS=0.14575 AD=0.34 PS=1.335 PD=2.68
M$4228 VPB|VPWR A|A1|C|Y A3|SLEEP|Y VPB|VPWR sky130_fd_pr__pfet_01v8_hvt L=0.15
+ W=1 AS=0.26 AD=0.135 PS=2.52 PD=1.27
M$4229 A3|SLEEP|Y B|D|X VPB|VPWR VPB|VPWR sky130_fd_pr__pfet_01v8_hvt L=0.15
+ W=1 AS=0.135 AD=0.26 PS=1.27 PD=2.52
M$4231 VPB|VPWR A1|A2|X \$5749 VPB|VPWR sky130_fd_pr__pfet_01v8_hvt L=0.15
+ W=0.64 AS=0.1696 AD=0.0768 PS=1.81 PD=0.88
M$4232 \$5749 A2|SLEEP|X B|SLEEP|Y VPB|VPWR sky130_fd_pr__pfet_01v8_hvt L=0.15
+ W=0.64 AS=0.0768 AD=0.0896 PS=0.88 PD=0.92
M$4233 B|SLEEP|Y A|B|B1|X VPB|VPWR VPB|VPWR sky130_fd_pr__pfet_01v8_hvt L=0.15
+ W=0.64 AS=0.0896 AD=0.1824 PS=0.92 PD=1.85
M$4234 VPB|VPWR A|A1|X \$5750 VPB|VPWR sky130_fd_pr__pfet_01v8_hvt L=0.15
+ W=0.64 AS=0.1696 AD=0.0768 PS=1.81 PD=0.88
M$4235 \$5750 A2|B|SLEEP|Y A|A1|Y VPB|VPWR sky130_fd_pr__pfet_01v8_hvt L=0.15
+ W=0.64 AS=0.0768 AD=0.0896 PS=0.88 PD=0.92
M$4236 A|A1|Y B1|C|Y VPB|VPWR VPB|VPWR sky130_fd_pr__pfet_01v8_hvt L=0.15
+ W=0.64 AS=0.0896 AD=0.1824 PS=0.92 PD=1.85
M$4237 \$5790 A|B|B1|X VPB|VPWR VPB|VPWR sky130_fd_pr__pfet_01v8_hvt L=0.15
+ W=0.42 AS=0.1092 AD=0.1573 PS=1.36 PD=1.39
M$4238 VPB|VPWR A2|SLEEP|X \$5959 VPB|VPWR sky130_fd_pr__pfet_01v8_hvt L=0.15
+ W=1 AS=0.1573 AD=0.105 PS=1.39 PD=1.21
M$4239 \$5959 \$5790 B1|C|X VPB|VPWR sky130_fd_pr__pfet_01v8_hvt L=0.15 W=1
+ AS=0.105 AD=0.26 PS=1.21 PD=2.52
M$4242 \$5791 B|SLEEP|Y \$5958 VPB|VPWR sky130_fd_pr__pfet_01v8_hvt L=0.15 W=1
+ AS=0.26 AD=0.135 PS=2.52 PD=1.27
M$4243 \$5958 A|Y VPB|VPWR VPB|VPWR sky130_fd_pr__pfet_01v8_hvt L=0.15 W=1
+ AS=0.135 AD=0.135 PS=1.27 PD=1.27
M$4244 VPB|VPWR A|Y \$5937 VPB|VPWR sky130_fd_pr__pfet_01v8_hvt L=0.15 W=1
+ AS=0.135 AD=0.135 PS=1.27 PD=1.27
M$4245 \$5937 B|SLEEP|Y VPB|VPWR VPB|VPWR sky130_fd_pr__pfet_01v8_hvt L=0.15
+ W=1 AS=0.135 AD=0.26 PS=1.27 PD=2.52
M$4246 VPB|VPWR A|Y \$5730 VPB|VPWR sky130_fd_pr__pfet_01v8_hvt L=0.15 W=0.42
+ AS=0.1573 AD=0.1092 PS=1.39 PD=1.36
M$4247 VPB|VPWR B|SLEEP|Y \$5751 VPB|VPWR sky130_fd_pr__pfet_01v8_hvt L=0.15
+ W=1 AS=0.1573 AD=0.105 PS=1.39 PD=1.21
M$4248 \$5751 \$5730 A|X VPB|VPWR sky130_fd_pr__pfet_01v8_hvt L=0.15 W=1
+ AS=0.105 AD=0.26 PS=1.21 PD=2.52
M$4249 \$5937 \$5791 A|X VPB|VPWR sky130_fd_pr__pfet_01v8_hvt L=0.15 W=1
+ AS=0.26 AD=0.3 PS=2.52 PD=2.6
M$4250 B|Y B|Y \$5752 VPB|VPWR sky130_fd_pr__pfet_01v8_hvt L=0.15 W=1 AS=0.26
+ AD=0.105 PS=2.52 PD=1.21
M$4251 \$5752 A|X VPB|VPWR VPB|VPWR sky130_fd_pr__pfet_01v8_hvt L=0.15 W=1
+ AS=0.105 AD=0.26 PS=1.21 PD=2.52
M$4252 \$5793 A|C|Y \$5948 VPB|VPWR sky130_fd_pr__pfet_01v8_hvt L=0.15 W=0.42
+ AS=0.1092 AD=0.0441 PS=1.36 PD=0.63
M$4253 \$5948 B|C|Y \$5949 VPB|VPWR sky130_fd_pr__pfet_01v8_hvt L=0.15 W=0.42
+ AS=0.0441 AD=0.0693 PS=0.63 PD=0.75
M$4254 \$5949 A|X VPB|VPWR VPB|VPWR sky130_fd_pr__pfet_01v8_hvt L=0.15 W=0.42
+ AS=0.0693 AD=0.14825 PS=0.75 PD=1.34
M$4255 VPB|VPWR \$5793 B|C|X VPB|VPWR sky130_fd_pr__pfet_01v8_hvt L=0.15 W=1
+ AS=0.14825 AD=0.28 PS=1.34 PD=2.56
M$4258 VPB|VPWR B|C|X \$5795 VPB|VPWR sky130_fd_pr__pfet_01v8_hvt L=0.15 W=1
+ AS=0.3 AD=0.135 PS=2.6 PD=1.27
M$4259 \$5795 A|B|Y VPB|VPWR VPB|VPWR sky130_fd_pr__pfet_01v8_hvt L=0.15 W=1
+ AS=0.135 AD=0.365 PS=1.27 PD=1.73
M$4260 VPB|VPWR A|B|Y \$5957 VPB|VPWR sky130_fd_pr__pfet_01v8_hvt L=0.15 W=1
+ AS=0.365 AD=0.105 PS=1.73 PD=1.21
M$4261 \$5957 B|C|X B|Y VPB|VPWR sky130_fd_pr__pfet_01v8_hvt L=0.15 W=1
+ AS=0.105 AD=0.165 PS=1.21 PD=1.33
M$4262 B|Y \$5795 VPB|VPWR VPB|VPWR sky130_fd_pr__pfet_01v8_hvt L=0.15 W=1
+ AS=0.165 AD=0.36 PS=1.33 PD=2.72
M$4263 VPB|VPWR A|B|Y \$5755 VPB|VPWR sky130_fd_pr__pfet_01v8_hvt L=0.15 W=1
+ AS=0.26 AD=0.135 PS=2.52 PD=1.27
M$4264 \$5755 B|C|X \$5756 VPB|VPWR sky130_fd_pr__pfet_01v8_hvt L=0.15 W=1
+ AS=0.135 AD=0.135 PS=1.27 PD=1.27
M$4265 \$5756 A|C|X A|Y VPB|VPWR sky130_fd_pr__pfet_01v8_hvt L=0.15 W=1
+ AS=0.135 AD=0.26 PS=1.27 PD=2.52
M$4266 VPB|VPWR B|C|D_N|X \$5798 VPB|VPWR sky130_fd_pr__pfet_01v8_hvt L=0.15
+ W=0.42 AS=0.14575 AD=0.1092 PS=1.335 PD=1.36
M$4267 VPB|VPWR A|B|Y \$5956 VPB|VPWR sky130_fd_pr__pfet_01v8_hvt L=0.15 W=1
+ AS=0.14575 AD=0.135 PS=1.335 PD=1.27
M$4268 \$5956 B|Y \$5955 VPB|VPWR sky130_fd_pr__pfet_01v8_hvt L=0.15 W=1
+ AS=0.135 AD=0.165 PS=1.27 PD=1.33
M$4269 \$5955 A|C|X \$5954 VPB|VPWR sky130_fd_pr__pfet_01v8_hvt L=0.15 W=1
+ AS=0.165 AD=0.135 PS=1.33 PD=1.27
M$4270 \$5954 \$5798 B|C|Y VPB|VPWR sky130_fd_pr__pfet_01v8_hvt L=0.15 W=1
+ AS=0.135 AD=0.52 PS=1.27 PD=3.04
M$4272 \$5799 \$5802 \$5803 VPB|VPWR sky130_fd_pr__pfet_01v8_hvt L=0.15 W=0.64
+ AS=0.246 AD=0.2452 PS=1.525 PD=1.45
M$4273 \$5799 A|B|X \$5804 VPB|VPWR sky130_fd_pr__pfet_01v8_hvt L=0.15 W=0.64
+ AS=0.246 AD=0.1458 PS=1.525 PD=1.205
M$4274 \$5803 A|B|X \$5800 VPB|VPWR sky130_fd_pr__pfet_01v8_hvt L=0.15 W=0.84
+ AS=0.2452 AD=0.3536 PS=1.45 PD=2.53
M$4275 \$5799 \$5800 VPB|VPWR VPB|VPWR sky130_fd_pr__pfet_01v8_hvt L=0.15 W=1
+ AS=0.285 AD=0.135 PS=2.57 PD=1.27
M$4276 VPB|VPWR A|B|X \$5800 VPB|VPWR sky130_fd_pr__pfet_01v8_hvt L=0.15 W=1
+ AS=0.135 AD=0.1715 PS=1.27 PD=1.355
M$4277 \$5800 \$5802 \$5804 VPB|VPWR sky130_fd_pr__pfet_01v8_hvt L=0.15 W=0.84
+ AS=0.1715 AD=0.1458 PS=1.355 PD=1.205
M$4279 \$5802 A|B|X VPB|VPWR VPB|VPWR sky130_fd_pr__pfet_01v8_hvt L=0.15 W=1
+ AS=0.2526 AD=0.26 PS=2.52 PD=2.52
M$4280 VPB|VPWR A|B|X \$5757 VPB|VPWR sky130_fd_pr__pfet_01v8_hvt L=0.15 W=1
+ AS=0.26 AD=0.105 PS=2.52 PD=1.21
M$4281 \$5757 B|C|Y A_N|Y VPB|VPWR sky130_fd_pr__pfet_01v8_hvt L=0.15 W=1
+ AS=0.105 AD=0.26 PS=1.21 PD=2.52
M$4282 VPB|VPWR A_N|Y \$5735 VPB|VPWR sky130_fd_pr__pfet_01v8_hvt L=0.15 W=0.42
+ AS=0.1092 AD=0.1087 PS=1.36 PD=1.36
M$4283 \$5805 B|C|Y VPB|VPWR VPB|VPWR sky130_fd_pr__pfet_01v8_hvt L=0.15 W=0.64
+ AS=0.1792 AD=0.2115 PS=1.84 PD=1.45
M$4284 VPB|VPWR \$5806 B|X VPB|VPWR sky130_fd_pr__pfet_01v8_hvt L=0.15 W=1
+ AS=0.2115 AD=0.28 PS=1.45 PD=2.56
M$4285 \$5736 \$5735 VPB|VPWR VPB|VPWR sky130_fd_pr__pfet_01v8_hvt L=0.15
+ W=0.42 AS=0.1085 AD=0.0567 PS=1.36 PD=0.69
M$4286 VPB|VPWR A|B|X \$5736 VPB|VPWR sky130_fd_pr__pfet_01v8_hvt L=0.15 W=0.42
+ AS=0.0567 AD=0.074375 PS=0.69 PD=0.815
M$4287 VPB|VPWR A|C|Y \$5736 VPB|VPWR sky130_fd_pr__pfet_01v8_hvt L=0.15 W=0.42
+ AS=0.142225 AD=0.074375 PS=1.335 PD=0.815
M$4288 VPB|VPWR \$5736 A|S|X VPB|VPWR sky130_fd_pr__pfet_01v8_hvt L=0.15 W=1
+ AS=0.142225 AD=0.26 PS=1.335 PD=2.52
M$4290 \$5738 A0|A2|X A|A2|Y VPB|VPWR sky130_fd_pr__pfet_01v8_hvt L=0.15 W=1
+ AS=0.28 AD=0.1525 PS=2.56 PD=1.305
M$4291 A|A2|Y A1|B|C|Y \$5758 VPB|VPWR sky130_fd_pr__pfet_01v8_hvt L=0.15 W=1
+ AS=0.1525 AD=0.1975 PS=1.305 PD=1.395
M$4292 \$5758 \$5740 VPB|VPWR VPB|VPWR sky130_fd_pr__pfet_01v8_hvt L=0.15 W=1
+ AS=0.1975 AD=0.3 PS=1.395 PD=1.6
M$4293 VPB|VPWR A|S|X \$5738 VPB|VPWR sky130_fd_pr__pfet_01v8_hvt L=0.15 W=1
+ AS=0.3 AD=0.26 PS=1.6 PD=2.52
M$4294 \$5740 A|S|X VPB|VPWR VPB|VPWR sky130_fd_pr__pfet_01v8_hvt L=0.15 W=1
+ AS=0.29 AD=0.26 PS=2.58 PD=2.52
M$4305 \$5809 A|B1|X VPB|VPWR VPB|VPWR sky130_fd_pr__pfet_01v8_hvt L=0.15
+ W=0.42 AS=0.1092 AD=0.1573 PS=1.36 PD=1.39
M$4306 VPB|VPWR B|SLEEP|X \$5953 VPB|VPWR sky130_fd_pr__pfet_01v8_hvt L=0.15
+ W=1 AS=0.1573 AD=0.105 PS=1.39 PD=1.21
M$4307 \$5953 \$5809 A1|X VPB|VPWR sky130_fd_pr__pfet_01v8_hvt L=0.15 W=1
+ AS=0.105 AD=0.26 PS=1.21 PD=2.52
M$4310 VPB|VPWR B|X A1|B|Y VPB|VPWR sky130_fd_pr__pfet_01v8_hvt L=0.15 W=1
+ AS=0.26 AD=0.135 PS=2.52 PD=1.27
M$4311 A1|B|Y A|Y VPB|VPWR VPB|VPWR sky130_fd_pr__pfet_01v8_hvt L=0.15 W=1
+ AS=0.135 AD=0.26 PS=1.27 PD=2.52
M$4312 \$5741 A|B1|Q \$5742 VPB|VPWR sky130_fd_pr__pfet_01v8_hvt L=0.15 W=1
+ AS=0.32 AD=0.165 PS=2.64 PD=1.33
M$4313 \$5742 A1|B|Y VPB|VPWR VPB|VPWR sky130_fd_pr__pfet_01v8_hvt L=0.15 W=1
+ AS=0.165 AD=0.165 PS=1.33 PD=1.33
M$4314 VPB|VPWR A2|C|Y \$5742 VPB|VPWR sky130_fd_pr__pfet_01v8_hvt L=0.15 W=1
+ AS=0.165 AD=0.16 PS=1.33 PD=1.32
M$4315 \$5742 A3|D|Y VPB|VPWR VPB|VPWR sky130_fd_pr__pfet_01v8_hvt L=0.15 W=1
+ AS=0.16 AD=0.1725 PS=1.32 PD=1.345
M$4316 VPB|VPWR \$5741 B1|B_N|X VPB|VPWR sky130_fd_pr__pfet_01v8_hvt L=0.15 W=1
+ AS=0.1725 AD=0.265 PS=1.345 PD=2.53
M$4317 VPB|VPWR B1|B_N|X \$5744 VPB|VPWR sky130_fd_pr__pfet_01v8_hvt L=0.15
+ W=0.42 AS=0.1573 AD=0.1092 PS=1.39 PD=1.36
M$4318 VPB|VPWR A|A1|X \$5762 VPB|VPWR sky130_fd_pr__pfet_01v8_hvt L=0.15 W=1
+ AS=0.1573 AD=0.105 PS=1.39 PD=1.21
M$4319 \$5762 \$5744 A|Y VPB|VPWR sky130_fd_pr__pfet_01v8_hvt L=0.15 W=1
+ AS=0.105 AD=0.26 PS=1.21 PD=2.52
M$4322 VPB|VPWR A|A1|X \$5760 VPB|VPWR sky130_fd_pr__pfet_01v8_hvt L=0.15 W=1
+ AS=0.265 AD=0.105 PS=2.53 PD=1.21
M$4323 \$5760 A2|B|X B|Y VPB|VPWR sky130_fd_pr__pfet_01v8_hvt L=0.15 W=1
+ AS=0.105 AD=0.195 PS=1.21 PD=1.39
M$4325 VPB|VPWR A|C1|Q B|Y VPB|VPWR sky130_fd_pr__pfet_01v8_hvt L=0.15 W=1
+ AS=0.195 AD=0.635 PS=1.39 PD=3.27
M$4340 \$5804 \$5805 \$5806 VPB|VPWR sky130_fd_pr__pfet_01v8_hvt L=0.15 W=0.84
+ AS=0.441 AD=0.1596 PS=2.73 PD=1.22
M$4341 \$5806 B|C|Y \$5803 VPB|VPWR sky130_fd_pr__pfet_01v8_hvt L=0.15 W=0.84
+ AS=0.1596 AD=0.2688 PS=1.22 PD=2.32
M$4367 \$5788 B|C|Y \$5942 VPB|VPWR sky130_fd_pr__pfet_01v8_hvt L=0.15 W=0.42
+ AS=0.1092 AD=0.0441 PS=1.36 PD=0.63
M$4368 \$5942 A|B1|X VPB|VPWR VPB|VPWR sky130_fd_pr__pfet_01v8_hvt L=0.15
+ W=0.42 AS=0.0441 AD=0.0567 PS=0.63 PD=0.69
M$4369 VPB|VPWR A|B1|X \$5943 VPB|VPWR sky130_fd_pr__pfet_01v8_hvt L=0.15
+ W=0.42 AS=0.0567 AD=0.0441 PS=0.69 PD=0.63
M$4370 \$5943 A|B|B1|X \$5788 VPB|VPWR sky130_fd_pr__pfet_01v8_hvt L=0.15
+ W=0.42 AS=0.0441 AD=0.0567 PS=0.63 PD=0.69
M$4371 \$5788 A|B|B1|X \$5944 VPB|VPWR sky130_fd_pr__pfet_01v8_hvt L=0.15
+ W=0.42 AS=0.0567 AD=0.0441 PS=0.69 PD=0.63
M$4372 VPB|VPWR B|C|Y \$5944 VPB|VPWR sky130_fd_pr__pfet_01v8_hvt L=0.15 W=0.42
+ AS=0.2492 AD=0.0441 PS=1.565 PD=0.63
M$4373 VPB|VPWR \$5788 A2|B|X VPB|VPWR sky130_fd_pr__pfet_01v8_hvt L=0.15 W=1
+ AS=0.2492 AD=0.365 PS=1.565 PD=2.73
M$4374 \$5960 A|B|X \$6050 VPB|VPWR sky130_fd_pr__pfet_01v8_hvt L=0.15 W=1
+ AS=0.26 AD=0.135 PS=2.52 PD=1.27
M$4375 \$6050 A|B|B1|X VPB|VPWR VPB|VPWR sky130_fd_pr__pfet_01v8_hvt L=0.15 W=1
+ AS=0.135 AD=0.135 PS=1.27 PD=1.27
M$4376 VPB|VPWR A|B|B1|X \$5961 VPB|VPWR sky130_fd_pr__pfet_01v8_hvt L=0.15 W=1
+ AS=0.135 AD=0.135 PS=1.27 PD=1.27
M$4377 \$5961 A|B|X VPB|VPWR VPB|VPWR sky130_fd_pr__pfet_01v8_hvt L=0.15 W=1
+ AS=0.135 AD=0.26 PS=1.27 PD=2.52
M$4378 \$5961 \$5960 A|A1|B|X VPB|VPWR sky130_fd_pr__pfet_01v8_hvt L=0.15 W=1
+ AS=0.26 AD=0.3 PS=2.52 PD=2.6
M$4381 VPB|VPWR B1|C|X B|C_N|Y VPB|VPWR sky130_fd_pr__pfet_01v8_hvt L=0.15 W=1
+ AS=0.26 AD=0.135 PS=2.52 PD=1.27
M$4382 B|C_N|Y A2|B|X VPB|VPWR VPB|VPWR sky130_fd_pr__pfet_01v8_hvt L=0.15 W=1
+ AS=0.135 AD=0.165 PS=1.27 PD=1.33
M$4383 VPB|VPWR A|A1|Y B|C_N|Y VPB|VPWR sky130_fd_pr__pfet_01v8_hvt L=0.15 W=1
+ AS=0.165 AD=0.26 PS=1.33 PD=2.52
M$4384 A_N|B|Y B1|C|X \$5965 VPB|VPWR sky130_fd_pr__pfet_01v8_hvt L=0.15 W=1
+ AS=0.265 AD=0.14 PS=2.53 PD=1.28
M$4385 \$5965 A|A1|Y VPB|VPWR VPB|VPWR sky130_fd_pr__pfet_01v8_hvt L=0.15 W=1
+ AS=0.14 AD=0.1475 PS=1.28 PD=1.295
M$4386 VPB|VPWR A2|B|X \$5965 VPB|VPWR sky130_fd_pr__pfet_01v8_hvt L=0.15 W=1
+ AS=0.1475 AD=0.265 PS=1.295 PD=2.53
M$4387 VPB|VPWR A2|B|X B|Y VPB|VPWR sky130_fd_pr__pfet_01v8_hvt L=0.15 W=1
+ AS=0.26 AD=0.135 PS=2.52 PD=1.27
M$4390 \$5968 \$6032 \$5969 VPB|VPWR sky130_fd_pr__pfet_01v8_hvt L=0.15 W=0.84
+ AS=0.1715 AD=0.1458 PS=1.355 PD=1.205
M$4391 \$5969 B|SLEEP|Y \$5967 VPB|VPWR sky130_fd_pr__pfet_01v8_hvt L=0.15
+ W=0.64 AS=0.1458 AD=0.246 PS=1.205 PD=1.525
M$4392 \$5967 \$5968 VPB|VPWR VPB|VPWR sky130_fd_pr__pfet_01v8_hvt L=0.15 W=1
+ AS=0.285 AD=0.135 PS=2.57 PD=1.27
M$4393 VPB|VPWR A|Y \$5968 VPB|VPWR sky130_fd_pr__pfet_01v8_hvt L=0.15 W=1
+ AS=0.135 AD=0.1715 PS=1.27 PD=1.355
M$4394 \$5970 \$6032 \$5967 VPB|VPWR sky130_fd_pr__pfet_01v8_hvt L=0.15 W=0.64
+ AS=0.2431 AD=0.246 PS=1.445 PD=1.525
M$4395 \$5970 B|SLEEP|Y \$5968 VPB|VPWR sky130_fd_pr__pfet_01v8_hvt L=0.15
+ W=0.84 AS=0.2431 AD=0.3528 PS=1.445 PD=2.52
M$4396 \$6032 B|SLEEP|Y VPB|VPWR VPB|VPWR sky130_fd_pr__pfet_01v8_hvt L=0.15
+ W=1 AS=0.26 AD=0.25655 PS=2.52 PD=2.52
M$4397 VPB|VPWR B|C|Y \$5972 VPB|VPWR sky130_fd_pr__pfet_01v8_hvt L=0.15 W=0.64
+ AS=0.169 AD=0.1792 PS=1.365 PD=1.84
M$4398 VPB|VPWR \$5971 A|A1|X VPB|VPWR sky130_fd_pr__pfet_01v8_hvt L=0.15 W=1
+ AS=0.169 AD=0.28 PS=1.365 PD=2.56
M$4399 VPB|VPWR B|Y \$5974 VPB|VPWR sky130_fd_pr__pfet_01v8_hvt L=0.15 W=1
+ AS=0.3 AD=0.135 PS=2.6 PD=1.27
M$4400 \$5974 A|C|Y VPB|VPWR VPB|VPWR sky130_fd_pr__pfet_01v8_hvt L=0.15 W=1
+ AS=0.135 AD=0.365 PS=1.27 PD=1.73
M$4401 VPB|VPWR A|C|Y \$6060 VPB|VPWR sky130_fd_pr__pfet_01v8_hvt L=0.15 W=1
+ AS=0.365 AD=0.105 PS=1.73 PD=1.21
M$4402 \$6060 B|Y A_N|B1|C|Y VPB|VPWR sky130_fd_pr__pfet_01v8_hvt L=0.15 W=1
+ AS=0.105 AD=0.165 PS=1.21 PD=1.33
M$4403 A_N|B1|C|Y \$5974 VPB|VPWR VPB|VPWR sky130_fd_pr__pfet_01v8_hvt L=0.15
+ W=1 AS=0.165 AD=0.36 PS=1.33 PD=2.72
M$4405 VPB|VPWR A|C|X \$6066 VPB|VPWR sky130_fd_pr__pfet_01v8_hvt L=0.15 W=1
+ AS=0.26 AD=0.105 PS=2.52 PD=1.21
M$4406 \$6066 B|X B1|Y VPB|VPWR sky130_fd_pr__pfet_01v8_hvt L=0.15 W=1 AS=0.105
+ AD=0.26 PS=1.21 PD=2.52
M$4410 VPB|VPWR B|X A1|B1|Y VPB|VPWR sky130_fd_pr__pfet_01v8_hvt L=0.15 W=1
+ AS=0.26 AD=0.135 PS=2.52 PD=1.27
M$4411 A1|B1|Y A|X VPB|VPWR VPB|VPWR sky130_fd_pr__pfet_01v8_hvt L=0.15 W=1
+ AS=0.135 AD=0.26 PS=1.27 PD=2.52
M$4413 B1|Y B1|Y \$5981 VPB|VPWR sky130_fd_pr__pfet_01v8_hvt L=0.15 W=1
+ AS=0.265 AD=0.14 PS=2.53 PD=1.28
M$4414 \$5981 A1|Y VPB|VPWR VPB|VPWR sky130_fd_pr__pfet_01v8_hvt L=0.15 W=1
+ AS=0.14 AD=0.1475 PS=1.28 PD=1.295
M$4415 VPB|VPWR A|A2|Y \$5981 VPB|VPWR sky130_fd_pr__pfet_01v8_hvt L=0.15 W=1
+ AS=0.1475 AD=0.265 PS=1.295 PD=2.53
M$4416 VPB|VPWR B|Y \$5983 VPB|VPWR sky130_fd_pr__pfet_01v8_hvt L=0.15 W=1
+ AS=0.3 AD=0.135 PS=2.6 PD=1.27
M$4417 \$5983 A|A2|Y VPB|VPWR VPB|VPWR sky130_fd_pr__pfet_01v8_hvt L=0.15 W=1
+ AS=0.135 AD=0.365 PS=1.27 PD=1.73
M$4418 VPB|VPWR A|A2|Y \$6067 VPB|VPWR sky130_fd_pr__pfet_01v8_hvt L=0.15 W=1
+ AS=0.365 AD=0.105 PS=1.73 PD=1.21
M$4419 \$6067 B|Y A2|B|C|Y VPB|VPWR sky130_fd_pr__pfet_01v8_hvt L=0.15 W=1
+ AS=0.105 AD=0.165 PS=1.21 PD=1.33
M$4420 A2|B|C|Y \$5983 VPB|VPWR VPB|VPWR sky130_fd_pr__pfet_01v8_hvt L=0.15 W=1
+ AS=0.165 AD=0.36 PS=1.33 PD=2.72
M$4422 VPB|VPWR B1|Y A2|Y VPB|VPWR sky130_fd_pr__pfet_01v8_hvt L=0.15 W=1.64
+ AS=0.3849 AD=0.2846 PS=3.255 PD=2.31
M$4423 A2|Y A2|B|C|Y \$6025 VPB|VPWR sky130_fd_pr__pfet_01v8_hvt L=0.15 W=0.64
+ AS=0.0896 AD=0.0768 PS=0.92 PD=0.88
M$4424 \$6025 A|A1|X VPB|VPWR VPB|VPWR sky130_fd_pr__pfet_01v8_hvt L=0.15
+ W=0.64 AS=0.0768 AD=0.1696 PS=0.88 PD=1.81
M$4425 VPB|VPWR A1|B1_N|Y \$6026 VPB|VPWR sky130_fd_pr__pfet_01v8_hvt L=0.15
+ W=0.64 AS=0.1696 AD=0.0768 PS=1.81 PD=0.88
M$4426 \$6026 A2|Y D1|Y VPB|VPWR sky130_fd_pr__pfet_01v8_hvt L=0.15 W=0.64
+ AS=0.0768 AD=0.0896 PS=0.88 PD=0.92
M$4427 D1|Y B1|Y VPB|VPWR VPB|VPWR sky130_fd_pr__pfet_01v8_hvt L=0.15 W=0.64
+ AS=0.0896 AD=0.1824 PS=0.92 PD=1.85
M$4428 VPB|VPWR A1|Y \$6064 VPB|VPWR sky130_fd_pr__pfet_01v8_hvt L=0.15 W=1
+ AS=0.265 AD=0.105 PS=2.53 PD=1.21
M$4429 \$6064 A2|Y B1|Y VPB|VPWR sky130_fd_pr__pfet_01v8_hvt L=0.15 W=1
+ AS=0.105 AD=0.195 PS=1.21 PD=1.39
M$4431 VPB|VPWR A2|C1|X B1|Y VPB|VPWR sky130_fd_pr__pfet_01v8_hvt L=0.15 W=1
+ AS=0.195 AD=0.635 PS=1.39 PD=3.27
M$4433 VPB|VPWR A|A1|Y \$6063 VPB|VPWR sky130_fd_pr__pfet_01v8_hvt L=0.15 W=1
+ AS=0.265 AD=0.195 PS=2.53 PD=1.39
M$4434 \$6063 A2|B|Y A2|Y VPB|VPWR sky130_fd_pr__pfet_01v8_hvt L=0.15 W=1
+ AS=0.195 AD=0.2025 PS=1.39 PD=1.405
M$4436 VPB|VPWR C1|Y A2|Y VPB|VPWR sky130_fd_pr__pfet_01v8_hvt L=0.15 W=1
+ AS=0.195 AD=0.14 PS=1.39 PD=1.28
M$4437 A2|Y D1|Y VPB|VPWR VPB|VPWR sky130_fd_pr__pfet_01v8_hvt L=0.15 W=1
+ AS=0.14 AD=0.265 PS=1.28 PD=2.53
M$4439 VPB|VPWR B|Y \$5991 VPB|VPWR sky130_fd_pr__pfet_01v8_hvt L=0.15 W=1
+ AS=0.3 AD=0.135 PS=2.6 PD=1.27
M$4440 \$5991 A|C|X VPB|VPWR VPB|VPWR sky130_fd_pr__pfet_01v8_hvt L=0.15 W=1
+ AS=0.135 AD=0.365 PS=1.27 PD=1.73
M$4441 VPB|VPWR A|C|X \$6061 VPB|VPWR sky130_fd_pr__pfet_01v8_hvt L=0.15 W=1
+ AS=0.365 AD=0.105 PS=1.73 PD=1.21
M$4442 \$6061 B|Y A|Y VPB|VPWR sky130_fd_pr__pfet_01v8_hvt L=0.15 W=1 AS=0.105
+ AD=0.165 PS=1.21 PD=1.33
M$4443 A|Y \$5991 VPB|VPWR VPB|VPWR sky130_fd_pr__pfet_01v8_hvt L=0.15 W=1
+ AS=0.165 AD=0.36 PS=1.33 PD=2.72
M$4447 \$5993 B|X \$6059 VPB|VPWR sky130_fd_pr__pfet_01v8_hvt L=0.15 W=1
+ AS=0.26 AD=0.135 PS=2.52 PD=1.27
M$4448 \$6059 A|Y VPB|VPWR VPB|VPWR sky130_fd_pr__pfet_01v8_hvt L=0.15 W=1
+ AS=0.135 AD=0.135 PS=1.27 PD=1.27
M$4449 VPB|VPWR A|Y \$5994 VPB|VPWR sky130_fd_pr__pfet_01v8_hvt L=0.15 W=1
+ AS=0.135 AD=0.135 PS=1.27 PD=1.27
M$4450 \$5994 B|X VPB|VPWR VPB|VPWR sky130_fd_pr__pfet_01v8_hvt L=0.15 W=1
+ AS=0.135 AD=0.26 PS=1.27 PD=2.52
M$4451 \$5994 \$5993 A|B1|X VPB|VPWR sky130_fd_pr__pfet_01v8_hvt L=0.15 W=1
+ AS=0.26 AD=0.3 PS=2.52 PD=2.6
M$4454 VPB|VPWR A|B|Y \$6058 VPB|VPWR sky130_fd_pr__pfet_01v8_hvt L=0.15 W=1
+ AS=0.26 AD=0.105 PS=2.52 PD=1.21
M$4455 \$6058 B|C|X A1|Y VPB|VPWR sky130_fd_pr__pfet_01v8_hvt L=0.15 W=1
+ AS=0.105 AD=0.26 PS=1.21 PD=2.52
M$4456 VPB|VPWR A1|Y \$6057 VPB|VPWR sky130_fd_pr__pfet_01v8_hvt L=0.15 W=1
+ AS=0.265 AD=0.105 PS=2.53 PD=1.21
M$4457 \$6057 A2|Y B1|Y VPB|VPWR sky130_fd_pr__pfet_01v8_hvt L=0.15 W=1
+ AS=0.105 AD=0.195 PS=1.21 PD=1.39
M$4458 B1|Y A|B1|X VPB|VPWR VPB|VPWR sky130_fd_pr__pfet_01v8_hvt L=0.15 W=1
+ AS=0.195 AD=0.195 PS=1.39 PD=1.39
M$4460 VPB|VPWR B|SLEEP|X \$5997 VPB|VPWR sky130_fd_pr__pfet_01v8_hvt L=0.15
+ W=1 AS=0.3 AD=0.135 PS=2.6 PD=1.27
M$4461 \$5997 A|B1|X VPB|VPWR VPB|VPWR sky130_fd_pr__pfet_01v8_hvt L=0.15 W=1
+ AS=0.135 AD=0.365 PS=1.27 PD=1.73
M$4462 VPB|VPWR A|B1|X \$6056 VPB|VPWR sky130_fd_pr__pfet_01v8_hvt L=0.15 W=1
+ AS=0.365 AD=0.105 PS=1.73 PD=1.21
M$4463 \$6056 B|SLEEP|X A|Y VPB|VPWR sky130_fd_pr__pfet_01v8_hvt L=0.15 W=1
+ AS=0.105 AD=0.165 PS=1.21 PD=1.33
M$4464 A|Y \$5997 VPB|VPWR VPB|VPWR sky130_fd_pr__pfet_01v8_hvt L=0.15 W=1
+ AS=0.165 AD=0.36 PS=1.33 PD=2.72
M$4465 VPB|VPWR A1|X \$5952 VPB|VPWR sky130_fd_pr__pfet_01v8_hvt L=0.15 W=0.64
+ AS=0.1696 AD=0.0768 PS=1.81 PD=0.88
M$4466 \$5952 A2|Y A3|D|Y VPB|VPWR sky130_fd_pr__pfet_01v8_hvt L=0.15 W=0.64
+ AS=0.0768 AD=0.0896 PS=0.88 PD=0.92
M$4467 A3|D|Y B1|Y VPB|VPWR VPB|VPWR sky130_fd_pr__pfet_01v8_hvt L=0.15 W=0.64
+ AS=0.0896 AD=0.1824 PS=0.92 PD=1.85
M$4469 \$6000 B|X \$6054 VPB|VPWR sky130_fd_pr__pfet_01v8_hvt L=0.15 W=1
+ AS=0.26 AD=0.135 PS=2.52 PD=1.27
M$4470 \$6054 A|Y VPB|VPWR VPB|VPWR sky130_fd_pr__pfet_01v8_hvt L=0.15 W=1
+ AS=0.135 AD=0.135 PS=1.27 PD=1.27
M$4471 VPB|VPWR A|Y \$6001 VPB|VPWR sky130_fd_pr__pfet_01v8_hvt L=0.15 W=1
+ AS=0.135 AD=0.135 PS=1.27 PD=1.27
M$4472 \$6001 B|X VPB|VPWR VPB|VPWR sky130_fd_pr__pfet_01v8_hvt L=0.15 W=1
+ AS=0.135 AD=0.26 PS=1.27 PD=2.52
M$4473 \$6001 \$6000 B|C|X VPB|VPWR sky130_fd_pr__pfet_01v8_hvt L=0.15 W=1
+ AS=0.26 AD=0.3 PS=2.52 PD=2.6
M$4475 VPB|VPWR B|X \$6004 VPB|VPWR sky130_fd_pr__pfet_01v8_hvt L=0.15 W=1
+ AS=0.3 AD=0.135 PS=2.6 PD=1.27
M$4476 \$6004 A|B|Y VPB|VPWR VPB|VPWR sky130_fd_pr__pfet_01v8_hvt L=0.15 W=1
+ AS=0.135 AD=0.365 PS=1.27 PD=1.73
M$4477 VPB|VPWR A|B|Y \$6053 VPB|VPWR sky130_fd_pr__pfet_01v8_hvt L=0.15 W=1
+ AS=0.365 AD=0.105 PS=1.73 PD=1.21
M$4478 \$6053 B|X B|Y VPB|VPWR sky130_fd_pr__pfet_01v8_hvt L=0.15 W=1 AS=0.105
+ AD=0.165 PS=1.21 PD=1.33
M$4479 B|Y \$6004 VPB|VPWR VPB|VPWR sky130_fd_pr__pfet_01v8_hvt L=0.15 W=1
+ AS=0.165 AD=0.36 PS=1.33 PD=2.72
M$4480 VPB|VPWR D|X \$6008 VPB|VPWR sky130_fd_pr__pfet_01v8_hvt L=0.15 W=0.42
+ AS=0.1092 AD=0.0651 PS=1.36 PD=0.73
M$4481 \$6008 \$6006 \$6009 VPB|VPWR sky130_fd_pr__pfet_01v8_hvt L=0.15 W=0.42
+ AS=0.0651 AD=0.07245 PS=0.73 PD=0.765
M$4482 \$6009 \$6005 \$6010 VPB|VPWR sky130_fd_pr__pfet_01v8_hvt L=0.15 W=0.42
+ AS=0.07245 AD=0.1155 PS=0.765 PD=0.97
M$4483 \$6010 \$6011 VPB|VPWR VPB|VPWR sky130_fd_pr__pfet_01v8_hvt L=0.15
+ W=0.42 AS=0.1155 AD=0.07035 PS=0.97 PD=0.755
M$4484 VPB|VPWR RESET_B|X \$6010 VPB|VPWR sky130_fd_pr__pfet_01v8_hvt L=0.15
+ W=0.42 AS=0.07035 AD=0.1092 PS=0.755 PD=1.36
M$4485 \$6011 \$6005 \$6012 VPB|VPWR sky130_fd_pr__pfet_01v8_hvt L=0.15 W=0.42
+ AS=0.12915 AD=0.0588 PS=1.185 PD=0.7
M$4486 \$6012 \$6006 \$6027 VPB|VPWR sky130_fd_pr__pfet_01v8_hvt L=0.15 W=0.42
+ AS=0.0588 AD=0.0567 PS=0.7 PD=0.69
M$4487 \$6027 \$6013 VPB|VPWR VPB|VPWR sky130_fd_pr__pfet_01v8_hvt L=0.15
+ W=0.42 AS=0.0567 AD=0.0819 PS=0.69 PD=0.81
M$4488 VPB|VPWR RESET_B|X \$6013 VPB|VPWR sky130_fd_pr__pfet_01v8_hvt L=0.15
+ W=0.42 AS=0.0819 AD=0.0567 PS=0.81 PD=0.69
M$4489 \$6013 \$6012 VPB|VPWR VPB|VPWR sky130_fd_pr__pfet_01v8_hvt L=0.15
+ W=0.42 AS=0.0567 AD=0.1134 PS=0.69 PD=1.38
M$4490 VPB|VPWR \$6009 \$6011 VPB|VPWR sky130_fd_pr__pfet_01v8_hvt L=0.15
+ W=0.84 AS=0.2184 AD=0.12915 PS=2.2 PD=1.185
M$4491 VPB|VPWR \$6013 A|Q VPB|VPWR sky130_fd_pr__pfet_01v8_hvt L=0.15 W=1
+ AS=0.3012 AD=0.26 PS=2.66 PD=2.52
M$4492 VPB|VPWR C|X \$6023 VPB|VPWR sky130_fd_pr__pfet_01v8_hvt L=0.15 W=0.42
+ AS=0.2492 AD=0.0441 PS=1.565 PD=0.63
M$4493 \$6023 B|X \$6015 VPB|VPWR sky130_fd_pr__pfet_01v8_hvt L=0.15 W=0.42
+ AS=0.0441 AD=0.0567 PS=0.63 PD=0.69
M$4494 \$6015 B|X \$6024 VPB|VPWR sky130_fd_pr__pfet_01v8_hvt L=0.15 W=0.42
+ AS=0.0567 AD=0.0441 PS=0.69 PD=0.63
M$4495 \$6024 A|Q VPB|VPWR VPB|VPWR sky130_fd_pr__pfet_01v8_hvt L=0.15 W=0.42
+ AS=0.0441 AD=0.0567 PS=0.63 PD=0.69
M$4496 VPB|VPWR A|Q \$6022 VPB|VPWR sky130_fd_pr__pfet_01v8_hvt L=0.15 W=0.42
+ AS=0.0567 AD=0.0441 PS=0.69 PD=0.63
M$4497 \$6022 C|X \$6015 VPB|VPWR sky130_fd_pr__pfet_01v8_hvt L=0.15 W=0.42
+ AS=0.0441 AD=0.1092 PS=0.63 PD=1.36
M$4498 A2|B|X \$6015 VPB|VPWR VPB|VPWR sky130_fd_pr__pfet_01v8_hvt L=0.15 W=1
+ AS=0.365 AD=0.2492 PS=2.73 PD=1.565
M$4499 VPB|VPWR B|Y \$6017 VPB|VPWR sky130_fd_pr__pfet_01v8_hvt L=0.15 W=1
+ AS=0.3 AD=0.135 PS=2.6 PD=1.27
M$4500 \$6017 A|Q VPB|VPWR VPB|VPWR sky130_fd_pr__pfet_01v8_hvt L=0.15 W=1
+ AS=0.135 AD=0.365 PS=1.27 PD=1.73
M$4501 VPB|VPWR A|Q \$6052 VPB|VPWR sky130_fd_pr__pfet_01v8_hvt L=0.15 W=1
+ AS=0.365 AD=0.105 PS=1.73 PD=1.21
M$4502 \$6052 B|Y A|Y VPB|VPWR sky130_fd_pr__pfet_01v8_hvt L=0.15 W=1 AS=0.105
+ AD=0.165 PS=1.21 PD=1.33
M$4503 A|Y \$6017 VPB|VPWR VPB|VPWR sky130_fd_pr__pfet_01v8_hvt L=0.15 W=1
+ AS=0.165 AD=0.36 PS=1.33 PD=2.72
M$4515 VPB|VPWR A_N|B|Y \$6124 VPB|VPWR sky130_fd_pr__pfet_01v8_hvt L=0.15
+ W=0.42 AS=0.14575 AD=0.1092 PS=1.335 PD=1.36
M$4516 VPB|VPWR \$6124 A3|Y VPB|VPWR sky130_fd_pr__pfet_01v8_hvt L=0.15 W=1
+ AS=0.265 AD=0.135 PS=2.53 PD=1.27
M$4517 A3|Y B|C_N|Y VPB|VPWR VPB|VPWR sky130_fd_pr__pfet_01v8_hvt L=0.15 W=1
+ AS=0.135 AD=0.14575 PS=1.27 PD=1.335
M$4520 B|Y B|C|Y \$6388 VPB|VPWR sky130_fd_pr__pfet_01v8_hvt L=0.15 W=1 AS=0.26
+ AD=0.105 PS=2.52 PD=1.21
M$4521 \$6388 A|X VPB|VPWR VPB|VPWR sky130_fd_pr__pfet_01v8_hvt L=0.15 W=1
+ AS=0.105 AD=0.26 PS=1.21 PD=2.52
M$4522 \$5971 B|C|Y \$5969 VPB|VPWR sky130_fd_pr__pfet_01v8_hvt L=0.15 W=0.84
+ AS=0.15295 AD=0.273 PS=1.315 PD=2.33
M$4523 \$5971 \$5972 \$5970 VPB|VPWR sky130_fd_pr__pfet_01v8_hvt L=0.15 W=0.84
+ AS=0.15295 AD=0.32235 PS=1.315 PD=2.45
M$4525 \$6125 \$6127 \$6128 VPB|VPWR sky130_fd_pr__pfet_01v8_hvt L=0.15 W=0.64
+ AS=0.246 AD=0.2431 PS=1.525 PD=1.445
M$4526 \$6125 A|B|Y \$6129 VPB|VPWR sky130_fd_pr__pfet_01v8_hvt L=0.15 W=0.64
+ AS=0.246 AD=0.1458 PS=1.525 PD=1.205
M$4527 \$6128 A|B|Y \$6126 VPB|VPWR sky130_fd_pr__pfet_01v8_hvt L=0.15 W=0.84
+ AS=0.2431 AD=0.3528 PS=1.445 PD=2.52
M$4528 \$6125 \$6126 VPB|VPWR VPB|VPWR sky130_fd_pr__pfet_01v8_hvt L=0.15 W=1
+ AS=0.285 AD=0.135 PS=2.57 PD=1.27
M$4529 VPB|VPWR A|B|Y \$6126 VPB|VPWR sky130_fd_pr__pfet_01v8_hvt L=0.15 W=1
+ AS=0.135 AD=0.1715 PS=1.27 PD=1.355
M$4530 \$6126 \$6127 \$6129 VPB|VPWR sky130_fd_pr__pfet_01v8_hvt L=0.15 W=0.84
+ AS=0.1715 AD=0.1458 PS=1.355 PD=1.205
M$4531 \$6127 A|B|Y VPB|VPWR VPB|VPWR sky130_fd_pr__pfet_01v8_hvt L=0.15 W=1
+ AS=0.26 AD=0.25655 PS=2.52 PD=2.52
M$4532 \$5975 B|C|X \$6020 VPB|VPWR sky130_fd_pr__pfet_01v8_hvt L=0.15 W=0.42
+ AS=0.1092 AD=0.0441 PS=1.36 PD=0.63
M$4533 \$6020 A|B|Y VPB|VPWR VPB|VPWR sky130_fd_pr__pfet_01v8_hvt L=0.15 W=0.42
+ AS=0.0441 AD=0.0567 PS=0.63 PD=0.69
M$4534 VPB|VPWR A|B|Y \$6019 VPB|VPWR sky130_fd_pr__pfet_01v8_hvt L=0.15 W=0.42
+ AS=0.0567 AD=0.0441 PS=0.69 PD=0.63
M$4535 \$6019 A|B|Y \$5975 VPB|VPWR sky130_fd_pr__pfet_01v8_hvt L=0.15 W=0.42
+ AS=0.0441 AD=0.0567 PS=0.63 PD=0.69
M$4536 \$5975 A|B|Y \$6021 VPB|VPWR sky130_fd_pr__pfet_01v8_hvt L=0.15 W=0.42
+ AS=0.0567 AD=0.0441 PS=0.69 PD=0.63
M$4537 VPB|VPWR B|C|X \$6021 VPB|VPWR sky130_fd_pr__pfet_01v8_hvt L=0.15 W=0.42
+ AS=0.2492 AD=0.0441 PS=1.565 PD=0.63
M$4538 VPB|VPWR \$5975 B|X VPB|VPWR sky130_fd_pr__pfet_01v8_hvt L=0.15 W=1
+ AS=0.2492 AD=0.365 PS=1.565 PD=2.73
M$4539 \$6128 \$6131 \$6130 VPB|VPWR sky130_fd_pr__pfet_01v8_hvt L=0.15 W=0.84
+ AS=0.32235 AD=0.15295 PS=2.45 PD=1.315
M$4540 \$6130 B|C|X \$6129 VPB|VPWR sky130_fd_pr__pfet_01v8_hvt L=0.15 W=0.84
+ AS=0.15295 AD=0.273 PS=1.315 PD=2.33
M$4541 \$6131 B|C|X VPB|VPWR VPB|VPWR sky130_fd_pr__pfet_01v8_hvt L=0.15 W=0.64
+ AS=0.1792 AD=0.169 PS=1.84 PD=1.365
M$4542 VPB|VPWR \$6130 B|B_N|C|X VPB|VPWR sky130_fd_pr__pfet_01v8_hvt L=0.15
+ W=1 AS=0.169 AD=0.28 PS=1.365 PD=2.56
M$4543 \$6133 B|X \$6389 VPB|VPWR sky130_fd_pr__pfet_01v8_hvt L=0.15 W=1
+ AS=0.26 AD=0.135 PS=2.52 PD=1.27
M$4544 \$6389 A|C|X VPB|VPWR VPB|VPWR sky130_fd_pr__pfet_01v8_hvt L=0.15 W=1
+ AS=0.135 AD=0.135 PS=1.27 PD=1.27
M$4545 VPB|VPWR A|C|X \$6345 VPB|VPWR sky130_fd_pr__pfet_01v8_hvt L=0.15 W=1
+ AS=0.135 AD=0.135 PS=1.27 PD=1.27
M$4546 \$6345 B|X VPB|VPWR VPB|VPWR sky130_fd_pr__pfet_01v8_hvt L=0.15 W=1
+ AS=0.135 AD=0.26 PS=1.27 PD=2.52
M$4547 \$6345 \$6133 A2|B|C|X VPB|VPWR sky130_fd_pr__pfet_01v8_hvt L=0.15 W=1
+ AS=0.26 AD=0.3 PS=2.52 PD=2.6
M$4548 A|Y B1|Y \$6346 VPB|VPWR sky130_fd_pr__pfet_01v8_hvt L=0.15 W=1 AS=0.265
+ AD=0.14 PS=2.53 PD=1.28
M$4549 \$6346 A|A1|B1|Y VPB|VPWR VPB|VPWR sky130_fd_pr__pfet_01v8_hvt L=0.15
+ W=1 AS=0.14 AD=0.1475 PS=1.28 PD=1.295
M$4550 VPB|VPWR A2|B|C|X \$6346 VPB|VPWR sky130_fd_pr__pfet_01v8_hvt L=0.15 W=1
+ AS=0.1475 AD=0.265 PS=1.295 PD=2.53
M$4551 \$5979 A|A1|B1|Y VPB|VPWR VPB|VPWR sky130_fd_pr__pfet_01v8_hvt L=0.15
+ W=0.42 AS=0.1092 AD=0.0567 PS=1.36 PD=0.69
M$4552 VPB|VPWR A2|B|C|X \$5979 VPB|VPWR sky130_fd_pr__pfet_01v8_hvt L=0.15
+ W=0.42 AS=0.0567 AD=0.06615 PS=0.69 PD=0.735
M$4553 VPB|VPWR B|C|D_N|X \$5979 VPB|VPWR sky130_fd_pr__pfet_01v8_hvt L=0.15
+ W=0.42 AS=0.142225 AD=0.06615 PS=1.335 PD=0.735
M$4554 VPB|VPWR \$5979 A|B|X VPB|VPWR sky130_fd_pr__pfet_01v8_hvt L=0.15 W=1
+ AS=0.142225 AD=0.26 PS=1.335 PD=2.52
M$4555 \$6135 B|C|D_N|X \$6387 VPB|VPWR sky130_fd_pr__pfet_01v8_hvt L=0.15 W=1
+ AS=0.26 AD=0.135 PS=2.52 PD=1.27
M$4556 \$6387 A|Y VPB|VPWR VPB|VPWR sky130_fd_pr__pfet_01v8_hvt L=0.15 W=1
+ AS=0.135 AD=0.135 PS=1.27 PD=1.27
M$4557 VPB|VPWR A|Y \$6347 VPB|VPWR sky130_fd_pr__pfet_01v8_hvt L=0.15 W=1
+ AS=0.135 AD=0.135 PS=1.27 PD=1.27
M$4558 \$6347 B|C|D_N|X VPB|VPWR VPB|VPWR sky130_fd_pr__pfet_01v8_hvt L=0.15
+ W=1 AS=0.135 AD=0.26 PS=1.27 PD=2.52
M$4559 \$6347 \$6135 A2|B|SLEEP|X VPB|VPWR sky130_fd_pr__pfet_01v8_hvt L=0.15
+ W=1 AS=0.26 AD=0.3 PS=2.52 PD=2.6
M$4561 VPB|VPWR B|X \$6137 VPB|VPWR sky130_fd_pr__pfet_01v8_hvt L=0.15 W=1
+ AS=0.3 AD=0.135 PS=2.6 PD=1.27
M$4562 \$6137 A|X VPB|VPWR VPB|VPWR sky130_fd_pr__pfet_01v8_hvt L=0.15 W=1
+ AS=0.135 AD=0.365 PS=1.27 PD=1.73
M$4563 VPB|VPWR A|X \$6386 VPB|VPWR sky130_fd_pr__pfet_01v8_hvt L=0.15 W=1
+ AS=0.365 AD=0.105 PS=1.73 PD=1.21
M$4564 \$6386 B|X A3|B|C|Y VPB|VPWR sky130_fd_pr__pfet_01v8_hvt L=0.15 W=1
+ AS=0.105 AD=0.165 PS=1.21 PD=1.33
M$4565 A3|B|C|Y \$6137 VPB|VPWR VPB|VPWR sky130_fd_pr__pfet_01v8_hvt L=0.15 W=1
+ AS=0.165 AD=0.36 PS=1.33 PD=2.72
M$4566 VPB|VPWR A|A1|Y \$6385 VPB|VPWR sky130_fd_pr__pfet_01v8_hvt L=0.15 W=1
+ AS=0.26 AD=0.135 PS=2.52 PD=1.27
M$4567 \$6385 A2|B|SLEEP|X \$6384 VPB|VPWR sky130_fd_pr__pfet_01v8_hvt L=0.15
+ W=1 AS=0.135 AD=0.135 PS=1.27 PD=1.27
M$4568 \$6384 A3|B|C|Y B|Y VPB|VPWR sky130_fd_pr__pfet_01v8_hvt L=0.15 W=1
+ AS=0.135 AD=0.3925 PS=1.27 PD=1.785
M$4569 B|Y A1|B1|Y VPB|VPWR VPB|VPWR sky130_fd_pr__pfet_01v8_hvt L=0.15 W=1
+ AS=0.3925 AD=0.3 PS=1.785 PD=2.6
M$4570 A1|Y A3|B|C|Y \$6383 VPB|VPWR sky130_fd_pr__pfet_01v8_hvt L=0.15 W=1
+ AS=0.26 AD=0.135 PS=2.52 PD=1.27
M$4571 \$6383 A2|B|SLEEP|X \$6382 VPB|VPWR sky130_fd_pr__pfet_01v8_hvt L=0.15
+ W=1 AS=0.135 AD=0.135 PS=1.27 PD=1.27
M$4572 \$6382 A|A1|Y VPB|VPWR VPB|VPWR sky130_fd_pr__pfet_01v8_hvt L=0.15 W=1
+ AS=0.135 AD=0.26 PS=1.27 PD=2.52
M$4574 \$6141 A|X \$6362 VPB|VPWR sky130_fd_pr__pfet_01v8_hvt L=0.15 W=0.42
+ AS=0.1092 AD=0.0441 PS=1.36 PD=0.63
M$4575 \$6362 B|SLEEP|X VPB|VPWR VPB|VPWR sky130_fd_pr__pfet_01v8_hvt L=0.15
+ W=0.42 AS=0.0441 AD=0.14575 PS=0.63 PD=1.335
M$4576 VPB|VPWR \$6141 A|A1|X VPB|VPWR sky130_fd_pr__pfet_01v8_hvt L=0.15 W=1
+ AS=0.14575 AD=0.34 PS=1.335 PD=2.68
M$4577 \$6142 A2|B|C|Y \$6381 VPB|VPWR sky130_fd_pr__pfet_01v8_hvt L=0.15 W=1
+ AS=0.26 AD=0.135 PS=2.52 PD=1.27
M$4578 \$6381 A|A1|X VPB|VPWR VPB|VPWR sky130_fd_pr__pfet_01v8_hvt L=0.15 W=1
+ AS=0.135 AD=0.135 PS=1.27 PD=1.27
M$4579 VPB|VPWR A|A1|X \$6348 VPB|VPWR sky130_fd_pr__pfet_01v8_hvt L=0.15 W=1
+ AS=0.135 AD=0.135 PS=1.27 PD=1.27
M$4580 \$6348 A2|B|C|Y VPB|VPWR VPB|VPWR sky130_fd_pr__pfet_01v8_hvt L=0.15 W=1
+ AS=0.135 AD=0.26 PS=1.27 PD=2.52
M$4581 \$6348 \$6142 A2|C1|X VPB|VPWR sky130_fd_pr__pfet_01v8_hvt L=0.15 W=1
+ AS=0.26 AD=0.3 PS=2.52 PD=2.6
M$4582 A1|B1_N|Y A2|B|C|Y \$6380 VPB|VPWR sky130_fd_pr__pfet_01v8_hvt L=0.15
+ W=1 AS=0.26 AD=0.135 PS=2.52 PD=1.27
M$4583 \$6380 B|X \$6379 VPB|VPWR sky130_fd_pr__pfet_01v8_hvt L=0.15 W=1
+ AS=0.135 AD=0.135 PS=1.27 PD=1.27
M$4584 \$6379 A|B|Y VPB|VPWR VPB|VPWR sky130_fd_pr__pfet_01v8_hvt L=0.15 W=1
+ AS=0.135 AD=0.26 PS=1.27 PD=2.52
M$4585 VPB|VPWR A1|B1_N|Y \$6144 VPB|VPWR sky130_fd_pr__pfet_01v8_hvt L=0.15
+ W=0.42 AS=0.17825 AD=0.1092 PS=1.4 PD=1.36
M$4586 VPB|VPWR \$6144 A2|B|Y VPB|VPWR sky130_fd_pr__pfet_01v8_hvt L=0.15 W=1
+ AS=0.17825 AD=0.1525 PS=1.4 PD=1.305
M$4587 A2|B|Y A2|C1|X \$6378 VPB|VPWR sky130_fd_pr__pfet_01v8_hvt L=0.15 W=1
+ AS=0.1525 AD=0.1275 PS=1.305 PD=1.255
M$4588 \$6378 A1|Y VPB|VPWR VPB|VPWR sky130_fd_pr__pfet_01v8_hvt L=0.15 W=1
+ AS=0.1275 AD=0.28 PS=1.255 PD=2.56
M$4589 \$6148 B|X \$6377 VPB|VPWR sky130_fd_pr__pfet_01v8_hvt L=0.15 W=1
+ AS=0.26 AD=0.135 PS=2.52 PD=1.27
M$4590 \$6377 A|B|Y VPB|VPWR VPB|VPWR sky130_fd_pr__pfet_01v8_hvt L=0.15 W=1
+ AS=0.135 AD=0.135 PS=1.27 PD=1.27
M$4591 VPB|VPWR A|B|Y \$6349 VPB|VPWR sky130_fd_pr__pfet_01v8_hvt L=0.15 W=1
+ AS=0.135 AD=0.135 PS=1.27 PD=1.27
M$4592 \$6349 B|X VPB|VPWR VPB|VPWR sky130_fd_pr__pfet_01v8_hvt L=0.15 W=1
+ AS=0.135 AD=0.26 PS=1.27 PD=2.52
M$4593 \$6349 \$6148 B|C|X VPB|VPWR sky130_fd_pr__pfet_01v8_hvt L=0.15 W=1
+ AS=0.26 AD=0.3 PS=2.52 PD=2.6
M$4595 \$6150 A2|B|Y \$6376 VPB|VPWR sky130_fd_pr__pfet_01v8_hvt L=0.15 W=1
+ AS=0.26 AD=0.135 PS=2.52 PD=1.27
M$4596 \$6376 A|A1|Y VPB|VPWR VPB|VPWR sky130_fd_pr__pfet_01v8_hvt L=0.15 W=1
+ AS=0.135 AD=0.135 PS=1.27 PD=1.27
M$4597 VPB|VPWR A|A1|Y \$6350 VPB|VPWR sky130_fd_pr__pfet_01v8_hvt L=0.15 W=1
+ AS=0.135 AD=0.135 PS=1.27 PD=1.27
M$4598 \$6350 A2|B|Y VPB|VPWR VPB|VPWR sky130_fd_pr__pfet_01v8_hvt L=0.15 W=1
+ AS=0.135 AD=0.26 PS=1.27 PD=2.52
M$4599 \$6350 \$6150 A|C|X VPB|VPWR sky130_fd_pr__pfet_01v8_hvt L=0.15 W=1
+ AS=0.26 AD=0.3 PS=2.52 PD=2.6
M$4602 B1|Y A|C|X VPB|VPWR VPB|VPWR sky130_fd_pr__pfet_01v8_hvt L=0.15 W=1
+ AS=0.135 AD=0.26 PS=1.27 PD=2.52
M$4603 \$6151 B|C|X \$6375 VPB|VPWR sky130_fd_pr__pfet_01v8_hvt L=0.15 W=1
+ AS=0.26 AD=0.135 PS=2.52 PD=1.27
M$4604 \$6375 A|B|X VPB|VPWR VPB|VPWR sky130_fd_pr__pfet_01v8_hvt L=0.15 W=1
+ AS=0.135 AD=0.135 PS=1.27 PD=1.27
M$4605 VPB|VPWR A|B|X \$6351 VPB|VPWR sky130_fd_pr__pfet_01v8_hvt L=0.15 W=1
+ AS=0.135 AD=0.135 PS=1.27 PD=1.27
M$4606 \$6351 B|C|X VPB|VPWR VPB|VPWR sky130_fd_pr__pfet_01v8_hvt L=0.15 W=1
+ AS=0.135 AD=0.26 PS=1.27 PD=2.52
M$4607 \$6351 \$6151 B|X VPB|VPWR sky130_fd_pr__pfet_01v8_hvt L=0.15 W=1
+ AS=0.26 AD=0.3 PS=2.52 PD=2.6
M$4609 \$6154 B|C|X \$6374 VPB|VPWR sky130_fd_pr__pfet_01v8_hvt L=0.15 W=1
+ AS=0.26 AD=0.135 PS=2.52 PD=1.27
M$4610 \$6374 A|B|X VPB|VPWR VPB|VPWR sky130_fd_pr__pfet_01v8_hvt L=0.15 W=1
+ AS=0.135 AD=0.135 PS=1.27 PD=1.27
M$4611 VPB|VPWR A|B|X \$6352 VPB|VPWR sky130_fd_pr__pfet_01v8_hvt L=0.15 W=1
+ AS=0.135 AD=0.135 PS=1.27 PD=1.27
M$4612 \$6352 B|C|X VPB|VPWR VPB|VPWR sky130_fd_pr__pfet_01v8_hvt L=0.15 W=1
+ AS=0.135 AD=0.26 PS=1.27 PD=2.52
M$4613 \$6352 \$6154 B|C|X VPB|VPWR sky130_fd_pr__pfet_01v8_hvt L=0.15 W=1
+ AS=0.26 AD=0.3 PS=2.52 PD=2.6
M$4614 VPB|VPWR B|C|X \$6368 VPB|VPWR sky130_fd_pr__pfet_01v8_hvt L=0.15 W=0.42
+ AS=0.2492 AD=0.0441 PS=1.565 PD=0.63
M$4615 \$6368 A|B|Y \$6155 VPB|VPWR sky130_fd_pr__pfet_01v8_hvt L=0.15 W=0.42
+ AS=0.0441 AD=0.0567 PS=0.63 PD=0.69
M$4616 \$6155 A|B|Y \$6369 VPB|VPWR sky130_fd_pr__pfet_01v8_hvt L=0.15 W=0.42
+ AS=0.0567 AD=0.0441 PS=0.69 PD=0.63
M$4617 \$6369 A|Y VPB|VPWR VPB|VPWR sky130_fd_pr__pfet_01v8_hvt L=0.15 W=0.42
+ AS=0.0441 AD=0.0567 PS=0.63 PD=0.69
M$4618 VPB|VPWR A|Y \$6370 VPB|VPWR sky130_fd_pr__pfet_01v8_hvt L=0.15 W=0.42
+ AS=0.0567 AD=0.0441 PS=0.69 PD=0.63
M$4619 \$6370 B|C|X \$6155 VPB|VPWR sky130_fd_pr__pfet_01v8_hvt L=0.15 W=0.42
+ AS=0.0441 AD=0.1092 PS=0.63 PD=1.36
M$4620 B|SLEEP|X \$6155 VPB|VPWR VPB|VPWR sky130_fd_pr__pfet_01v8_hvt L=0.15
+ W=1 AS=0.365 AD=0.2492 PS=2.73 PD=1.565
M$4621 VPB|VPWR B|B_N|X \$6341 VPB|VPWR sky130_fd_pr__pfet_01v8_hvt L=0.15
+ W=0.42 AS=0.1573 AD=0.1092 PS=1.39 PD=1.36
M$4622 C1|Y \$6341 \$6373 VPB|VPWR sky130_fd_pr__pfet_01v8_hvt L=0.15 W=1
+ AS=0.26 AD=0.105 PS=2.52 PD=1.21
M$4623 \$6373 A|Y VPB|VPWR VPB|VPWR sky130_fd_pr__pfet_01v8_hvt L=0.15 W=1
+ AS=0.105 AD=0.1573 PS=1.21 PD=1.39
M$4625 \$6156 \$6158 \$6159 VPB|VPWR sky130_fd_pr__pfet_01v8_hvt L=0.15 W=0.64
+ AS=0.246 AD=0.2431 PS=1.525 PD=1.445
M$4626 \$6156 A|B|Y \$6160 VPB|VPWR sky130_fd_pr__pfet_01v8_hvt L=0.15 W=0.64
+ AS=0.246 AD=0.1458 PS=1.525 PD=1.205
M$4627 \$6159 A|B|Y \$6157 VPB|VPWR sky130_fd_pr__pfet_01v8_hvt L=0.15 W=0.84
+ AS=0.2431 AD=0.3528 PS=1.445 PD=2.52
M$4628 \$6156 \$6157 VPB|VPWR VPB|VPWR sky130_fd_pr__pfet_01v8_hvt L=0.15 W=1
+ AS=0.285 AD=0.135 PS=2.57 PD=1.27
M$4629 VPB|VPWR A|C|Y \$6157 VPB|VPWR sky130_fd_pr__pfet_01v8_hvt L=0.15 W=1
+ AS=0.135 AD=0.1715 PS=1.27 PD=1.355
M$4630 \$6157 \$6158 \$6160 VPB|VPWR sky130_fd_pr__pfet_01v8_hvt L=0.15 W=0.84
+ AS=0.1715 AD=0.1458 PS=1.355 PD=1.205
M$4631 \$5999 C|Y \$6028 VPB|VPWR sky130_fd_pr__pfet_01v8_hvt L=0.15 W=0.42
+ AS=0.1092 AD=0.0441 PS=1.36 PD=0.63
M$4632 \$6028 A|C|Y VPB|VPWR VPB|VPWR sky130_fd_pr__pfet_01v8_hvt L=0.15 W=0.42
+ AS=0.0441 AD=0.0567 PS=0.63 PD=0.69
M$4633 VPB|VPWR A|C|Y \$6029 VPB|VPWR sky130_fd_pr__pfet_01v8_hvt L=0.15 W=0.42
+ AS=0.0567 AD=0.0441 PS=0.69 PD=0.63
M$4634 \$6029 B|Y \$5999 VPB|VPWR sky130_fd_pr__pfet_01v8_hvt L=0.15 W=0.42
+ AS=0.0441 AD=0.0567 PS=0.63 PD=0.69
M$4635 \$5999 B|Y \$6030 VPB|VPWR sky130_fd_pr__pfet_01v8_hvt L=0.15 W=0.42
+ AS=0.0567 AD=0.0441 PS=0.69 PD=0.63
M$4636 VPB|VPWR C|Y \$6030 VPB|VPWR sky130_fd_pr__pfet_01v8_hvt L=0.15 W=0.42
+ AS=0.2492 AD=0.0441 PS=1.565 PD=0.63
M$4637 VPB|VPWR \$5999 B|X VPB|VPWR sky130_fd_pr__pfet_01v8_hvt L=0.15 W=1
+ AS=0.2492 AD=0.365 PS=1.565 PD=2.73
M$4638 \$6158 A|B|Y VPB|VPWR VPB|VPWR sky130_fd_pr__pfet_01v8_hvt L=0.15 W=1
+ AS=0.26 AD=0.25655 PS=2.52 PD=2.52
M$4639 \$6159 \$6162 \$6161 VPB|VPWR sky130_fd_pr__pfet_01v8_hvt L=0.15 W=0.84
+ AS=0.32235 AD=0.15295 PS=2.45 PD=1.315
M$4640 \$6161 C|Y \$6160 VPB|VPWR sky130_fd_pr__pfet_01v8_hvt L=0.15 W=0.84
+ AS=0.15295 AD=0.273 PS=1.315 PD=2.33
M$4641 \$6162 C|Y VPB|VPWR VPB|VPWR sky130_fd_pr__pfet_01v8_hvt L=0.15 W=0.64
+ AS=0.1792 AD=0.169 PS=1.84 PD=1.365
M$4642 VPB|VPWR \$6161 B|X VPB|VPWR sky130_fd_pr__pfet_01v8_hvt L=0.15 W=1
+ AS=0.169 AD=0.28 PS=1.365 PD=2.56
M$4644 VPB|VPWR B|C|X A2|C|Y VPB|VPWR sky130_fd_pr__pfet_01v8_hvt L=0.15 W=1
+ AS=0.26 AD=0.135 PS=2.52 PD=1.27
M$4645 A2|C|Y B|X VPB|VPWR VPB|VPWR sky130_fd_pr__pfet_01v8_hvt L=0.15 W=1
+ AS=0.135 AD=0.165 PS=1.27 PD=1.33
M$4646 VPB|VPWR A|B|Y A2|C|Y VPB|VPWR sky130_fd_pr__pfet_01v8_hvt L=0.15 W=1
+ AS=0.165 AD=0.26 PS=1.33 PD=2.52
M$4647 \$6163 B|C|X \$6372 VPB|VPWR sky130_fd_pr__pfet_01v8_hvt L=0.15 W=1
+ AS=0.26 AD=0.135 PS=2.52 PD=1.27
M$4648 \$6372 A|Y VPB|VPWR VPB|VPWR sky130_fd_pr__pfet_01v8_hvt L=0.15 W=1
+ AS=0.135 AD=0.135 PS=1.27 PD=1.27
M$4649 VPB|VPWR A|Y \$6353 VPB|VPWR sky130_fd_pr__pfet_01v8_hvt L=0.15 W=1
+ AS=0.135 AD=0.135 PS=1.27 PD=1.27
M$4650 \$6353 B|C|X VPB|VPWR VPB|VPWR sky130_fd_pr__pfet_01v8_hvt L=0.15 W=1
+ AS=0.135 AD=0.26 PS=1.27 PD=2.52
M$4651 \$6353 \$6163 C|X VPB|VPWR sky130_fd_pr__pfet_01v8_hvt L=0.15 W=1
+ AS=0.26 AD=0.3 PS=2.52 PD=2.6
M$4653 \$6005 CLK|TICK VPB|VPWR VPB|VPWR sky130_fd_pr__pfet_01v8_hvt L=0.15
+ W=0.64 AS=0.1664 AD=0.0864 PS=1.8 PD=0.91
M$4654 VPB|VPWR \$6005 \$6006 VPB|VPWR sky130_fd_pr__pfet_01v8_hvt L=0.15
+ W=0.64 AS=0.0864 AD=0.1664 PS=0.91 PD=1.8
M$4655 VPB|VPWR C|X \$6166 VPB|VPWR sky130_fd_pr__pfet_01v8_hvt L=0.15 W=0.64
+ AS=0.2115 AD=0.1792 PS=1.45 PD=1.84
M$4656 D|X \$6164 VPB|VPWR VPB|VPWR sky130_fd_pr__pfet_01v8_hvt L=0.15 W=1
+ AS=0.28 AD=0.2115 PS=2.56 PD=1.45
M$4657 VPB|VPWR B|X \$6169 VPB|VPWR sky130_fd_pr__pfet_01v8_hvt L=0.15 W=1
+ AS=0.26 AD=0.2526 PS=2.52 PD=2.52
M$4658 \$6168 \$6169 \$6171 VPB|VPWR sky130_fd_pr__pfet_01v8_hvt L=0.15 W=0.64
+ AS=0.2452 AD=0.246 PS=1.45 PD=1.525
M$4659 \$6171 B|X \$6167 VPB|VPWR sky130_fd_pr__pfet_01v8_hvt L=0.15 W=0.64
+ AS=0.246 AD=0.1458 PS=1.525 PD=1.205
M$4660 \$6170 B|X \$6168 VPB|VPWR sky130_fd_pr__pfet_01v8_hvt L=0.15 W=0.84
+ AS=0.3536 AD=0.2452 PS=2.53 PD=1.45
M$4661 \$6170 \$6169 \$6167 VPB|VPWR sky130_fd_pr__pfet_01v8_hvt L=0.15 W=0.84
+ AS=0.1715 AD=0.1458 PS=1.355 PD=1.205
M$4662 \$6170 A|Q VPB|VPWR VPB|VPWR sky130_fd_pr__pfet_01v8_hvt L=0.15 W=1
+ AS=0.1715 AD=0.135 PS=1.355 PD=1.27
M$4663 VPB|VPWR \$6170 \$6171 VPB|VPWR sky130_fd_pr__pfet_01v8_hvt L=0.15 W=1
+ AS=0.135 AD=0.285 PS=1.27 PD=2.57
M$4664 A|Q \$6173 VPB|VPWR VPB|VPWR sky130_fd_pr__pfet_01v8_hvt L=0.15 W=1
+ AS=0.26 AD=0.3012 PS=2.52 PD=2.66
M$4673 VPB|VPWR B|D|X A2|B|Y VPB|VPWR sky130_fd_pr__pfet_01v8_hvt L=0.15 W=1
+ AS=0.26 AD=0.135 PS=2.52 PD=1.27
M$4674 A2|B|Y A|A2|B|B_N|X VPB|VPWR VPB|VPWR sky130_fd_pr__pfet_01v8_hvt L=0.15
+ W=1 AS=0.135 AD=0.26 PS=1.27 PD=2.52
M$4678 VPB|VPWR A|A1|B|X \$6427 VPB|VPWR sky130_fd_pr__pfet_01v8_hvt L=0.15 W=1
+ AS=0.26 AD=0.135 PS=2.52 PD=1.27
M$4679 \$6427 A2|B|Y \$6428 VPB|VPWR sky130_fd_pr__pfet_01v8_hvt L=0.15 W=1
+ AS=0.135 AD=0.135 PS=1.27 PD=1.27
M$4680 \$6428 A3|Y B|C|Y VPB|VPWR sky130_fd_pr__pfet_01v8_hvt L=0.15 W=1
+ AS=0.135 AD=0.3925 PS=1.27 PD=1.785
M$4689 VPB|VPWR A|B1|X \$6398 VPB|VPWR sky130_fd_pr__pfet_01v8_hvt L=0.15
+ W=0.42 AS=0.1573 AD=0.1092 PS=1.39 PD=1.36
M$4690 VPB|VPWR A2|B|SLEEP|X \$6432 VPB|VPWR sky130_fd_pr__pfet_01v8_hvt L=0.15
+ W=1 AS=0.1573 AD=0.105 PS=1.39 PD=1.21
M$4691 \$6432 \$6398 A|X VPB|VPWR sky130_fd_pr__pfet_01v8_hvt L=0.15 W=1
+ AS=0.105 AD=0.26 PS=1.21 PD=2.52
M$4693 VPB|VPWR A|A1|Y \$6434 VPB|VPWR sky130_fd_pr__pfet_01v8_hvt L=0.15 W=1
+ AS=0.26 AD=0.105 PS=2.52 PD=1.21
M$4694 \$6434 A2|B|SLEEP|X A|Y VPB|VPWR sky130_fd_pr__pfet_01v8_hvt L=0.15 W=1
+ AS=0.105 AD=0.26 PS=1.21 PD=2.52
M$4695 \$6400 A3|B|C|Y \$6435 VPB|VPWR sky130_fd_pr__pfet_01v8_hvt L=0.15 W=1
+ AS=0.26 AD=0.135 PS=2.52 PD=1.27
M$4696 \$6435 A|Y VPB|VPWR VPB|VPWR sky130_fd_pr__pfet_01v8_hvt L=0.15 W=1
+ AS=0.135 AD=0.135 PS=1.27 PD=1.27
M$4697 VPB|VPWR A|Y \$6401 VPB|VPWR sky130_fd_pr__pfet_01v8_hvt L=0.15 W=1
+ AS=0.135 AD=0.135 PS=1.27 PD=1.27
M$4698 \$6401 A3|B|C|Y VPB|VPWR VPB|VPWR sky130_fd_pr__pfet_01v8_hvt L=0.15 W=1
+ AS=0.135 AD=0.26 PS=1.27 PD=2.52
M$4699 \$6401 \$6400 A|X VPB|VPWR sky130_fd_pr__pfet_01v8_hvt L=0.15 W=1
+ AS=0.26 AD=0.3 PS=2.52 PD=2.6
M$4701 VPB|VPWR B|SLEEP|X \$6403 VPB|VPWR sky130_fd_pr__pfet_01v8_hvt L=0.15
+ W=1 AS=0.3 AD=0.135 PS=2.6 PD=1.27
M$4702 \$6403 A|X VPB|VPWR VPB|VPWR sky130_fd_pr__pfet_01v8_hvt L=0.15 W=1
+ AS=0.135 AD=0.365 PS=1.27 PD=1.73
M$4703 VPB|VPWR A|X \$6436 VPB|VPWR sky130_fd_pr__pfet_01v8_hvt L=0.15 W=1
+ AS=0.365 AD=0.105 PS=1.73 PD=1.21
M$4704 \$6436 B|SLEEP|X A|B|Y VPB|VPWR sky130_fd_pr__pfet_01v8_hvt L=0.15 W=1
+ AS=0.105 AD=0.165 PS=1.21 PD=1.33
M$4705 A|B|Y \$6403 VPB|VPWR VPB|VPWR sky130_fd_pr__pfet_01v8_hvt L=0.15 W=1
+ AS=0.165 AD=0.36 PS=1.33 PD=2.72
M$4707 B1|Y A|B|Y \$6439 VPB|VPWR sky130_fd_pr__pfet_01v8_hvt L=0.15 W=1
+ AS=0.26 AD=0.105 PS=2.52 PD=1.21
M$4708 \$6439 A|Y VPB|VPWR VPB|VPWR sky130_fd_pr__pfet_01v8_hvt L=0.15 W=1
+ AS=0.105 AD=0.26 PS=1.21 PD=2.52
M$4709 VPB|VPWR A|B|Y \$6440 VPB|VPWR sky130_fd_pr__pfet_01v8_hvt L=0.15 W=1
+ AS=0.26 AD=0.105 PS=2.52 PD=1.21
M$4710 \$6440 B|X A1|Y VPB|VPWR sky130_fd_pr__pfet_01v8_hvt L=0.15 W=1 AS=0.105
+ AD=0.26 PS=1.21 PD=2.52
M$4715 \$6407 \$6448 \$6409 VPB|VPWR sky130_fd_pr__pfet_01v8_hvt L=0.15 W=0.84
+ AS=0.1715 AD=0.1458 PS=1.355 PD=1.205
M$4716 \$6409 A|B|X \$6406 VPB|VPWR sky130_fd_pr__pfet_01v8_hvt L=0.15 W=0.64
+ AS=0.1458 AD=0.246 PS=1.205 PD=1.525
M$4717 \$6406 \$6407 VPB|VPWR VPB|VPWR sky130_fd_pr__pfet_01v8_hvt L=0.15 W=1
+ AS=0.285 AD=0.135 PS=2.57 PD=1.27
M$4718 VPB|VPWR A|Y \$6407 VPB|VPWR sky130_fd_pr__pfet_01v8_hvt L=0.15 W=1
+ AS=0.135 AD=0.1715 PS=1.27 PD=1.355
M$4719 \$6410 \$6448 \$6406 VPB|VPWR sky130_fd_pr__pfet_01v8_hvt L=0.15 W=0.64
+ AS=0.2431 AD=0.246 PS=1.445 PD=1.525
M$4720 \$6410 A|B|X \$6407 VPB|VPWR sky130_fd_pr__pfet_01v8_hvt L=0.15 W=0.84
+ AS=0.2431 AD=0.3528 PS=1.445 PD=2.52
M$4721 \$6448 A|B|X VPB|VPWR VPB|VPWR sky130_fd_pr__pfet_01v8_hvt L=0.15 W=1
+ AS=0.26 AD=0.25655 PS=2.52 PD=2.52
M$4722 \$6411 B|C|X \$6409 VPB|VPWR sky130_fd_pr__pfet_01v8_hvt L=0.15 W=0.84
+ AS=0.15295 AD=0.273 PS=1.315 PD=2.33
M$4723 \$6411 \$6412 \$6410 VPB|VPWR sky130_fd_pr__pfet_01v8_hvt L=0.15 W=0.84
+ AS=0.15295 AD=0.32235 PS=1.315 PD=2.45
M$4724 \$6153 B|C|X \$6365 VPB|VPWR sky130_fd_pr__pfet_01v8_hvt L=0.15 W=0.42
+ AS=0.1092 AD=0.0441 PS=1.36 PD=0.63
M$4725 \$6365 A|Y VPB|VPWR VPB|VPWR sky130_fd_pr__pfet_01v8_hvt L=0.15 W=0.42
+ AS=0.0441 AD=0.0567 PS=0.63 PD=0.69
M$4726 VPB|VPWR A|Y \$6366 VPB|VPWR sky130_fd_pr__pfet_01v8_hvt L=0.15 W=0.42
+ AS=0.0567 AD=0.0441 PS=0.69 PD=0.63
M$4727 \$6366 B|X \$6153 VPB|VPWR sky130_fd_pr__pfet_01v8_hvt L=0.15 W=0.42
+ AS=0.0441 AD=0.0567 PS=0.63 PD=0.69
M$4728 \$6153 B|X \$6367 VPB|VPWR sky130_fd_pr__pfet_01v8_hvt L=0.15 W=0.42
+ AS=0.0567 AD=0.0441 PS=0.69 PD=0.63
M$4729 VPB|VPWR B|C|X \$6367 VPB|VPWR sky130_fd_pr__pfet_01v8_hvt L=0.15 W=0.42
+ AS=0.2492 AD=0.0441 PS=1.565 PD=0.63
M$4730 VPB|VPWR \$6153 B|X VPB|VPWR sky130_fd_pr__pfet_01v8_hvt L=0.15 W=1
+ AS=0.2492 AD=0.365 PS=1.565 PD=2.73
M$4731 VPB|VPWR B|C|X \$6412 VPB|VPWR sky130_fd_pr__pfet_01v8_hvt L=0.15 W=0.64
+ AS=0.169 AD=0.1792 PS=1.365 PD=1.84
M$4732 VPB|VPWR \$6411 A|B|X VPB|VPWR sky130_fd_pr__pfet_01v8_hvt L=0.15 W=1
+ AS=0.169 AD=0.28 PS=1.365 PD=2.56
M$4733 \$6415 \$6449 \$6416 VPB|VPWR sky130_fd_pr__pfet_01v8_hvt L=0.15 W=0.84
+ AS=0.1715 AD=0.1458 PS=1.355 PD=1.205
M$4734 \$6416 A|B|X \$6414 VPB|VPWR sky130_fd_pr__pfet_01v8_hvt L=0.15 W=0.64
+ AS=0.1458 AD=0.246 PS=1.205 PD=1.525
M$4735 \$6414 \$6415 VPB|VPWR VPB|VPWR sky130_fd_pr__pfet_01v8_hvt L=0.15 W=1
+ AS=0.285 AD=0.135 PS=2.57 PD=1.27
M$4736 VPB|VPWR A|B|Y \$6415 VPB|VPWR sky130_fd_pr__pfet_01v8_hvt L=0.15 W=1
+ AS=0.135 AD=0.1715 PS=1.27 PD=1.355
M$4737 \$6417 \$6449 \$6414 VPB|VPWR sky130_fd_pr__pfet_01v8_hvt L=0.15 W=0.64
+ AS=0.2452 AD=0.246 PS=1.45 PD=1.525
M$4738 \$6417 A|B|X \$6415 VPB|VPWR sky130_fd_pr__pfet_01v8_hvt L=0.15 W=0.84
+ AS=0.2452 AD=0.3536 PS=1.45 PD=2.53
M$4739 \$6449 A|B|X VPB|VPWR VPB|VPWR sky130_fd_pr__pfet_01v8_hvt L=0.15 W=1
+ AS=0.2526 AD=0.26 PS=2.52 PD=2.52
M$4740 \$6416 \$6419 \$6418 VPB|VPWR sky130_fd_pr__pfet_01v8_hvt L=0.15 W=0.84
+ AS=0.441 AD=0.1596 PS=2.73 PD=1.22
M$4741 \$6418 B|C|X \$6417 VPB|VPWR sky130_fd_pr__pfet_01v8_hvt L=0.15 W=0.84
+ AS=0.1596 AD=0.2688 PS=1.22 PD=2.32
M$4742 VPB|VPWR B|C|X \$6419 VPB|VPWR sky130_fd_pr__pfet_01v8_hvt L=0.15 W=0.64
+ AS=0.2115 AD=0.1792 PS=1.45 PD=1.84
M$4743 VPB|VPWR \$6418 B|B_N|X VPB|VPWR sky130_fd_pr__pfet_01v8_hvt L=0.15 W=1
+ AS=0.2115 AD=0.28 PS=1.45 PD=2.56
M$4745 VPB|VPWR B|B_N|X \$6421 VPB|VPWR sky130_fd_pr__pfet_01v8_hvt L=0.15 W=1
+ AS=0.3 AD=0.135 PS=2.6 PD=1.27
M$4746 \$6421 A|Y VPB|VPWR VPB|VPWR sky130_fd_pr__pfet_01v8_hvt L=0.15 W=1
+ AS=0.135 AD=0.365 PS=1.27 PD=1.73
M$4747 VPB|VPWR A|Y \$6444 VPB|VPWR sky130_fd_pr__pfet_01v8_hvt L=0.15 W=1
+ AS=0.365 AD=0.105 PS=1.73 PD=1.21
M$4748 \$6444 B|B_N|X C|Y VPB|VPWR sky130_fd_pr__pfet_01v8_hvt L=0.15 W=1
+ AS=0.105 AD=0.165 PS=1.21 PD=1.33
M$4749 C|Y \$6421 VPB|VPWR VPB|VPWR sky130_fd_pr__pfet_01v8_hvt L=0.15 W=1
+ AS=0.165 AD=0.36 PS=1.33 PD=2.72
M$4758 \$6168 C|X \$6164 VPB|VPWR sky130_fd_pr__pfet_01v8_hvt L=0.15 W=0.84
+ AS=0.2688 AD=0.1596 PS=2.32 PD=1.22
M$4759 \$6164 \$6166 \$6167 VPB|VPWR sky130_fd_pr__pfet_01v8_hvt L=0.15 W=0.84
+ AS=0.1596 AD=0.441 PS=1.22 PD=2.73
M$4761 VPB|VPWR B|C|X \$6443 VPB|VPWR sky130_fd_pr__pfet_01v8_hvt L=0.15 W=0.42
+ AS=0.2492 AD=0.0441 PS=1.565 PD=0.63
M$4762 \$6443 B|Y \$6422 VPB|VPWR sky130_fd_pr__pfet_01v8_hvt L=0.15 W=0.42
+ AS=0.0441 AD=0.0567 PS=0.63 PD=0.69
M$4763 \$6422 B|Y \$6442 VPB|VPWR sky130_fd_pr__pfet_01v8_hvt L=0.15 W=0.42
+ AS=0.0567 AD=0.0441 PS=0.69 PD=0.63
M$4764 \$6442 A|Q VPB|VPWR VPB|VPWR sky130_fd_pr__pfet_01v8_hvt L=0.15 W=0.42
+ AS=0.0441 AD=0.0567 PS=0.63 PD=0.69
M$4765 VPB|VPWR A|Q \$6441 VPB|VPWR sky130_fd_pr__pfet_01v8_hvt L=0.15 W=0.42
+ AS=0.0567 AD=0.0441 PS=0.69 PD=0.63
M$4766 \$6441 B|C|X \$6422 VPB|VPWR sky130_fd_pr__pfet_01v8_hvt L=0.15 W=0.42
+ AS=0.0441 AD=0.1092 PS=0.63 PD=1.36
M$4767 B|X \$6422 VPB|VPWR VPB|VPWR sky130_fd_pr__pfet_01v8_hvt L=0.15 W=1
+ AS=0.365 AD=0.2492 PS=2.73 PD=1.565
M$4768 VPB|VPWR \$6354 \$6173 VPB|VPWR sky130_fd_pr__pfet_01v8_hvt L=0.15
+ W=0.42 AS=0.1134 AD=0.0567 PS=1.38 PD=0.69
M$4769 \$6173 RESET_B|X VPB|VPWR VPB|VPWR sky130_fd_pr__pfet_01v8_hvt L=0.15
+ W=0.42 AS=0.0567 AD=0.0819 PS=0.69 PD=0.81
M$4770 VPB|VPWR \$6173 \$6371 VPB|VPWR sky130_fd_pr__pfet_01v8_hvt L=0.15
+ W=0.42 AS=0.0819 AD=0.0567 PS=0.81 PD=0.69
M$4771 \$6371 \$6175 \$6354 VPB|VPWR sky130_fd_pr__pfet_01v8_hvt L=0.15 W=0.42
+ AS=0.0567 AD=0.0588 PS=0.69 PD=0.7
M$4772 \$6176 \$6174 \$6354 VPB|VPWR sky130_fd_pr__pfet_01v8_hvt L=0.15 W=0.42
+ AS=0.12915 AD=0.0588 PS=1.185 PD=0.7
M$4773 \$6176 \$6177 VPB|VPWR VPB|VPWR sky130_fd_pr__pfet_01v8_hvt L=0.15
+ W=0.84 AS=0.12915 AD=0.2184 PS=1.185 PD=2.2
M$4774 VPB|VPWR B|C|X \$6424 VPB|VPWR sky130_fd_pr__pfet_01v8_hvt L=0.15 W=1
+ AS=0.3 AD=0.135 PS=2.6 PD=1.27
M$4775 \$6424 A|Y VPB|VPWR VPB|VPWR sky130_fd_pr__pfet_01v8_hvt L=0.15 W=1
+ AS=0.135 AD=0.365 PS=1.27 PD=1.73
M$4776 VPB|VPWR A|Y \$6438 VPB|VPWR sky130_fd_pr__pfet_01v8_hvt L=0.15 W=1
+ AS=0.365 AD=0.105 PS=1.73 PD=1.21
M$4777 \$6438 B|C|X D|Y VPB|VPWR sky130_fd_pr__pfet_01v8_hvt L=0.15 W=1
+ AS=0.105 AD=0.165 PS=1.21 PD=1.33
M$4778 D|Y \$6424 VPB|VPWR VPB|VPWR sky130_fd_pr__pfet_01v8_hvt L=0.15 W=1
+ AS=0.165 AD=0.36 PS=1.33 PD=2.72
M$4779 \$6355 RESET_B|X VPB|VPWR VPB|VPWR sky130_fd_pr__pfet_01v8_hvt L=0.15
+ W=0.42 AS=0.1092 AD=0.07035 PS=1.36 PD=0.755
M$4780 VPB|VPWR \$6176 \$6355 VPB|VPWR sky130_fd_pr__pfet_01v8_hvt L=0.15
+ W=0.42 AS=0.07035 AD=0.1155 PS=0.755 PD=0.97
M$4781 \$6355 \$6174 \$6177 VPB|VPWR sky130_fd_pr__pfet_01v8_hvt L=0.15 W=0.42
+ AS=0.1155 AD=0.07245 PS=0.97 PD=0.765
M$4782 \$6177 \$6175 \$6178 VPB|VPWR sky130_fd_pr__pfet_01v8_hvt L=0.15 W=0.42
+ AS=0.07245 AD=0.0651 PS=0.765 PD=0.73
M$4783 \$6178 D|Y VPB|VPWR VPB|VPWR sky130_fd_pr__pfet_01v8_hvt L=0.15 W=0.42
+ AS=0.0651 AD=0.1092 PS=0.73 PD=1.36
M$4785 \$6175 \$6174 VPB|VPWR VPB|VPWR sky130_fd_pr__pfet_01v8_hvt L=0.15
+ W=0.64 AS=0.1664 AD=0.0864 PS=1.8 PD=0.91
M$4786 VPB|VPWR CLK|TICK \$6174 VPB|VPWR sky130_fd_pr__pfet_01v8_hvt L=0.15
+ W=0.64 AS=0.0864 AD=0.1664 PS=0.91 PD=1.8
M$4793 \$6468 A|FINE_MUX[13] VPB|VPWR VPB|VPWR sky130_fd_pr__pfet_01v8_hvt
+ L=0.15 W=1 AS=0.27 AD=0.1701 PS=2.54 PD=1.36
M$4794 VPB|VPWR \$6468 \$6469 VPB|VPWR sky130_fd_pr__pfet_01v8_hvt L=0.5 W=0.82
+ AS=0.1701 AD=0.2173 PS=1.36 PD=2.17
M$4795 VPB|VPWR \$6469 \$6470 VPB|VPWR sky130_fd_pr__pfet_01v8_hvt L=0.5 W=0.82
+ AS=0.15575 AD=0.2173 PS=1.325 PD=2.17
M$4796 VPB|VPWR \$6470 A|B1|X VPB|VPWR sky130_fd_pr__pfet_01v8_hvt L=0.15 W=1
+ AS=0.15575 AD=0.355 PS=1.325 PD=2.71
M$4799 \$6622 A2|B|X VPB|VPWR VPB|VPWR sky130_fd_pr__pfet_01v8_hvt L=0.15 W=1
+ AS=0.265 AD=0.1475 PS=2.53 PD=1.295
M$4800 VPB|VPWR A|A1|C|Y \$6622 VPB|VPWR sky130_fd_pr__pfet_01v8_hvt L=0.15 W=1
+ AS=0.1475 AD=0.14 PS=1.295 PD=1.28
M$4801 \$6622 B1|Y A|Y VPB|VPWR sky130_fd_pr__pfet_01v8_hvt L=0.15 W=1 AS=0.14
+ AD=0.265 PS=1.28 PD=2.53
M$4803 \$6475 A2|B|X \$6635 VPB|VPWR sky130_fd_pr__pfet_01v8_hvt L=0.15 W=1
+ AS=0.26 AD=0.135 PS=2.52 PD=1.27
M$4804 \$6635 A|A1|C|Y VPB|VPWR VPB|VPWR sky130_fd_pr__pfet_01v8_hvt L=0.15 W=1
+ AS=0.135 AD=0.135 PS=1.27 PD=1.27
M$4805 VPB|VPWR A|A1|C|Y \$6623 VPB|VPWR sky130_fd_pr__pfet_01v8_hvt L=0.15 W=1
+ AS=0.135 AD=0.135 PS=1.27 PD=1.27
M$4806 \$6623 A2|B|X VPB|VPWR VPB|VPWR sky130_fd_pr__pfet_01v8_hvt L=0.15 W=1
+ AS=0.135 AD=0.26 PS=1.27 PD=2.52
M$4807 VPB|VPWR B|D|X \$6640 VPB|VPWR sky130_fd_pr__pfet_01v8_hvt L=0.15 W=1
+ AS=0.3 AD=0.135 PS=2.6 PD=1.27
M$4808 \$6640 A|Y VPB|VPWR VPB|VPWR sky130_fd_pr__pfet_01v8_hvt L=0.15 W=1
+ AS=0.135 AD=0.365 PS=1.27 PD=1.73
M$4809 VPB|VPWR A|Y \$6686 VPB|VPWR sky130_fd_pr__pfet_01v8_hvt L=0.15 W=1
+ AS=0.365 AD=0.105 PS=1.73 PD=1.21
M$4810 \$6686 B|D|X A|B1|Y VPB|VPWR sky130_fd_pr__pfet_01v8_hvt L=0.15 W=1
+ AS=0.105 AD=0.165 PS=1.21 PD=1.33
M$4811 A|B1|Y \$6640 VPB|VPWR VPB|VPWR sky130_fd_pr__pfet_01v8_hvt L=0.15 W=1
+ AS=0.165 AD=0.36 PS=1.33 PD=2.72
M$4812 \$6623 \$6475 A|A2|B|B_N|X VPB|VPWR sky130_fd_pr__pfet_01v8_hvt L=0.15
+ W=1 AS=0.26 AD=0.3 PS=2.52 PD=2.6
M$4813 VPB|VPWR A|A2|B|B_N|X \$6476 VPB|VPWR sky130_fd_pr__pfet_01v8_hvt L=0.15
+ W=0.42 AS=0.1573 AD=0.1092 PS=1.39 PD=1.36
M$4814 B1|Y \$6476 \$6637 VPB|VPWR sky130_fd_pr__pfet_01v8_hvt L=0.15 W=1
+ AS=0.26 AD=0.105 PS=2.52 PD=1.21
M$4815 \$6637 A|Y VPB|VPWR VPB|VPWR sky130_fd_pr__pfet_01v8_hvt L=0.15 W=1
+ AS=0.105 AD=0.1573 PS=1.21 PD=1.39
M$4819 \$6478 A|A1|B|X \$6639 VPB|VPWR sky130_fd_pr__pfet_01v8_hvt L=0.15 W=1
+ AS=0.26 AD=0.135 PS=2.52 PD=1.27
M$4820 \$6639 A|B1|X VPB|VPWR VPB|VPWR sky130_fd_pr__pfet_01v8_hvt L=0.15 W=1
+ AS=0.135 AD=0.135 PS=1.27 PD=1.27
M$4821 VPB|VPWR A|B1|X \$6624 VPB|VPWR sky130_fd_pr__pfet_01v8_hvt L=0.15 W=1
+ AS=0.135 AD=0.135 PS=1.27 PD=1.27
M$4822 \$6624 A|A1|B|X VPB|VPWR VPB|VPWR sky130_fd_pr__pfet_01v8_hvt L=0.15 W=1
+ AS=0.135 AD=0.26 PS=1.27 PD=2.52
M$4823 \$6624 \$6478 A1|B|SLEEP|X VPB|VPWR sky130_fd_pr__pfet_01v8_hvt L=0.15
+ W=1 AS=0.26 AD=0.3 PS=2.52 PD=2.6
M$4824 VPB|VPWR A|Y \$6638 VPB|VPWR sky130_fd_pr__pfet_01v8_hvt L=0.15 W=1
+ AS=0.26 AD=0.105 PS=2.52 PD=1.21
M$4825 \$6638 A2|B|Y A|Y VPB|VPWR sky130_fd_pr__pfet_01v8_hvt L=0.15 W=1
+ AS=0.105 AD=0.26 PS=1.21 PD=2.52
M$4828 VPB|VPWR B|C_N|Y \$6394 VPB|VPWR sky130_fd_pr__pfet_01v8_hvt L=0.15
+ W=0.42 AS=0.1092 AD=0.1092 PS=1.36 PD=1.36
M$4829 \$6395 \$6394 \$6429 VPB|VPWR sky130_fd_pr__pfet_01v8_hvt L=0.15 W=0.42
+ AS=0.1092 AD=0.0441 PS=1.36 PD=0.63
M$4830 \$6429 A_N|B|Y \$6430 VPB|VPWR sky130_fd_pr__pfet_01v8_hvt L=0.15 W=0.42
+ AS=0.0441 AD=0.06825 PS=0.63 PD=0.745
M$4831 VPB|VPWR A|Y \$6430 VPB|VPWR sky130_fd_pr__pfet_01v8_hvt L=0.15 W=0.42
+ AS=0.14825 AD=0.06825 PS=1.34 PD=0.745
M$4832 VPB|VPWR \$6395 A2|B|C|X VPB|VPWR sky130_fd_pr__pfet_01v8_hvt L=0.15 W=1
+ AS=0.14825 AD=0.275 PS=1.34 PD=2.55
M$4833 VPB|VPWR B|Y A|A1|B|Y VPB|VPWR sky130_fd_pr__pfet_01v8_hvt L=0.15 W=1
+ AS=0.26 AD=0.135 PS=2.52 PD=1.27
M$4834 A|A1|B|Y A|Y VPB|VPWR VPB|VPWR sky130_fd_pr__pfet_01v8_hvt L=0.15 W=1
+ AS=0.135 AD=0.26 PS=1.27 PD=2.52
M$4838 VPB|VPWR A|A1|X \$6642 VPB|VPWR sky130_fd_pr__pfet_01v8_hvt L=0.15
+ W=0.42 AS=0.1113 AD=0.0609 PS=1.37 PD=0.71
M$4839 \$6642 A2|B|Y VPB|VPWR VPB|VPWR sky130_fd_pr__pfet_01v8_hvt L=0.15
+ W=0.42 AS=0.0609 AD=0.1841 PS=0.71 PD=1.26
M$4840 VPB|VPWR \$6642 B|X VPB|VPWR sky130_fd_pr__pfet_01v8_hvt L=0.15 W=0.64
+ AS=0.1841 AD=0.1696 PS=1.26 PD=1.81
M$4841 VPB|VPWR A|A1|X \$6687 VPB|VPWR sky130_fd_pr__pfet_01v8_hvt L=0.15 W=1
+ AS=0.26 AD=0.105 PS=2.52 PD=1.21
M$4842 \$6687 A2|B|Y A|B|Y VPB|VPWR sky130_fd_pr__pfet_01v8_hvt L=0.15 W=1
+ AS=0.105 AD=0.26 PS=1.21 PD=2.52
M$4843 VPB|VPWR A|A1|X \$6636 VPB|VPWR sky130_fd_pr__pfet_01v8_hvt L=0.15
+ W=0.64 AS=0.1696 AD=0.0768 PS=1.81 PD=0.88
M$4844 \$6636 A2|B|Y C|Y VPB|VPWR sky130_fd_pr__pfet_01v8_hvt L=0.15 W=0.64
+ AS=0.0768 AD=0.0896 PS=0.88 PD=0.92
M$4845 C|Y A_N|B1|C|Y VPB|VPWR VPB|VPWR sky130_fd_pr__pfet_01v8_hvt L=0.15
+ W=0.64 AS=0.0896 AD=0.1824 PS=0.92 PD=1.85
M$4848 VPB|VPWR A_N|B1|C|Y \$6645 VPB|VPWR sky130_fd_pr__pfet_01v8_hvt L=0.15
+ W=0.42 AS=0.14575 AD=0.1092 PS=1.335 PD=1.36
M$4850 A|B1|Y \$6645 VPB|VPWR VPB|VPWR sky130_fd_pr__pfet_01v8_hvt L=0.15 W=1
+ AS=0.135 AD=0.265 PS=1.27 PD=2.53
M$4851 VPB|VPWR A_N|B1|C|Y \$6647 VPB|VPWR sky130_fd_pr__pfet_01v8_hvt L=0.15
+ W=0.42 AS=0.14575 AD=0.1092 PS=1.335 PD=1.36
M$4853 A|B|Y \$6647 VPB|VPWR VPB|VPWR sky130_fd_pr__pfet_01v8_hvt L=0.15 W=1
+ AS=0.135 AD=0.265 PS=1.27 PD=2.53
M$4857 VPB|VPWR B|B_N|C|X \$6649 VPB|VPWR sky130_fd_pr__pfet_01v8_hvt L=0.15
+ W=0.42 AS=0.1573 AD=0.1092 PS=1.39 PD=1.36
M$4858 VPB|VPWR A|B1|Y \$6689 VPB|VPWR sky130_fd_pr__pfet_01v8_hvt L=0.15 W=1
+ AS=0.1573 AD=0.105 PS=1.39 PD=1.21
M$4859 \$6689 \$6649 A|A1|B1|Y VPB|VPWR sky130_fd_pr__pfet_01v8_hvt L=0.15 W=1
+ AS=0.105 AD=0.26 PS=1.21 PD=2.52
M$4860 VPB|VPWR B|B_N|C|X \$6650 VPB|VPWR sky130_fd_pr__pfet_01v8_hvt L=0.15
+ W=1 AS=0.3 AD=0.135 PS=2.6 PD=1.27
M$4861 \$6650 A|B1|Y VPB|VPWR VPB|VPWR sky130_fd_pr__pfet_01v8_hvt L=0.15 W=1
+ AS=0.135 AD=0.365 PS=1.27 PD=1.73
M$4862 VPB|VPWR A|B1|Y \$6690 VPB|VPWR sky130_fd_pr__pfet_01v8_hvt L=0.15 W=1
+ AS=0.365 AD=0.105 PS=1.73 PD=1.21
M$4863 \$6690 B|B_N|C|X A2|B|Y VPB|VPWR sky130_fd_pr__pfet_01v8_hvt L=0.15 W=1
+ AS=0.105 AD=0.165 PS=1.21 PD=1.33
M$4864 A2|B|Y \$6650 VPB|VPWR VPB|VPWR sky130_fd_pr__pfet_01v8_hvt L=0.15 W=1
+ AS=0.165 AD=0.36 PS=1.33 PD=2.72
M$4865 \$6484 A|A1|B|X VPB|VPWR VPB|VPWR sky130_fd_pr__pfet_01v8_hvt L=0.15
+ W=0.42 AS=0.1092 AD=0.0567 PS=1.36 PD=0.69
M$4866 VPB|VPWR A2|B|Y \$6484 VPB|VPWR sky130_fd_pr__pfet_01v8_hvt L=0.15
+ W=0.42 AS=0.0567 AD=0.06615 PS=0.69 PD=0.735
M$4867 VPB|VPWR A2|B|C|X \$6484 VPB|VPWR sky130_fd_pr__pfet_01v8_hvt L=0.15
+ W=0.42 AS=0.142225 AD=0.06615 PS=1.335 PD=0.735
M$4868 VPB|VPWR \$6484 A|B1|X VPB|VPWR sky130_fd_pr__pfet_01v8_hvt L=0.15 W=1
+ AS=0.142225 AD=0.26 PS=1.335 PD=2.52
M$4869 VPB|VPWR A2|B|C|X \$6651 VPB|VPWR sky130_fd_pr__pfet_01v8_hvt L=0.15 W=1
+ AS=0.3 AD=0.135 PS=2.6 PD=1.27
M$4870 \$6651 A|Y VPB|VPWR VPB|VPWR sky130_fd_pr__pfet_01v8_hvt L=0.15 W=1
+ AS=0.135 AD=0.365 PS=1.27 PD=1.73
M$4871 VPB|VPWR A|Y \$6691 VPB|VPWR sky130_fd_pr__pfet_01v8_hvt L=0.15 W=1
+ AS=0.365 AD=0.105 PS=1.73 PD=1.21
M$4872 \$6691 A2|B|C|X A2|B|Y VPB|VPWR sky130_fd_pr__pfet_01v8_hvt L=0.15 W=1
+ AS=0.105 AD=0.165 PS=1.21 PD=1.33
M$4873 A2|B|Y \$6651 VPB|VPWR VPB|VPWR sky130_fd_pr__pfet_01v8_hvt L=0.15 W=1
+ AS=0.165 AD=0.36 PS=1.33 PD=2.72
M$4877 A|Y A|B1|X \$6654 VPB|VPWR sky130_fd_pr__pfet_01v8_hvt L=0.15 W=1
+ AS=0.265 AD=0.14 PS=2.53 PD=1.28
M$4878 \$6654 A|A1|B1|X VPB|VPWR VPB|VPWR sky130_fd_pr__pfet_01v8_hvt L=0.15
+ W=1 AS=0.14 AD=0.1475 PS=1.28 PD=1.295
M$4879 VPB|VPWR A2|B|Y \$6654 VPB|VPWR sky130_fd_pr__pfet_01v8_hvt L=0.15 W=1
+ AS=0.1475 AD=0.265 PS=1.295 PD=2.53
M$4881 A|A1|Y A|A1|B1|X VPB|VPWR VPB|VPWR sky130_fd_pr__pfet_01v8_hvt L=0.15
+ W=1 AS=0.135 AD=0.26 PS=1.27 PD=2.52
M$4882 VPB|VPWR A2|B|SLEEP|X \$6655 VPB|VPWR sky130_fd_pr__pfet_01v8_hvt L=0.15
+ W=1 AS=0.3 AD=0.135 PS=2.6 PD=1.27
M$4883 \$6655 A|Y VPB|VPWR VPB|VPWR sky130_fd_pr__pfet_01v8_hvt L=0.15 W=1
+ AS=0.135 AD=0.365 PS=1.27 PD=1.73
M$4884 VPB|VPWR A|Y \$6693 VPB|VPWR sky130_fd_pr__pfet_01v8_hvt L=0.15 W=1
+ AS=0.365 AD=0.105 PS=1.73 PD=1.21
M$4885 \$6693 A2|B|SLEEP|X B|C|Y VPB|VPWR sky130_fd_pr__pfet_01v8_hvt L=0.15
+ W=1 AS=0.105 AD=0.165 PS=1.21 PD=1.33
M$4886 B|C|Y \$6655 VPB|VPWR VPB|VPWR sky130_fd_pr__pfet_01v8_hvt L=0.15 W=1
+ AS=0.165 AD=0.36 PS=1.33 PD=2.72
M$4890 VPB|VPWR B|Y \$6658 VPB|VPWR sky130_fd_pr__pfet_01v8_hvt L=0.15 W=1
+ AS=0.3 AD=0.135 PS=2.6 PD=1.27
M$4891 \$6658 A|B|Y VPB|VPWR VPB|VPWR sky130_fd_pr__pfet_01v8_hvt L=0.15 W=1
+ AS=0.135 AD=0.365 PS=1.27 PD=1.73
M$4892 VPB|VPWR A|B|Y \$6694 VPB|VPWR sky130_fd_pr__pfet_01v8_hvt L=0.15 W=1
+ AS=0.365 AD=0.105 PS=1.73 PD=1.21
M$4893 \$6694 B|Y B|Y VPB|VPWR sky130_fd_pr__pfet_01v8_hvt L=0.15 W=1 AS=0.105
+ AD=0.165 PS=1.21 PD=1.33
M$4894 B|Y \$6658 VPB|VPWR VPB|VPWR sky130_fd_pr__pfet_01v8_hvt L=0.15 W=1
+ AS=0.165 AD=0.36 PS=1.33 PD=2.72
M$4897 VPB|VPWR A|Y \$6695 VPB|VPWR sky130_fd_pr__pfet_01v8_hvt L=0.15 W=1
+ AS=0.26 AD=0.105 PS=2.52 PD=1.21
M$4898 \$6695 B|Y A1|Y VPB|VPWR sky130_fd_pr__pfet_01v8_hvt L=0.15 W=1 AS=0.105
+ AD=0.26 PS=1.21 PD=2.52
M$4903 VPB|VPWR A|B|C|Y \$6662 VPB|VPWR sky130_fd_pr__pfet_01v8_hvt L=0.15 W=1
+ AS=0.3 AD=0.135 PS=2.6 PD=1.27
M$4904 \$6662 A|X VPB|VPWR VPB|VPWR sky130_fd_pr__pfet_01v8_hvt L=0.15 W=1
+ AS=0.135 AD=0.365 PS=1.27 PD=1.73
M$4905 VPB|VPWR A|X \$6697 VPB|VPWR sky130_fd_pr__pfet_01v8_hvt L=0.15 W=1
+ AS=0.365 AD=0.105 PS=1.73 PD=1.21
M$4906 \$6697 A|B|C|Y A|B|Y VPB|VPWR sky130_fd_pr__pfet_01v8_hvt L=0.15 W=1
+ AS=0.105 AD=0.165 PS=1.21 PD=1.33
M$4907 A|B|Y \$6662 VPB|VPWR VPB|VPWR sky130_fd_pr__pfet_01v8_hvt L=0.15 W=1
+ AS=0.165 AD=0.36 PS=1.33 PD=2.72
M$4918 B|Y A2|B|Y \$6704 VPB|VPWR sky130_fd_pr__pfet_01v8_hvt L=0.15 W=0.64
+ AS=0.0896 AD=0.0768 PS=0.92 PD=0.88
M$4919 \$6704 A|A1|B|C|Y VPB|VPWR VPB|VPWR sky130_fd_pr__pfet_01v8_hvt L=0.15
+ W=0.64 AS=0.0768 AD=0.1696 PS=0.88 PD=1.81
M$4924 A|B|Y A2|B|C|Y VPB|VPWR VPB|VPWR sky130_fd_pr__pfet_01v8_hvt L=0.15 W=1
+ AS=0.135 AD=0.165 PS=1.27 PD=1.33
M$4925 VPB|VPWR A|A1|B1|Y A|B|Y VPB|VPWR sky130_fd_pr__pfet_01v8_hvt L=0.15 W=1
+ AS=0.165 AD=0.26 PS=1.33 PD=2.52
M$4929 A|Y A|B1_N|X VPB|VPWR VPB|VPWR sky130_fd_pr__pfet_01v8_hvt L=0.15 W=1
+ AS=0.135 AD=0.26 PS=1.27 PD=2.52
M$4935 A|B|Y A|A_N|Y VPB|VPWR VPB|VPWR sky130_fd_pr__pfet_01v8_hvt L=0.15 W=1
+ AS=0.135 AD=0.26 PS=1.27 PD=2.52
M$4936 VPB|VPWR A|A1|Y \$6706 VPB|VPWR sky130_fd_pr__pfet_01v8_hvt L=0.15 W=1
+ AS=0.26 AD=0.105 PS=2.52 PD=1.21
M$4937 \$6706 A2|B|C|X A|A_N|Y VPB|VPWR sky130_fd_pr__pfet_01v8_hvt L=0.15 W=1
+ AS=0.105 AD=0.26 PS=1.21 PD=2.52
M$4940 VPB|VPWR A|Y \$6708 VPB|VPWR sky130_fd_pr__pfet_01v8_hvt L=0.15 W=1
+ AS=0.26 AD=0.105 PS=2.52 PD=1.21
M$4941 \$6708 B|C|Y A|C|Y VPB|VPWR sky130_fd_pr__pfet_01v8_hvt L=0.15 W=1
+ AS=0.105 AD=0.26 PS=1.21 PD=2.52
M$4942 A|B|Y B|C|Y \$6634 VPB|VPWR sky130_fd_pr__pfet_01v8_hvt L=0.15 W=1
+ AS=0.26 AD=0.105 PS=2.52 PD=1.21
M$4943 \$6634 A|B|Y VPB|VPWR VPB|VPWR sky130_fd_pr__pfet_01v8_hvt L=0.15 W=1
+ AS=0.105 AD=0.26 PS=1.21 PD=2.52
M$4946 VPB|VPWR D|X \$6676 VPB|VPWR sky130_fd_pr__pfet_01v8_hvt L=0.15 W=0.42
+ AS=0.1092 AD=0.0651 PS=1.36 PD=0.73
M$4947 \$6676 \$6674 \$6677 VPB|VPWR sky130_fd_pr__pfet_01v8_hvt L=0.15 W=0.42
+ AS=0.0651 AD=0.07245 PS=0.73 PD=0.765
M$4948 \$6677 \$6673 \$6678 VPB|VPWR sky130_fd_pr__pfet_01v8_hvt L=0.15 W=0.42
+ AS=0.07245 AD=0.1155 PS=0.765 PD=0.97
M$4949 \$6678 \$6679 VPB|VPWR VPB|VPWR sky130_fd_pr__pfet_01v8_hvt L=0.15
+ W=0.42 AS=0.1155 AD=0.07035 PS=0.97 PD=0.755
M$4950 VPB|VPWR RESET_B|X \$6678 VPB|VPWR sky130_fd_pr__pfet_01v8_hvt L=0.15
+ W=0.42 AS=0.07035 AD=0.1092 PS=0.755 PD=1.36
M$4953 \$6679 \$6673 \$6680 VPB|VPWR sky130_fd_pr__pfet_01v8_hvt L=0.15 W=0.42
+ AS=0.12915 AD=0.0588 PS=1.185 PD=0.7
M$4954 \$6680 \$6674 \$6707 VPB|VPWR sky130_fd_pr__pfet_01v8_hvt L=0.15 W=0.42
+ AS=0.0588 AD=0.0567 PS=0.7 PD=0.69
M$4955 \$6707 \$6681 VPB|VPWR VPB|VPWR sky130_fd_pr__pfet_01v8_hvt L=0.15
+ W=0.42 AS=0.0567 AD=0.0819 PS=0.69 PD=0.81
M$4956 VPB|VPWR RESET_B|X \$6681 VPB|VPWR sky130_fd_pr__pfet_01v8_hvt L=0.15
+ W=0.42 AS=0.0819 AD=0.0567 PS=0.81 PD=0.69
M$4957 \$6681 \$6680 VPB|VPWR VPB|VPWR sky130_fd_pr__pfet_01v8_hvt L=0.15
+ W=0.42 AS=0.0567 AD=0.1134 PS=0.69 PD=1.38
M$4958 VPB|VPWR \$6677 \$6679 VPB|VPWR sky130_fd_pr__pfet_01v8_hvt L=0.15
+ W=0.84 AS=0.2184 AD=0.12915 PS=2.2 PD=1.185
M$4959 VPB|VPWR \$6681 A|Q VPB|VPWR sky130_fd_pr__pfet_01v8_hvt L=0.15 W=1
+ AS=0.3012 AD=0.26 PS=2.66 PD=2.52
M$4962 VPB|VPWR B|Y \$6491 VPB|VPWR sky130_fd_pr__pfet_01v8_hvt L=0.15 W=1
+ AS=0.3 AD=0.135 PS=2.6 PD=1.27
M$4963 \$6491 A|B|X VPB|VPWR VPB|VPWR sky130_fd_pr__pfet_01v8_hvt L=0.15 W=1
+ AS=0.135 AD=0.365 PS=1.27 PD=1.73
M$4964 VPB|VPWR A|B|X \$6633 VPB|VPWR sky130_fd_pr__pfet_01v8_hvt L=0.15 W=1
+ AS=0.365 AD=0.105 PS=1.73 PD=1.21
M$4965 \$6633 B|Y D|Y VPB|VPWR sky130_fd_pr__pfet_01v8_hvt L=0.15 W=1 AS=0.105
+ AD=0.165 PS=1.21 PD=1.33
M$4966 D|Y \$6491 VPB|VPWR VPB|VPWR sky130_fd_pr__pfet_01v8_hvt L=0.15 W=1
+ AS=0.165 AD=0.36 PS=1.33 PD=2.72
M$4981 \$6770 A|FINE_MUX[14] VPB|VPWR VPB|VPWR sky130_fd_pr__pfet_01v8_hvt
+ L=0.15 W=1 AS=0.27 AD=0.1701 PS=2.54 PD=1.36
M$4982 VPB|VPWR \$6770 \$6771 VPB|VPWR sky130_fd_pr__pfet_01v8_hvt L=0.5 W=0.82
+ AS=0.1701 AD=0.2173 PS=1.36 PD=2.17
M$4983 VPB|VPWR \$6771 \$6772 VPB|VPWR sky130_fd_pr__pfet_01v8_hvt L=0.5 W=0.82
+ AS=0.15575 AD=0.2173 PS=1.325 PD=2.17
M$4984 VPB|VPWR \$6772 A|B1|X VPB|VPWR sky130_fd_pr__pfet_01v8_hvt L=0.15 W=1
+ AS=0.15575 AD=0.355 PS=1.325 PD=2.71
M$4989 VPB|VPWR A1|B|SLEEP|X \$7022 VPB|VPWR sky130_fd_pr__pfet_01v8_hvt L=0.15
+ W=1 AS=0.26 AD=0.135 PS=2.52 PD=1.27
M$4990 \$7022 A2|B|Y \$7021 VPB|VPWR sky130_fd_pr__pfet_01v8_hvt L=0.15 W=1
+ AS=0.135 AD=0.135 PS=1.27 PD=1.27
M$4991 \$7021 A3|A4|X A2|B|Y VPB|VPWR sky130_fd_pr__pfet_01v8_hvt L=0.15 W=1
+ AS=0.135 AD=0.3925 PS=1.27 PD=1.785
M$4994 \$6775 \$6777 \$6778 VPB|VPWR sky130_fd_pr__pfet_01v8_hvt L=0.15 W=0.64
+ AS=0.246 AD=0.2431 PS=1.525 PD=1.445
M$4995 \$6775 A2|B|Y \$6779 VPB|VPWR sky130_fd_pr__pfet_01v8_hvt L=0.15 W=0.64
+ AS=0.246 AD=0.1458 PS=1.525 PD=1.205
M$4996 \$6778 A2|B|Y \$6776 VPB|VPWR sky130_fd_pr__pfet_01v8_hvt L=0.15 W=0.84
+ AS=0.2431 AD=0.3528 PS=1.445 PD=2.52
M$4997 \$6775 \$6776 VPB|VPWR VPB|VPWR sky130_fd_pr__pfet_01v8_hvt L=0.15 W=1
+ AS=0.285 AD=0.135 PS=2.57 PD=1.27
M$4998 VPB|VPWR A|A1|X \$6776 VPB|VPWR sky130_fd_pr__pfet_01v8_hvt L=0.15 W=1
+ AS=0.135 AD=0.1715 PS=1.27 PD=1.355
M$4999 \$6776 \$6777 \$6779 VPB|VPWR sky130_fd_pr__pfet_01v8_hvt L=0.15 W=0.84
+ AS=0.1715 AD=0.1458 PS=1.355 PD=1.205
M$5000 \$6777 A2|B|Y VPB|VPWR VPB|VPWR sky130_fd_pr__pfet_01v8_hvt L=0.15 W=1
+ AS=0.26 AD=0.25655 PS=2.52 PD=2.52
M$5001 \$6778 \$6782 \$6781 VPB|VPWR sky130_fd_pr__pfet_01v8_hvt L=0.15 W=0.84
+ AS=0.32235 AD=0.15295 PS=2.45 PD=1.315
M$5002 \$6781 C|Y \$6779 VPB|VPWR sky130_fd_pr__pfet_01v8_hvt L=0.15 W=0.84
+ AS=0.15295 AD=0.273 PS=1.315 PD=2.33
M$5003 \$6782 C|Y VPB|VPWR VPB|VPWR sky130_fd_pr__pfet_01v8_hvt L=0.15 W=0.64
+ AS=0.1792 AD=0.169 PS=1.84 PD=1.365
M$5004 VPB|VPWR \$6781 A|X VPB|VPWR sky130_fd_pr__pfet_01v8_hvt L=0.15 W=1
+ AS=0.169 AD=0.28 PS=1.365 PD=2.56
M$5006 VPB|VPWR A_N|B1|C|Y \$6786 VPB|VPWR sky130_fd_pr__pfet_01v8_hvt L=0.15
+ W=0.64 AS=0.169 AD=0.1792 PS=1.365 PD=1.84
M$5007 A2|X \$6785 VPB|VPWR VPB|VPWR sky130_fd_pr__pfet_01v8_hvt L=0.15 W=1
+ AS=0.28 AD=0.169 PS=2.56 PD=1.365
M$5008 \$6785 \$6786 \$6787 VPB|VPWR sky130_fd_pr__pfet_01v8_hvt L=0.15 W=0.84
+ AS=0.15295 AD=0.32235 PS=1.315 PD=2.45
M$5009 \$6785 A_N|B1|C|Y \$6788 VPB|VPWR sky130_fd_pr__pfet_01v8_hvt L=0.15
+ W=0.84 AS=0.15295 AD=0.273 PS=1.315 PD=2.33
M$5010 VPB|VPWR A|B|X \$6789 VPB|VPWR sky130_fd_pr__pfet_01v8_hvt L=0.15 W=1
+ AS=0.25655 AD=0.26 PS=2.52 PD=2.52
M$5011 \$6787 \$6789 \$6791 VPB|VPWR sky130_fd_pr__pfet_01v8_hvt L=0.15 W=0.64
+ AS=0.2431 AD=0.246 PS=1.445 PD=1.525
M$5012 \$6791 A|B|X \$6788 VPB|VPWR sky130_fd_pr__pfet_01v8_hvt L=0.15 W=0.64
+ AS=0.246 AD=0.1458 PS=1.525 PD=1.205
M$5013 \$6790 A|B|X \$6787 VPB|VPWR sky130_fd_pr__pfet_01v8_hvt L=0.15 W=0.84
+ AS=0.3528 AD=0.2431 PS=2.52 PD=1.445
M$5014 \$6790 \$6789 \$6788 VPB|VPWR sky130_fd_pr__pfet_01v8_hvt L=0.15 W=0.84
+ AS=0.1715 AD=0.1458 PS=1.355 PD=1.205
M$5015 \$6790 A|B|Y VPB|VPWR VPB|VPWR sky130_fd_pr__pfet_01v8_hvt L=0.15 W=1
+ AS=0.1715 AD=0.135 PS=1.355 PD=1.27
M$5016 VPB|VPWR \$6790 \$6791 VPB|VPWR sky130_fd_pr__pfet_01v8_hvt L=0.15 W=1
+ AS=0.135 AD=0.285 PS=1.27 PD=2.57
M$5017 \$6648 A|B|X VPB|VPWR VPB|VPWR sky130_fd_pr__pfet_01v8_hvt L=0.15 W=0.42
+ AS=0.1092 AD=0.0567 PS=1.36 PD=0.69
M$5018 VPB|VPWR A|B|Y \$6648 VPB|VPWR sky130_fd_pr__pfet_01v8_hvt L=0.15 W=0.42
+ AS=0.0567 AD=0.06615 PS=0.69 PD=0.735
M$5019 VPB|VPWR C|Y \$6648 VPB|VPWR sky130_fd_pr__pfet_01v8_hvt L=0.15 W=0.42
+ AS=0.142225 AD=0.06615 PS=1.335 PD=0.735
M$5020 VPB|VPWR \$6648 A|A1|B|X VPB|VPWR sky130_fd_pr__pfet_01v8_hvt L=0.15 W=1
+ AS=0.142225 AD=0.26 PS=1.335 PD=2.52
M$5022 A|Y A|A1|B1|Y \$7002 VPB|VPWR sky130_fd_pr__pfet_01v8_hvt L=0.15 W=1
+ AS=0.265 AD=0.14 PS=2.53 PD=1.28
M$5023 \$7002 A|A1|B|X VPB|VPWR VPB|VPWR sky130_fd_pr__pfet_01v8_hvt L=0.15 W=1
+ AS=0.14 AD=0.1475 PS=1.28 PD=1.295
M$5024 VPB|VPWR A2|B|Y \$7002 VPB|VPWR sky130_fd_pr__pfet_01v8_hvt L=0.15 W=1
+ AS=0.1475 AD=0.265 PS=1.295 PD=2.53
M$5027 \$6792 A2|B|Y \$7032 VPB|VPWR sky130_fd_pr__pfet_01v8_hvt L=0.15 W=1
+ AS=0.26 AD=0.135 PS=2.52 PD=1.27
M$5028 \$7032 A|A1|B1|X VPB|VPWR VPB|VPWR sky130_fd_pr__pfet_01v8_hvt L=0.15
+ W=1 AS=0.135 AD=0.135 PS=1.27 PD=1.27
M$5029 VPB|VPWR A|A1|B1|X \$7003 VPB|VPWR sky130_fd_pr__pfet_01v8_hvt L=0.15
+ W=1 AS=0.135 AD=0.135 PS=1.27 PD=1.27
M$5030 \$7003 A2|B|Y VPB|VPWR VPB|VPWR sky130_fd_pr__pfet_01v8_hvt L=0.15 W=1
+ AS=0.135 AD=0.26 PS=1.27 PD=2.52
M$5031 \$7003 \$6792 B|X VPB|VPWR sky130_fd_pr__pfet_01v8_hvt L=0.15 W=1
+ AS=0.26 AD=0.3 PS=2.52 PD=2.6
M$5033 \$6793 A|A_N|Y VPB|VPWR VPB|VPWR sky130_fd_pr__pfet_01v8_hvt L=0.15
+ W=0.42 AS=0.1092 AD=0.14575 PS=1.36 PD=1.335
M$5035 A|Y \$6793 VPB|VPWR VPB|VPWR sky130_fd_pr__pfet_01v8_hvt L=0.15 W=1
+ AS=0.135 AD=0.265 PS=1.27 PD=2.53
M$5037 \$6796 B|Y \$7031 VPB|VPWR sky130_fd_pr__pfet_01v8_hvt L=0.15 W=1
+ AS=0.26 AD=0.135 PS=2.52 PD=1.27
M$5038 \$7031 A|Y VPB|VPWR VPB|VPWR sky130_fd_pr__pfet_01v8_hvt L=0.15 W=1
+ AS=0.135 AD=0.135 PS=1.27 PD=1.27
M$5039 VPB|VPWR A|Y \$7004 VPB|VPWR sky130_fd_pr__pfet_01v8_hvt L=0.15 W=1
+ AS=0.135 AD=0.135 PS=1.27 PD=1.27
M$5040 \$7004 B|Y VPB|VPWR VPB|VPWR sky130_fd_pr__pfet_01v8_hvt L=0.15 W=1
+ AS=0.135 AD=0.26 PS=1.27 PD=2.52
M$5041 \$7004 \$6796 A|X VPB|VPWR sky130_fd_pr__pfet_01v8_hvt L=0.15 W=1
+ AS=0.26 AD=0.3 PS=2.52 PD=2.6
M$5042 \$6798 \$6800 \$6801 VPB|VPWR sky130_fd_pr__pfet_01v8_hvt L=0.15 W=0.64
+ AS=0.246 AD=0.2431 PS=1.525 PD=1.445
M$5043 \$6798 B|Y \$6802 VPB|VPWR sky130_fd_pr__pfet_01v8_hvt L=0.15 W=0.64
+ AS=0.246 AD=0.1458 PS=1.525 PD=1.205
M$5044 \$6801 B|Y \$6799 VPB|VPWR sky130_fd_pr__pfet_01v8_hvt L=0.15 W=0.84
+ AS=0.2431 AD=0.3528 PS=1.445 PD=2.52
M$5045 \$6798 \$6799 VPB|VPWR VPB|VPWR sky130_fd_pr__pfet_01v8_hvt L=0.15 W=1
+ AS=0.285 AD=0.135 PS=2.57 PD=1.27
M$5046 VPB|VPWR A|X \$6799 VPB|VPWR sky130_fd_pr__pfet_01v8_hvt L=0.15 W=1
+ AS=0.135 AD=0.1715 PS=1.27 PD=1.355
M$5047 \$6799 \$6800 \$6802 VPB|VPWR sky130_fd_pr__pfet_01v8_hvt L=0.15 W=0.84
+ AS=0.1715 AD=0.1458 PS=1.355 PD=1.205
M$5048 \$6800 B|Y VPB|VPWR VPB|VPWR sky130_fd_pr__pfet_01v8_hvt L=0.15 W=1
+ AS=0.26 AD=0.25655 PS=2.52 PD=2.52
M$5049 \$6801 \$6804 \$6803 VPB|VPWR sky130_fd_pr__pfet_01v8_hvt L=0.15 W=0.84
+ AS=0.32235 AD=0.15295 PS=2.45 PD=1.315
M$5050 \$6803 B|C|X \$6802 VPB|VPWR sky130_fd_pr__pfet_01v8_hvt L=0.15 W=0.84
+ AS=0.15295 AD=0.273 PS=1.315 PD=2.33
M$5051 \$6804 B|C|X VPB|VPWR VPB|VPWR sky130_fd_pr__pfet_01v8_hvt L=0.15 W=0.64
+ AS=0.1792 AD=0.169 PS=1.84 PD=1.365
M$5052 VPB|VPWR \$6803 A|B|C|X VPB|VPWR sky130_fd_pr__pfet_01v8_hvt L=0.15 W=1
+ AS=0.169 AD=0.28 PS=1.365 PD=2.56
M$5054 \$6664 B|C|X \$6699 VPB|VPWR sky130_fd_pr__pfet_01v8_hvt L=0.15 W=0.42
+ AS=0.1092 AD=0.0441 PS=1.36 PD=0.63
M$5055 \$6699 A|Y VPB|VPWR VPB|VPWR sky130_fd_pr__pfet_01v8_hvt L=0.15 W=0.42
+ AS=0.0441 AD=0.0567 PS=0.63 PD=0.69
M$5056 VPB|VPWR A|Y \$6701 VPB|VPWR sky130_fd_pr__pfet_01v8_hvt L=0.15 W=0.42
+ AS=0.0567 AD=0.0441 PS=0.69 PD=0.63
M$5057 \$6701 A|B|Y \$6664 VPB|VPWR sky130_fd_pr__pfet_01v8_hvt L=0.15 W=0.42
+ AS=0.0441 AD=0.0567 PS=0.63 PD=0.69
M$5058 \$6664 A|B|Y \$6700 VPB|VPWR sky130_fd_pr__pfet_01v8_hvt L=0.15 W=0.42
+ AS=0.0567 AD=0.0441 PS=0.69 PD=0.63
M$5059 VPB|VPWR B|C|X \$6700 VPB|VPWR sky130_fd_pr__pfet_01v8_hvt L=0.15 W=0.42
+ AS=0.2492 AD=0.0441 PS=1.565 PD=0.63
M$5060 VPB|VPWR \$6664 A|B|X VPB|VPWR sky130_fd_pr__pfet_01v8_hvt L=0.15 W=1
+ AS=0.2492 AD=0.365 PS=1.565 PD=2.73
M$5061 A|Y A|B|C|X \$7030 VPB|VPWR sky130_fd_pr__pfet_01v8_hvt L=0.15 W=1
+ AS=0.26 AD=0.105 PS=2.52 PD=1.21
M$5062 \$7030 A|B1|Y VPB|VPWR VPB|VPWR sky130_fd_pr__pfet_01v8_hvt L=0.15 W=1
+ AS=0.105 AD=0.26 PS=1.21 PD=2.52
M$5063 VPB|VPWR B|C|Y \$6806 VPB|VPWR sky130_fd_pr__pfet_01v8_hvt L=0.15 W=1
+ AS=0.3 AD=0.135 PS=2.6 PD=1.27
M$5064 \$6806 A|Y VPB|VPWR VPB|VPWR sky130_fd_pr__pfet_01v8_hvt L=0.15 W=1
+ AS=0.135 AD=0.365 PS=1.27 PD=1.73
M$5065 VPB|VPWR A|Y \$7029 VPB|VPWR sky130_fd_pr__pfet_01v8_hvt L=0.15 W=1
+ AS=0.365 AD=0.105 PS=1.73 PD=1.21
M$5066 \$7029 B|C|Y A2|B|Y VPB|VPWR sky130_fd_pr__pfet_01v8_hvt L=0.15 W=1
+ AS=0.105 AD=0.165 PS=1.21 PD=1.33
M$5067 A2|B|Y \$6806 VPB|VPWR VPB|VPWR sky130_fd_pr__pfet_01v8_hvt L=0.15 W=1
+ AS=0.165 AD=0.36 PS=1.33 PD=2.72
M$5068 VPB|VPWR A|A1|B|C|Y \$7026 VPB|VPWR sky130_fd_pr__pfet_01v8_hvt L=0.15
+ W=1 AS=0.26 AD=0.135 PS=2.52 PD=1.27
M$5069 \$7026 A2|B|Y \$7027 VPB|VPWR sky130_fd_pr__pfet_01v8_hvt L=0.15 W=1
+ AS=0.135 AD=0.135 PS=1.27 PD=1.27
M$5070 \$7027 A|B|C|X A|Y VPB|VPWR sky130_fd_pr__pfet_01v8_hvt L=0.15 W=1
+ AS=0.135 AD=0.26 PS=1.27 PD=2.52
M$5071 VPB|VPWR B|Y \$6809 VPB|VPWR sky130_fd_pr__pfet_01v8_hvt L=0.15 W=1
+ AS=0.3 AD=0.135 PS=2.6 PD=1.27
M$5072 \$6809 A|B|C|X VPB|VPWR VPB|VPWR sky130_fd_pr__pfet_01v8_hvt L=0.15 W=1
+ AS=0.135 AD=0.365 PS=1.27 PD=1.73
M$5073 VPB|VPWR A|B|C|X \$7025 VPB|VPWR sky130_fd_pr__pfet_01v8_hvt L=0.15 W=1
+ AS=0.365 AD=0.105 PS=1.73 PD=1.21
M$5074 \$7025 B|Y B|C|Y VPB|VPWR sky130_fd_pr__pfet_01v8_hvt L=0.15 W=1
+ AS=0.105 AD=0.165 PS=1.21 PD=1.33
M$5075 B|C|Y \$6809 VPB|VPWR VPB|VPWR sky130_fd_pr__pfet_01v8_hvt L=0.15 W=1
+ AS=0.165 AD=0.36 PS=1.33 PD=2.72
M$5077 VPB|VPWR B|C|Y \$6813 VPB|VPWR sky130_fd_pr__pfet_01v8_hvt L=0.15 W=1
+ AS=0.3 AD=0.135 PS=2.6 PD=1.27
M$5078 \$6813 A|Y VPB|VPWR VPB|VPWR sky130_fd_pr__pfet_01v8_hvt L=0.15 W=1
+ AS=0.135 AD=0.365 PS=1.27 PD=1.73
M$5079 VPB|VPWR A|Y \$7024 VPB|VPWR sky130_fd_pr__pfet_01v8_hvt L=0.15 W=1
+ AS=0.365 AD=0.105 PS=1.73 PD=1.21
M$5080 \$7024 B|C|Y B|Y VPB|VPWR sky130_fd_pr__pfet_01v8_hvt L=0.15 W=1
+ AS=0.105 AD=0.165 PS=1.21 PD=1.33
M$5081 B|Y \$6813 VPB|VPWR VPB|VPWR sky130_fd_pr__pfet_01v8_hvt L=0.15 W=1
+ AS=0.165 AD=0.36 PS=1.33 PD=2.72
M$5083 VPB|VPWR A|B1_N|X \$6815 VPB|VPWR sky130_fd_pr__pfet_01v8_hvt L=0.15
+ W=0.42 AS=0.17825 AD=0.1092 PS=1.4 PD=1.36
M$5084 VPB|VPWR \$6815 A|Y VPB|VPWR sky130_fd_pr__pfet_01v8_hvt L=0.15 W=1
+ AS=0.17825 AD=0.1525 PS=1.4 PD=1.305
M$5085 A|Y A2|B|C|X \$7023 VPB|VPWR sky130_fd_pr__pfet_01v8_hvt L=0.15 W=1
+ AS=0.1525 AD=0.1275 PS=1.305 PD=1.255
M$5086 \$7023 A|A1|Y VPB|VPWR VPB|VPWR sky130_fd_pr__pfet_01v8_hvt L=0.15 W=1
+ AS=0.1275 AD=0.28 PS=1.255 PD=2.56
M$5087 VPB|VPWR B|Y \$6819 VPB|VPWR sky130_fd_pr__pfet_01v8_hvt L=0.15 W=1
+ AS=0.3 AD=0.135 PS=2.6 PD=1.27
M$5088 \$6819 A|Y VPB|VPWR VPB|VPWR sky130_fd_pr__pfet_01v8_hvt L=0.15 W=1
+ AS=0.135 AD=0.365 PS=1.27 PD=1.73
M$5089 VPB|VPWR A|Y \$7020 VPB|VPWR sky130_fd_pr__pfet_01v8_hvt L=0.15 W=1
+ AS=0.365 AD=0.105 PS=1.73 PD=1.21
M$5090 \$7020 B|Y B|C|Y VPB|VPWR sky130_fd_pr__pfet_01v8_hvt L=0.15 W=1
+ AS=0.105 AD=0.165 PS=1.21 PD=1.33
M$5091 B|C|Y \$6819 VPB|VPWR VPB|VPWR sky130_fd_pr__pfet_01v8_hvt L=0.15 W=1
+ AS=0.165 AD=0.36 PS=1.33 PD=2.72
M$5092 \$6821 A|A_N|Y VPB|VPWR VPB|VPWR sky130_fd_pr__pfet_01v8_hvt L=0.15
+ W=0.42 AS=0.1092 AD=0.14575 PS=1.36 PD=1.335
M$5095 VPB|VPWR \$6821 A|Y VPB|VPWR sky130_fd_pr__pfet_01v8_hvt L=0.15 W=1
+ AS=0.1925 AD=0.28 PS=1.385 PD=2.56
M$5097 B|Y A2|B|C|X VPB|VPWR VPB|VPWR sky130_fd_pr__pfet_01v8_hvt L=0.15 W=1
+ AS=0.135 AD=0.26 PS=1.27 PD=2.52
M$5099 \$6669 A|Y VPB|VPWR VPB|VPWR sky130_fd_pr__pfet_01v8_hvt L=0.15 W=0.42
+ AS=0.1092 AD=0.0567 PS=1.36 PD=0.69
M$5100 VPB|VPWR A|B|Y \$6669 VPB|VPWR sky130_fd_pr__pfet_01v8_hvt L=0.15 W=0.42
+ AS=0.0567 AD=0.06615 PS=0.69 PD=0.735
M$5101 VPB|VPWR B|C|Y \$6669 VPB|VPWR sky130_fd_pr__pfet_01v8_hvt L=0.15 W=0.42
+ AS=0.142225 AD=0.06615 PS=1.335 PD=0.735
M$5102 VPB|VPWR \$6669 A|X VPB|VPWR sky130_fd_pr__pfet_01v8_hvt L=0.15 W=1
+ AS=0.142225 AD=0.26 PS=1.335 PD=2.52
M$5103 \$6671 A|C|Y \$6710 VPB|VPWR sky130_fd_pr__pfet_01v8_hvt L=0.15 W=0.42
+ AS=0.1092 AD=0.0441 PS=1.36 PD=0.63
M$5104 \$6710 A|B|Y \$6709 VPB|VPWR sky130_fd_pr__pfet_01v8_hvt L=0.15 W=0.42
+ AS=0.0441 AD=0.0693 PS=0.63 PD=0.75
M$5105 VPB|VPWR A|X \$6709 VPB|VPWR sky130_fd_pr__pfet_01v8_hvt L=0.15 W=0.42
+ AS=0.14825 AD=0.0693 PS=1.34 PD=0.75
M$5106 VPB|VPWR \$6671 B|C|X VPB|VPWR sky130_fd_pr__pfet_01v8_hvt L=0.15 W=1
+ AS=0.14825 AD=0.28 PS=1.34 PD=2.56
M$5108 \$6673 CLK|TICK VPB|VPWR VPB|VPWR sky130_fd_pr__pfet_01v8_hvt L=0.15
+ W=0.64 AS=0.1664 AD=0.0864 PS=1.8 PD=0.91
M$5109 VPB|VPWR \$6673 \$6674 VPB|VPWR sky130_fd_pr__pfet_01v8_hvt L=0.15
+ W=0.64 AS=0.0864 AD=0.1664 PS=0.91 PD=1.8
M$5111 VPB|VPWR C|Y \$6824 VPB|VPWR sky130_fd_pr__pfet_01v8_hvt L=0.15 W=0.64
+ AS=0.2115 AD=0.1792 PS=1.45 PD=1.84
M$5112 D|X \$6822 VPB|VPWR VPB|VPWR sky130_fd_pr__pfet_01v8_hvt L=0.15 W=1
+ AS=0.28 AD=0.2115 PS=2.56 PD=1.45
M$5113 VPB|VPWR B|X \$6827 VPB|VPWR sky130_fd_pr__pfet_01v8_hvt L=0.15 W=1
+ AS=0.26 AD=0.2526 PS=2.52 PD=2.52
M$5114 \$6826 \$6827 \$6829 VPB|VPWR sky130_fd_pr__pfet_01v8_hvt L=0.15 W=0.64
+ AS=0.2452 AD=0.246 PS=1.45 PD=1.525
M$5115 \$6829 B|X \$6825 VPB|VPWR sky130_fd_pr__pfet_01v8_hvt L=0.15 W=0.64
+ AS=0.246 AD=0.1458 PS=1.525 PD=1.205
M$5116 \$6828 B|X \$6826 VPB|VPWR sky130_fd_pr__pfet_01v8_hvt L=0.15 W=0.84
+ AS=0.3536 AD=0.2452 PS=2.53 PD=1.45
M$5117 \$6828 \$6827 \$6825 VPB|VPWR sky130_fd_pr__pfet_01v8_hvt L=0.15 W=0.84
+ AS=0.1715 AD=0.1458 PS=1.355 PD=1.205
M$5118 \$6828 A|Q VPB|VPWR VPB|VPWR sky130_fd_pr__pfet_01v8_hvt L=0.15 W=1
+ AS=0.1715 AD=0.135 PS=1.355 PD=1.27
M$5119 VPB|VPWR \$6828 \$6829 VPB|VPWR sky130_fd_pr__pfet_01v8_hvt L=0.15 W=1
+ AS=0.135 AD=0.285 PS=1.27 PD=2.57
M$5120 \$6683 B|C|X \$6703 VPB|VPWR sky130_fd_pr__pfet_01v8_hvt L=0.15 W=0.42
+ AS=0.1092 AD=0.0441 PS=1.36 PD=0.63
M$5121 \$6703 A|Q VPB|VPWR VPB|VPWR sky130_fd_pr__pfet_01v8_hvt L=0.15 W=0.42
+ AS=0.0441 AD=0.0567 PS=0.63 PD=0.69
M$5122 VPB|VPWR A|Q \$6698 VPB|VPWR sky130_fd_pr__pfet_01v8_hvt L=0.15 W=0.42
+ AS=0.0567 AD=0.0441 PS=0.69 PD=0.63
M$5123 \$6698 A|B|X \$6683 VPB|VPWR sky130_fd_pr__pfet_01v8_hvt L=0.15 W=0.42
+ AS=0.0441 AD=0.0567 PS=0.63 PD=0.69
M$5124 \$6683 A|B|X \$6702 VPB|VPWR sky130_fd_pr__pfet_01v8_hvt L=0.15 W=0.42
+ AS=0.0567 AD=0.0441 PS=0.69 PD=0.63
M$5125 VPB|VPWR B|C|X \$6702 VPB|VPWR sky130_fd_pr__pfet_01v8_hvt L=0.15 W=0.42
+ AS=0.2492 AD=0.0441 PS=1.565 PD=0.63
M$5126 VPB|VPWR \$6683 B|C|X VPB|VPWR sky130_fd_pr__pfet_01v8_hvt L=0.15 W=1
+ AS=0.2492 AD=0.365 PS=1.565 PD=2.73
M$5127 A|Q \$6830 VPB|VPWR VPB|VPWR sky130_fd_pr__pfet_01v8_hvt L=0.15 W=1
+ AS=0.26 AD=0.3012 PS=2.52 PD=2.66
M$5136 VPB|VPWR A|A2|B|B_N|X B1|SLEEP|Y VPB|VPWR sky130_fd_pr__pfet_01v8_hvt
+ L=0.15 W=1 AS=0.26 AD=0.135 PS=2.52 PD=1.27
M$5137 B1|SLEEP|Y A|A1|X VPB|VPWR VPB|VPWR sky130_fd_pr__pfet_01v8_hvt L=0.15
+ W=1 AS=0.135 AD=0.26 PS=1.27 PD=2.52
M$5138 A|A1|X \$7035 \$7072 VPB|VPWR sky130_fd_pr__pfet_01v8_hvt L=0.15 W=1
+ AS=0.26 AD=0.105 PS=2.52 PD=1.21
M$5139 \$7072 A1|B|SLEEP|X VPB|VPWR VPB|VPWR sky130_fd_pr__pfet_01v8_hvt L=0.15
+ W=1 AS=0.105 AD=0.1573 PS=1.21 PD=1.39
M$5140 VPB|VPWR A|B1|X \$7035 VPB|VPWR sky130_fd_pr__pfet_01v8_hvt L=0.15
+ W=0.42 AS=0.1573 AD=0.1092 PS=1.39 PD=1.36
M$5142 VPB|VPWR A1|B|SLEEP|X \$7036 VPB|VPWR sky130_fd_pr__pfet_01v8_hvt L=0.15
+ W=1 AS=0.3 AD=0.135 PS=2.6 PD=1.27
M$5143 \$7036 A|B1|X VPB|VPWR VPB|VPWR sky130_fd_pr__pfet_01v8_hvt L=0.15 W=1
+ AS=0.135 AD=0.365 PS=1.27 PD=1.73
M$5144 VPB|VPWR A|B1|X \$7073 VPB|VPWR sky130_fd_pr__pfet_01v8_hvt L=0.15 W=1
+ AS=0.365 AD=0.105 PS=1.73 PD=1.21
M$5145 \$7073 A1|B|SLEEP|X A|B|Y VPB|VPWR sky130_fd_pr__pfet_01v8_hvt L=0.15
+ W=1 AS=0.105 AD=0.165 PS=1.21 PD=1.33
M$5146 A|B|Y \$7036 VPB|VPWR VPB|VPWR sky130_fd_pr__pfet_01v8_hvt L=0.15 W=1
+ AS=0.165 AD=0.36 PS=1.33 PD=2.72
M$5148 VPB|VPWR A2|B|C|X \$7038 VPB|VPWR sky130_fd_pr__pfet_01v8_hvt L=0.15
+ W=0.42 AS=0.1841 AD=0.0609 PS=1.26 PD=0.71
M$5149 \$7038 A|A1|B|Y VPB|VPWR VPB|VPWR sky130_fd_pr__pfet_01v8_hvt L=0.15
+ W=0.42 AS=0.0609 AD=0.1113 PS=0.71 PD=1.37
M$5150 A3|A4|X \$7038 VPB|VPWR VPB|VPWR sky130_fd_pr__pfet_01v8_hvt L=0.15
+ W=0.64 AS=0.1696 AD=0.1841 PS=1.81 PD=1.26
M$5152 A1|B|Y C|Y \$7074 VPB|VPWR sky130_fd_pr__pfet_01v8_hvt L=0.15 W=1
+ AS=0.26 AD=0.135 PS=2.52 PD=1.27
M$5153 \$7074 B|X \$7075 VPB|VPWR sky130_fd_pr__pfet_01v8_hvt L=0.15 W=1
+ AS=0.135 AD=0.135 PS=1.27 PD=1.27
M$5154 \$7075 A|B|Y VPB|VPWR VPB|VPWR sky130_fd_pr__pfet_01v8_hvt L=0.15 W=1
+ AS=0.135 AD=0.26 PS=1.27 PD=2.52
M$5156 VPB|VPWR A1|B|Y \$7076 VPB|VPWR sky130_fd_pr__pfet_01v8_hvt L=0.15 W=1
+ AS=0.26 AD=0.1525 PS=2.52 PD=1.305
M$5157 \$7076 A2|X \$7040 VPB|VPWR sky130_fd_pr__pfet_01v8_hvt L=0.15 W=1
+ AS=0.1525 AD=0.195 PS=1.305 PD=1.39
M$5158 \$7040 A|B1|Y VPB|VPWR VPB|VPWR sky130_fd_pr__pfet_01v8_hvt L=0.15 W=1
+ AS=0.195 AD=0.3275 PS=1.39 PD=1.655
M$5159 VPB|VPWR \$7040 A|B|X VPB|VPWR sky130_fd_pr__pfet_01v8_hvt L=0.15 W=1
+ AS=0.3275 AD=0.28 PS=1.655 PD=2.56
M$5161 \$7043 \$7089 \$7044 VPB|VPWR sky130_fd_pr__pfet_01v8_hvt L=0.15 W=0.84
+ AS=0.1715 AD=0.1458 PS=1.355 PD=1.205
M$5162 \$7044 A|A1|B|X \$7042 VPB|VPWR sky130_fd_pr__pfet_01v8_hvt L=0.15
+ W=0.64 AS=0.1458 AD=0.246 PS=1.205 PD=1.525
M$5163 \$7042 \$7043 VPB|VPWR VPB|VPWR sky130_fd_pr__pfet_01v8_hvt L=0.15 W=1
+ AS=0.285 AD=0.135 PS=2.57 PD=1.27
M$5164 VPB|VPWR A|B1|Y \$7043 VPB|VPWR sky130_fd_pr__pfet_01v8_hvt L=0.15 W=1
+ AS=0.135 AD=0.1715 PS=1.27 PD=1.355
M$5165 \$7045 \$7089 \$7042 VPB|VPWR sky130_fd_pr__pfet_01v8_hvt L=0.15 W=0.64
+ AS=0.2431 AD=0.246 PS=1.445 PD=1.525
M$5166 \$7045 A|A1|B|X \$7043 VPB|VPWR sky130_fd_pr__pfet_01v8_hvt L=0.15
+ W=0.84 AS=0.2431 AD=0.3528 PS=1.445 PD=2.52
M$5167 \$7089 A|A1|B|X VPB|VPWR VPB|VPWR sky130_fd_pr__pfet_01v8_hvt L=0.15 W=1
+ AS=0.26 AD=0.25655 PS=2.52 PD=2.52
M$5168 VPB|VPWR B|B_N|C|X \$7047 VPB|VPWR sky130_fd_pr__pfet_01v8_hvt L=0.15
+ W=0.64 AS=0.169 AD=0.1792 PS=1.365 PD=1.84
M$5169 VPB|VPWR \$7046 B|C|X VPB|VPWR sky130_fd_pr__pfet_01v8_hvt L=0.15 W=1
+ AS=0.169 AD=0.28 PS=1.365 PD=2.56
M$5172 VPB|VPWR A|B|X A1|Y VPB|VPWR sky130_fd_pr__pfet_01v8_hvt L=0.15 W=1
+ AS=0.26 AD=0.135 PS=2.52 PD=1.27
M$5176 VPB|VPWR B|X \$7050 VPB|VPWR sky130_fd_pr__pfet_01v8_hvt L=0.15 W=1
+ AS=0.3 AD=0.135 PS=2.6 PD=1.27
M$5177 \$7050 A|A_N|Y VPB|VPWR VPB|VPWR sky130_fd_pr__pfet_01v8_hvt L=0.15 W=1
+ AS=0.135 AD=0.365 PS=1.27 PD=1.73
M$5178 VPB|VPWR A|A_N|Y \$7079 VPB|VPWR sky130_fd_pr__pfet_01v8_hvt L=0.15 W=1
+ AS=0.365 AD=0.105 PS=1.73 PD=1.21
M$5179 \$7079 B|X B|C|Y VPB|VPWR sky130_fd_pr__pfet_01v8_hvt L=0.15 W=1
+ AS=0.105 AD=0.165 PS=1.21 PD=1.33
M$5180 B|C|Y \$7050 VPB|VPWR VPB|VPWR sky130_fd_pr__pfet_01v8_hvt L=0.15 W=1
+ AS=0.165 AD=0.36 PS=1.33 PD=2.72
M$5181 \$6795 B|C|Y \$7008 VPB|VPWR sky130_fd_pr__pfet_01v8_hvt L=0.15 W=0.42
+ AS=0.1092 AD=0.0441 PS=1.36 PD=0.63
M$5182 \$7008 A|Y VPB|VPWR VPB|VPWR sky130_fd_pr__pfet_01v8_hvt L=0.15 W=0.42
+ AS=0.0441 AD=0.0567 PS=0.63 PD=0.69
M$5183 VPB|VPWR A|Y \$7009 VPB|VPWR sky130_fd_pr__pfet_01v8_hvt L=0.15 W=0.42
+ AS=0.0567 AD=0.0441 PS=0.69 PD=0.63
M$5184 \$7009 A|B|Y \$6795 VPB|VPWR sky130_fd_pr__pfet_01v8_hvt L=0.15 W=0.42
+ AS=0.0441 AD=0.0567 PS=0.63 PD=0.69
M$5185 \$6795 A|B|Y \$7010 VPB|VPWR sky130_fd_pr__pfet_01v8_hvt L=0.15 W=0.42
+ AS=0.0567 AD=0.0441 PS=0.69 PD=0.63
M$5186 VPB|VPWR B|C|Y \$7010 VPB|VPWR sky130_fd_pr__pfet_01v8_hvt L=0.15 W=0.42
+ AS=0.2492 AD=0.0441 PS=1.565 PD=0.63
M$5187 VPB|VPWR \$6795 B|SLEEP|X VPB|VPWR sky130_fd_pr__pfet_01v8_hvt L=0.15
+ W=1 AS=0.2492 AD=0.365 PS=1.565 PD=2.73
M$5188 VPB|VPWR B|C|Y \$7051 VPB|VPWR sky130_fd_pr__pfet_01v8_hvt L=0.15 W=1
+ AS=0.3 AD=0.135 PS=2.6 PD=1.27
M$5189 \$7051 A|Y VPB|VPWR VPB|VPWR sky130_fd_pr__pfet_01v8_hvt L=0.15 W=1
+ AS=0.135 AD=0.365 PS=1.27 PD=1.73
M$5190 VPB|VPWR A|Y \$7080 VPB|VPWR sky130_fd_pr__pfet_01v8_hvt L=0.15 W=1
+ AS=0.365 AD=0.105 PS=1.73 PD=1.21
M$5191 \$7080 B|C|Y B|Y VPB|VPWR sky130_fd_pr__pfet_01v8_hvt L=0.15 W=1
+ AS=0.105 AD=0.165 PS=1.21 PD=1.33
M$5192 B|Y \$7051 VPB|VPWR VPB|VPWR sky130_fd_pr__pfet_01v8_hvt L=0.15 W=1
+ AS=0.165 AD=0.36 PS=1.33 PD=2.72
M$5194 \$6797 A|B|C|Y \$7011 VPB|VPWR sky130_fd_pr__pfet_01v8_hvt L=0.15 W=0.42
+ AS=0.1092 AD=0.0441 PS=1.36 PD=0.63
M$5195 \$7011 A|Y VPB|VPWR VPB|VPWR sky130_fd_pr__pfet_01v8_hvt L=0.15 W=0.42
+ AS=0.0441 AD=0.0567 PS=0.63 PD=0.69
M$5196 VPB|VPWR A|Y \$7012 VPB|VPWR sky130_fd_pr__pfet_01v8_hvt L=0.15 W=0.42
+ AS=0.0567 AD=0.0441 PS=0.69 PD=0.63
M$5197 \$7012 B|Y \$6797 VPB|VPWR sky130_fd_pr__pfet_01v8_hvt L=0.15 W=0.42
+ AS=0.0441 AD=0.0567 PS=0.63 PD=0.69
M$5198 \$6797 B|Y \$7013 VPB|VPWR sky130_fd_pr__pfet_01v8_hvt L=0.15 W=0.42
+ AS=0.0567 AD=0.0441 PS=0.69 PD=0.63
M$5199 VPB|VPWR A|B|C|Y \$7013 VPB|VPWR sky130_fd_pr__pfet_01v8_hvt L=0.15
+ W=0.42 AS=0.2492 AD=0.0441 PS=1.565 PD=0.63
M$5200 VPB|VPWR \$6797 B|X VPB|VPWR sky130_fd_pr__pfet_01v8_hvt L=0.15 W=1
+ AS=0.2492 AD=0.365 PS=1.565 PD=2.73
M$5203 VPB|VPWR A|B|C|Y B|Y VPB|VPWR sky130_fd_pr__pfet_01v8_hvt L=0.15 W=1.68
+ AS=0.3486 AD=0.3318 PS=3.35 PD=3.31
M$5209 \$7053 \$7090 \$7054 VPB|VPWR sky130_fd_pr__pfet_01v8_hvt L=0.15 W=0.84
+ AS=0.1715 AD=0.1458 PS=1.355 PD=1.205
M$5210 \$7054 A|A1|B|C|Y \$7052 VPB|VPWR sky130_fd_pr__pfet_01v8_hvt L=0.15
+ W=0.64 AS=0.1458 AD=0.246 PS=1.205 PD=1.525
M$5211 \$7052 \$7053 VPB|VPWR VPB|VPWR sky130_fd_pr__pfet_01v8_hvt L=0.15 W=1
+ AS=0.285 AD=0.135 PS=2.57 PD=1.27
M$5212 VPB|VPWR A|Y \$7053 VPB|VPWR sky130_fd_pr__pfet_01v8_hvt L=0.15 W=1
+ AS=0.135 AD=0.1715 PS=1.27 PD=1.355
M$5213 \$7055 \$7090 \$7052 VPB|VPWR sky130_fd_pr__pfet_01v8_hvt L=0.15 W=0.64
+ AS=0.2452 AD=0.246 PS=1.45 PD=1.525
M$5214 \$7055 A|A1|B|C|Y \$7053 VPB|VPWR sky130_fd_pr__pfet_01v8_hvt L=0.15
+ W=0.84 AS=0.2452 AD=0.3536 PS=1.45 PD=2.53
M$5215 \$7090 A|A1|B|C|Y VPB|VPWR VPB|VPWR sky130_fd_pr__pfet_01v8_hvt L=0.15
+ W=1 AS=0.2526 AD=0.26 PS=2.52 PD=2.52
M$5216 VPB|VPWR B|C|Y \$7057 VPB|VPWR sky130_fd_pr__pfet_01v8_hvt L=0.15 W=0.64
+ AS=0.2115 AD=0.1792 PS=1.45 PD=1.84
M$5217 VPB|VPWR \$7056 A|B|X VPB|VPWR sky130_fd_pr__pfet_01v8_hvt L=0.15 W=1
+ AS=0.2115 AD=0.28 PS=1.45 PD=2.56
M$5219 B|C|X \$6812 VPB|VPWR VPB|VPWR sky130_fd_pr__pfet_01v8_hvt L=0.15 W=0.64
+ AS=0.1696 AD=0.1841 PS=1.81 PD=1.26
M$5220 VPB|VPWR B|C|Y \$6812 VPB|VPWR sky130_fd_pr__pfet_01v8_hvt L=0.15 W=0.42
+ AS=0.1841 AD=0.0609 PS=1.26 PD=0.71
M$5221 \$6812 A|B1|Y VPB|VPWR VPB|VPWR sky130_fd_pr__pfet_01v8_hvt L=0.15
+ W=0.42 AS=0.0609 AD=0.1113 PS=0.71 PD=1.37
M$5223 A|Y A|B1|Y \$7059 VPB|VPWR sky130_fd_pr__pfet_01v8_hvt L=0.15 W=1
+ AS=0.265 AD=0.14 PS=2.53 PD=1.28
M$5224 \$7059 A|A1|B1|Y VPB|VPWR VPB|VPWR sky130_fd_pr__pfet_01v8_hvt L=0.15
+ W=1 AS=0.14 AD=0.1475 PS=1.28 PD=1.295
M$5225 VPB|VPWR A2|B|C|Y \$7059 VPB|VPWR sky130_fd_pr__pfet_01v8_hvt L=0.15 W=1
+ AS=0.1475 AD=0.265 PS=1.295 PD=2.53
M$5227 \$7061 \$7092 \$7062 VPB|VPWR sky130_fd_pr__pfet_01v8_hvt L=0.15 W=0.84
+ AS=0.1715 AD=0.1458 PS=1.355 PD=1.205
M$5228 \$7062 B|C|X \$7060 VPB|VPWR sky130_fd_pr__pfet_01v8_hvt L=0.15 W=0.64
+ AS=0.1458 AD=0.246 PS=1.205 PD=1.525
M$5229 \$7060 \$7061 VPB|VPWR VPB|VPWR sky130_fd_pr__pfet_01v8_hvt L=0.15 W=1
+ AS=0.285 AD=0.135 PS=2.57 PD=1.27
M$5230 VPB|VPWR A|A1|Y \$7061 VPB|VPWR sky130_fd_pr__pfet_01v8_hvt L=0.15 W=1
+ AS=0.135 AD=0.1715 PS=1.27 PD=1.355
M$5231 \$7063 \$7092 \$7060 VPB|VPWR sky130_fd_pr__pfet_01v8_hvt L=0.15 W=0.64
+ AS=0.2452 AD=0.246 PS=1.45 PD=1.525
M$5232 \$7063 B|C|X \$7061 VPB|VPWR sky130_fd_pr__pfet_01v8_hvt L=0.15 W=0.84
+ AS=0.2452 AD=0.3536 PS=1.45 PD=2.53
M$5233 \$7092 B|C|X VPB|VPWR VPB|VPWR sky130_fd_pr__pfet_01v8_hvt L=0.15 W=1
+ AS=0.2526 AD=0.26 PS=2.52 PD=2.52
M$5234 VPB|VPWR A2|B|C|X \$7065 VPB|VPWR sky130_fd_pr__pfet_01v8_hvt L=0.15
+ W=0.64 AS=0.2115 AD=0.1792 PS=1.45 PD=1.84
M$5235 VPB|VPWR \$7064 B|X VPB|VPWR sky130_fd_pr__pfet_01v8_hvt L=0.15 W=1
+ AS=0.2115 AD=0.28 PS=1.45 PD=2.56
M$5239 VPB|VPWR B|X \$7067 VPB|VPWR sky130_fd_pr__pfet_01v8_hvt L=0.15 W=1
+ AS=0.3 AD=0.135 PS=2.6 PD=1.27
M$5240 \$7067 A|Y VPB|VPWR VPB|VPWR sky130_fd_pr__pfet_01v8_hvt L=0.15 W=1
+ AS=0.135 AD=0.365 PS=1.27 PD=1.73
M$5241 VPB|VPWR A|Y \$7087 VPB|VPWR sky130_fd_pr__pfet_01v8_hvt L=0.15 W=1
+ AS=0.365 AD=0.105 PS=1.73 PD=1.21
M$5242 \$7087 B|X C|Y VPB|VPWR sky130_fd_pr__pfet_01v8_hvt L=0.15 W=1 AS=0.105
+ AD=0.165 PS=1.21 PD=1.33
M$5243 C|Y \$7067 VPB|VPWR VPB|VPWR sky130_fd_pr__pfet_01v8_hvt L=0.15 W=1
+ AS=0.165 AD=0.36 PS=1.33 PD=2.72
M$5246 \$6826 C|Y \$6822 VPB|VPWR sky130_fd_pr__pfet_01v8_hvt L=0.15 W=0.84
+ AS=0.2688 AD=0.1596 PS=2.32 PD=1.22
M$5247 \$6822 \$6824 \$6825 VPB|VPWR sky130_fd_pr__pfet_01v8_hvt L=0.15 W=0.84
+ AS=0.1596 AD=0.441 PS=1.22 PD=2.73
M$5248 VPB|VPWR B|C|X \$7069 VPB|VPWR sky130_fd_pr__pfet_01v8_hvt L=0.15 W=1
+ AS=0.3 AD=0.135 PS=2.6 PD=1.27
M$5249 \$7069 A|Q VPB|VPWR VPB|VPWR sky130_fd_pr__pfet_01v8_hvt L=0.15 W=1
+ AS=0.135 AD=0.365 PS=1.27 PD=1.73
M$5250 VPB|VPWR A|Q \$7082 VPB|VPWR sky130_fd_pr__pfet_01v8_hvt L=0.15 W=1
+ AS=0.365 AD=0.105 PS=1.73 PD=1.21
M$5251 \$7082 B|C|X B|Y VPB|VPWR sky130_fd_pr__pfet_01v8_hvt L=0.15 W=1
+ AS=0.105 AD=0.165 PS=1.21 PD=1.33
M$5252 B|Y \$7069 VPB|VPWR VPB|VPWR sky130_fd_pr__pfet_01v8_hvt L=0.15 W=1
+ AS=0.165 AD=0.36 PS=1.33 PD=2.72
M$5253 VPB|VPWR \$7006 \$6830 VPB|VPWR sky130_fd_pr__pfet_01v8_hvt L=0.15
+ W=0.42 AS=0.1134 AD=0.0567 PS=1.38 PD=0.69
M$5254 \$6830 RESET_B|X VPB|VPWR VPB|VPWR sky130_fd_pr__pfet_01v8_hvt L=0.15
+ W=0.42 AS=0.0567 AD=0.0819 PS=0.69 PD=0.81
M$5255 VPB|VPWR \$6830 \$7017 VPB|VPWR sky130_fd_pr__pfet_01v8_hvt L=0.15
+ W=0.42 AS=0.0819 AD=0.0567 PS=0.81 PD=0.69
M$5256 \$7017 \$6832 \$7006 VPB|VPWR sky130_fd_pr__pfet_01v8_hvt L=0.15 W=0.42
+ AS=0.0567 AD=0.0588 PS=0.69 PD=0.7
M$5257 \$6833 \$6831 \$7006 VPB|VPWR sky130_fd_pr__pfet_01v8_hvt L=0.15 W=0.42
+ AS=0.12915 AD=0.0588 PS=1.185 PD=0.7
M$5258 \$6833 \$6834 VPB|VPWR VPB|VPWR sky130_fd_pr__pfet_01v8_hvt L=0.15
+ W=0.84 AS=0.12915 AD=0.2184 PS=1.185 PD=2.2
M$5260 \$7007 RESET_B|X VPB|VPWR VPB|VPWR sky130_fd_pr__pfet_01v8_hvt L=0.15
+ W=0.42 AS=0.1092 AD=0.07035 PS=1.36 PD=0.755
M$5261 VPB|VPWR \$6833 \$7007 VPB|VPWR sky130_fd_pr__pfet_01v8_hvt L=0.15
+ W=0.42 AS=0.07035 AD=0.1155 PS=0.755 PD=0.97
M$5262 \$7007 \$6831 \$6834 VPB|VPWR sky130_fd_pr__pfet_01v8_hvt L=0.15 W=0.42
+ AS=0.1155 AD=0.07245 PS=0.97 PD=0.765
M$5263 \$6834 \$6832 \$6835 VPB|VPWR sky130_fd_pr__pfet_01v8_hvt L=0.15 W=0.42
+ AS=0.07245 AD=0.0651 PS=0.765 PD=0.73
M$5264 \$6835 D|Y VPB|VPWR VPB|VPWR sky130_fd_pr__pfet_01v8_hvt L=0.15 W=0.42
+ AS=0.0651 AD=0.1092 PS=0.73 PD=1.36
M$5266 \$6832 \$6831 VPB|VPWR VPB|VPWR sky130_fd_pr__pfet_01v8_hvt L=0.15
+ W=0.64 AS=0.1664 AD=0.0864 PS=1.8 PD=0.91
M$5267 VPB|VPWR CLK|TICK \$6831 VPB|VPWR sky130_fd_pr__pfet_01v8_hvt L=0.15
+ W=0.64 AS=0.0864 AD=0.1664 PS=0.91 PD=1.8
M$5276 \$7275 A|A2|B|B_N|X VPB|VPWR VPB|VPWR sky130_fd_pr__pfet_01v8_hvt L=0.15
+ W=1 AS=0.265 AD=0.1475 PS=2.53 PD=1.295
M$5277 VPB|VPWR A|A1|X \$7275 VPB|VPWR sky130_fd_pr__pfet_01v8_hvt L=0.15 W=1
+ AS=0.1475 AD=0.14 PS=1.295 PD=1.28
M$5278 \$7275 A|B1|Y A2|B|Y VPB|VPWR sky130_fd_pr__pfet_01v8_hvt L=0.15 W=1
+ AS=0.14 AD=0.265 PS=1.28 PD=2.53
M$5279 VPB|VPWR A|A2|B|B_N|X \$7121 VPB|VPWR sky130_fd_pr__pfet_01v8_hvt L=0.15
+ W=1 AS=0.3 AD=0.135 PS=2.6 PD=1.27
M$5280 \$7121 A|Y VPB|VPWR VPB|VPWR sky130_fd_pr__pfet_01v8_hvt L=0.15 W=1
+ AS=0.135 AD=0.365 PS=1.27 PD=1.73
M$5281 VPB|VPWR A|Y \$7289 VPB|VPWR sky130_fd_pr__pfet_01v8_hvt L=0.15 W=1
+ AS=0.365 AD=0.105 PS=1.73 PD=1.21
M$5282 \$7289 A|A2|B|B_N|X A2|B|C|Y VPB|VPWR sky130_fd_pr__pfet_01v8_hvt L=0.15
+ W=1 AS=0.105 AD=0.165 PS=1.21 PD=1.33
M$5283 A2|B|C|Y \$7121 VPB|VPWR VPB|VPWR sky130_fd_pr__pfet_01v8_hvt L=0.15 W=1
+ AS=0.165 AD=0.36 PS=1.33 PD=2.72
M$5285 VPB|VPWR A2|B|C|Y A3|Y VPB|VPWR sky130_fd_pr__pfet_01v8_hvt L=0.15 W=1
+ AS=0.26 AD=0.135 PS=2.52 PD=1.27
M$5287 VPB|VPWR A|A1|B1|X \$7293 VPB|VPWR sky130_fd_pr__pfet_01v8_hvt L=0.15
+ W=1 AS=0.28 AD=0.175 PS=2.56 PD=1.35
M$5288 \$7293 A2|B|Y \$7291 VPB|VPWR sky130_fd_pr__pfet_01v8_hvt L=0.15 W=1
+ AS=0.175 AD=0.135 PS=1.35 PD=1.27
M$5289 \$7291 A3|Y \$7295 VPB|VPWR sky130_fd_pr__pfet_01v8_hvt L=0.15 W=1
+ AS=0.135 AD=0.3125 PS=1.27 PD=1.625
M$5290 \$7295 A3|A4|X C|Y VPB|VPWR sky130_fd_pr__pfet_01v8_hvt L=0.15 W=1
+ AS=0.3125 AD=0.135 PS=1.625 PD=1.27
M$5295 \$7128 A|X VPB|VPWR VPB|VPWR sky130_fd_pr__pfet_01v8_hvt L=0.15 W=0.42
+ AS=0.1092 AD=0.1573 PS=1.36 PD=1.39
M$5296 VPB|VPWR B|SLEEP|Y \$7296 VPB|VPWR sky130_fd_pr__pfet_01v8_hvt L=0.15
+ W=1 AS=0.1573 AD=0.105 PS=1.39 PD=1.21
M$5297 \$7296 \$7128 A|B|X VPB|VPWR sky130_fd_pr__pfet_01v8_hvt L=0.15 W=1
+ AS=0.105 AD=0.26 PS=1.21 PD=2.52
M$5300 \$7046 B|B_N|C|X \$7044 VPB|VPWR sky130_fd_pr__pfet_01v8_hvt L=0.15
+ W=0.84 AS=0.15295 AD=0.273 PS=1.315 PD=2.33
M$5301 \$7046 \$7047 \$7045 VPB|VPWR sky130_fd_pr__pfet_01v8_hvt L=0.15 W=0.84
+ AS=0.15295 AD=0.32235 PS=1.315 PD=2.45
M$5302 \$7276 A|Y VPB|VPWR VPB|VPWR sky130_fd_pr__pfet_01v8_hvt L=0.15 W=0.42
+ AS=0.1092 AD=0.0567 PS=1.36 PD=0.69
M$5303 VPB|VPWR A|B|X \$7276 VPB|VPWR sky130_fd_pr__pfet_01v8_hvt L=0.15 W=0.42
+ AS=0.0567 AD=0.06615 PS=0.69 PD=0.735
M$5304 VPB|VPWR B|B_N|C|X \$7276 VPB|VPWR sky130_fd_pr__pfet_01v8_hvt L=0.15
+ W=0.42 AS=0.142225 AD=0.06615 PS=1.335 PD=0.735
M$5305 VPB|VPWR \$7276 A|A1|B1|X VPB|VPWR sky130_fd_pr__pfet_01v8_hvt L=0.15
+ W=1 AS=0.142225 AD=0.26 PS=1.335 PD=2.52
M$5310 \$7132 B|C|X \$7292 VPB|VPWR sky130_fd_pr__pfet_01v8_hvt L=0.15 W=1
+ AS=0.26 AD=0.135 PS=2.52 PD=1.27
M$5311 \$7292 A|Y VPB|VPWR VPB|VPWR sky130_fd_pr__pfet_01v8_hvt L=0.15 W=1
+ AS=0.135 AD=0.135 PS=1.27 PD=1.27
M$5312 VPB|VPWR A|Y \$7277 VPB|VPWR sky130_fd_pr__pfet_01v8_hvt L=0.15 W=1
+ AS=0.135 AD=0.135 PS=1.27 PD=1.27
M$5313 \$7277 B|C|X VPB|VPWR VPB|VPWR sky130_fd_pr__pfet_01v8_hvt L=0.15 W=1
+ AS=0.135 AD=0.26 PS=1.27 PD=2.52
M$5314 \$7277 \$7132 A2|X VPB|VPWR sky130_fd_pr__pfet_01v8_hvt L=0.15 W=1
+ AS=0.26 AD=0.3 PS=2.52 PD=2.6
M$5315 \$7278 A2|X VPB|VPWR VPB|VPWR sky130_fd_pr__pfet_01v8_hvt L=0.15 W=1
+ AS=0.265 AD=0.1475 PS=2.53 PD=1.295
M$5316 VPB|VPWR A1|Y \$7278 VPB|VPWR sky130_fd_pr__pfet_01v8_hvt L=0.15 W=1
+ AS=0.1475 AD=0.14 PS=1.295 PD=1.28
M$5317 \$7278 A|A1|B1|X A|B|C|Y VPB|VPWR sky130_fd_pr__pfet_01v8_hvt L=0.15 W=1
+ AS=0.14 AD=0.265 PS=1.28 PD=2.53
M$5321 VPB|VPWR A|B|C|Y A|Y VPB|VPWR sky130_fd_pr__pfet_01v8_hvt L=0.15 W=2
+ AS=0.3 AD=0.395 PS=2.6 PD=3.79
M$5322 A|Y B|C|Y VPB|VPWR VPB|VPWR sky130_fd_pr__pfet_01v8_hvt L=0.15 W=1
+ AS=0.135 AD=0.26 PS=1.27 PD=2.52
M$5325 VPB|VPWR B|C|Y A|B|C|Y VPB|VPWR sky130_fd_pr__pfet_01v8_hvt L=0.15 W=1
+ AS=0.26 AD=0.135 PS=2.52 PD=1.27
M$5326 A|B|C|Y A|B1|X VPB|VPWR VPB|VPWR sky130_fd_pr__pfet_01v8_hvt L=0.15
+ W=1.64 AS=0.2246 AD=0.4424 PS=2.19 PD=4.37
M$5328 B|Y A|B1|X \$7280 VPB|VPWR sky130_fd_pr__pfet_01v8_hvt L=0.15 W=1
+ AS=0.265 AD=0.14 PS=2.53 PD=1.28
M$5329 \$7280 A|A1|Y VPB|VPWR VPB|VPWR sky130_fd_pr__pfet_01v8_hvt L=0.15 W=1
+ AS=0.14 AD=0.1475 PS=1.28 PD=1.295
M$5330 VPB|VPWR A2|B|Y \$7280 VPB|VPWR sky130_fd_pr__pfet_01v8_hvt L=0.15 W=1
+ AS=0.1475 AD=0.265 PS=1.295 PD=2.53
M$5333 A|B1|Y B|C|Y VPB|VPWR VPB|VPWR sky130_fd_pr__pfet_01v8_hvt L=0.15 W=1
+ AS=0.135 AD=0.26 PS=1.27 PD=2.52
M$5335 \$7054 \$7057 \$7056 VPB|VPWR sky130_fd_pr__pfet_01v8_hvt L=0.15 W=0.84
+ AS=0.441 AD=0.1596 PS=2.73 PD=1.22
M$5336 \$7056 B|C|Y \$7055 VPB|VPWR sky130_fd_pr__pfet_01v8_hvt L=0.15 W=0.84
+ AS=0.1596 AD=0.2688 PS=1.22 PD=2.32
M$5338 VPB|VPWR A|B|B1|Y \$7287 VPB|VPWR sky130_fd_pr__pfet_01v8_hvt L=0.15 W=1
+ AS=0.26 AD=0.105 PS=2.52 PD=1.21
M$5339 \$7287 A|B|X A|B1|Y VPB|VPWR sky130_fd_pr__pfet_01v8_hvt L=0.15 W=1
+ AS=0.105 AD=0.26 PS=1.21 PD=2.52
M$5341 \$7141 B|Y \$7286 VPB|VPWR sky130_fd_pr__pfet_01v8_hvt L=0.15 W=1
+ AS=0.26 AD=0.135 PS=2.52 PD=1.27
M$5342 \$7286 A|B|X VPB|VPWR VPB|VPWR sky130_fd_pr__pfet_01v8_hvt L=0.15 W=1
+ AS=0.135 AD=0.135 PS=1.27 PD=1.27
M$5343 VPB|VPWR A|B|X \$7281 VPB|VPWR sky130_fd_pr__pfet_01v8_hvt L=0.15 W=1
+ AS=0.135 AD=0.135 PS=1.27 PD=1.27
M$5344 \$7281 B|Y VPB|VPWR VPB|VPWR sky130_fd_pr__pfet_01v8_hvt L=0.15 W=1
+ AS=0.135 AD=0.26 PS=1.27 PD=2.52
M$5345 \$7281 \$7141 A2|B|C|X VPB|VPWR sky130_fd_pr__pfet_01v8_hvt L=0.15 W=1
+ AS=0.26 AD=0.3 PS=2.52 PD=2.6
M$5348 \$7062 \$7065 \$7064 VPB|VPWR sky130_fd_pr__pfet_01v8_hvt L=0.15 W=0.84
+ AS=0.441 AD=0.1596 PS=2.73 PD=1.22
M$5349 \$7064 A2|B|C|X \$7063 VPB|VPWR sky130_fd_pr__pfet_01v8_hvt L=0.15
+ W=0.84 AS=0.1596 AD=0.2688 PS=1.22 PD=2.32
M$5353 \$7068 C|Y \$7086 VPB|VPWR sky130_fd_pr__pfet_01v8_hvt L=0.15 W=0.42
+ AS=0.1092 AD=0.0441 PS=1.36 PD=0.63
M$5354 \$7086 A|Q VPB|VPWR VPB|VPWR sky130_fd_pr__pfet_01v8_hvt L=0.15 W=0.42
+ AS=0.0441 AD=0.0567 PS=0.63 PD=0.69
M$5355 VPB|VPWR A|Q \$7084 VPB|VPWR sky130_fd_pr__pfet_01v8_hvt L=0.15 W=0.42
+ AS=0.0567 AD=0.0441 PS=0.69 PD=0.63
M$5356 \$7084 B|X \$7068 VPB|VPWR sky130_fd_pr__pfet_01v8_hvt L=0.15 W=0.42
+ AS=0.0441 AD=0.0567 PS=0.63 PD=0.69
M$5357 \$7068 B|X \$7083 VPB|VPWR sky130_fd_pr__pfet_01v8_hvt L=0.15 W=0.42
+ AS=0.0567 AD=0.0441 PS=0.69 PD=0.63
M$5358 VPB|VPWR C|Y \$7083 VPB|VPWR sky130_fd_pr__pfet_01v8_hvt L=0.15 W=0.42
+ AS=0.2492 AD=0.0441 PS=1.565 PD=0.63
M$5359 VPB|VPWR \$7068 A|B|X VPB|VPWR sky130_fd_pr__pfet_01v8_hvt L=0.15 W=1
+ AS=0.2492 AD=0.365 PS=1.565 PD=2.73
M$5370 VPB|VPWR A|B1|Y \$7297 VPB|VPWR sky130_fd_pr__pfet_01v8_hvt L=0.15
+ W=0.42 AS=0.1573 AD=0.1092 PS=1.39 PD=1.36
M$5371 VPB|VPWR B1|SLEEP|Y \$7338 VPB|VPWR sky130_fd_pr__pfet_01v8_hvt L=0.15
+ W=1 AS=0.1573 AD=0.105 PS=1.39 PD=1.21
M$5372 \$7338 \$7297 A|A1|B1|X VPB|VPWR sky130_fd_pr__pfet_01v8_hvt L=0.15 W=1
+ AS=0.105 AD=0.26 PS=1.21 PD=2.52
M$5373 VPB|VPWR A|A1|X \$7339 VPB|VPWR sky130_fd_pr__pfet_01v8_hvt L=0.15
+ W=0.64 AS=0.1696 AD=0.0768 PS=1.81 PD=0.88
M$5374 \$7339 A2|B|C|Y A|A0|B|Y VPB|VPWR sky130_fd_pr__pfet_01v8_hvt L=0.15
+ W=0.64 AS=0.0768 AD=0.0896 PS=0.88 PD=0.92
M$5375 A|A0|B|Y B1|SLEEP|Y VPB|VPWR VPB|VPWR sky130_fd_pr__pfet_01v8_hvt L=0.15
+ W=0.64 AS=0.0896 AD=0.1824 PS=0.92 PD=1.85
M$5377 VPB|VPWR A|A1|B1|X \$7340 VPB|VPWR sky130_fd_pr__pfet_01v8_hvt L=0.15
+ W=1 AS=0.26 AD=0.105 PS=2.52 PD=1.21
M$5378 \$7340 A2|B|Y A2|D|Y VPB|VPWR sky130_fd_pr__pfet_01v8_hvt L=0.15 W=1
+ AS=0.105 AD=0.26 PS=1.21 PD=2.52
M$5379 \$7300 A2|B|C|X VPB|VPWR VPB|VPWR sky130_fd_pr__pfet_01v8_hvt L=0.15 W=1
+ AS=0.265 AD=0.14 PS=2.53 PD=1.28
M$5380 VPB|VPWR A|A1|B|Y \$7300 VPB|VPWR sky130_fd_pr__pfet_01v8_hvt L=0.15 W=1
+ AS=0.14 AD=0.1375 PS=1.28 PD=1.275
M$5381 \$7300 A|A1|B1|X \$7301 VPB|VPWR sky130_fd_pr__pfet_01v8_hvt L=0.15 W=1
+ AS=0.1375 AD=0.26 PS=1.275 PD=2.52
M$5382 VPB|VPWR \$7301 A2|C|X VPB|VPWR sky130_fd_pr__pfet_01v8_hvt L=0.15 W=1
+ AS=0.26 AD=0.26 PS=2.52 PD=2.52
M$5384 A1|B|Y A|A1|B|Y VPB|VPWR VPB|VPWR sky130_fd_pr__pfet_01v8_hvt L=0.15 W=1
+ AS=0.135 AD=0.165 PS=1.27 PD=1.33
M$5385 VPB|VPWR A|A1|B1|X A1|B|Y VPB|VPWR sky130_fd_pr__pfet_01v8_hvt L=0.15
+ W=1 AS=0.165 AD=0.26 PS=1.33 PD=2.52
M$5389 \$7304 B|SLEEP|Y \$7342 VPB|VPWR sky130_fd_pr__pfet_01v8_hvt L=0.15 W=1
+ AS=0.26 AD=0.135 PS=2.52 PD=1.27
M$5390 \$7342 A|X VPB|VPWR VPB|VPWR sky130_fd_pr__pfet_01v8_hvt L=0.15 W=1
+ AS=0.135 AD=0.135 PS=1.27 PD=1.27
M$5391 VPB|VPWR A|X \$7305 VPB|VPWR sky130_fd_pr__pfet_01v8_hvt L=0.15 W=1
+ AS=0.135 AD=0.135 PS=1.27 PD=1.27
M$5392 \$7305 B|SLEEP|Y VPB|VPWR VPB|VPWR sky130_fd_pr__pfet_01v8_hvt L=0.15
+ W=1 AS=0.135 AD=0.26 PS=1.27 PD=2.52
M$5393 \$7305 \$7304 A|X VPB|VPWR sky130_fd_pr__pfet_01v8_hvt L=0.15 W=1
+ AS=0.26 AD=0.3 PS=2.52 PD=2.6
M$5395 VPB|VPWR A|X \$7343 VPB|VPWR sky130_fd_pr__pfet_01v8_hvt L=0.15 W=1
+ AS=0.26 AD=0.105 PS=2.52 PD=1.21
M$5396 \$7343 B|X A|Y VPB|VPWR sky130_fd_pr__pfet_01v8_hvt L=0.15 W=1 AS=0.105
+ AD=0.26 PS=1.21 PD=2.52
M$5401 B|Y A|B|X \$7344 VPB|VPWR sky130_fd_pr__pfet_01v8_hvt L=0.15 W=1 AS=0.26
+ AD=0.105 PS=2.52 PD=1.21
M$5402 \$7344 A|Y VPB|VPWR VPB|VPWR sky130_fd_pr__pfet_01v8_hvt L=0.15 W=1
+ AS=0.105 AD=0.26 PS=1.21 PD=2.52
M$5403 \$7308 B|Y \$7345 VPB|VPWR sky130_fd_pr__pfet_01v8_hvt L=0.15 W=1
+ AS=0.26 AD=0.135 PS=2.52 PD=1.27
M$5404 \$7345 A|B|X VPB|VPWR VPB|VPWR sky130_fd_pr__pfet_01v8_hvt L=0.15 W=1
+ AS=0.135 AD=0.135 PS=1.27 PD=1.27
M$5405 VPB|VPWR A|B|X \$7309 VPB|VPWR sky130_fd_pr__pfet_01v8_hvt L=0.15 W=1
+ AS=0.135 AD=0.135 PS=1.27 PD=1.27
M$5406 \$7309 B|Y VPB|VPWR VPB|VPWR sky130_fd_pr__pfet_01v8_hvt L=0.15 W=1
+ AS=0.135 AD=0.26 PS=1.27 PD=2.52
M$5407 \$7309 \$7308 A_N|B|B1|C|X VPB|VPWR sky130_fd_pr__pfet_01v8_hvt L=0.15
+ W=1 AS=0.26 AD=0.3 PS=2.52 PD=2.6
M$5409 VPB|VPWR A_N|B|B1|C|X \$7311 VPB|VPWR sky130_fd_pr__pfet_01v8_hvt L=0.15
+ W=0.42 AS=0.14575 AD=0.1092 PS=1.335 PD=1.36
M$5410 VPB|VPWR A|D|Y A|B|Y VPB|VPWR sky130_fd_pr__pfet_01v8_hvt L=0.15 W=1
+ AS=0.14575 AD=0.135 PS=1.335 PD=1.27
M$5412 VPB|VPWR A|B|C|Y A|B|Y VPB|VPWR sky130_fd_pr__pfet_01v8_hvt L=0.15 W=1
+ AS=0.1925 AD=0.195 PS=1.385 PD=1.39
M$5413 A|B|Y \$7311 VPB|VPWR VPB|VPWR sky130_fd_pr__pfet_01v8_hvt L=0.15 W=1
+ AS=0.195 AD=0.28 PS=1.39 PD=2.56
M$5414 VPB|VPWR A|A2|B|X \$7347 VPB|VPWR sky130_fd_pr__pfet_01v8_hvt L=0.15 W=1
+ AS=0.26 AD=0.105 PS=2.52 PD=1.21
M$5415 \$7347 A_N|B|B1|C|X A|Y VPB|VPWR sky130_fd_pr__pfet_01v8_hvt L=0.15 W=1
+ AS=0.105 AD=0.26 PS=1.21 PD=2.52
M$5417 VPB|VPWR A|B1|SLEEP|Y A|Y VPB|VPWR sky130_fd_pr__pfet_01v8_hvt L=0.15
+ W=1 AS=0.26 AD=0.135 PS=2.52 PD=1.27
M$5419 VPB|VPWR B|C|Y \$7313 VPB|VPWR sky130_fd_pr__pfet_01v8_hvt L=0.15 W=1
+ AS=0.3 AD=0.135 PS=2.6 PD=1.27
M$5420 \$7313 A|Y VPB|VPWR VPB|VPWR sky130_fd_pr__pfet_01v8_hvt L=0.15 W=1
+ AS=0.135 AD=0.365 PS=1.27 PD=1.73
M$5421 VPB|VPWR A|Y \$7349 VPB|VPWR sky130_fd_pr__pfet_01v8_hvt L=0.15 W=1
+ AS=0.365 AD=0.105 PS=1.73 PD=1.21
M$5422 \$7349 B|C|Y A|C|Y VPB|VPWR sky130_fd_pr__pfet_01v8_hvt L=0.15 W=1
+ AS=0.105 AD=0.165 PS=1.21 PD=1.33
M$5423 A|C|Y \$7313 VPB|VPWR VPB|VPWR sky130_fd_pr__pfet_01v8_hvt L=0.15 W=1
+ AS=0.165 AD=0.36 PS=1.33 PD=2.72
M$5425 VPB|VPWR A|C|Y \$7316 VPB|VPWR sky130_fd_pr__pfet_01v8_hvt L=0.15 W=0.42
+ AS=0.142225 AD=0.06615 PS=1.335 PD=0.735
M$5426 \$7316 A2|B|Y VPB|VPWR VPB|VPWR sky130_fd_pr__pfet_01v8_hvt L=0.15
+ W=0.42 AS=0.06615 AD=0.0567 PS=0.735 PD=0.69
M$5427 VPB|VPWR A|A1|Y \$7316 VPB|VPWR sky130_fd_pr__pfet_01v8_hvt L=0.15
+ W=0.42 AS=0.0567 AD=0.1092 PS=0.69 PD=1.36
M$5428 B|C|X \$7316 VPB|VPWR VPB|VPWR sky130_fd_pr__pfet_01v8_hvt L=0.15 W=1
+ AS=0.26 AD=0.142225 PS=2.52 PD=1.335
M$5429 VPB|VPWR B|Y \$7317 VPB|VPWR sky130_fd_pr__pfet_01v8_hvt L=0.15 W=1
+ AS=0.3 AD=0.135 PS=2.6 PD=1.27
M$5430 \$7317 A|C|Y VPB|VPWR VPB|VPWR sky130_fd_pr__pfet_01v8_hvt L=0.15 W=1
+ AS=0.135 AD=0.365 PS=1.27 PD=1.73
M$5431 VPB|VPWR A|C|Y \$7350 VPB|VPWR sky130_fd_pr__pfet_01v8_hvt L=0.15 W=1
+ AS=0.365 AD=0.105 PS=1.73 PD=1.21
M$5432 \$7350 B|Y B|C|Y VPB|VPWR sky130_fd_pr__pfet_01v8_hvt L=0.15 W=1
+ AS=0.105 AD=0.165 PS=1.21 PD=1.33
M$5433 B|C|Y \$7317 VPB|VPWR VPB|VPWR sky130_fd_pr__pfet_01v8_hvt L=0.15 W=1
+ AS=0.165 AD=0.36 PS=1.33 PD=2.72
M$5437 VPB|VPWR A|B|X A|B|B1|Y VPB|VPWR sky130_fd_pr__pfet_01v8_hvt L=0.15 W=1
+ AS=0.26 AD=0.135 PS=2.52 PD=1.27
M$5438 A|B|B1|Y A|Y VPB|VPWR VPB|VPWR sky130_fd_pr__pfet_01v8_hvt L=0.15 W=1
+ AS=0.135 AD=0.26 PS=1.27 PD=2.52
M$5440 VPB|VPWR A|A2|B|Y \$7354 VPB|VPWR sky130_fd_pr__pfet_01v8_hvt L=0.15 W=1
+ AS=0.26 AD=0.105 PS=2.52 PD=1.21
M$5441 \$7354 A|B|X A2|B|C|Y VPB|VPWR sky130_fd_pr__pfet_01v8_hvt L=0.15 W=1
+ AS=0.105 AD=0.26 PS=1.21 PD=2.52
M$5442 VPB|VPWR A|B|B1|Y B|Y VPB|VPWR sky130_fd_pr__pfet_01v8_hvt L=0.15 W=1.64
+ AS=0.3174 AD=0.3496 PS=3.12 PD=3.44
M$5443 B|Y A|A2|B|Y \$7355 VPB|VPWR sky130_fd_pr__pfet_01v8_hvt L=0.15 W=0.64
+ AS=0.0896 AD=0.0768 PS=0.92 PD=0.88
M$5444 \$7355 A|A1|Y VPB|VPWR VPB|VPWR sky130_fd_pr__pfet_01v8_hvt L=0.15
+ W=0.64 AS=0.0768 AD=0.1696 PS=0.88 PD=1.81
M$5446 A|A1|Y A|A1|B1|Y \$7320 VPB|VPWR sky130_fd_pr__pfet_01v8_hvt L=0.15 W=1
+ AS=0.265 AD=0.14 PS=2.53 PD=1.28
M$5447 \$7320 A|A1|Y VPB|VPWR VPB|VPWR sky130_fd_pr__pfet_01v8_hvt L=0.15 W=1
+ AS=0.14 AD=0.1475 PS=1.28 PD=1.295
M$5448 VPB|VPWR A|A2|B|C_N|Y \$7320 VPB|VPWR sky130_fd_pr__pfet_01v8_hvt L=0.15
+ W=1 AS=0.1475 AD=0.265 PS=1.295 PD=2.53
M$5451 B|Y A|B1|Y \$7322 VPB|VPWR sky130_fd_pr__pfet_01v8_hvt L=0.15 W=1
+ AS=0.265 AD=0.14 PS=2.53 PD=1.28
M$5452 \$7322 A|A1|X VPB|VPWR VPB|VPWR sky130_fd_pr__pfet_01v8_hvt L=0.15 W=1
+ AS=0.14 AD=0.1475 PS=1.28 PD=1.295
M$5453 VPB|VPWR A|A2|B|Y \$7322 VPB|VPWR sky130_fd_pr__pfet_01v8_hvt L=0.15 W=1
+ AS=0.1475 AD=0.265 PS=1.295 PD=2.53
M$5456 VPB|VPWR D|X \$7326 VPB|VPWR sky130_fd_pr__pfet_01v8_hvt L=0.15 W=0.42
+ AS=0.1092 AD=0.0651 PS=1.36 PD=0.73
M$5457 \$7326 \$7324 \$7327 VPB|VPWR sky130_fd_pr__pfet_01v8_hvt L=0.15 W=0.42
+ AS=0.0651 AD=0.07245 PS=0.73 PD=0.765
M$5458 \$7327 \$7323 \$7328 VPB|VPWR sky130_fd_pr__pfet_01v8_hvt L=0.15 W=0.42
+ AS=0.07245 AD=0.1155 PS=0.765 PD=0.97
M$5459 \$7328 \$7329 VPB|VPWR VPB|VPWR sky130_fd_pr__pfet_01v8_hvt L=0.15
+ W=0.42 AS=0.1155 AD=0.07035 PS=0.97 PD=0.755
M$5460 VPB|VPWR RESET_B|X \$7328 VPB|VPWR sky130_fd_pr__pfet_01v8_hvt L=0.15
+ W=0.42 AS=0.07035 AD=0.1092 PS=0.755 PD=1.36
M$5461 \$7329 \$7323 \$7330 VPB|VPWR sky130_fd_pr__pfet_01v8_hvt L=0.15 W=0.42
+ AS=0.12915 AD=0.0588 PS=1.185 PD=0.7
M$5462 \$7330 \$7324 \$7357 VPB|VPWR sky130_fd_pr__pfet_01v8_hvt L=0.15 W=0.42
+ AS=0.0588 AD=0.0567 PS=0.7 PD=0.69
M$5463 \$7357 \$7331 VPB|VPWR VPB|VPWR sky130_fd_pr__pfet_01v8_hvt L=0.15
+ W=0.42 AS=0.0567 AD=0.0819 PS=0.69 PD=0.81
M$5464 VPB|VPWR RESET_B|X \$7331 VPB|VPWR sky130_fd_pr__pfet_01v8_hvt L=0.15
+ W=0.42 AS=0.0819 AD=0.0567 PS=0.81 PD=0.69
M$5465 \$7331 \$7330 VPB|VPWR VPB|VPWR sky130_fd_pr__pfet_01v8_hvt L=0.15
+ W=0.42 AS=0.0567 AD=0.1134 PS=0.69 PD=1.38
M$5466 VPB|VPWR \$7327 \$7329 VPB|VPWR sky130_fd_pr__pfet_01v8_hvt L=0.15
+ W=0.84 AS=0.2184 AD=0.12915 PS=2.2 PD=1.185
M$5467 VPB|VPWR \$7331 A|Q VPB|VPWR sky130_fd_pr__pfet_01v8_hvt L=0.15 W=1
+ AS=0.3012 AD=0.26 PS=2.66 PD=2.52
M$5468 VPB|VPWR B|C|X \$7352 VPB|VPWR sky130_fd_pr__pfet_01v8_hvt L=0.15 W=0.42
+ AS=0.2492 AD=0.0441 PS=1.565 PD=0.63
M$5469 \$7352 A|B|X \$7335 VPB|VPWR sky130_fd_pr__pfet_01v8_hvt L=0.15 W=0.42
+ AS=0.0441 AD=0.0567 PS=0.63 PD=0.69
M$5470 \$7335 A|B|X \$7353 VPB|VPWR sky130_fd_pr__pfet_01v8_hvt L=0.15 W=0.42
+ AS=0.0567 AD=0.0441 PS=0.69 PD=0.63
M$5471 \$7353 A|Q VPB|VPWR VPB|VPWR sky130_fd_pr__pfet_01v8_hvt L=0.15 W=0.42
+ AS=0.0441 AD=0.0567 PS=0.63 PD=0.69
M$5472 VPB|VPWR A|Q \$7351 VPB|VPWR sky130_fd_pr__pfet_01v8_hvt L=0.15 W=0.42
+ AS=0.0567 AD=0.0441 PS=0.69 PD=0.63
M$5473 \$7351 B|C|X \$7335 VPB|VPWR sky130_fd_pr__pfet_01v8_hvt L=0.15 W=0.42
+ AS=0.0441 AD=0.1092 PS=0.63 PD=1.36
M$5474 B|X \$7335 VPB|VPWR VPB|VPWR sky130_fd_pr__pfet_01v8_hvt L=0.15 W=1
+ AS=0.365 AD=0.2492 PS=2.73 PD=1.565
M$5487 VPB|VPWR A2|D|Y A|B1|Y VPB|VPWR sky130_fd_pr__pfet_01v8_hvt L=0.15 W=1
+ AS=0.26 AD=0.135 PS=2.52 PD=1.27
M$5488 A|B1|Y A2|B|C|Y VPB|VPWR VPB|VPWR sky130_fd_pr__pfet_01v8_hvt L=0.15 W=1
+ AS=0.135 AD=0.135 PS=1.27 PD=1.27
M$5489 VPB|VPWR A|B|Y A|B1|Y VPB|VPWR sky130_fd_pr__pfet_01v8_hvt L=0.15 W=3
+ AS=0.53 AD=0.465 PS=5.06 PD=3.93
M$5490 A|B1|Y A|B1|X VPB|VPWR VPB|VPWR sky130_fd_pr__pfet_01v8_hvt L=0.15
+ W=1.64 AS=0.309 AD=0.4184 PS=2.42 PD=3.61
M$5492 \$7616 A2|C|X VPB|VPWR VPB|VPWR sky130_fd_pr__pfet_01v8_hvt L=0.15 W=1
+ AS=0.265 AD=0.1475 PS=2.53 PD=1.295
M$5493 VPB|VPWR A1|B|Y \$7616 VPB|VPWR sky130_fd_pr__pfet_01v8_hvt L=0.15 W=1
+ AS=0.1475 AD=0.14 PS=1.295 PD=1.28
M$5494 \$7616 A|B1|Y A2|A4|Y VPB|VPWR sky130_fd_pr__pfet_01v8_hvt L=0.15 W=1
+ AS=0.14 AD=0.265 PS=1.28 PD=2.53
M$5495 \$7404 A|B1|Y VPB|VPWR VPB|VPWR sky130_fd_pr__pfet_01v8_hvt L=0.15
+ W=0.42 AS=0.1092 AD=0.0567 PS=1.36 PD=0.69
M$5496 VPB|VPWR A1|B|Y \$7404 VPB|VPWR sky130_fd_pr__pfet_01v8_hvt L=0.15
+ W=0.42 AS=0.0567 AD=0.06615 PS=0.69 PD=0.735
M$5497 VPB|VPWR A2|C|X \$7404 VPB|VPWR sky130_fd_pr__pfet_01v8_hvt L=0.15
+ W=0.42 AS=0.142225 AD=0.06615 PS=1.335 PD=0.735
M$5498 VPB|VPWR \$7404 A1|A3|X VPB|VPWR sky130_fd_pr__pfet_01v8_hvt L=0.15 W=1
+ AS=0.142225 AD=0.26 PS=1.335 PD=2.52
M$5499 \$7407 A|A0|B|Y \$7626 VPB|VPWR sky130_fd_pr__pfet_01v8_hvt L=0.15
+ W=0.42 AS=0.1092 AD=0.0441 PS=1.36 PD=0.63
M$5500 \$7626 B|C|SLEEP|Y VPB|VPWR VPB|VPWR sky130_fd_pr__pfet_01v8_hvt L=0.15
+ W=0.42 AS=0.0441 AD=0.14575 PS=0.63 PD=1.335
M$5501 VPB|VPWR \$7407 A2|X VPB|VPWR sky130_fd_pr__pfet_01v8_hvt L=0.15 W=1
+ AS=0.14575 AD=0.34 PS=1.335 PD=2.68
M$5504 \$7409 B|X \$7645 VPB|VPWR sky130_fd_pr__pfet_01v8_hvt L=0.15 W=1
+ AS=0.26 AD=0.135 PS=2.52 PD=1.27
M$5505 \$7645 A|X VPB|VPWR VPB|VPWR sky130_fd_pr__pfet_01v8_hvt L=0.15 W=1
+ AS=0.135 AD=0.135 PS=1.27 PD=1.27
M$5506 VPB|VPWR A|X \$7618 VPB|VPWR sky130_fd_pr__pfet_01v8_hvt L=0.15 W=1
+ AS=0.135 AD=0.135 PS=1.27 PD=1.27
M$5507 \$7618 B|X VPB|VPWR VPB|VPWR sky130_fd_pr__pfet_01v8_hvt L=0.15 W=1
+ AS=0.135 AD=0.26 PS=1.27 PD=2.52
M$5508 \$7618 \$7409 A|X VPB|VPWR sky130_fd_pr__pfet_01v8_hvt L=0.15 W=1
+ AS=0.26 AD=0.3 PS=2.52 PD=2.6
M$5512 VPB|VPWR A_N|B|B1|C|X A|A2|Y VPB|VPWR sky130_fd_pr__pfet_01v8_hvt L=0.15
+ W=1 AS=0.26 AD=0.135 PS=2.52 PD=1.27
M$5513 A|A2|Y A|A2|B|X VPB|VPWR VPB|VPWR sky130_fd_pr__pfet_01v8_hvt L=0.15 W=1
+ AS=0.135 AD=0.165 PS=1.27 PD=1.33
M$5514 VPB|VPWR A|A1|Y A|A2|Y VPB|VPWR sky130_fd_pr__pfet_01v8_hvt L=0.15 W=1
+ AS=0.165 AD=0.26 PS=1.33 PD=2.52
M$5515 \$7619 A|A2|B|X VPB|VPWR VPB|VPWR sky130_fd_pr__pfet_01v8_hvt L=0.15 W=1
+ AS=0.265 AD=0.1475 PS=2.53 PD=1.295
M$5516 VPB|VPWR A|A1|Y \$7619 VPB|VPWR sky130_fd_pr__pfet_01v8_hvt L=0.15 W=1
+ AS=0.1475 AD=0.14 PS=1.295 PD=1.28
M$5517 \$7619 A_N|B|B1|C|X A|B1|SLEEP|Y VPB|VPWR sky130_fd_pr__pfet_01v8_hvt
+ L=0.15 W=1 AS=0.14 AD=0.265 PS=1.28 PD=2.53
M$5519 \$7414 A|A2|Y VPB|VPWR VPB|VPWR sky130_fd_pr__pfet_01v8_hvt L=0.15
+ W=0.42 AS=0.1092 AD=0.1573 PS=1.36 PD=1.39
M$5520 VPB|VPWR A|B1|SLEEP|Y \$7644 VPB|VPWR sky130_fd_pr__pfet_01v8_hvt L=0.15
+ W=1 AS=0.1573 AD=0.105 PS=1.39 PD=1.21
M$5521 \$7644 \$7414 A|B|B_N|X VPB|VPWR sky130_fd_pr__pfet_01v8_hvt L=0.15 W=1
+ AS=0.105 AD=0.26 PS=1.21 PD=2.52
M$5522 VPB|VPWR B|Y \$7416 VPB|VPWR sky130_fd_pr__pfet_01v8_hvt L=0.15 W=1
+ AS=0.3 AD=0.135 PS=2.6 PD=1.27
M$5523 \$7416 A|B|C|Y VPB|VPWR VPB|VPWR sky130_fd_pr__pfet_01v8_hvt L=0.15 W=1
+ AS=0.135 AD=0.365 PS=1.27 PD=1.73
M$5524 VPB|VPWR A|B|C|Y \$7643 VPB|VPWR sky130_fd_pr__pfet_01v8_hvt L=0.15 W=1
+ AS=0.365 AD=0.105 PS=1.73 PD=1.21
M$5525 \$7643 B|Y A2|B|Y VPB|VPWR sky130_fd_pr__pfet_01v8_hvt L=0.15 W=1
+ AS=0.105 AD=0.165 PS=1.21 PD=1.33
M$5526 A2|B|Y \$7416 VPB|VPWR VPB|VPWR sky130_fd_pr__pfet_01v8_hvt L=0.15 W=1
+ AS=0.165 AD=0.36 PS=1.33 PD=2.72
M$5528 VPB|VPWR A2|B|Y \$7418 VPB|VPWR sky130_fd_pr__pfet_01v8_hvt L=0.15 W=1
+ AS=0.3 AD=0.135 PS=2.6 PD=1.27
M$5529 \$7418 A|A1|Y VPB|VPWR VPB|VPWR sky130_fd_pr__pfet_01v8_hvt L=0.15 W=1
+ AS=0.135 AD=0.365 PS=1.27 PD=1.73
M$5530 VPB|VPWR A|A1|Y \$7642 VPB|VPWR sky130_fd_pr__pfet_01v8_hvt L=0.15 W=1
+ AS=0.365 AD=0.105 PS=1.73 PD=1.21
M$5531 \$7642 A2|B|Y B|Y VPB|VPWR sky130_fd_pr__pfet_01v8_hvt L=0.15 W=1
+ AS=0.105 AD=0.165 PS=1.21 PD=1.33
M$5532 B|Y \$7418 VPB|VPWR VPB|VPWR sky130_fd_pr__pfet_01v8_hvt L=0.15 W=1
+ AS=0.165 AD=0.36 PS=1.33 PD=2.72
M$5534 A|Y B|Y \$7641 VPB|VPWR sky130_fd_pr__pfet_01v8_hvt L=0.15 W=1 AS=0.26
+ AD=0.105 PS=2.52 PD=1.21
M$5535 \$7641 A|X VPB|VPWR VPB|VPWR sky130_fd_pr__pfet_01v8_hvt L=0.15 W=1
+ AS=0.105 AD=0.26 PS=1.21 PD=2.52
M$5536 \$7420 B|Y \$7639 VPB|VPWR sky130_fd_pr__pfet_01v8_hvt L=0.15 W=1
+ AS=0.26 AD=0.135 PS=2.52 PD=1.27
M$5537 \$7639 A|X VPB|VPWR VPB|VPWR sky130_fd_pr__pfet_01v8_hvt L=0.15 W=1
+ AS=0.135 AD=0.135 PS=1.27 PD=1.27
M$5538 VPB|VPWR A|X \$7620 VPB|VPWR sky130_fd_pr__pfet_01v8_hvt L=0.15 W=1
+ AS=0.135 AD=0.135 PS=1.27 PD=1.27
M$5539 \$7620 B|Y VPB|VPWR VPB|VPWR sky130_fd_pr__pfet_01v8_hvt L=0.15 W=1
+ AS=0.135 AD=0.26 PS=1.27 PD=2.52
M$5540 \$7620 \$7420 A|B|X VPB|VPWR sky130_fd_pr__pfet_01v8_hvt L=0.15 W=1
+ AS=0.26 AD=0.3 PS=2.52 PD=2.6
M$5541 VPB|VPWR A|B|X A|A1|B|C|Y VPB|VPWR sky130_fd_pr__pfet_01v8_hvt L=0.15
+ W=1 AS=0.26 AD=0.135 PS=2.52 PD=1.27
M$5542 A|A1|B|C|Y B|C|Y VPB|VPWR VPB|VPWR sky130_fd_pr__pfet_01v8_hvt L=0.15
+ W=1 AS=0.135 AD=0.26 PS=1.27 PD=2.52
M$5543 \$7422 B|C|Y \$7627 VPB|VPWR sky130_fd_pr__pfet_01v8_hvt L=0.15 W=0.42
+ AS=0.1092 AD=0.0441 PS=1.36 PD=0.63
M$5544 \$7627 A|B|X \$7628 VPB|VPWR sky130_fd_pr__pfet_01v8_hvt L=0.15 W=0.42
+ AS=0.0441 AD=0.0693 PS=0.63 PD=0.75
M$5545 \$7628 A|Y VPB|VPWR VPB|VPWR sky130_fd_pr__pfet_01v8_hvt L=0.15 W=0.42
+ AS=0.0693 AD=0.14825 PS=0.75 PD=1.34
M$5546 VPB|VPWR \$7422 A|X VPB|VPWR sky130_fd_pr__pfet_01v8_hvt L=0.15 W=1
+ AS=0.14825 AD=0.28 PS=1.34 PD=2.56
M$5548 A|A2|B|Y A|B|B1|Y VPB|VPWR VPB|VPWR sky130_fd_pr__pfet_01v8_hvt L=0.15
+ W=1 AS=0.135 AD=0.165 PS=1.27 PD=1.33
M$5549 VPB|VPWR A|X A|A2|B|Y VPB|VPWR sky130_fd_pr__pfet_01v8_hvt L=0.15 W=1
+ AS=0.165 AD=0.26 PS=1.33 PD=2.52
M$5551 \$7423 A|A2|B|Y \$7638 VPB|VPWR sky130_fd_pr__pfet_01v8_hvt L=0.15 W=1
+ AS=0.26 AD=0.135 PS=2.52 PD=1.27
M$5552 \$7638 A|A1|Y VPB|VPWR VPB|VPWR sky130_fd_pr__pfet_01v8_hvt L=0.15 W=1
+ AS=0.135 AD=0.135 PS=1.27 PD=1.27
M$5553 VPB|VPWR A|A1|Y \$7621 VPB|VPWR sky130_fd_pr__pfet_01v8_hvt L=0.15 W=1
+ AS=0.135 AD=0.135 PS=1.27 PD=1.27
M$5554 \$7621 A|A2|B|Y VPB|VPWR VPB|VPWR sky130_fd_pr__pfet_01v8_hvt L=0.15 W=1
+ AS=0.135 AD=0.26 PS=1.27 PD=2.52
M$5555 \$7621 \$7423 A|B|C|X VPB|VPWR sky130_fd_pr__pfet_01v8_hvt L=0.15 W=1
+ AS=0.26 AD=0.3 PS=2.52 PD=2.6
M$5556 VPB|VPWR A2|B|C|Y \$7425 VPB|VPWR sky130_fd_pr__pfet_01v8_hvt L=0.15
+ W=0.42 AS=0.142225 AD=0.06615 PS=1.335 PD=0.735
M$5557 \$7425 A|A2|B|C_N|Y VPB|VPWR VPB|VPWR sky130_fd_pr__pfet_01v8_hvt L=0.15
+ W=0.42 AS=0.06615 AD=0.0567 PS=0.735 PD=0.69
M$5558 VPB|VPWR A|A1|Y \$7425 VPB|VPWR sky130_fd_pr__pfet_01v8_hvt L=0.15
+ W=0.42 AS=0.0567 AD=0.1092 PS=0.69 PD=1.36
M$5559 A|B1_N|X \$7425 VPB|VPWR VPB|VPWR sky130_fd_pr__pfet_01v8_hvt L=0.15 W=1
+ AS=0.26 AD=0.142225 PS=2.52 PD=1.335
M$5561 VPB|VPWR A|B|C|X A|A1|Y VPB|VPWR sky130_fd_pr__pfet_01v8_hvt L=0.15 W=1
+ AS=0.26 AD=0.135 PS=2.52 PD=1.27
M$5562 A|A1|Y A|B1|Y VPB|VPWR VPB|VPWR sky130_fd_pr__pfet_01v8_hvt L=0.15 W=1
+ AS=0.135 AD=0.26 PS=1.27 PD=2.52
M$5563 \$7426 A|A1|X VPB|VPWR VPB|VPWR sky130_fd_pr__pfet_01v8_hvt L=0.15
+ W=0.42 AS=0.1092 AD=0.0567 PS=1.36 PD=0.69
M$5564 VPB|VPWR A|A2|B|Y \$7426 VPB|VPWR sky130_fd_pr__pfet_01v8_hvt L=0.15
+ W=0.42 AS=0.0567 AD=0.06615 PS=0.69 PD=0.735
M$5565 VPB|VPWR A|B|C|X \$7426 VPB|VPWR sky130_fd_pr__pfet_01v8_hvt L=0.15
+ W=0.42 AS=0.142225 AD=0.06615 PS=1.335 PD=0.735
M$5566 VPB|VPWR \$7426 B|C|X VPB|VPWR sky130_fd_pr__pfet_01v8_hvt L=0.15 W=1
+ AS=0.142225 AD=0.26 PS=1.335 PD=2.52
M$5567 VPB|VPWR B|Y \$7428 VPB|VPWR sky130_fd_pr__pfet_01v8_hvt L=0.15 W=1
+ AS=0.3 AD=0.135 PS=2.6 PD=1.27
M$5568 \$7428 A|B|C|X VPB|VPWR VPB|VPWR sky130_fd_pr__pfet_01v8_hvt L=0.15 W=1
+ AS=0.135 AD=0.365 PS=1.27 PD=1.73
M$5569 VPB|VPWR A|B|C|X \$7637 VPB|VPWR sky130_fd_pr__pfet_01v8_hvt L=0.15 W=1
+ AS=0.365 AD=0.105 PS=1.73 PD=1.21
M$5570 \$7637 B|Y B|B_N|Y VPB|VPWR sky130_fd_pr__pfet_01v8_hvt L=0.15 W=1
+ AS=0.105 AD=0.165 PS=1.21 PD=1.33
M$5571 B|B_N|Y \$7428 VPB|VPWR VPB|VPWR sky130_fd_pr__pfet_01v8_hvt L=0.15 W=1
+ AS=0.165 AD=0.36 PS=1.33 PD=2.72
M$5572 \$7430 B|B_N|Y VPB|VPWR VPB|VPWR sky130_fd_pr__pfet_01v8_hvt L=0.15
+ W=0.42 AS=0.1092 AD=0.1573 PS=1.36 PD=1.39
M$5573 VPB|VPWR A|Y \$7636 VPB|VPWR sky130_fd_pr__pfet_01v8_hvt L=0.15 W=1
+ AS=0.1573 AD=0.105 PS=1.39 PD=1.21
M$5574 \$7636 \$7430 A|Y VPB|VPWR sky130_fd_pr__pfet_01v8_hvt L=0.15 W=1
+ AS=0.105 AD=0.26 PS=1.21 PD=2.52
M$5575 \$7431 B|B_N|Y \$7635 VPB|VPWR sky130_fd_pr__pfet_01v8_hvt L=0.15 W=1
+ AS=0.26 AD=0.135 PS=2.52 PD=1.27
M$5576 \$7635 A|Y VPB|VPWR VPB|VPWR sky130_fd_pr__pfet_01v8_hvt L=0.15 W=1
+ AS=0.135 AD=0.135 PS=1.27 PD=1.27
M$5577 VPB|VPWR A|Y \$7622 VPB|VPWR sky130_fd_pr__pfet_01v8_hvt L=0.15 W=1
+ AS=0.135 AD=0.135 PS=1.27 PD=1.27
M$5578 \$7622 B|B_N|Y VPB|VPWR VPB|VPWR sky130_fd_pr__pfet_01v8_hvt L=0.15 W=1
+ AS=0.135 AD=0.26 PS=1.27 PD=2.52
M$5579 \$7622 \$7431 C|X VPB|VPWR sky130_fd_pr__pfet_01v8_hvt L=0.15 W=1
+ AS=0.26 AD=0.3 PS=2.52 PD=2.6
M$5581 \$7323 CLK|TICK VPB|VPWR VPB|VPWR sky130_fd_pr__pfet_01v8_hvt L=0.15
+ W=0.64 AS=0.1664 AD=0.0864 PS=1.8 PD=0.91
M$5582 VPB|VPWR \$7323 \$7324 VPB|VPWR sky130_fd_pr__pfet_01v8_hvt L=0.15
+ W=0.64 AS=0.0864 AD=0.1664 PS=0.91 PD=1.8
M$5583 VPB|VPWR C|X \$7434 VPB|VPWR sky130_fd_pr__pfet_01v8_hvt L=0.15 W=0.64
+ AS=0.2115 AD=0.1792 PS=1.45 PD=1.84
M$5584 D|X \$7433 VPB|VPWR VPB|VPWR sky130_fd_pr__pfet_01v8_hvt L=0.15 W=1
+ AS=0.28 AD=0.2115 PS=2.56 PD=1.45
M$5585 VPB|VPWR B|X \$7437 VPB|VPWR sky130_fd_pr__pfet_01v8_hvt L=0.15 W=1
+ AS=0.26 AD=0.2526 PS=2.52 PD=2.52
M$5586 \$7436 \$7437 \$7439 VPB|VPWR sky130_fd_pr__pfet_01v8_hvt L=0.15 W=0.64
+ AS=0.2452 AD=0.246 PS=1.45 PD=1.525
M$5587 \$7439 B|X \$7435 VPB|VPWR sky130_fd_pr__pfet_01v8_hvt L=0.15 W=0.64
+ AS=0.246 AD=0.1458 PS=1.525 PD=1.205
M$5588 \$7438 B|X \$7436 VPB|VPWR sky130_fd_pr__pfet_01v8_hvt L=0.15 W=0.84
+ AS=0.3536 AD=0.2452 PS=2.53 PD=1.45
M$5589 \$7438 \$7437 \$7435 VPB|VPWR sky130_fd_pr__pfet_01v8_hvt L=0.15 W=0.84
+ AS=0.1715 AD=0.1458 PS=1.355 PD=1.205
M$5590 \$7438 A|Q VPB|VPWR VPB|VPWR sky130_fd_pr__pfet_01v8_hvt L=0.15 W=1
+ AS=0.1715 AD=0.135 PS=1.355 PD=1.27
M$5591 VPB|VPWR \$7438 \$7439 VPB|VPWR sky130_fd_pr__pfet_01v8_hvt L=0.15 W=1
+ AS=0.135 AD=0.285 PS=1.27 PD=2.57
M$5592 A|Q \$7440 VPB|VPWR VPB|VPWR sky130_fd_pr__pfet_01v8_hvt L=0.15 W=1
+ AS=0.26 AD=0.3012 PS=2.52 PD=2.66
M$5603 A1|Y A|A0|B|Y \$7903 VPB|VPWR sky130_fd_pr__pfet_01v8_hvt L=0.15 W=1
+ AS=0.26 AD=0.105 PS=2.52 PD=1.21
M$5604 \$7903 A|Y VPB|VPWR VPB|VPWR sky130_fd_pr__pfet_01v8_hvt L=0.15 W=1
+ AS=0.105 AD=0.26 PS=1.21 PD=2.52
M$5607 VPB|VPWR A|B|Y \$7717 VPB|VPWR sky130_fd_pr__pfet_01v8_hvt L=0.15 W=1
+ AS=0.3 AD=0.135 PS=2.6 PD=1.27
M$5608 \$7717 A|B1|X VPB|VPWR VPB|VPWR sky130_fd_pr__pfet_01v8_hvt L=0.15 W=1
+ AS=0.135 AD=0.365 PS=1.27 PD=1.73
M$5609 VPB|VPWR A|B1|X \$7904 VPB|VPWR sky130_fd_pr__pfet_01v8_hvt L=0.15 W=1
+ AS=0.365 AD=0.105 PS=1.73 PD=1.21
M$5610 \$7904 A|B|Y A|A1|B|Y VPB|VPWR sky130_fd_pr__pfet_01v8_hvt L=0.15 W=1
+ AS=0.105 AD=0.165 PS=1.21 PD=1.33
M$5611 A|A1|B|Y \$7717 VPB|VPWR VPB|VPWR sky130_fd_pr__pfet_01v8_hvt L=0.15 W=1
+ AS=0.165 AD=0.36 PS=1.33 PD=2.72
M$5612 VPB|VPWR A1|Y \$7675 VPB|VPWR sky130_fd_pr__pfet_01v8_hvt L=0.15 W=0.64
+ AS=0.1696 AD=0.0768 PS=1.81 PD=0.88
M$5613 \$7675 A2|D|Y B|C|SLEEP|Y VPB|VPWR sky130_fd_pr__pfet_01v8_hvt L=0.15
+ W=0.64 AS=0.0768 AD=0.0896 PS=0.88 PD=0.92
M$5614 B|C|SLEEP|Y A|B1|Y VPB|VPWR VPB|VPWR sky130_fd_pr__pfet_01v8_hvt L=0.15
+ W=0.64 AS=0.0896 AD=0.1824 PS=0.92 PD=1.85
M$5616 \$7649 A2|C|X VPB|VPWR VPB|VPWR sky130_fd_pr__pfet_01v8_hvt L=0.15 W=1
+ AS=0.265 AD=0.14 PS=2.53 PD=1.28
M$5617 VPB|VPWR A1|B|Y \$7649 VPB|VPWR sky130_fd_pr__pfet_01v8_hvt L=0.15 W=1
+ AS=0.14 AD=0.1375 PS=1.28 PD=1.275
M$5618 \$7649 B1|X \$7650 VPB|VPWR sky130_fd_pr__pfet_01v8_hvt L=0.15 W=1
+ AS=0.1375 AD=0.26 PS=1.275 PD=2.52
M$5619 VPB|VPWR \$7650 A2|A3|C|X VPB|VPWR sky130_fd_pr__pfet_01v8_hvt L=0.15
+ W=1 AS=0.26 AD=0.26 PS=2.52 PD=2.52
M$5620 VPB|VPWR A|S|Y \$7905 VPB|VPWR sky130_fd_pr__pfet_01v8_hvt L=0.15 W=1
+ AS=0.26 AD=0.105 PS=2.52 PD=1.21
M$5621 \$7905 A|A0|B|Y A|Y VPB|VPWR sky130_fd_pr__pfet_01v8_hvt L=0.15 W=1
+ AS=0.105 AD=0.26 PS=1.21 PD=2.52
M$5622 VPB|VPWR A|A1|B|Y \$7677 VPB|VPWR sky130_fd_pr__pfet_01v8_hvt L=0.15 W=1
+ AS=0.28 AD=0.175 PS=2.56 PD=1.35
M$5623 \$7677 A2|X \$7678 VPB|VPWR sky130_fd_pr__pfet_01v8_hvt L=0.15 W=1
+ AS=0.175 AD=0.135 PS=1.35 PD=1.27
M$5624 \$7678 A1|A3|X \$7679 VPB|VPWR sky130_fd_pr__pfet_01v8_hvt L=0.15 W=1
+ AS=0.135 AD=0.3125 PS=1.27 PD=1.625
M$5625 \$7679 A2|A4|Y B|SLEEP|Y VPB|VPWR sky130_fd_pr__pfet_01v8_hvt L=0.15 W=1
+ AS=0.3125 AD=0.135 PS=1.625 PD=1.27
M$5626 B|SLEEP|Y A|B1|X VPB|VPWR VPB|VPWR sky130_fd_pr__pfet_01v8_hvt L=0.15
+ W=4 AS=0.9625 AD=1.2125 PS=6.925 PD=9.425
M$5629 B|X \$7723 VPB|VPWR VPB|VPWR sky130_fd_pr__pfet_01v8_hvt L=0.15 W=1
+ AS=0.265 AD=0.1725 PS=2.53 PD=1.345
M$5630 VPB|VPWR A2|A3|C|X \$7894 VPB|VPWR sky130_fd_pr__pfet_01v8_hvt L=0.15
+ W=1 AS=0.1725 AD=0.16 PS=1.345 PD=1.32
M$5631 \$7894 A1|A2|B|Y VPB|VPWR VPB|VPWR sky130_fd_pr__pfet_01v8_hvt L=0.15
+ W=1 AS=0.16 AD=0.165 PS=1.32 PD=1.33
M$5632 VPB|VPWR A1|X \$7894 VPB|VPWR sky130_fd_pr__pfet_01v8_hvt L=0.15 W=1
+ AS=0.165 AD=0.165 PS=1.33 PD=1.33
M$5633 \$7894 B1|Y \$7723 VPB|VPWR sky130_fd_pr__pfet_01v8_hvt L=0.15 W=1
+ AS=0.165 AD=0.32 PS=1.33 PD=2.64
M$5635 VPB|VPWR A|X \$7411 VPB|VPWR sky130_fd_pr__pfet_01v8_hvt L=0.15 W=0.42
+ AS=0.1113 AD=0.0609 PS=1.37 PD=0.71
M$5636 VPB|VPWR B|X \$7411 VPB|VPWR sky130_fd_pr__pfet_01v8_hvt L=0.15 W=0.42
+ AS=0.1841 AD=0.0609 PS=1.26 PD=0.71
M$5637 VPB|VPWR \$7411 A|B|X VPB|VPWR sky130_fd_pr__pfet_01v8_hvt L=0.15 W=0.64
+ AS=0.1841 AD=0.1696 PS=1.26 PD=1.81
M$5638 VPB|VPWR B|X \$7655 VPB|VPWR sky130_fd_pr__pfet_01v8_hvt L=0.15 W=1
+ AS=0.3 AD=0.135 PS=2.6 PD=1.27
M$5639 \$7655 A|X VPB|VPWR VPB|VPWR sky130_fd_pr__pfet_01v8_hvt L=0.15 W=1
+ AS=0.135 AD=0.365 PS=1.27 PD=1.73
M$5640 VPB|VPWR A|X \$7681 VPB|VPWR sky130_fd_pr__pfet_01v8_hvt L=0.15 W=1
+ AS=0.365 AD=0.105 PS=1.73 PD=1.21
M$5641 \$7681 B|X A|Y VPB|VPWR sky130_fd_pr__pfet_01v8_hvt L=0.15 W=1 AS=0.105
+ AD=0.165 PS=1.21 PD=1.33
M$5642 A|Y \$7655 VPB|VPWR VPB|VPWR sky130_fd_pr__pfet_01v8_hvt L=0.15 W=1
+ AS=0.165 AD=0.36 PS=1.33 PD=2.72
M$5645 VPB|VPWR A|Y C_N|Y VPB|VPWR sky130_fd_pr__pfet_01v8_hvt L=0.15 W=1
+ AS=0.26 AD=0.135 PS=2.52 PD=1.27
M$5646 C_N|Y B|X VPB|VPWR VPB|VPWR sky130_fd_pr__pfet_01v8_hvt L=0.15 W=1
+ AS=0.135 AD=0.26 PS=1.27 PD=2.52
M$5647 VPB|VPWR A|Y \$7682 VPB|VPWR sky130_fd_pr__pfet_01v8_hvt L=0.15 W=1
+ AS=0.26 AD=0.105 PS=2.52 PD=1.21
M$5648 \$7682 B|X A|D|Y VPB|VPWR sky130_fd_pr__pfet_01v8_hvt L=0.15 W=1
+ AS=0.105 AD=0.26 PS=1.21 PD=2.52
M$5649 VPB|VPWR C_N|Y \$7659 VPB|VPWR sky130_fd_pr__pfet_01v8_hvt L=0.15 W=0.42
+ AS=0.1092 AD=0.1092 PS=1.36 PD=1.36
M$5650 \$7661 \$7659 \$7685 VPB|VPWR sky130_fd_pr__pfet_01v8_hvt L=0.15 W=0.42
+ AS=0.1092 AD=0.0441 PS=1.36 PD=0.63
M$5651 \$7685 B|C|X \$7684 VPB|VPWR sky130_fd_pr__pfet_01v8_hvt L=0.15 W=0.42
+ AS=0.0441 AD=0.06825 PS=0.63 PD=0.745
M$5652 VPB|VPWR A|D|Y \$7684 VPB|VPWR sky130_fd_pr__pfet_01v8_hvt L=0.15 W=0.42
+ AS=0.14825 AD=0.06825 PS=1.34 PD=0.745
M$5653 VPB|VPWR \$7661 A|A2|B|X VPB|VPWR sky130_fd_pr__pfet_01v8_hvt L=0.15 W=1
+ AS=0.14825 AD=0.275 PS=1.34 PD=2.55
M$5654 VPB|VPWR A|D|Y A|A1|Y VPB|VPWR sky130_fd_pr__pfet_01v8_hvt L=0.15 W=1.68
+ AS=0.3318 AD=0.3486 PS=3.31 PD=3.35
M$5657 \$7662 A|A2|Y VPB|VPWR VPB|VPWR sky130_fd_pr__pfet_01v8_hvt L=0.15 W=1
+ AS=0.265 AD=0.1475 PS=2.53 PD=1.295
M$5658 VPB|VPWR A|A1|Y \$7662 VPB|VPWR sky130_fd_pr__pfet_01v8_hvt L=0.15 W=1
+ AS=0.1475 AD=0.14 PS=1.295 PD=1.28
M$5659 \$7662 A|B1|SLEEP|Y B|Y VPB|VPWR sky130_fd_pr__pfet_01v8_hvt L=0.15 W=1
+ AS=0.14 AD=0.265 PS=1.28 PD=2.53
M$5660 \$7664 A|A1|Y VPB|VPWR VPB|VPWR sky130_fd_pr__pfet_01v8_hvt L=0.15
+ W=0.42 AS=0.1092 AD=0.0567 PS=1.36 PD=0.69
M$5661 VPB|VPWR A|B|B_N|X \$7664 VPB|VPWR sky130_fd_pr__pfet_01v8_hvt L=0.15
+ W=0.42 AS=0.0567 AD=0.06615 PS=0.69 PD=0.735
M$5662 VPB|VPWR A|B|C|Y \$7664 VPB|VPWR sky130_fd_pr__pfet_01v8_hvt L=0.15
+ W=0.42 AS=0.142225 AD=0.06615 PS=1.335 PD=0.735
M$5663 VPB|VPWR \$7664 A|B1|X VPB|VPWR sky130_fd_pr__pfet_01v8_hvt L=0.15 W=1
+ AS=0.142225 AD=0.26 PS=1.335 PD=2.52
M$5667 VPB|VPWR A|B|B_N|X \$7665 VPB|VPWR sky130_fd_pr__pfet_01v8_hvt L=0.15
+ W=0.42 AS=0.1573 AD=0.1092 PS=1.39 PD=1.36
M$5668 VPB|VPWR A|B|X \$7690 VPB|VPWR sky130_fd_pr__pfet_01v8_hvt L=0.15 W=1
+ AS=0.1573 AD=0.105 PS=1.39 PD=1.21
M$5669 \$7690 \$7665 A|A1|Y VPB|VPWR sky130_fd_pr__pfet_01v8_hvt L=0.15 W=1
+ AS=0.105 AD=0.26 PS=1.21 PD=2.52
M$5670 VPB|VPWR B|Y \$7727 VPB|VPWR sky130_fd_pr__pfet_01v8_hvt L=0.15 W=1
+ AS=0.3 AD=0.135 PS=2.6 PD=1.27
M$5671 \$7727 A|B|B_N|X VPB|VPWR VPB|VPWR sky130_fd_pr__pfet_01v8_hvt L=0.15
+ W=1 AS=0.135 AD=0.365 PS=1.27 PD=1.73
M$5672 VPB|VPWR A|B|B_N|X \$7914 VPB|VPWR sky130_fd_pr__pfet_01v8_hvt L=0.15
+ W=1 AS=0.365 AD=0.105 PS=1.73 PD=1.21
M$5673 \$7914 B|Y A|C|SLEEP|Y VPB|VPWR sky130_fd_pr__pfet_01v8_hvt L=0.15 W=1
+ AS=0.105 AD=0.165 PS=1.21 PD=1.33
M$5674 A|C|SLEEP|Y \$7727 VPB|VPWR VPB|VPWR sky130_fd_pr__pfet_01v8_hvt L=0.15
+ W=1 AS=0.165 AD=0.36 PS=1.33 PD=2.72
M$5677 \$7731 A|B1|Y \$7915 VPB|VPWR sky130_fd_pr__pfet_01v8_hvt L=0.15 W=0.42
+ AS=0.1092 AD=0.0441 PS=1.36 PD=0.63
M$5678 \$7915 A|C|SLEEP|Y VPB|VPWR VPB|VPWR sky130_fd_pr__pfet_01v8_hvt L=0.15
+ W=0.42 AS=0.0441 AD=0.14575 PS=0.63 PD=1.335
M$5679 VPB|VPWR \$7731 A|X VPB|VPWR sky130_fd_pr__pfet_01v8_hvt L=0.15 W=1
+ AS=0.14575 AD=0.34 PS=1.335 PD=2.68
M$5680 VPB|VPWR A|A1|X \$7917 VPB|VPWR sky130_fd_pr__pfet_01v8_hvt L=0.15 W=1
+ AS=0.26 AD=0.135 PS=2.52 PD=1.27
M$5681 \$7917 A2|B|Y \$7918 VPB|VPWR sky130_fd_pr__pfet_01v8_hvt L=0.15 W=1
+ AS=0.135 AD=0.135 PS=1.27 PD=1.27
M$5682 \$7918 A|C|SLEEP|Y B|C|Y VPB|VPWR sky130_fd_pr__pfet_01v8_hvt L=0.15 W=1
+ AS=0.135 AD=0.26 PS=1.27 PD=2.52
M$5684 \$7735 B|Y \$7920 VPB|VPWR sky130_fd_pr__pfet_01v8_hvt L=0.15 W=1
+ AS=0.26 AD=0.135 PS=2.52 PD=1.27
M$5685 \$7920 A|C|SLEEP|Y VPB|VPWR VPB|VPWR sky130_fd_pr__pfet_01v8_hvt L=0.15
+ W=1 AS=0.135 AD=0.135 PS=1.27 PD=1.27
M$5686 VPB|VPWR A|C|SLEEP|Y \$7895 VPB|VPWR sky130_fd_pr__pfet_01v8_hvt L=0.15
+ W=1 AS=0.135 AD=0.135 PS=1.27 PD=1.27
M$5687 \$7895 B|Y VPB|VPWR VPB|VPWR sky130_fd_pr__pfet_01v8_hvt L=0.15 W=1
+ AS=0.135 AD=0.26 PS=1.27 PD=2.52
M$5688 \$7895 \$7735 A|B|C|X VPB|VPWR sky130_fd_pr__pfet_01v8_hvt L=0.15 W=1
+ AS=0.26 AD=0.3 PS=2.52 PD=2.6
M$5690 A|Y A|B|C|X \$7921 VPB|VPWR sky130_fd_pr__pfet_01v8_hvt L=0.15 W=1
+ AS=0.26 AD=0.105 PS=2.52 PD=1.21
M$5691 \$7921 A|B1|Y VPB|VPWR VPB|VPWR sky130_fd_pr__pfet_01v8_hvt L=0.15 W=1
+ AS=0.105 AD=0.26 PS=1.21 PD=2.52
M$5694 VPB|VPWR B|X \$7740 VPB|VPWR sky130_fd_pr__pfet_01v8_hvt L=0.15 W=1
+ AS=0.3 AD=0.135 PS=2.6 PD=1.27
M$5695 \$7740 A|A2|B|C_N|Y VPB|VPWR VPB|VPWR sky130_fd_pr__pfet_01v8_hvt L=0.15
+ W=1 AS=0.135 AD=0.365 PS=1.27 PD=1.73
M$5696 VPB|VPWR A|A2|B|C_N|Y \$7913 VPB|VPWR sky130_fd_pr__pfet_01v8_hvt L=0.15
+ W=1 AS=0.365 AD=0.105 PS=1.73 PD=1.21
M$5697 \$7913 B|X A|A2|B|Y VPB|VPWR sky130_fd_pr__pfet_01v8_hvt L=0.15 W=1
+ AS=0.105 AD=0.165 PS=1.21 PD=1.33
M$5698 A|A2|B|Y \$7740 VPB|VPWR VPB|VPWR sky130_fd_pr__pfet_01v8_hvt L=0.15 W=1
+ AS=0.165 AD=0.36 PS=1.33 PD=2.72
M$5702 \$7668 B|Y \$7692 VPB|VPWR sky130_fd_pr__pfet_01v8_hvt L=0.15 W=1
+ AS=0.26 AD=0.135 PS=2.52 PD=1.27
M$5703 \$7692 A|A2|B|Y VPB|VPWR VPB|VPWR sky130_fd_pr__pfet_01v8_hvt L=0.15 W=1
+ AS=0.135 AD=0.135 PS=1.27 PD=1.27
M$5704 VPB|VPWR A|A2|B|Y \$7670 VPB|VPWR sky130_fd_pr__pfet_01v8_hvt L=0.15 W=1
+ AS=0.135 AD=0.135 PS=1.27 PD=1.27
M$5705 \$7670 B|Y VPB|VPWR VPB|VPWR sky130_fd_pr__pfet_01v8_hvt L=0.15 W=1
+ AS=0.135 AD=0.26 PS=1.27 PD=2.52
M$5706 VPB|VPWR A|A1|X \$7912 VPB|VPWR sky130_fd_pr__pfet_01v8_hvt L=0.15 W=1
+ AS=0.26 AD=0.105 PS=2.52 PD=1.21
M$5707 \$7912 A|B|X B|Y VPB|VPWR sky130_fd_pr__pfet_01v8_hvt L=0.15 W=1
+ AS=0.105 AD=0.26 PS=1.21 PD=2.52
M$5708 \$7670 \$7668 B|C|X VPB|VPWR sky130_fd_pr__pfet_01v8_hvt L=0.15 W=1
+ AS=0.26 AD=0.3 PS=2.52 PD=2.6
M$5711 \$7436 C|X \$7433 VPB|VPWR sky130_fd_pr__pfet_01v8_hvt L=0.15 W=0.84
+ AS=0.2688 AD=0.1596 PS=2.32 PD=1.22
M$5712 \$7433 \$7434 \$7435 VPB|VPWR sky130_fd_pr__pfet_01v8_hvt L=0.15 W=0.84
+ AS=0.1596 AD=0.441 PS=1.22 PD=2.73
M$5713 VPB|VPWR C|X \$7689 VPB|VPWR sky130_fd_pr__pfet_01v8_hvt L=0.15 W=0.42
+ AS=0.2492 AD=0.0441 PS=1.565 PD=0.63
M$5714 \$7689 B|X \$7671 VPB|VPWR sky130_fd_pr__pfet_01v8_hvt L=0.15 W=0.42
+ AS=0.0441 AD=0.0567 PS=0.63 PD=0.69
M$5715 \$7671 B|X \$7688 VPB|VPWR sky130_fd_pr__pfet_01v8_hvt L=0.15 W=0.42
+ AS=0.0567 AD=0.0441 PS=0.69 PD=0.63
M$5716 \$7688 A|Q VPB|VPWR VPB|VPWR sky130_fd_pr__pfet_01v8_hvt L=0.15 W=0.42
+ AS=0.0441 AD=0.0567 PS=0.63 PD=0.69
M$5717 VPB|VPWR A|Q \$7687 VPB|VPWR sky130_fd_pr__pfet_01v8_hvt L=0.15 W=0.42
+ AS=0.0567 AD=0.0441 PS=0.69 PD=0.63
M$5718 \$7687 C|X \$7671 VPB|VPWR sky130_fd_pr__pfet_01v8_hvt L=0.15 W=0.42
+ AS=0.0441 AD=0.1092 PS=0.63 PD=1.36
M$5719 B|X \$7671 VPB|VPWR VPB|VPWR sky130_fd_pr__pfet_01v8_hvt L=0.15 W=1
+ AS=0.365 AD=0.2492 PS=2.73 PD=1.565
M$5720 VPB|VPWR B|C|X \$7672 VPB|VPWR sky130_fd_pr__pfet_01v8_hvt L=0.15 W=1
+ AS=0.3 AD=0.135 PS=2.6 PD=1.27
M$5721 \$7672 A|Q VPB|VPWR VPB|VPWR sky130_fd_pr__pfet_01v8_hvt L=0.15 W=1
+ AS=0.135 AD=0.365 PS=1.27 PD=1.73
M$5722 VPB|VPWR A|Q \$7683 VPB|VPWR sky130_fd_pr__pfet_01v8_hvt L=0.15 W=1
+ AS=0.365 AD=0.105 PS=1.73 PD=1.21
M$5723 \$7683 B|C|X B|Y VPB|VPWR sky130_fd_pr__pfet_01v8_hvt L=0.15 W=1
+ AS=0.105 AD=0.165 PS=1.21 PD=1.33
M$5724 B|Y \$7672 VPB|VPWR VPB|VPWR sky130_fd_pr__pfet_01v8_hvt L=0.15 W=1
+ AS=0.165 AD=0.36 PS=1.33 PD=2.72
M$5725 VPB|VPWR B|Y \$7743 VPB|VPWR sky130_fd_pr__pfet_01v8_hvt L=0.15 W=1
+ AS=0.3 AD=0.135 PS=2.6 PD=1.27
M$5726 \$7743 A|B|X VPB|VPWR VPB|VPWR sky130_fd_pr__pfet_01v8_hvt L=0.15 W=1
+ AS=0.135 AD=0.365 PS=1.27 PD=1.73
M$5727 VPB|VPWR A|B|X \$7909 VPB|VPWR sky130_fd_pr__pfet_01v8_hvt L=0.15 W=1
+ AS=0.365 AD=0.105 PS=1.73 PD=1.21
M$5728 \$7909 B|Y D|Y VPB|VPWR sky130_fd_pr__pfet_01v8_hvt L=0.15 W=1 AS=0.105
+ AD=0.165 PS=1.21 PD=1.33
M$5729 D|Y \$7743 VPB|VPWR VPB|VPWR sky130_fd_pr__pfet_01v8_hvt L=0.15 W=1
+ AS=0.165 AD=0.36 PS=1.33 PD=2.72
M$5730 VPB|VPWR \$7623 \$7440 VPB|VPWR sky130_fd_pr__pfet_01v8_hvt L=0.15
+ W=0.42 AS=0.1134 AD=0.0567 PS=1.38 PD=0.69
M$5731 \$7440 RESET_B|X VPB|VPWR VPB|VPWR sky130_fd_pr__pfet_01v8_hvt L=0.15
+ W=0.42 AS=0.0567 AD=0.0819 PS=0.69 PD=0.81
M$5732 VPB|VPWR \$7440 \$7632 VPB|VPWR sky130_fd_pr__pfet_01v8_hvt L=0.15
+ W=0.42 AS=0.0819 AD=0.0567 PS=0.81 PD=0.69
M$5733 \$7632 \$7442 \$7623 VPB|VPWR sky130_fd_pr__pfet_01v8_hvt L=0.15 W=0.42
+ AS=0.0567 AD=0.0588 PS=0.69 PD=0.7
M$5734 \$7443 \$7441 \$7623 VPB|VPWR sky130_fd_pr__pfet_01v8_hvt L=0.15 W=0.42
+ AS=0.12915 AD=0.0588 PS=1.185 PD=0.7
M$5735 \$7443 \$7444 VPB|VPWR VPB|VPWR sky130_fd_pr__pfet_01v8_hvt L=0.15
+ W=0.84 AS=0.12915 AD=0.2184 PS=1.185 PD=2.2
M$5737 \$7624 RESET_B|X VPB|VPWR VPB|VPWR sky130_fd_pr__pfet_01v8_hvt L=0.15
+ W=0.42 AS=0.1092 AD=0.07035 PS=1.36 PD=0.755
M$5738 VPB|VPWR \$7443 \$7624 VPB|VPWR sky130_fd_pr__pfet_01v8_hvt L=0.15
+ W=0.42 AS=0.07035 AD=0.1155 PS=0.755 PD=0.97
M$5739 \$7624 \$7441 \$7444 VPB|VPWR sky130_fd_pr__pfet_01v8_hvt L=0.15 W=0.42
+ AS=0.1155 AD=0.07245 PS=0.97 PD=0.765
M$5740 \$7444 \$7442 \$7445 VPB|VPWR sky130_fd_pr__pfet_01v8_hvt L=0.15 W=0.42
+ AS=0.07245 AD=0.0651 PS=0.765 PD=0.73
M$5741 \$7445 D|Y VPB|VPWR VPB|VPWR sky130_fd_pr__pfet_01v8_hvt L=0.15 W=0.42
+ AS=0.0651 AD=0.1092 PS=0.73 PD=1.36
M$5742 VPB|VPWR B|C|Y \$7745 VPB|VPWR sky130_fd_pr__pfet_01v8_hvt L=0.15 W=1
+ AS=0.3 AD=0.135 PS=2.6 PD=1.27
M$5743 \$7745 A|Q VPB|VPWR VPB|VPWR sky130_fd_pr__pfet_01v8_hvt L=0.15 W=1
+ AS=0.135 AD=0.365 PS=1.27 PD=1.73
M$5744 VPB|VPWR A|Q \$7908 VPB|VPWR sky130_fd_pr__pfet_01v8_hvt L=0.15 W=1
+ AS=0.365 AD=0.105 PS=1.73 PD=1.21
M$5745 \$7908 B|C|Y B|Y VPB|VPWR sky130_fd_pr__pfet_01v8_hvt L=0.15 W=1
+ AS=0.105 AD=0.165 PS=1.21 PD=1.33
M$5746 B|Y \$7745 VPB|VPWR VPB|VPWR sky130_fd_pr__pfet_01v8_hvt L=0.15 W=1
+ AS=0.165 AD=0.36 PS=1.33 PD=2.72
M$5748 A|Q \$7749 VPB|VPWR VPB|VPWR sky130_fd_pr__pfet_01v8_hvt L=0.15 W=1
+ AS=0.26 AD=0.3012 PS=2.52 PD=2.66
M$5749 \$7442 \$7441 VPB|VPWR VPB|VPWR sky130_fd_pr__pfet_01v8_hvt L=0.15
+ W=0.64 AS=0.1664 AD=0.0864 PS=1.8 PD=0.91
M$5750 VPB|VPWR CLK|TICK \$7441 VPB|VPWR sky130_fd_pr__pfet_01v8_hvt L=0.15
+ W=0.64 AS=0.0864 AD=0.1664 PS=0.91 PD=1.8
M$5763 VPB|VPWR B1|X A1|A2|B|Y VPB|VPWR sky130_fd_pr__pfet_01v8_hvt L=0.15
+ W=0.64 AS=0.1824 AD=0.0896 PS=1.85 PD=0.92
M$5764 A1|A2|B|Y A2|A4|Y \$7907 VPB|VPWR sky130_fd_pr__pfet_01v8_hvt L=0.15
+ W=0.64 AS=0.0896 AD=0.0768 PS=0.92 PD=0.88
M$5765 \$7907 A1|A3|X VPB|VPWR VPB|VPWR sky130_fd_pr__pfet_01v8_hvt L=0.15
+ W=0.64 AS=0.0768 AD=0.1696 PS=0.88 PD=1.81
M$5783 B|Y A2|B|Y \$7919 VPB|VPWR sky130_fd_pr__pfet_01v8_hvt L=0.15 W=0.64
+ AS=0.0896 AD=0.0768 PS=0.92 PD=0.88
M$5784 \$7919 A|A1|X VPB|VPWR VPB|VPWR sky130_fd_pr__pfet_01v8_hvt L=0.15
+ W=0.64 AS=0.0768 AD=0.1696 PS=0.88 PD=1.81
M$5793 \$7751 \$7750 VPB|VPWR VPB|VPWR sky130_fd_pr__pfet_01v8_hvt L=0.15
+ W=0.64 AS=0.1664 AD=0.0864 PS=1.8 PD=0.91
M$5794 VPB|VPWR CLK|TICK \$7750 VPB|VPWR sky130_fd_pr__pfet_01v8_hvt L=0.15
+ W=0.64 AS=0.0864 AD=0.1664 PS=0.91 PD=1.8
M$5805 \$7922 A|A0|B|Y \$7964 VPB|VPWR sky130_fd_pr__pfet_01v8_hvt L=0.15 W=1
+ AS=0.26 AD=0.135 PS=2.52 PD=1.27
M$5806 \$7964 A|Y VPB|VPWR VPB|VPWR sky130_fd_pr__pfet_01v8_hvt L=0.15 W=1
+ AS=0.135 AD=0.135 PS=1.27 PD=1.27
M$5807 VPB|VPWR A|Y \$7923 VPB|VPWR sky130_fd_pr__pfet_01v8_hvt L=0.15 W=1
+ AS=0.135 AD=0.135 PS=1.27 PD=1.27
M$5808 \$7923 A|A0|B|Y VPB|VPWR VPB|VPWR sky130_fd_pr__pfet_01v8_hvt L=0.15 W=1
+ AS=0.135 AD=0.26 PS=1.27 PD=2.52
M$5809 \$7923 \$7922 A1|B|C|X VPB|VPWR sky130_fd_pr__pfet_01v8_hvt L=0.15 W=1
+ AS=0.26 AD=0.3 PS=2.52 PD=2.6
M$5813 VPB|VPWR B|Y A|S|Y VPB|VPWR sky130_fd_pr__pfet_01v8_hvt L=0.15 W=1
+ AS=0.26 AD=0.135 PS=2.52 PD=1.27
M$5814 A|S|Y A|B1|X VPB|VPWR VPB|VPWR sky130_fd_pr__pfet_01v8_hvt L=0.15 W=1
+ AS=0.135 AD=0.26 PS=1.27 PD=2.52
M$5816 VPB|VPWR A|A1|B|Y \$7927 VPB|VPWR sky130_fd_pr__pfet_01v8_hvt L=0.15 W=1
+ AS=0.3 AD=0.135 PS=2.6 PD=1.27
M$5817 \$7927 A|B1|X VPB|VPWR VPB|VPWR sky130_fd_pr__pfet_01v8_hvt L=0.15 W=1
+ AS=0.135 AD=0.365 PS=1.27 PD=1.73
M$5818 VPB|VPWR A|B1|X \$7968 VPB|VPWR sky130_fd_pr__pfet_01v8_hvt L=0.15 W=1
+ AS=0.365 AD=0.105 PS=1.73 PD=1.21
M$5819 \$7968 A|A1|B|Y A|B|Y VPB|VPWR sky130_fd_pr__pfet_01v8_hvt L=0.15 W=1
+ AS=0.105 AD=0.165 PS=1.21 PD=1.33
M$5820 A|B|Y \$7927 VPB|VPWR VPB|VPWR sky130_fd_pr__pfet_01v8_hvt L=0.15 W=1
+ AS=0.165 AD=0.36 PS=1.33 PD=2.72
M$5822 VPB|VPWR A|B1|Y A|B1|Y VPB|VPWR sky130_fd_pr__pfet_01v8_hvt L=0.15
+ W=1.68 AS=0.3318 AD=0.3486 PS=3.31 PD=3.35
M$5824 \$7931 A2|A3|C|X VPB|VPWR VPB|VPWR sky130_fd_pr__pfet_01v8_hvt L=0.15
+ W=1 AS=0.265 AD=0.1475 PS=2.53 PD=1.295
M$5825 VPB|VPWR A1|A2|B|Y \$7931 VPB|VPWR sky130_fd_pr__pfet_01v8_hvt L=0.15
+ W=1 AS=0.1475 AD=0.14 PS=1.295 PD=1.28
M$5826 \$7931 A|B1|Y A3|B1|Y VPB|VPWR sky130_fd_pr__pfet_01v8_hvt L=0.15 W=1
+ AS=0.14 AD=0.265 PS=1.28 PD=2.53
M$5827 VPB|VPWR A|A1|Y \$7969 VPB|VPWR sky130_fd_pr__pfet_01v8_hvt L=0.15 W=1
+ AS=0.27 AD=0.105 PS=2.54 PD=1.21
M$5828 \$7969 A2|X A2|A3|C|Y VPB|VPWR sky130_fd_pr__pfet_01v8_hvt L=0.15 W=1
+ AS=0.105 AD=0.2325 PS=1.21 PD=1.465
M$5829 A2|A3|C|Y A4|B2|X \$7970 VPB|VPWR sky130_fd_pr__pfet_01v8_hvt L=0.15 W=1
+ AS=0.2325 AD=0.1125 PS=1.465 PD=1.225
M$5830 \$7970 A3|B1|Y VPB|VPWR VPB|VPWR sky130_fd_pr__pfet_01v8_hvt L=0.15 W=1
+ AS=0.1125 AD=0.26 PS=1.225 PD=2.52
M$5831 VPB|VPWR A2|A3|C|X A1|A2|B|Y VPB|VPWR sky130_fd_pr__pfet_01v8_hvt L=0.15
+ W=1 AS=0.26 AD=0.135 PS=2.52 PD=1.27
M$5832 A1|A2|B|Y A1|A2|B|Y VPB|VPWR VPB|VPWR sky130_fd_pr__pfet_01v8_hvt L=0.15
+ W=1 AS=0.135 AD=0.165 PS=1.27 PD=1.33
M$5833 VPB|VPWR A|Y A1|A2|B|Y VPB|VPWR sky130_fd_pr__pfet_01v8_hvt L=0.15 W=1
+ AS=0.165 AD=0.26 PS=1.33 PD=2.52
M$5835 \$7939 \$7996 \$7940 VPB|VPWR sky130_fd_pr__pfet_01v8_hvt L=0.15 W=0.84
+ AS=0.1715 AD=0.1458 PS=1.355 PD=1.205
M$5836 \$7940 B|X \$7938 VPB|VPWR sky130_fd_pr__pfet_01v8_hvt L=0.15 W=0.64
+ AS=0.1458 AD=0.246 PS=1.205 PD=1.525
M$5837 \$7938 \$7939 VPB|VPWR VPB|VPWR sky130_fd_pr__pfet_01v8_hvt L=0.15 W=1
+ AS=0.285 AD=0.135 PS=2.57 PD=1.27
M$5838 VPB|VPWR A|Y \$7939 VPB|VPWR sky130_fd_pr__pfet_01v8_hvt L=0.15 W=1
+ AS=0.135 AD=0.1715 PS=1.27 PD=1.355
M$5839 \$7941 \$7996 \$7938 VPB|VPWR sky130_fd_pr__pfet_01v8_hvt L=0.15 W=0.64
+ AS=0.2431 AD=0.246 PS=1.445 PD=1.525
M$5840 \$7941 B|X \$7939 VPB|VPWR sky130_fd_pr__pfet_01v8_hvt L=0.15 W=0.84
+ AS=0.2431 AD=0.3528 PS=1.445 PD=2.52
M$5841 \$7996 B|X VPB|VPWR VPB|VPWR sky130_fd_pr__pfet_01v8_hvt L=0.15 W=1
+ AS=0.26 AD=0.25655 PS=2.52 PD=2.52
M$5842 VPB|VPWR B|C|X \$7943 VPB|VPWR sky130_fd_pr__pfet_01v8_hvt L=0.15 W=0.64
+ AS=0.169 AD=0.1792 PS=1.365 PD=1.84
M$5843 VPB|VPWR \$7942 A|B1|X VPB|VPWR sky130_fd_pr__pfet_01v8_hvt L=0.15 W=1
+ AS=0.169 AD=0.28 PS=1.365 PD=2.56
M$5845 VPB|VPWR A|A1|Y \$7974 VPB|VPWR sky130_fd_pr__pfet_01v8_hvt L=0.15 W=1
+ AS=0.26 AD=0.135 PS=2.52 PD=1.27
M$5846 \$7974 A2|SLEEP|X \$7975 VPB|VPWR sky130_fd_pr__pfet_01v8_hvt L=0.15 W=1
+ AS=0.135 AD=0.135 PS=1.27 PD=1.27
M$5847 \$7975 A2|A3|X B|Y VPB|VPWR sky130_fd_pr__pfet_01v8_hvt L=0.15 W=1
+ AS=0.135 AD=0.3925 PS=1.27 PD=1.785
M$5848 B|Y A|B1|C1|X VPB|VPWR VPB|VPWR sky130_fd_pr__pfet_01v8_hvt L=0.15 W=2
+ AS=0.785 AD=0.6 PS=3.57 PD=5.2
M$5853 B|Y A2|B|Y \$7979 VPB|VPWR sky130_fd_pr__pfet_01v8_hvt L=0.15 W=0.64
+ AS=0.0896 AD=0.0768 PS=0.92 PD=0.88
M$5854 \$7979 A|A1|X VPB|VPWR VPB|VPWR sky130_fd_pr__pfet_01v8_hvt L=0.15
+ W=0.64 AS=0.0768 AD=0.1696 PS=0.88 PD=1.81
M$5857 A|A1|B1|Y A|B|C|X \$7980 VPB|VPWR sky130_fd_pr__pfet_01v8_hvt L=0.15 W=1
+ AS=0.26 AD=0.135 PS=2.52 PD=1.27
M$5858 \$7980 A2|B|Y \$7981 VPB|VPWR sky130_fd_pr__pfet_01v8_hvt L=0.15 W=1
+ AS=0.135 AD=0.135 PS=1.27 PD=1.27
M$5859 \$7981 A|A1|X VPB|VPWR VPB|VPWR sky130_fd_pr__pfet_01v8_hvt L=0.15 W=1
+ AS=0.135 AD=0.26 PS=1.27 PD=2.52
M$5860 VPB|VPWR B|Y \$7947 VPB|VPWR sky130_fd_pr__pfet_01v8_hvt L=0.15 W=1
+ AS=0.3 AD=0.135 PS=2.6 PD=1.27
M$5861 \$7947 A|B|C|X VPB|VPWR VPB|VPWR sky130_fd_pr__pfet_01v8_hvt L=0.15 W=1
+ AS=0.135 AD=0.365 PS=1.27 PD=1.73
M$5862 VPB|VPWR A|B|C|X \$7982 VPB|VPWR sky130_fd_pr__pfet_01v8_hvt L=0.15 W=1
+ AS=0.365 AD=0.105 PS=1.73 PD=1.21
M$5863 \$7982 B|Y A|A2|B|C_N|Y VPB|VPWR sky130_fd_pr__pfet_01v8_hvt L=0.15 W=1
+ AS=0.105 AD=0.165 PS=1.21 PD=1.33
M$5864 A|A2|B|C_N|Y \$7947 VPB|VPWR VPB|VPWR sky130_fd_pr__pfet_01v8_hvt L=0.15
+ W=1 AS=0.165 AD=0.36 PS=1.33 PD=2.72
M$5866 VPB|VPWR A|Y D_N|Y VPB|VPWR sky130_fd_pr__pfet_01v8_hvt L=0.15 W=1
+ AS=0.26 AD=0.135 PS=2.52 PD=1.27
M$5867 D_N|Y B|Y VPB|VPWR VPB|VPWR sky130_fd_pr__pfet_01v8_hvt L=0.15 W=1
+ AS=0.135 AD=0.26 PS=1.27 PD=2.52
M$5868 A|B1|Y \$7950 \$7984 VPB|VPWR sky130_fd_pr__pfet_01v8_hvt L=0.15 W=1
+ AS=0.2559 AD=0.135 PS=2.52 PD=1.27
M$5869 \$7984 \$7949 \$7985 VPB|VPWR sky130_fd_pr__pfet_01v8_hvt L=0.15 W=1
+ AS=0.135 AD=0.165 PS=1.27 PD=1.33
M$5870 \$7985 B|C|Y \$7986 VPB|VPWR sky130_fd_pr__pfet_01v8_hvt L=0.15 W=1
+ AS=0.165 AD=0.135 PS=1.33 PD=1.27
M$5871 \$7986 A|A1|Y VPB|VPWR VPB|VPWR sky130_fd_pr__pfet_01v8_hvt L=0.15 W=1
+ AS=0.135 AD=0.26 PS=1.27 PD=2.52
M$5872 A|A1|Y B|Y \$7987 VPB|VPWR sky130_fd_pr__pfet_01v8_hvt L=0.15 W=1
+ AS=0.26 AD=0.105 PS=2.52 PD=1.21
M$5873 \$7987 A|Y VPB|VPWR VPB|VPWR sky130_fd_pr__pfet_01v8_hvt L=0.15 W=1
+ AS=0.105 AD=0.26 PS=1.21 PD=2.52
M$5875 VPB|VPWR A|X \$7952 VPB|VPWR sky130_fd_pr__pfet_01v8_hvt L=0.15 W=0.42
+ AS=0.1573 AD=0.1092 PS=1.39 PD=1.36
M$5876 VPB|VPWR B|SLEEP|Y \$7989 VPB|VPWR sky130_fd_pr__pfet_01v8_hvt L=0.15
+ W=1 AS=0.1573 AD=0.105 PS=1.39 PD=1.21
M$5877 \$7989 \$7952 A|A1|X VPB|VPWR sky130_fd_pr__pfet_01v8_hvt L=0.15 W=1
+ AS=0.105 AD=0.26 PS=1.21 PD=2.52
M$5878 A|B|X \$7953 \$7990 VPB|VPWR sky130_fd_pr__pfet_01v8_hvt L=0.15 W=1
+ AS=0.26 AD=0.105 PS=2.52 PD=1.21
M$5879 \$7990 B|SLEEP|Y VPB|VPWR VPB|VPWR sky130_fd_pr__pfet_01v8_hvt L=0.15
+ W=1 AS=0.105 AD=0.1573 PS=1.21 PD=1.39
M$5880 VPB|VPWR A|Y \$7953 VPB|VPWR sky130_fd_pr__pfet_01v8_hvt L=0.15 W=0.42
+ AS=0.1573 AD=0.1092 PS=1.39 PD=1.36
M$5882 VPB|VPWR \$7955 D|Y VPB|VPWR sky130_fd_pr__pfet_01v8_hvt L=0.15 W=1
+ AS=0.36 AD=0.165 PS=2.72 PD=1.33
M$5883 D|Y B|Y \$7992 VPB|VPWR sky130_fd_pr__pfet_01v8_hvt L=0.15 W=1 AS=0.165
+ AD=0.105 PS=1.33 PD=1.21
M$5884 \$7992 A|B|X VPB|VPWR VPB|VPWR sky130_fd_pr__pfet_01v8_hvt L=0.15 W=1
+ AS=0.105 AD=0.365 PS=1.21 PD=1.73
M$5885 VPB|VPWR A|B|X \$7955 VPB|VPWR sky130_fd_pr__pfet_01v8_hvt L=0.15 W=1
+ AS=0.365 AD=0.135 PS=1.73 PD=1.27
M$5886 \$7955 B|Y VPB|VPWR VPB|VPWR sky130_fd_pr__pfet_01v8_hvt L=0.15 W=1
+ AS=0.135 AD=0.3 PS=1.27 PD=2.6
M$5888 VPB|VPWR B|C|Y \$7978 VPB|VPWR sky130_fd_pr__pfet_01v8_hvt L=0.15 W=0.42
+ AS=0.2492 AD=0.0441 PS=1.565 PD=0.63
M$5889 \$7978 A|B|X \$7960 VPB|VPWR sky130_fd_pr__pfet_01v8_hvt L=0.15 W=0.42
+ AS=0.0441 AD=0.0567 PS=0.63 PD=0.69
M$5890 \$7960 A|B|X \$7977 VPB|VPWR sky130_fd_pr__pfet_01v8_hvt L=0.15 W=0.42
+ AS=0.0567 AD=0.0441 PS=0.69 PD=0.63
M$5891 \$7977 A|Q VPB|VPWR VPB|VPWR sky130_fd_pr__pfet_01v8_hvt L=0.15 W=0.42
+ AS=0.0441 AD=0.0567 PS=0.63 PD=0.69
M$5892 VPB|VPWR A|Q \$7976 VPB|VPWR sky130_fd_pr__pfet_01v8_hvt L=0.15 W=0.42
+ AS=0.0567 AD=0.0441 PS=0.69 PD=0.63
M$5893 \$7976 B|C|Y \$7960 VPB|VPWR sky130_fd_pr__pfet_01v8_hvt L=0.15 W=0.42
+ AS=0.0441 AD=0.1092 PS=0.63 PD=1.36
M$5894 A|B|X \$7960 VPB|VPWR VPB|VPWR sky130_fd_pr__pfet_01v8_hvt L=0.15 W=1
+ AS=0.365 AD=0.2492 PS=2.73 PD=1.565
M$5896 VPB|VPWR \$7893 \$7749 VPB|VPWR sky130_fd_pr__pfet_01v8_hvt L=0.15
+ W=0.42 AS=0.1134 AD=0.0567 PS=1.38 PD=0.69
M$5897 \$7749 RESET_B|X VPB|VPWR VPB|VPWR sky130_fd_pr__pfet_01v8_hvt L=0.15
+ W=0.42 AS=0.0567 AD=0.0819 PS=0.69 PD=0.81
M$5898 VPB|VPWR \$7749 \$7906 VPB|VPWR sky130_fd_pr__pfet_01v8_hvt L=0.15
+ W=0.42 AS=0.0819 AD=0.0567 PS=0.81 PD=0.69
M$5899 \$7906 \$7751 \$7893 VPB|VPWR sky130_fd_pr__pfet_01v8_hvt L=0.15 W=0.42
+ AS=0.0567 AD=0.0588 PS=0.69 PD=0.7
M$5900 \$7752 \$7750 \$7893 VPB|VPWR sky130_fd_pr__pfet_01v8_hvt L=0.15 W=0.42
+ AS=0.12915 AD=0.0588 PS=1.185 PD=0.7
M$5901 \$7752 \$7753 VPB|VPWR VPB|VPWR sky130_fd_pr__pfet_01v8_hvt L=0.15
+ W=0.84 AS=0.12915 AD=0.2184 PS=1.185 PD=2.2
M$5902 VPB|VPWR B|Y \$7961 VPB|VPWR sky130_fd_pr__pfet_01v8_hvt L=0.15 W=1
+ AS=0.3 AD=0.135 PS=2.6 PD=1.27
M$5903 \$7961 A|B|X VPB|VPWR VPB|VPWR sky130_fd_pr__pfet_01v8_hvt L=0.15 W=1
+ AS=0.135 AD=0.365 PS=1.27 PD=1.73
M$5904 VPB|VPWR A|B|X \$7971 VPB|VPWR sky130_fd_pr__pfet_01v8_hvt L=0.15 W=1
+ AS=0.365 AD=0.105 PS=1.73 PD=1.21
M$5905 \$7971 B|Y D|Y VPB|VPWR sky130_fd_pr__pfet_01v8_hvt L=0.15 W=1 AS=0.105
+ AD=0.165 PS=1.21 PD=1.33
M$5906 D|Y \$7961 VPB|VPWR VPB|VPWR sky130_fd_pr__pfet_01v8_hvt L=0.15 W=1
+ AS=0.165 AD=0.36 PS=1.33 PD=2.72
M$5907 \$7898 RESET_B|X VPB|VPWR VPB|VPWR sky130_fd_pr__pfet_01v8_hvt L=0.15
+ W=0.42 AS=0.1092 AD=0.07035 PS=1.36 PD=0.755
M$5908 VPB|VPWR \$7752 \$7898 VPB|VPWR sky130_fd_pr__pfet_01v8_hvt L=0.15
+ W=0.42 AS=0.07035 AD=0.1155 PS=0.755 PD=0.97
M$5909 \$7898 \$7750 \$7753 VPB|VPWR sky130_fd_pr__pfet_01v8_hvt L=0.15 W=0.42
+ AS=0.1155 AD=0.07245 PS=0.97 PD=0.765
M$5910 \$7753 \$7751 \$7755 VPB|VPWR sky130_fd_pr__pfet_01v8_hvt L=0.15 W=0.42
+ AS=0.07245 AD=0.0651 PS=0.765 PD=0.73
M$5911 \$7755 D|Y VPB|VPWR VPB|VPWR sky130_fd_pr__pfet_01v8_hvt L=0.15 W=0.42
+ AS=0.0651 AD=0.1092 PS=0.73 PD=1.36
M$5916 \$7925 B|C|SLEEP|Y \$7965 VPB|VPWR sky130_fd_pr__pfet_01v8_hvt L=0.15
+ W=0.42 AS=0.1092 AD=0.0441 PS=1.36 PD=0.63
M$5917 \$7965 A|A0|B|Y \$7966 VPB|VPWR sky130_fd_pr__pfet_01v8_hvt L=0.15
+ W=0.42 AS=0.0441 AD=0.0693 PS=0.63 PD=0.75
M$5918 VPB|VPWR A|S|Y \$7966 VPB|VPWR sky130_fd_pr__pfet_01v8_hvt L=0.15 W=0.42
+ AS=0.14825 AD=0.0693 PS=1.34 PD=0.75
M$5919 VPB|VPWR \$7925 B1|X VPB|VPWR sky130_fd_pr__pfet_01v8_hvt L=0.15 W=1
+ AS=0.14825 AD=0.28 PS=1.34 PD=2.56
M$5920 \$8238 A|A0|B|Y A|B|SLEEP|Y VPB|VPWR sky130_fd_pr__pfet_01v8_hvt L=0.15
+ W=1 AS=0.28 AD=0.1525 PS=2.56 PD=1.305
M$5921 A|B|SLEEP|Y A1|B|C|X \$8259 VPB|VPWR sky130_fd_pr__pfet_01v8_hvt L=0.15
+ W=1 AS=0.1525 AD=0.1975 PS=1.305 PD=1.395
M$5922 \$8259 \$8040 VPB|VPWR VPB|VPWR sky130_fd_pr__pfet_01v8_hvt L=0.15 W=1
+ AS=0.1975 AD=0.3 PS=1.395 PD=1.6
M$5923 VPB|VPWR A|S|Y \$8238 VPB|VPWR sky130_fd_pr__pfet_01v8_hvt L=0.15 W=1
+ AS=0.3 AD=0.26 PS=1.6 PD=2.52
M$5924 \$8040 A|S|Y VPB|VPWR VPB|VPWR sky130_fd_pr__pfet_01v8_hvt L=0.15 W=1
+ AS=0.29 AD=0.26 PS=2.58 PD=2.52
M$5925 VPB|VPWR B|C|SLEEP|Y \$8041 VPB|VPWR sky130_fd_pr__pfet_01v8_hvt L=0.15
+ W=1 AS=0.3 AD=0.135 PS=2.6 PD=1.27
M$5926 \$8041 A|Y VPB|VPWR VPB|VPWR sky130_fd_pr__pfet_01v8_hvt L=0.15 W=1
+ AS=0.135 AD=0.365 PS=1.27 PD=1.73
M$5927 VPB|VPWR A|Y \$8260 VPB|VPWR sky130_fd_pr__pfet_01v8_hvt L=0.15 W=1
+ AS=0.365 AD=0.105 PS=1.73 PD=1.21
M$5928 \$8260 B|C|SLEEP|Y A2|C|D|Y VPB|VPWR sky130_fd_pr__pfet_01v8_hvt L=0.15
+ W=1 AS=0.105 AD=0.165 PS=1.21 PD=1.33
M$5929 A2|C|D|Y \$8041 VPB|VPWR VPB|VPWR sky130_fd_pr__pfet_01v8_hvt L=0.15 W=1
+ AS=0.165 AD=0.36 PS=1.33 PD=2.72
M$5930 \$7929 A|B|Y VPB|VPWR VPB|VPWR sky130_fd_pr__pfet_01v8_hvt L=0.15 W=0.42
+ AS=0.1092 AD=0.0567 PS=1.36 PD=0.69
M$5931 VPB|VPWR A1|B|C|X \$7929 VPB|VPWR sky130_fd_pr__pfet_01v8_hvt L=0.15
+ W=0.42 AS=0.0567 AD=0.06615 PS=0.69 PD=0.735
M$5932 VPB|VPWR A2|C|D|Y \$7929 VPB|VPWR sky130_fd_pr__pfet_01v8_hvt L=0.15
+ W=0.42 AS=0.142225 AD=0.06615 PS=1.335 PD=0.735
M$5933 VPB|VPWR \$7929 A1|X VPB|VPWR sky130_fd_pr__pfet_01v8_hvt L=0.15 W=1
+ AS=0.142225 AD=0.26 PS=1.335 PD=2.52
M$5934 VPB|VPWR A2|C|D|Y A|B1|Y VPB|VPWR sky130_fd_pr__pfet_01v8_hvt L=0.15 W=1
+ AS=0.26 AD=0.135 PS=2.52 PD=1.27
M$5935 A|B1|Y A1|B|C|X VPB|VPWR VPB|VPWR sky130_fd_pr__pfet_01v8_hvt L=0.15 W=1
+ AS=0.135 AD=0.135 PS=1.27 PD=1.27
M$5938 \$7933 A|B1|Y VPB|VPWR VPB|VPWR sky130_fd_pr__pfet_01v8_hvt L=0.15
+ W=0.42 AS=0.1092 AD=0.0567 PS=1.36 PD=0.69
M$5939 VPB|VPWR A1|A2|B|Y \$7933 VPB|VPWR sky130_fd_pr__pfet_01v8_hvt L=0.15
+ W=0.42 AS=0.0567 AD=0.06615 PS=0.69 PD=0.735
M$5940 VPB|VPWR A2|A3|C|X \$7933 VPB|VPWR sky130_fd_pr__pfet_01v8_hvt L=0.15
+ W=0.42 AS=0.142225 AD=0.06615 PS=1.335 PD=0.735
M$5941 VPB|VPWR \$7933 A4|B2|X VPB|VPWR sky130_fd_pr__pfet_01v8_hvt L=0.15 W=1
+ AS=0.142225 AD=0.26 PS=1.335 PD=2.52
M$5942 B|X \$8044 VPB|VPWR VPB|VPWR sky130_fd_pr__pfet_01v8_hvt L=0.15 W=1
+ AS=0.425 AD=0.135 PS=2.85 PD=1.27
M$5943 VPB|VPWR A|B1|X \$8044 VPB|VPWR sky130_fd_pr__pfet_01v8_hvt L=0.15 W=1
+ AS=0.135 AD=0.26 PS=1.27 PD=1.52
M$5944 \$8044 A4|B2|X \$8264 VPB|VPWR sky130_fd_pr__pfet_01v8_hvt L=0.15 W=1
+ AS=0.26 AD=0.22 PS=1.52 PD=1.44
M$5945 \$8264 A3|B1|Y \$8265 VPB|VPWR sky130_fd_pr__pfet_01v8_hvt L=0.15 W=1
+ AS=0.22 AD=0.195 PS=1.44 PD=1.39
M$5946 \$8265 A2|X \$8266 VPB|VPWR sky130_fd_pr__pfet_01v8_hvt L=0.15 W=1
+ AS=0.195 AD=0.195 PS=1.39 PD=1.39
M$5947 \$8266 A|A1|B|Y VPB|VPWR VPB|VPWR sky130_fd_pr__pfet_01v8_hvt L=0.15 W=1
+ AS=0.195 AD=0.28 PS=1.39 PD=2.56
M$5948 \$7942 B|C|X \$7940 VPB|VPWR sky130_fd_pr__pfet_01v8_hvt L=0.15 W=0.84
+ AS=0.15295 AD=0.273 PS=1.315 PD=2.33
M$5949 \$7942 \$7943 \$7941 VPB|VPWR sky130_fd_pr__pfet_01v8_hvt L=0.15 W=0.84
+ AS=0.15295 AD=0.32235 PS=1.315 PD=2.45
M$5950 \$8240 A2|A3|C|Y VPB|VPWR VPB|VPWR sky130_fd_pr__pfet_01v8_hvt L=0.15
+ W=1 AS=0.265 AD=0.1475 PS=2.53 PD=1.295
M$5951 VPB|VPWR A1|A2|B|Y \$8240 VPB|VPWR sky130_fd_pr__pfet_01v8_hvt L=0.15
+ W=1 AS=0.1475 AD=0.14 PS=1.295 PD=1.28
M$5952 \$8240 A|B1|Y A|A1|Y VPB|VPWR sky130_fd_pr__pfet_01v8_hvt L=0.15 W=1
+ AS=0.14 AD=0.265 PS=1.28 PD=2.53
M$5953 VPB|VPWR A1|A3|B|X \$8269 VPB|VPWR sky130_fd_pr__pfet_01v8_hvt L=0.15
+ W=1 AS=0.265 AD=0.105 PS=2.53 PD=1.21
M$5954 \$8269 A2|A3|X A|Y VPB|VPWR sky130_fd_pr__pfet_01v8_hvt L=0.15 W=1
+ AS=0.105 AD=0.195 PS=1.21 PD=1.39
M$5956 VPB|VPWR A|B1|C1|X A|Y VPB|VPWR sky130_fd_pr__pfet_01v8_hvt L=0.15 W=2
+ AS=0.33 AD=0.895 PS=2.66 PD=5.79
M$5957 \$8050 B|Y \$8270 VPB|VPWR sky130_fd_pr__pfet_01v8_hvt L=0.15 W=1
+ AS=0.26 AD=0.135 PS=2.52 PD=1.27
M$5958 \$8270 A|B1|X VPB|VPWR VPB|VPWR sky130_fd_pr__pfet_01v8_hvt L=0.15 W=1
+ AS=0.135 AD=0.135 PS=1.27 PD=1.27
M$5959 VPB|VPWR A|B1|X \$8245 VPB|VPWR sky130_fd_pr__pfet_01v8_hvt L=0.15 W=1
+ AS=0.135 AD=0.135 PS=1.27 PD=1.27
M$5960 \$8245 B|Y VPB|VPWR VPB|VPWR sky130_fd_pr__pfet_01v8_hvt L=0.15 W=1
+ AS=0.135 AD=0.26 PS=1.27 PD=2.52
M$5961 \$8245 \$8050 A|X VPB|VPWR sky130_fd_pr__pfet_01v8_hvt L=0.15 W=1
+ AS=0.26 AD=0.3 PS=2.52 PD=2.6
M$5962 \$8052 A|X \$8271 VPB|VPWR sky130_fd_pr__pfet_01v8_hvt L=0.15 W=0.42
+ AS=0.1092 AD=0.0441 PS=1.36 PD=0.63
M$5963 \$8271 B|SLEEP|Y VPB|VPWR VPB|VPWR sky130_fd_pr__pfet_01v8_hvt L=0.15
+ W=0.42 AS=0.0441 AD=0.14575 PS=0.63 PD=1.335
M$5964 VPB|VPWR \$8052 A|B|X VPB|VPWR sky130_fd_pr__pfet_01v8_hvt L=0.15 W=1
+ AS=0.14575 AD=0.34 PS=1.335 PD=2.68
M$5965 \$8054 B|SLEEP|Y \$8272 VPB|VPWR sky130_fd_pr__pfet_01v8_hvt L=0.15 W=1
+ AS=0.26 AD=0.135 PS=2.52 PD=1.27
M$5966 \$8272 A|X VPB|VPWR VPB|VPWR sky130_fd_pr__pfet_01v8_hvt L=0.15 W=1
+ AS=0.135 AD=0.135 PS=1.27 PD=1.27
M$5967 VPB|VPWR A|X \$8246 VPB|VPWR sky130_fd_pr__pfet_01v8_hvt L=0.15 W=1
+ AS=0.135 AD=0.135 PS=1.27 PD=1.27
M$5968 \$8246 B|SLEEP|Y VPB|VPWR VPB|VPWR sky130_fd_pr__pfet_01v8_hvt L=0.15
+ W=1 AS=0.135 AD=0.26 PS=1.27 PD=2.52
M$5969 \$8246 \$8054 A|B1|X VPB|VPWR sky130_fd_pr__pfet_01v8_hvt L=0.15 W=1
+ AS=0.26 AD=0.3 PS=2.52 PD=2.6
M$5970 \$8057 B|Y \$8273 VPB|VPWR sky130_fd_pr__pfet_01v8_hvt L=0.15 W=1
+ AS=0.26 AD=0.135 PS=2.52 PD=1.27
M$5971 \$8273 A|B1|X VPB|VPWR VPB|VPWR sky130_fd_pr__pfet_01v8_hvt L=0.15 W=1
+ AS=0.135 AD=0.135 PS=1.27 PD=1.27
M$5972 VPB|VPWR A|B1|X \$8247 VPB|VPWR sky130_fd_pr__pfet_01v8_hvt L=0.15 W=1
+ AS=0.135 AD=0.135 PS=1.27 PD=1.27
M$5973 \$8247 B|Y VPB|VPWR VPB|VPWR sky130_fd_pr__pfet_01v8_hvt L=0.15 W=1
+ AS=0.135 AD=0.26 PS=1.27 PD=2.52
M$5974 \$8247 \$8057 A|A1|X VPB|VPWR sky130_fd_pr__pfet_01v8_hvt L=0.15 W=1
+ AS=0.26 AD=0.3 PS=2.52 PD=2.6
M$5975 \$8058 A2|B|Y \$8276 VPB|VPWR sky130_fd_pr__pfet_01v8_hvt L=0.15 W=1
+ AS=0.26 AD=0.135 PS=2.52 PD=1.27
M$5976 \$8276 A|A1|X VPB|VPWR VPB|VPWR sky130_fd_pr__pfet_01v8_hvt L=0.15 W=1
+ AS=0.135 AD=0.135 PS=1.27 PD=1.27
M$5977 VPB|VPWR A|A1|X \$8248 VPB|VPWR sky130_fd_pr__pfet_01v8_hvt L=0.15 W=1
+ AS=0.135 AD=0.135 PS=1.27 PD=1.27
M$5978 \$8248 A2|B|Y VPB|VPWR VPB|VPWR sky130_fd_pr__pfet_01v8_hvt L=0.15 W=1
+ AS=0.135 AD=0.26 PS=1.27 PD=2.52
M$5979 \$8248 \$8058 A|B|X VPB|VPWR sky130_fd_pr__pfet_01v8_hvt L=0.15 W=1
+ AS=0.26 AD=0.3 PS=2.52 PD=2.6
M$5981 VPB|VPWR A|B|X A|B1|Y VPB|VPWR sky130_fd_pr__pfet_01v8_hvt L=0.15 W=1
+ AS=0.165 AD=0.135 PS=1.33 PD=1.27
M$5982 A|B1|Y B|C|X VPB|VPWR VPB|VPWR sky130_fd_pr__pfet_01v8_hvt L=0.15 W=1
+ AS=0.135 AD=0.26 PS=1.27 PD=2.52
M$5983 \$8063 B|Y \$8277 VPB|VPWR sky130_fd_pr__pfet_01v8_hvt L=0.15 W=1
+ AS=0.26 AD=0.135 PS=2.52 PD=1.27
M$5984 \$8277 A|B|X VPB|VPWR VPB|VPWR sky130_fd_pr__pfet_01v8_hvt L=0.15 W=1
+ AS=0.135 AD=0.135 PS=1.27 PD=1.27
M$5985 VPB|VPWR A|B|X \$8249 VPB|VPWR sky130_fd_pr__pfet_01v8_hvt L=0.15 W=1
+ AS=0.135 AD=0.135 PS=1.27 PD=1.27
M$5986 \$8249 B|Y VPB|VPWR VPB|VPWR sky130_fd_pr__pfet_01v8_hvt L=0.15 W=1
+ AS=0.135 AD=0.26 PS=1.27 PD=2.52
M$5987 \$8249 \$8063 A|A1|X VPB|VPWR sky130_fd_pr__pfet_01v8_hvt L=0.15 W=1
+ AS=0.26 AD=0.3 PS=2.52 PD=2.6
M$5988 VPB|VPWR A2|B|Y \$8064 VPB|VPWR sky130_fd_pr__pfet_01v8_hvt L=0.15 W=1
+ AS=0.3 AD=0.135 PS=2.6 PD=1.27
M$5989 \$8064 A|A1|X VPB|VPWR VPB|VPWR sky130_fd_pr__pfet_01v8_hvt L=0.15 W=1
+ AS=0.135 AD=0.365 PS=1.27 PD=1.73
M$5990 VPB|VPWR A|A1|X \$8275 VPB|VPWR sky130_fd_pr__pfet_01v8_hvt L=0.15 W=1
+ AS=0.365 AD=0.105 PS=1.73 PD=1.21
M$5991 \$8275 A2|B|Y A|Y VPB|VPWR sky130_fd_pr__pfet_01v8_hvt L=0.15 W=1
+ AS=0.105 AD=0.165 PS=1.21 PD=1.33
M$5992 A|Y \$8064 VPB|VPWR VPB|VPWR sky130_fd_pr__pfet_01v8_hvt L=0.15 W=1
+ AS=0.165 AD=0.36 PS=1.33 PD=2.72
M$5993 \$7949 A|A2|B|C_N|Y VPB|VPWR VPB|VPWR sky130_fd_pr__pfet_01v8_hvt L=0.15
+ W=0.42 AS=0.1092 AD=0.1226125 PS=1.36 PD=1.32
M$5994 VPB|VPWR D_N|Y \$7950 VPB|VPWR sky130_fd_pr__pfet_01v8_hvt L=0.15 W=0.42
+ AS=0.1226125 AD=0.1085 PS=1.32 PD=1.36
M$5995 \$8066 \$8068 \$8069 VPB|VPWR sky130_fd_pr__pfet_01v8_hvt L=0.15 W=0.64
+ AS=0.246 AD=0.2431 PS=1.525 PD=1.445
M$5996 \$8066 B|Y \$8070 VPB|VPWR sky130_fd_pr__pfet_01v8_hvt L=0.15 W=0.64
+ AS=0.246 AD=0.1458 PS=1.525 PD=1.205
M$5997 \$8069 B|Y \$8067 VPB|VPWR sky130_fd_pr__pfet_01v8_hvt L=0.15 W=0.84
+ AS=0.2431 AD=0.3528 PS=1.445 PD=2.52
M$5998 \$8066 \$8067 VPB|VPWR VPB|VPWR sky130_fd_pr__pfet_01v8_hvt L=0.15 W=1
+ AS=0.285 AD=0.135 PS=2.57 PD=1.27
M$5999 VPB|VPWR A|Y \$8067 VPB|VPWR sky130_fd_pr__pfet_01v8_hvt L=0.15 W=1
+ AS=0.135 AD=0.1715 PS=1.27 PD=1.355
M$6000 \$8067 \$8068 \$8070 VPB|VPWR sky130_fd_pr__pfet_01v8_hvt L=0.15 W=0.84
+ AS=0.1715 AD=0.1458 PS=1.355 PD=1.205
M$6001 \$8068 B|Y VPB|VPWR VPB|VPWR sky130_fd_pr__pfet_01v8_hvt L=0.15 W=1
+ AS=0.26 AD=0.25655 PS=2.52 PD=2.52
M$6002 \$8069 \$8071 \$8072 VPB|VPWR sky130_fd_pr__pfet_01v8_hvt L=0.15 W=0.84
+ AS=0.32235 AD=0.15295 PS=2.45 PD=1.315
M$6003 \$8072 B|C|Y \$8070 VPB|VPWR sky130_fd_pr__pfet_01v8_hvt L=0.15 W=0.84
+ AS=0.15295 AD=0.273 PS=1.315 PD=2.33
M$6004 \$8071 B|C|Y VPB|VPWR VPB|VPWR sky130_fd_pr__pfet_01v8_hvt L=0.15 W=0.64
+ AS=0.1792 AD=0.169 PS=1.84 PD=1.365
M$6005 VPB|VPWR \$8072 A|X VPB|VPWR sky130_fd_pr__pfet_01v8_hvt L=0.15 W=1
+ AS=0.169 AD=0.28 PS=1.365 PD=2.56
M$6006 VPB|VPWR B|SLEEP|Y \$8073 VPB|VPWR sky130_fd_pr__pfet_01v8_hvt L=0.15
+ W=1 AS=0.3 AD=0.135 PS=2.6 PD=1.27
M$6007 \$8073 A|X VPB|VPWR VPB|VPWR sky130_fd_pr__pfet_01v8_hvt L=0.15 W=1
+ AS=0.135 AD=0.365 PS=1.27 PD=1.73
M$6008 VPB|VPWR A|X \$8268 VPB|VPWR sky130_fd_pr__pfet_01v8_hvt L=0.15 W=1
+ AS=0.365 AD=0.105 PS=1.73 PD=1.21
M$6009 \$8268 B|SLEEP|Y A|Y VPB|VPWR sky130_fd_pr__pfet_01v8_hvt L=0.15 W=1
+ AS=0.105 AD=0.165 PS=1.21 PD=1.33
M$6010 A|Y \$8073 VPB|VPWR VPB|VPWR sky130_fd_pr__pfet_01v8_hvt L=0.15 W=1
+ AS=0.165 AD=0.36 PS=1.33 PD=2.72
M$6011 \$8076 B|SLEEP|Y \$8267 VPB|VPWR sky130_fd_pr__pfet_01v8_hvt L=0.15 W=1
+ AS=0.26 AD=0.135 PS=2.52 PD=1.27
M$6012 \$8267 A|Y VPB|VPWR VPB|VPWR sky130_fd_pr__pfet_01v8_hvt L=0.15 W=1
+ AS=0.135 AD=0.135 PS=1.27 PD=1.27
M$6013 VPB|VPWR A|Y \$8250 VPB|VPWR sky130_fd_pr__pfet_01v8_hvt L=0.15 W=1
+ AS=0.135 AD=0.135 PS=1.27 PD=1.27
M$6014 \$8250 B|SLEEP|Y VPB|VPWR VPB|VPWR sky130_fd_pr__pfet_01v8_hvt L=0.15
+ W=1 AS=0.135 AD=0.26 PS=1.27 PD=2.52
M$6015 \$8250 \$8076 B|C|X VPB|VPWR sky130_fd_pr__pfet_01v8_hvt L=0.15 W=1
+ AS=0.26 AD=0.3 PS=2.52 PD=2.6
M$6016 \$7959 B|C|X \$7993 VPB|VPWR sky130_fd_pr__pfet_01v8_hvt L=0.15 W=0.42
+ AS=0.1092 AD=0.0441 PS=1.36 PD=0.63
M$6017 \$7993 A|Q VPB|VPWR VPB|VPWR sky130_fd_pr__pfet_01v8_hvt L=0.15 W=0.42
+ AS=0.0441 AD=0.0567 PS=0.63 PD=0.69
M$6018 VPB|VPWR A|Q \$7991 VPB|VPWR sky130_fd_pr__pfet_01v8_hvt L=0.15 W=0.42
+ AS=0.0567 AD=0.0441 PS=0.69 PD=0.63
M$6019 \$7991 A|B|X \$7959 VPB|VPWR sky130_fd_pr__pfet_01v8_hvt L=0.15 W=0.42
+ AS=0.0441 AD=0.0567 PS=0.63 PD=0.69
M$6020 \$7959 A|B|X \$7988 VPB|VPWR sky130_fd_pr__pfet_01v8_hvt L=0.15 W=0.42
+ AS=0.0567 AD=0.0441 PS=0.69 PD=0.63
M$6021 VPB|VPWR B|C|X \$7988 VPB|VPWR sky130_fd_pr__pfet_01v8_hvt L=0.15 W=0.42
+ AS=0.2492 AD=0.0441 PS=1.565 PD=0.63
M$6022 VPB|VPWR \$7959 A|B|X VPB|VPWR sky130_fd_pr__pfet_01v8_hvt L=0.15 W=1
+ AS=0.2492 AD=0.365 PS=1.565 PD=2.73
M$6023 VPB|VPWR \$8083 A|Q VPB|VPWR sky130_fd_pr__pfet_01v8_hvt L=0.15 W=1
+ AS=0.3012 AD=0.26 PS=2.66 PD=2.52
M$6042 VPB|VPWR A1|Y \$8318 VPB|VPWR sky130_fd_pr__pfet_01v8_hvt L=0.15 W=0.64
+ AS=0.1696 AD=0.0768 PS=1.81 PD=0.88
M$6043 \$8318 A2|C|D|Y B|SLEEP|Y VPB|VPWR sky130_fd_pr__pfet_01v8_hvt L=0.15
+ W=0.64 AS=0.0768 AD=0.0896 PS=0.88 PD=0.92
M$6044 B|SLEEP|Y A|B1|Y VPB|VPWR VPB|VPWR sky130_fd_pr__pfet_01v8_hvt L=0.15
+ W=0.64 AS=0.0896 AD=0.1824 PS=0.92 PD=1.85
M$6046 \$8280 A|B|SLEEP|Y \$8319 VPB|VPWR sky130_fd_pr__pfet_01v8_hvt L=0.15
+ W=1 AS=0.26 AD=0.135 PS=2.52 PD=1.27
M$6047 \$8319 A|Y VPB|VPWR VPB|VPWR sky130_fd_pr__pfet_01v8_hvt L=0.15 W=1
+ AS=0.135 AD=0.135 PS=1.27 PD=1.27
M$6048 VPB|VPWR A|Y \$8281 VPB|VPWR sky130_fd_pr__pfet_01v8_hvt L=0.15 W=1
+ AS=0.135 AD=0.135 PS=1.27 PD=1.27
M$6049 \$8281 A|B|SLEEP|Y VPB|VPWR VPB|VPWR sky130_fd_pr__pfet_01v8_hvt L=0.15
+ W=1 AS=0.135 AD=0.26 PS=1.27 PD=2.52
M$6050 \$8281 \$8280 A2|B|C|X VPB|VPWR sky130_fd_pr__pfet_01v8_hvt L=0.15 W=1
+ AS=0.26 AD=0.3 PS=2.52 PD=2.6
M$6053 VPB|VPWR A|B1|X \$8322 VPB|VPWR sky130_fd_pr__pfet_01v8_hvt L=0.15 W=1
+ AS=0.26 AD=0.105 PS=2.52 PD=1.21
M$6054 \$8322 B|SLEEP|Y A|Y VPB|VPWR sky130_fd_pr__pfet_01v8_hvt L=0.15 W=1
+ AS=0.105 AD=0.26 PS=1.21 PD=2.52
M$6057 B|X \$8341 VPB|VPWR VPB|VPWR sky130_fd_pr__pfet_01v8_hvt L=0.15 W=1
+ AS=0.265 AD=0.1725 PS=2.53 PD=1.345
M$6058 VPB|VPWR A2|A3|C|Y \$8285 VPB|VPWR sky130_fd_pr__pfet_01v8_hvt L=0.15
+ W=1 AS=0.1725 AD=0.16 PS=1.345 PD=1.32
M$6059 \$8285 A1|A2|B|Y VPB|VPWR VPB|VPWR sky130_fd_pr__pfet_01v8_hvt L=0.15
+ W=1 AS=0.16 AD=0.165 PS=1.32 PD=1.33
M$6060 VPB|VPWR A1|X \$8285 VPB|VPWR sky130_fd_pr__pfet_01v8_hvt L=0.15 W=1
+ AS=0.165 AD=0.165 PS=1.33 PD=1.33
M$6061 \$8285 B1|Y \$8341 VPB|VPWR sky130_fd_pr__pfet_01v8_hvt L=0.15 W=1
+ AS=0.165 AD=0.32 PS=1.33 PD=2.64
M$6063 B|C|X \$8342 VPB|VPWR VPB|VPWR sky130_fd_pr__pfet_01v8_hvt L=0.15 W=1
+ AS=0.265 AD=0.1725 PS=2.53 PD=1.345
M$6064 VPB|VPWR A3|Y \$8287 VPB|VPWR sky130_fd_pr__pfet_01v8_hvt L=0.15 W=1
+ AS=0.1725 AD=0.16 PS=1.345 PD=1.32
M$6065 \$8287 A2|A3|C|Y VPB|VPWR VPB|VPWR sky130_fd_pr__pfet_01v8_hvt L=0.15
+ W=1 AS=0.16 AD=0.165 PS=1.32 PD=1.33
M$6066 VPB|VPWR A1|A2|B|Y \$8287 VPB|VPWR sky130_fd_pr__pfet_01v8_hvt L=0.15
+ W=1 AS=0.165 AD=0.165 PS=1.33 PD=1.33
M$6067 \$8287 A|A1|B1|Y \$8342 VPB|VPWR sky130_fd_pr__pfet_01v8_hvt L=0.15 W=1
+ AS=0.165 AD=0.32 PS=1.33 PD=2.64
M$6069 \$8242 A|B1|Y VPB|VPWR VPB|VPWR sky130_fd_pr__pfet_01v8_hvt L=0.15
+ W=0.42 AS=0.1092 AD=0.0567 PS=1.36 PD=0.69
M$6070 VPB|VPWR A1|A2|B|Y \$8242 VPB|VPWR sky130_fd_pr__pfet_01v8_hvt L=0.15
+ W=0.42 AS=0.0567 AD=0.06615 PS=0.69 PD=0.735
M$6071 VPB|VPWR A2|A3|C|Y \$8242 VPB|VPWR sky130_fd_pr__pfet_01v8_hvt L=0.15
+ W=0.42 AS=0.142225 AD=0.06615 PS=1.335 PD=0.735
M$6072 VPB|VPWR \$8242 A2|SLEEP|X VPB|VPWR sky130_fd_pr__pfet_01v8_hvt L=0.15
+ W=1 AS=0.142225 AD=0.26 PS=1.335 PD=2.52
M$6077 VPB|VPWR A|A1|B|Y \$8327 VPB|VPWR sky130_fd_pr__pfet_01v8_hvt L=0.15
+ W=0.64 AS=0.1792 AD=0.0864 PS=1.84 PD=0.91
M$6078 \$8327 A2|Y \$8328 VPB|VPWR sky130_fd_pr__pfet_01v8_hvt L=0.15 W=0.64
+ AS=0.0864 AD=0.0864 PS=0.91 PD=0.91
M$6079 \$8328 A3|B|X A|B1|Y VPB|VPWR sky130_fd_pr__pfet_01v8_hvt L=0.15 W=0.64
+ AS=0.0864 AD=0.144 PS=0.91 PD=1.09
M$6081 VPB|VPWR A|B1|C1|X A|B1|Y VPB|VPWR sky130_fd_pr__pfet_01v8_hvt L=0.15
+ W=0.64 AS=0.1184 AD=0.1984 PS=1.01 PD=1.9
M$6084 VPB|VPWR A1|Y \$8329 VPB|VPWR sky130_fd_pr__pfet_01v8_hvt L=0.15 W=1
+ AS=0.26 AD=0.135 PS=2.52 PD=1.27
M$6085 \$8329 A2|Y \$8330 VPB|VPWR sky130_fd_pr__pfet_01v8_hvt L=0.15 W=1
+ AS=0.135 AD=0.135 PS=1.27 PD=1.27
M$6086 \$8330 A3|B|X A2|B|Y VPB|VPWR sky130_fd_pr__pfet_01v8_hvt L=0.15 W=1
+ AS=0.135 AD=0.3925 PS=1.27 PD=1.785
M$6100 \$8078 CLK|TICK VPB|VPWR VPB|VPWR sky130_fd_pr__pfet_01v8_hvt L=0.15
+ W=0.64 AS=0.1664 AD=0.0864 PS=1.8 PD=0.91
M$6101 VPB|VPWR \$8078 \$8079 VPB|VPWR sky130_fd_pr__pfet_01v8_hvt L=0.15
+ W=0.64 AS=0.0864 AD=0.1664 PS=0.91 PD=1.8
M$6103 VPB|VPWR D|Y \$8080 VPB|VPWR sky130_fd_pr__pfet_01v8_hvt L=0.15 W=0.42
+ AS=0.1092 AD=0.0651 PS=1.36 PD=0.73
M$6104 \$8080 \$8079 \$8081 VPB|VPWR sky130_fd_pr__pfet_01v8_hvt L=0.15 W=0.42
+ AS=0.0651 AD=0.07245 PS=0.73 PD=0.765
M$6105 \$8081 \$8078 \$8251 VPB|VPWR sky130_fd_pr__pfet_01v8_hvt L=0.15 W=0.42
+ AS=0.07245 AD=0.1155 PS=0.765 PD=0.97
M$6106 \$8251 \$8244 VPB|VPWR VPB|VPWR sky130_fd_pr__pfet_01v8_hvt L=0.15
+ W=0.42 AS=0.1155 AD=0.07035 PS=0.97 PD=0.755
M$6107 VPB|VPWR RESET_B|X \$8251 VPB|VPWR sky130_fd_pr__pfet_01v8_hvt L=0.15
+ W=0.42 AS=0.07035 AD=0.1092 PS=0.755 PD=1.36
M$6108 VPB|VPWR \$8295 B|Y VPB|VPWR sky130_fd_pr__pfet_01v8_hvt L=0.15 W=1
+ AS=0.36 AD=0.165 PS=2.72 PD=1.33
M$6109 B|Y B|C|X \$8337 VPB|VPWR sky130_fd_pr__pfet_01v8_hvt L=0.15 W=1
+ AS=0.165 AD=0.105 PS=1.33 PD=1.21
M$6110 \$8337 A|Q VPB|VPWR VPB|VPWR sky130_fd_pr__pfet_01v8_hvt L=0.15 W=1
+ AS=0.105 AD=0.365 PS=1.21 PD=1.73
M$6111 VPB|VPWR A|Q \$8295 VPB|VPWR sky130_fd_pr__pfet_01v8_hvt L=0.15 W=1
+ AS=0.365 AD=0.135 PS=1.73 PD=1.27
M$6112 \$8295 B|C|X VPB|VPWR VPB|VPWR sky130_fd_pr__pfet_01v8_hvt L=0.15 W=1
+ AS=0.135 AD=0.3 PS=1.27 PD=2.6
M$6113 VPB|VPWR \$8081 \$8244 VPB|VPWR sky130_fd_pr__pfet_01v8_hvt L=0.15
+ W=0.84 AS=0.2184 AD=0.12915 PS=2.2 PD=1.185
M$6114 \$8244 \$8078 \$8082 VPB|VPWR sky130_fd_pr__pfet_01v8_hvt L=0.15 W=0.42
+ AS=0.12915 AD=0.0588 PS=1.185 PD=0.7
M$6115 \$8082 \$8079 \$8261 VPB|VPWR sky130_fd_pr__pfet_01v8_hvt L=0.15 W=0.42
+ AS=0.0588 AD=0.0567 PS=0.7 PD=0.69
M$6116 \$8261 \$8083 VPB|VPWR VPB|VPWR sky130_fd_pr__pfet_01v8_hvt L=0.15
+ W=0.42 AS=0.0567 AD=0.0819 PS=0.69 PD=0.81
M$6117 VPB|VPWR RESET_B|X \$8083 VPB|VPWR sky130_fd_pr__pfet_01v8_hvt L=0.15
+ W=0.42 AS=0.0819 AD=0.0567 PS=0.81 PD=0.69
M$6118 \$8083 \$8082 VPB|VPWR VPB|VPWR sky130_fd_pr__pfet_01v8_hvt L=0.15
+ W=0.42 AS=0.0567 AD=0.1134 PS=0.69 PD=1.38
M$6121 VPB|VPWR D|Y \$8299 VPB|VPWR sky130_fd_pr__pfet_01v8_hvt L=0.15 W=0.42
+ AS=0.1092 AD=0.0651 PS=1.36 PD=0.73
M$6122 \$8299 \$8297 \$8300 VPB|VPWR sky130_fd_pr__pfet_01v8_hvt L=0.15 W=0.42
+ AS=0.0651 AD=0.07245 PS=0.73 PD=0.765
M$6123 \$8300 \$8296 \$8301 VPB|VPWR sky130_fd_pr__pfet_01v8_hvt L=0.15 W=0.42
+ AS=0.07245 AD=0.1155 PS=0.765 PD=0.97
M$6124 \$8301 \$8302 VPB|VPWR VPB|VPWR sky130_fd_pr__pfet_01v8_hvt L=0.15
+ W=0.42 AS=0.1155 AD=0.07035 PS=0.97 PD=0.755
M$6125 VPB|VPWR RESET_B|X \$8301 VPB|VPWR sky130_fd_pr__pfet_01v8_hvt L=0.15
+ W=0.42 AS=0.07035 AD=0.1092 PS=0.755 PD=1.36
M$6126 \$8302 \$8296 \$8303 VPB|VPWR sky130_fd_pr__pfet_01v8_hvt L=0.15 W=0.42
+ AS=0.12915 AD=0.0588 PS=1.185 PD=0.7
M$6127 \$8303 \$8297 \$8336 VPB|VPWR sky130_fd_pr__pfet_01v8_hvt L=0.15 W=0.42
+ AS=0.0588 AD=0.0567 PS=0.7 PD=0.69
M$6128 \$8336 \$8346 VPB|VPWR VPB|VPWR sky130_fd_pr__pfet_01v8_hvt L=0.15
+ W=0.42 AS=0.0567 AD=0.0819 PS=0.69 PD=0.81
M$6129 VPB|VPWR RESET_B|X \$8346 VPB|VPWR sky130_fd_pr__pfet_01v8_hvt L=0.15
+ W=0.42 AS=0.0819 AD=0.0567 PS=0.81 PD=0.69
M$6130 \$8346 \$8303 VPB|VPWR VPB|VPWR sky130_fd_pr__pfet_01v8_hvt L=0.15
+ W=0.42 AS=0.0567 AD=0.1134 PS=0.69 PD=1.38
M$6131 VPB|VPWR \$8300 \$8302 VPB|VPWR sky130_fd_pr__pfet_01v8_hvt L=0.15
+ W=0.84 AS=0.2184 AD=0.12915 PS=2.2 PD=1.185
M$6132 \$8084 B|C|X \$8258 VPB|VPWR sky130_fd_pr__pfet_01v8_hvt L=0.15 W=0.42
+ AS=0.1092 AD=0.0441 PS=1.36 PD=0.63
M$6133 \$8258 A|Q VPB|VPWR VPB|VPWR sky130_fd_pr__pfet_01v8_hvt L=0.15 W=0.42
+ AS=0.0441 AD=0.0567 PS=0.63 PD=0.69
M$6134 VPB|VPWR A|Q \$8257 VPB|VPWR sky130_fd_pr__pfet_01v8_hvt L=0.15 W=0.42
+ AS=0.0567 AD=0.0441 PS=0.69 PD=0.63
M$6135 \$8257 A|B|Y \$8084 VPB|VPWR sky130_fd_pr__pfet_01v8_hvt L=0.15 W=0.42
+ AS=0.0441 AD=0.0567 PS=0.63 PD=0.69
M$6136 \$8084 A|B|Y \$8256 VPB|VPWR sky130_fd_pr__pfet_01v8_hvt L=0.15 W=0.42
+ AS=0.0567 AD=0.0441 PS=0.69 PD=0.63
M$6137 VPB|VPWR B|C|X \$8256 VPB|VPWR sky130_fd_pr__pfet_01v8_hvt L=0.15 W=0.42
+ AS=0.2492 AD=0.0441 PS=1.565 PD=0.63
M$6138 VPB|VPWR \$8084 A|B|X VPB|VPWR sky130_fd_pr__pfet_01v8_hvt L=0.15 W=1
+ AS=0.2492 AD=0.365 PS=1.565 PD=2.73
M$6139 VPB|VPWR \$8346 A|Q VPB|VPWR sky130_fd_pr__pfet_01v8_hvt L=0.15 W=1
+ AS=0.3012 AD=0.26 PS=2.66 PD=2.52
M$6144 VPB|VPWR A|X \$8326 VPB|VPWR sky130_fd_pr__pfet_01v8_hvt L=0.15 W=1
+ AS=0.26 AD=0.105 PS=2.52 PD=1.21
M$6145 \$8326 B|Y D|Y VPB|VPWR sky130_fd_pr__pfet_01v8_hvt L=0.15 W=1 AS=0.105
+ AD=0.26 PS=1.21 PD=2.52
M$6146 \$8306 B|Y \$8325 VPB|VPWR sky130_fd_pr__pfet_01v8_hvt L=0.15 W=1
+ AS=0.26 AD=0.135 PS=2.52 PD=1.27
M$6147 \$8325 A|X VPB|VPWR VPB|VPWR sky130_fd_pr__pfet_01v8_hvt L=0.15 W=1
+ AS=0.135 AD=0.135 PS=1.27 PD=1.27
M$6148 VPB|VPWR A|X \$8307 VPB|VPWR sky130_fd_pr__pfet_01v8_hvt L=0.15 W=1
+ AS=0.135 AD=0.135 PS=1.27 PD=1.27
M$6149 \$8307 B|Y VPB|VPWR VPB|VPWR sky130_fd_pr__pfet_01v8_hvt L=0.15 W=1
+ AS=0.135 AD=0.26 PS=1.27 PD=2.52
M$6150 \$8307 \$8306 D|X VPB|VPWR sky130_fd_pr__pfet_01v8_hvt L=0.15 W=1
+ AS=0.26 AD=0.3 PS=2.52 PD=2.6
M$6152 A|Q \$8349 VPB|VPWR VPB|VPWR sky130_fd_pr__pfet_01v8_hvt L=0.15 W=1
+ AS=0.26 AD=0.3012 PS=2.52 PD=2.66
M$6153 VPB|VPWR \$8309 \$8349 VPB|VPWR sky130_fd_pr__pfet_01v8_hvt L=0.15
+ W=0.42 AS=0.1134 AD=0.0567 PS=1.38 PD=0.69
M$6154 \$8349 RESET_B|X VPB|VPWR VPB|VPWR sky130_fd_pr__pfet_01v8_hvt L=0.15
+ W=0.42 AS=0.0567 AD=0.0819 PS=0.69 PD=0.81
M$6155 VPB|VPWR \$8349 \$8320 VPB|VPWR sky130_fd_pr__pfet_01v8_hvt L=0.15
+ W=0.42 AS=0.0819 AD=0.0567 PS=0.81 PD=0.69
M$6156 \$8320 \$8310 \$8309 VPB|VPWR sky130_fd_pr__pfet_01v8_hvt L=0.15 W=0.42
+ AS=0.0567 AD=0.0588 PS=0.69 PD=0.7
M$6157 \$8309 \$8350 \$8311 VPB|VPWR sky130_fd_pr__pfet_01v8_hvt L=0.15 W=0.42
+ AS=0.0588 AD=0.12915 PS=0.7 PD=1.185
M$6158 \$8311 \$8313 VPB|VPWR VPB|VPWR sky130_fd_pr__pfet_01v8_hvt L=0.15
+ W=0.84 AS=0.12915 AD=0.2184 PS=1.185 PD=2.2
M$6159 \$8312 RESET_B|X VPB|VPWR VPB|VPWR sky130_fd_pr__pfet_01v8_hvt L=0.15
+ W=0.42 AS=0.1092 AD=0.07035 PS=1.36 PD=0.755
M$6160 VPB|VPWR \$8311 \$8312 VPB|VPWR sky130_fd_pr__pfet_01v8_hvt L=0.15
+ W=0.42 AS=0.07035 AD=0.1155 PS=0.755 PD=0.97
M$6161 \$8312 \$8350 \$8313 VPB|VPWR sky130_fd_pr__pfet_01v8_hvt L=0.15 W=0.42
+ AS=0.1155 AD=0.07245 PS=0.97 PD=0.765
M$6162 \$8313 \$8310 \$8314 VPB|VPWR sky130_fd_pr__pfet_01v8_hvt L=0.15 W=0.42
+ AS=0.07245 AD=0.0651 PS=0.765 PD=0.73
M$6163 \$8314 D|X VPB|VPWR VPB|VPWR sky130_fd_pr__pfet_01v8_hvt L=0.15 W=0.42
+ AS=0.0651 AD=0.1092 PS=0.73 PD=1.36
M$6178 A1|Y A|B|SLEEP|Y \$8552 VPB|VPWR sky130_fd_pr__pfet_01v8_hvt L=0.15 W=1
+ AS=0.26 AD=0.105 PS=2.52 PD=1.21
M$6179 \$8552 A|Y VPB|VPWR VPB|VPWR sky130_fd_pr__pfet_01v8_hvt L=0.15 W=1
+ AS=0.105 AD=0.26 PS=1.21 PD=2.52
M$6180 VPB|VPWR A|B|Y \$8381 VPB|VPWR sky130_fd_pr__pfet_01v8_hvt L=0.15 W=1
+ AS=0.3 AD=0.135 PS=2.6 PD=1.27
M$6181 \$8381 A|X VPB|VPWR VPB|VPWR sky130_fd_pr__pfet_01v8_hvt L=0.15 W=1
+ AS=0.135 AD=0.365 PS=1.27 PD=1.73
M$6182 VPB|VPWR A|X \$8553 VPB|VPWR sky130_fd_pr__pfet_01v8_hvt L=0.15 W=1
+ AS=0.365 AD=0.105 PS=1.73 PD=1.21
M$6183 \$8553 A|B|Y A|A1|B|Y VPB|VPWR sky130_fd_pr__pfet_01v8_hvt L=0.15 W=1
+ AS=0.105 AD=0.165 PS=1.21 PD=1.33
M$6184 A|A1|B|Y \$8381 VPB|VPWR VPB|VPWR sky130_fd_pr__pfet_01v8_hvt L=0.15 W=1
+ AS=0.165 AD=0.36 PS=1.33 PD=2.72
M$6187 \$8283 A|B|SLEEP|Y \$8321 VPB|VPWR sky130_fd_pr__pfet_01v8_hvt L=0.15
+ W=0.42 AS=0.1092 AD=0.0441 PS=1.36 PD=0.63
M$6188 VPB|VPWR B|SLEEP|Y \$8321 VPB|VPWR sky130_fd_pr__pfet_01v8_hvt L=0.15
+ W=0.42 AS=0.14575 AD=0.0441 PS=1.335 PD=0.63
M$6189 VPB|VPWR \$8283 A2|X VPB|VPWR sky130_fd_pr__pfet_01v8_hvt L=0.15 W=1
+ AS=0.14575 AD=0.34 PS=1.335 PD=2.68
M$6190 \$8383 A|A1|Y \$8555 VPB|VPWR sky130_fd_pr__pfet_01v8_hvt L=0.15 W=0.42
+ AS=0.1092 AD=0.0441 PS=1.36 PD=0.63
M$6191 \$8555 A|B|SLEEP|Y VPB|VPWR VPB|VPWR sky130_fd_pr__pfet_01v8_hvt L=0.15
+ W=0.42 AS=0.0441 AD=0.14575 PS=0.63 PD=1.335
M$6192 VPB|VPWR \$8383 A|B1|X VPB|VPWR sky130_fd_pr__pfet_01v8_hvt L=0.15 W=1
+ AS=0.14575 AD=0.34 PS=1.335 PD=2.68
M$6193 \$8384 B|SLEEP|Y \$8557 VPB|VPWR sky130_fd_pr__pfet_01v8_hvt L=0.15 W=1
+ AS=0.26 AD=0.135 PS=2.52 PD=1.27
M$6194 \$8557 A|B1|X VPB|VPWR VPB|VPWR sky130_fd_pr__pfet_01v8_hvt L=0.15 W=1
+ AS=0.135 AD=0.135 PS=1.27 PD=1.27
M$6195 VPB|VPWR A|B1|X \$8544 VPB|VPWR sky130_fd_pr__pfet_01v8_hvt L=0.15 W=1
+ AS=0.135 AD=0.135 PS=1.27 PD=1.27
M$6196 \$8544 B|SLEEP|Y VPB|VPWR VPB|VPWR sky130_fd_pr__pfet_01v8_hvt L=0.15
+ W=1 AS=0.135 AD=0.26 PS=1.27 PD=2.52
M$6197 \$8544 \$8384 A2|C|D|X VPB|VPWR sky130_fd_pr__pfet_01v8_hvt L=0.15 W=1
+ AS=0.26 AD=0.3 PS=2.52 PD=2.6
M$6203 \$8290 A|A1|Y \$8324 VPB|VPWR sky130_fd_pr__pfet_01v8_hvt L=0.15 W=0.42
+ AS=0.1092 AD=0.0441 PS=1.36 PD=0.63
M$6204 VPB|VPWR A2|SLEEP|X \$8324 VPB|VPWR sky130_fd_pr__pfet_01v8_hvt L=0.15
+ W=0.42 AS=0.14575 AD=0.0441 PS=1.335 PD=0.63
M$6205 VPB|VPWR \$8290 A1|A3|B|X VPB|VPWR sky130_fd_pr__pfet_01v8_hvt L=0.15
+ W=1 AS=0.14575 AD=0.34 PS=1.335 PD=2.68
M$6207 \$8387 \$8390 \$8391 VPB|VPWR sky130_fd_pr__pfet_01v8_hvt L=0.15 W=0.64
+ AS=0.246 AD=0.2431 PS=1.525 PD=1.445
M$6208 \$8387 A1|A3|B|X \$8392 VPB|VPWR sky130_fd_pr__pfet_01v8_hvt L=0.15
+ W=0.64 AS=0.246 AD=0.1458 PS=1.525 PD=1.205
M$6209 \$8391 A1|A3|B|X \$8388 VPB|VPWR sky130_fd_pr__pfet_01v8_hvt L=0.15
+ W=0.84 AS=0.2431 AD=0.3528 PS=1.445 PD=2.52
M$6210 \$8387 \$8388 VPB|VPWR VPB|VPWR sky130_fd_pr__pfet_01v8_hvt L=0.15 W=1
+ AS=0.285 AD=0.135 PS=2.57 PD=1.27
M$6211 VPB|VPWR A|Y \$8388 VPB|VPWR sky130_fd_pr__pfet_01v8_hvt L=0.15 W=1
+ AS=0.135 AD=0.1715 PS=1.27 PD=1.355
M$6212 \$8388 \$8390 \$8392 VPB|VPWR sky130_fd_pr__pfet_01v8_hvt L=0.15 W=0.84
+ AS=0.1715 AD=0.1458 PS=1.355 PD=1.205
M$6213 \$8390 A1|A3|B|X VPB|VPWR VPB|VPWR sky130_fd_pr__pfet_01v8_hvt L=0.15
+ W=1 AS=0.26 AD=0.25655 PS=2.52 PD=2.52
M$6214 \$8391 \$8393 \$8394 VPB|VPWR sky130_fd_pr__pfet_01v8_hvt L=0.15 W=0.84
+ AS=0.32235 AD=0.15295 PS=2.45 PD=1.315
M$6215 \$8394 C|Y \$8392 VPB|VPWR sky130_fd_pr__pfet_01v8_hvt L=0.15 W=0.84
+ AS=0.15295 AD=0.273 PS=1.315 PD=2.33
M$6216 \$8393 C|Y VPB|VPWR VPB|VPWR sky130_fd_pr__pfet_01v8_hvt L=0.15 W=0.64
+ AS=0.1792 AD=0.169 PS=1.84 PD=1.365
M$6217 VPB|VPWR \$8394 A3|B|X VPB|VPWR sky130_fd_pr__pfet_01v8_hvt L=0.15 W=1
+ AS=0.169 AD=0.28 PS=1.365 PD=2.56
M$6219 VPB|VPWR A|A1|B|Y \$8560 VPB|VPWR sky130_fd_pr__pfet_01v8_hvt L=0.15 W=1
+ AS=0.26 AD=0.135 PS=2.52 PD=1.27
M$6220 \$8560 A2|Y \$8561 VPB|VPWR sky130_fd_pr__pfet_01v8_hvt L=0.15 W=1
+ AS=0.135 AD=0.135 PS=1.27 PD=1.27
M$6221 \$8561 A3|B|X B|Y VPB|VPWR sky130_fd_pr__pfet_01v8_hvt L=0.15 W=1
+ AS=0.135 AD=0.3925 PS=1.27 PD=1.785
M$6223 VPB|VPWR A|A1|B|Y \$8397 VPB|VPWR sky130_fd_pr__pfet_01v8_hvt L=0.15 W=1
+ AS=0.3 AD=0.135 PS=2.6 PD=1.27
M$6224 \$8397 A|B1|C1|X VPB|VPWR VPB|VPWR sky130_fd_pr__pfet_01v8_hvt L=0.15
+ W=1 AS=0.135 AD=0.365 PS=1.27 PD=1.73
M$6225 VPB|VPWR A|B1|C1|X \$8563 VPB|VPWR sky130_fd_pr__pfet_01v8_hvt L=0.15
+ W=1 AS=0.365 AD=0.105 PS=1.73 PD=1.21
M$6226 \$8563 A|A1|B|Y A|B|Y VPB|VPWR sky130_fd_pr__pfet_01v8_hvt L=0.15 W=1
+ AS=0.105 AD=0.165 PS=1.21 PD=1.33
M$6227 A|B|Y \$8397 VPB|VPWR VPB|VPWR sky130_fd_pr__pfet_01v8_hvt L=0.15 W=1
+ AS=0.165 AD=0.36 PS=1.33 PD=2.72
M$6231 VPB|VPWR A|B|Y \$8400 VPB|VPWR sky130_fd_pr__pfet_01v8_hvt L=0.15 W=1
+ AS=0.3 AD=0.135 PS=2.6 PD=1.27
M$6232 \$8400 A|B1|X VPB|VPWR VPB|VPWR sky130_fd_pr__pfet_01v8_hvt L=0.15 W=1
+ AS=0.135 AD=0.365 PS=1.27 PD=1.73
M$6233 VPB|VPWR A|B1|X \$8559 VPB|VPWR sky130_fd_pr__pfet_01v8_hvt L=0.15 W=1
+ AS=0.365 AD=0.105 PS=1.73 PD=1.21
M$6234 \$8559 A|B|Y A|B|Y VPB|VPWR sky130_fd_pr__pfet_01v8_hvt L=0.15 W=1
+ AS=0.105 AD=0.165 PS=1.21 PD=1.33
M$6235 A|B|Y \$8400 VPB|VPWR VPB|VPWR sky130_fd_pr__pfet_01v8_hvt L=0.15 W=1
+ AS=0.165 AD=0.36 PS=1.33 PD=2.72
M$6238 VPB|VPWR B|Y A2|B|Y VPB|VPWR sky130_fd_pr__pfet_01v8_hvt L=0.15 W=1
+ AS=0.26 AD=0.135 PS=2.52 PD=1.27
M$6239 A2|B|Y A|X VPB|VPWR VPB|VPWR sky130_fd_pr__pfet_01v8_hvt L=0.15 W=1
+ AS=0.135 AD=0.26 PS=1.27 PD=2.52
M$6241 \$8294 B|C|Y \$8333 VPB|VPWR sky130_fd_pr__pfet_01v8_hvt L=0.15 W=0.42
+ AS=0.1092 AD=0.0441 PS=1.36 PD=0.63
M$6242 \$8333 A|Y VPB|VPWR VPB|VPWR sky130_fd_pr__pfet_01v8_hvt L=0.15 W=0.42
+ AS=0.0441 AD=0.0567 PS=0.63 PD=0.69
M$6243 VPB|VPWR A|Y \$8334 VPB|VPWR sky130_fd_pr__pfet_01v8_hvt L=0.15 W=0.42
+ AS=0.0567 AD=0.0441 PS=0.69 PD=0.63
M$6244 \$8334 B|Y \$8294 VPB|VPWR sky130_fd_pr__pfet_01v8_hvt L=0.15 W=0.42
+ AS=0.0441 AD=0.0567 PS=0.63 PD=0.69
M$6245 \$8294 B|Y \$8335 VPB|VPWR sky130_fd_pr__pfet_01v8_hvt L=0.15 W=0.42
+ AS=0.0567 AD=0.0441 PS=0.69 PD=0.63
M$6246 VPB|VPWR B|C|Y \$8335 VPB|VPWR sky130_fd_pr__pfet_01v8_hvt L=0.15 W=0.42
+ AS=0.2492 AD=0.0441 PS=1.565 PD=0.63
M$6247 VPB|VPWR \$8294 B|X VPB|VPWR sky130_fd_pr__pfet_01v8_hvt L=0.15 W=1
+ AS=0.2492 AD=0.365 PS=1.565 PD=2.73
M$6253 \$8296 CLK|TICK VPB|VPWR VPB|VPWR sky130_fd_pr__pfet_01v8_hvt L=0.15
+ W=0.64 AS=0.1664 AD=0.0864 PS=1.8 PD=0.91
M$6254 VPB|VPWR \$8296 \$8297 VPB|VPWR sky130_fd_pr__pfet_01v8_hvt L=0.15
+ W=0.64 AS=0.0864 AD=0.1664 PS=0.91 PD=1.8
M$6256 VPB|VPWR B|C|X \$8405 VPB|VPWR sky130_fd_pr__pfet_01v8_hvt L=0.15 W=1
+ AS=0.3 AD=0.135 PS=2.6 PD=1.27
M$6257 \$8405 A|Q VPB|VPWR VPB|VPWR sky130_fd_pr__pfet_01v8_hvt L=0.15 W=1
+ AS=0.135 AD=0.365 PS=1.27 PD=1.73
M$6258 VPB|VPWR A|Q \$8556 VPB|VPWR sky130_fd_pr__pfet_01v8_hvt L=0.15 W=1
+ AS=0.365 AD=0.105 PS=1.73 PD=1.21
M$6259 \$8556 B|C|X B|Y VPB|VPWR sky130_fd_pr__pfet_01v8_hvt L=0.15 W=1
+ AS=0.105 AD=0.165 PS=1.21 PD=1.33
M$6260 B|Y \$8405 VPB|VPWR VPB|VPWR sky130_fd_pr__pfet_01v8_hvt L=0.15 W=1
+ AS=0.165 AD=0.36 PS=1.33 PD=2.72
M$6262 VPB|VPWR A|Q A1|Y VPB|VPWR sky130_fd_pr__pfet_01v8_hvt L=0.15 W=1.68
+ AS=0.3486 AD=0.3318 PS=3.35 PD=3.31
M$6264 VPB|VPWR \$8414 \$8543 VPB|VPWR sky130_fd_pr__pfet_01v8_hvt L=0.15
+ W=0.84 AS=0.2184 AD=0.12915 PS=2.2 PD=1.185
M$6265 \$8543 \$8411 \$8415 VPB|VPWR sky130_fd_pr__pfet_01v8_hvt L=0.15 W=0.42
+ AS=0.12915 AD=0.0588 PS=1.185 PD=0.7
M$6266 \$8415 \$8412 \$8550 VPB|VPWR sky130_fd_pr__pfet_01v8_hvt L=0.15 W=0.42
+ AS=0.0588 AD=0.0567 PS=0.7 PD=0.69
M$6267 \$8550 \$8416 VPB|VPWR VPB|VPWR sky130_fd_pr__pfet_01v8_hvt L=0.15
+ W=0.42 AS=0.0567 AD=0.0819 PS=0.69 PD=0.81
M$6268 VPB|VPWR RESET_B|X \$8416 VPB|VPWR sky130_fd_pr__pfet_01v8_hvt L=0.15
+ W=0.42 AS=0.0819 AD=0.0567 PS=0.81 PD=0.69
M$6269 \$8416 \$8415 VPB|VPWR VPB|VPWR sky130_fd_pr__pfet_01v8_hvt L=0.15
+ W=0.42 AS=0.0567 AD=0.1134 PS=0.69 PD=1.38
M$6270 VPB|VPWR \$8416 A|Q VPB|VPWR sky130_fd_pr__pfet_01v8_hvt L=0.15 W=1
+ AS=0.3012 AD=0.26 PS=2.66 PD=2.52
M$6273 \$8310 \$8350 VPB|VPWR VPB|VPWR sky130_fd_pr__pfet_01v8_hvt L=0.15
+ W=0.64 AS=0.1664 AD=0.0864 PS=1.8 PD=0.91
M$6274 VPB|VPWR CLK|TICK \$8350 VPB|VPWR sky130_fd_pr__pfet_01v8_hvt L=0.15
+ W=0.64 AS=0.0864 AD=0.1664 PS=0.91 PD=1.8
M$6290 VPB|VPWR A|A1|Y A1|Y VPB|VPWR sky130_fd_pr__pfet_01v8_hvt L=0.15 W=1.68
+ AS=0.3318 AD=0.3486 PS=3.31 PD=3.35
M$6292 VPB|VPWR A1|Y \$8592 VPB|VPWR sky130_fd_pr__pfet_01v8_hvt L=0.15 W=0.64
+ AS=0.1696 AD=0.0768 PS=1.81 PD=0.88
M$6293 \$8592 A2|B|C|X A|B|C|Y VPB|VPWR sky130_fd_pr__pfet_01v8_hvt L=0.15
+ W=0.64 AS=0.0768 AD=0.0896 PS=0.88 PD=0.92
M$6295 VPB|VPWR A|A1|B|Y \$8567 VPB|VPWR sky130_fd_pr__pfet_01v8_hvt L=0.15 W=1
+ AS=0.3 AD=0.135 PS=2.6 PD=1.27
M$6296 \$8567 A|B1|X VPB|VPWR VPB|VPWR sky130_fd_pr__pfet_01v8_hvt L=0.15 W=1
+ AS=0.135 AD=0.365 PS=1.27 PD=1.73
M$6297 VPB|VPWR A|B1|X \$8593 VPB|VPWR sky130_fd_pr__pfet_01v8_hvt L=0.15 W=1
+ AS=0.365 AD=0.105 PS=1.73 PD=1.21
M$6298 \$8593 A|A1|B|Y A|B|Y VPB|VPWR sky130_fd_pr__pfet_01v8_hvt L=0.15 W=1
+ AS=0.105 AD=0.165 PS=1.21 PD=1.33
M$6299 A|B|Y \$8567 VPB|VPWR VPB|VPWR sky130_fd_pr__pfet_01v8_hvt L=0.15 W=1
+ AS=0.165 AD=0.36 PS=1.33 PD=2.72
M$6301 VPB|VPWR A2|C|D|X B1|Y VPB|VPWR sky130_fd_pr__pfet_01v8_hvt L=0.15 W=1
+ AS=0.26 AD=0.135 PS=2.52 PD=1.27
M$6302 B1|Y A2|B|C|X VPB|VPWR VPB|VPWR sky130_fd_pr__pfet_01v8_hvt L=0.15 W=1
+ AS=0.135 AD=0.135 PS=1.27 PD=1.27
M$6306 VPB|VPWR B1|Y A|B1|Y VPB|VPWR sky130_fd_pr__pfet_01v8_hvt L=0.15 W=0.64
+ AS=0.1824 AD=0.0896 PS=1.85 PD=0.92
M$6307 A|B1|Y A|A2|B|C|SLEEP|Y \$8595 VPB|VPWR sky130_fd_pr__pfet_01v8_hvt
+ L=0.15 W=0.64 AS=0.0896 AD=0.0768 PS=0.92 PD=0.88
M$6308 \$8595 A|A1|X VPB|VPWR VPB|VPWR sky130_fd_pr__pfet_01v8_hvt L=0.15
+ W=0.64 AS=0.0768 AD=0.1696 PS=0.88 PD=1.81
M$6311 C|Y A|A2|B|C|SLEEP|Y \$8598 VPB|VPWR sky130_fd_pr__pfet_01v8_hvt L=0.15
+ W=1 AS=0.26 AD=0.105 PS=2.52 PD=1.21
M$6312 \$8598 A|B|B1|Y VPB|VPWR VPB|VPWR sky130_fd_pr__pfet_01v8_hvt L=0.15 W=1
+ AS=0.105 AD=0.26 PS=1.21 PD=2.52
M$6314 VPB|VPWR A1|B|Y A|Y VPB|VPWR sky130_fd_pr__pfet_01v8_hvt L=0.15 W=1
+ AS=0.26 AD=0.135 PS=2.52 PD=1.27
M$6317 VPB|VPWR \$8573 A2|Y VPB|VPWR sky130_fd_pr__pfet_01v8_hvt L=0.15 W=1
+ AS=0.265 AD=0.135 PS=2.53 PD=1.27
M$6318 A2|Y A1|B|Y VPB|VPWR VPB|VPWR sky130_fd_pr__pfet_01v8_hvt L=0.15 W=1
+ AS=0.135 AD=0.14575 PS=1.27 PD=1.335
M$6319 VPB|VPWR A2|A_N|B|X \$8573 VPB|VPWR sky130_fd_pr__pfet_01v8_hvt L=0.15
+ W=0.42 AS=0.14575 AD=0.1092 PS=1.335 PD=1.36
M$6321 VPB|VPWR A|B1|X A|A1|B|Y VPB|VPWR sky130_fd_pr__pfet_01v8_hvt L=0.15 W=1
+ AS=0.26 AD=0.135 PS=2.52 PD=1.27
M$6322 A|A1|B|Y A|B|Y VPB|VPWR VPB|VPWR sky130_fd_pr__pfet_01v8_hvt L=0.15 W=1
+ AS=0.135 AD=0.26 PS=1.27 PD=2.52
M$6324 \$8575 A|B|Y \$8600 VPB|VPWR sky130_fd_pr__pfet_01v8_hvt L=0.15 W=1
+ AS=0.26 AD=0.135 PS=2.52 PD=1.27
M$6325 \$8600 A|X VPB|VPWR VPB|VPWR sky130_fd_pr__pfet_01v8_hvt L=0.15 W=1
+ AS=0.135 AD=0.135 PS=1.27 PD=1.27
M$6326 VPB|VPWR A|X \$8576 VPB|VPWR sky130_fd_pr__pfet_01v8_hvt L=0.15 W=1
+ AS=0.135 AD=0.135 PS=1.27 PD=1.27
M$6327 \$8576 A|B|Y VPB|VPWR VPB|VPWR sky130_fd_pr__pfet_01v8_hvt L=0.15 W=1
+ AS=0.135 AD=0.26 PS=1.27 PD=2.52
M$6328 \$8576 \$8575 A|B|X VPB|VPWR sky130_fd_pr__pfet_01v8_hvt L=0.15 W=1
+ AS=0.26 AD=0.3 PS=2.52 PD=2.6
M$6332 \$8578 A|B|X \$8603 VPB|VPWR sky130_fd_pr__pfet_01v8_hvt L=0.15 W=1
+ AS=0.26 AD=0.135 PS=2.52 PD=1.27
M$6333 \$8603 A|X VPB|VPWR VPB|VPWR sky130_fd_pr__pfet_01v8_hvt L=0.15 W=1
+ AS=0.135 AD=0.135 PS=1.27 PD=1.27
M$6334 VPB|VPWR A|X \$8579 VPB|VPWR sky130_fd_pr__pfet_01v8_hvt L=0.15 W=1
+ AS=0.135 AD=0.135 PS=1.27 PD=1.27
M$6335 \$8579 A|B|X VPB|VPWR VPB|VPWR sky130_fd_pr__pfet_01v8_hvt L=0.15 W=1
+ AS=0.135 AD=0.26 PS=1.27 PD=2.52
M$6336 \$8579 \$8578 A|A1|B|X VPB|VPWR sky130_fd_pr__pfet_01v8_hvt L=0.15 W=1
+ AS=0.26 AD=0.3 PS=2.52 PD=2.6
M$6339 VPB|VPWR A|A1|Y \$8605 VPB|VPWR sky130_fd_pr__pfet_01v8_hvt L=0.15 W=1
+ AS=0.26 AD=0.135 PS=2.52 PD=1.27
M$6340 \$8605 A2|B|X \$8604 VPB|VPWR sky130_fd_pr__pfet_01v8_hvt L=0.15 W=1
+ AS=0.135 AD=0.135 PS=1.27 PD=1.27
M$6341 \$8604 A3|B1|C|SLEEP|Y A|B1|Y VPB|VPWR sky130_fd_pr__pfet_01v8_hvt
+ L=0.15 W=1 AS=0.135 AD=0.26 PS=1.27 PD=2.52
M$6342 A|Y A|B1|Y \$8583 VPB|VPWR sky130_fd_pr__pfet_01v8_hvt L=0.15 W=1
+ AS=0.265 AD=0.14 PS=2.53 PD=1.28
M$6343 \$8583 A|A1|Y VPB|VPWR VPB|VPWR sky130_fd_pr__pfet_01v8_hvt L=0.15 W=1
+ AS=0.14 AD=0.1475 PS=1.28 PD=1.295
M$6344 VPB|VPWR A2|B|Y \$8583 VPB|VPWR sky130_fd_pr__pfet_01v8_hvt L=0.15 W=1
+ AS=0.1475 AD=0.265 PS=1.295 PD=2.53
M$6349 VPB|VPWR \$8584 D|Y VPB|VPWR sky130_fd_pr__pfet_01v8_hvt L=0.15 W=1
+ AS=0.36 AD=0.165 PS=2.72 PD=1.33
M$6350 D|Y B|Y \$8602 VPB|VPWR sky130_fd_pr__pfet_01v8_hvt L=0.15 W=1 AS=0.165
+ AD=0.105 PS=1.33 PD=1.21
M$6351 \$8602 A|B|Y VPB|VPWR VPB|VPWR sky130_fd_pr__pfet_01v8_hvt L=0.15 W=1
+ AS=0.105 AD=0.365 PS=1.21 PD=1.73
M$6352 VPB|VPWR A|B|Y \$8584 VPB|VPWR sky130_fd_pr__pfet_01v8_hvt L=0.15 W=1
+ AS=0.365 AD=0.135 PS=1.73 PD=1.27
M$6353 \$8584 B|Y VPB|VPWR VPB|VPWR sky130_fd_pr__pfet_01v8_hvt L=0.15 W=1
+ AS=0.135 AD=0.3 PS=1.27 PD=2.6
M$6355 VPB|VPWR B1|Y A|B|Y VPB|VPWR sky130_fd_pr__pfet_01v8_hvt L=0.15 W=0.64
+ AS=0.1824 AD=0.0896 PS=1.85 PD=0.92
M$6356 A|B|Y A2|B|X \$8551 VPB|VPWR sky130_fd_pr__pfet_01v8_hvt L=0.15 W=0.64
+ AS=0.0896 AD=0.0768 PS=0.92 PD=0.88
M$6357 \$8551 A1|Y VPB|VPWR VPB|VPWR sky130_fd_pr__pfet_01v8_hvt L=0.15 W=0.64
+ AS=0.0768 AD=0.1696 PS=0.88 PD=1.81
M$6358 VPB|VPWR A2|B|X \$8585 VPB|VPWR sky130_fd_pr__pfet_01v8_hvt L=0.15 W=1
+ AS=0.3 AD=0.135 PS=2.6 PD=1.27
M$6359 \$8585 A|Q VPB|VPWR VPB|VPWR sky130_fd_pr__pfet_01v8_hvt L=0.15 W=1
+ AS=0.135 AD=0.365 PS=1.27 PD=1.73
M$6360 VPB|VPWR A|Q \$8597 VPB|VPWR sky130_fd_pr__pfet_01v8_hvt L=0.15 W=1
+ AS=0.365 AD=0.105 PS=1.73 PD=1.21
M$6361 \$8597 A2|B|X B|Y VPB|VPWR sky130_fd_pr__pfet_01v8_hvt L=0.15 W=1
+ AS=0.105 AD=0.165 PS=1.21 PD=1.33
M$6362 B|Y \$8585 VPB|VPWR VPB|VPWR sky130_fd_pr__pfet_01v8_hvt L=0.15 W=1
+ AS=0.165 AD=0.36 PS=1.33 PD=2.72
M$6363 \$8411 CLK|TICK VPB|VPWR VPB|VPWR sky130_fd_pr__pfet_01v8_hvt L=0.15
+ W=0.64 AS=0.1664 AD=0.0864 PS=1.8 PD=0.91
M$6364 VPB|VPWR \$8411 \$8412 VPB|VPWR sky130_fd_pr__pfet_01v8_hvt L=0.15
+ W=0.64 AS=0.0864 AD=0.1664 PS=0.91 PD=1.8
M$6365 VPB|VPWR B|Y \$8586 VPB|VPWR sky130_fd_pr__pfet_01v8_hvt L=0.15 W=0.42
+ AS=0.1841 AD=0.0609 PS=1.26 PD=0.71
M$6366 \$8586 A|Q VPB|VPWR VPB|VPWR sky130_fd_pr__pfet_01v8_hvt L=0.15 W=0.42
+ AS=0.0609 AD=0.1113 PS=0.71 PD=1.37
M$6367 A|X \$8586 VPB|VPWR VPB|VPWR sky130_fd_pr__pfet_01v8_hvt L=0.15 W=0.64
+ AS=0.1696 AD=0.1841 PS=1.81 PD=1.26
M$6368 VPB|VPWR D|Y \$8413 VPB|VPWR sky130_fd_pr__pfet_01v8_hvt L=0.15 W=0.42
+ AS=0.1092 AD=0.0651 PS=1.36 PD=0.73
M$6369 \$8413 \$8412 \$8414 VPB|VPWR sky130_fd_pr__pfet_01v8_hvt L=0.15 W=0.42
+ AS=0.0651 AD=0.07245 PS=0.73 PD=0.765
M$6370 \$8414 \$8411 \$8545 VPB|VPWR sky130_fd_pr__pfet_01v8_hvt L=0.15 W=0.42
+ AS=0.07245 AD=0.1155 PS=0.765 PD=0.97
M$6371 \$8545 \$8543 VPB|VPWR VPB|VPWR sky130_fd_pr__pfet_01v8_hvt L=0.15
+ W=0.42 AS=0.1155 AD=0.07035 PS=0.97 PD=0.755
M$6372 VPB|VPWR RESET_B|X \$8545 VPB|VPWR sky130_fd_pr__pfet_01v8_hvt L=0.15
+ W=0.42 AS=0.07035 AD=0.1092 PS=0.755 PD=1.36
M$6373 B|Y B|Y \$8594 VPB|VPWR sky130_fd_pr__pfet_01v8_hvt L=0.15 W=1 AS=0.26
+ AD=0.105 PS=2.52 PD=1.21
M$6374 \$8594 A|Q VPB|VPWR VPB|VPWR sky130_fd_pr__pfet_01v8_hvt L=0.15 W=1
+ AS=0.105 AD=0.26 PS=1.21 PD=2.52
M$6391 \$8569 A|B|Y VPB|VPWR VPB|VPWR sky130_fd_pr__pfet_01v8_hvt L=0.15 W=0.42
+ AS=0.1092 AD=0.0567 PS=1.36 PD=0.69
M$6392 VPB|VPWR A2|B|C|X \$8569 VPB|VPWR sky130_fd_pr__pfet_01v8_hvt L=0.15
+ W=0.42 AS=0.0567 AD=0.06615 PS=0.69 PD=0.735
M$6393 VPB|VPWR A2|C|D|X \$8569 VPB|VPWR sky130_fd_pr__pfet_01v8_hvt L=0.15
+ W=0.42 AS=0.142225 AD=0.06615 PS=1.335 PD=0.735
M$6394 VPB|VPWR \$8569 A1|X VPB|VPWR sky130_fd_pr__pfet_01v8_hvt L=0.15 W=1
+ AS=0.142225 AD=0.26 PS=1.335 PD=2.52
M$6396 A3|Y A|A2|B|C|SLEEP|Y \$8834 VPB|VPWR sky130_fd_pr__pfet_01v8_hvt L=0.15
+ W=1 AS=0.26 AD=0.135 PS=2.52 PD=1.27
M$6397 \$8834 A|B|C|Y \$8835 VPB|VPWR sky130_fd_pr__pfet_01v8_hvt L=0.15 W=1
+ AS=0.135 AD=0.135 PS=1.27 PD=1.27
M$6398 \$8835 A|A2|B|Y VPB|VPWR VPB|VPWR sky130_fd_pr__pfet_01v8_hvt L=0.15 W=1
+ AS=0.135 AD=0.26 PS=1.27 PD=2.52
M$6399 \$8644 A|B|C|Y \$8837 VPB|VPWR sky130_fd_pr__pfet_01v8_hvt L=0.15 W=0.42
+ AS=0.1092 AD=0.0441 PS=1.36 PD=0.63
M$6400 \$8837 A|A2|B|Y \$8836 VPB|VPWR sky130_fd_pr__pfet_01v8_hvt L=0.15
+ W=0.42 AS=0.0441 AD=0.0693 PS=0.63 PD=0.75
M$6401 \$8836 A|A1|B1|Y VPB|VPWR VPB|VPWR sky130_fd_pr__pfet_01v8_hvt L=0.15
+ W=0.42 AS=0.0693 AD=0.14825 PS=0.75 PD=1.34
M$6402 VPB|VPWR \$8644 A|A1|X VPB|VPWR sky130_fd_pr__pfet_01v8_hvt L=0.15 W=1
+ AS=0.14825 AD=0.28 PS=1.34 PD=2.56
M$6406 VPB|VPWR B|Y \$8646 VPB|VPWR sky130_fd_pr__pfet_01v8_hvt L=0.15 W=1
+ AS=0.3 AD=0.135 PS=2.6 PD=1.27
M$6407 \$8646 A|A2|B|C|SLEEP|Y VPB|VPWR VPB|VPWR sky130_fd_pr__pfet_01v8_hvt
+ L=0.15 W=1 AS=0.135 AD=0.365 PS=1.27 PD=1.73
M$6408 VPB|VPWR A|A2|B|C|SLEEP|Y \$8838 VPB|VPWR sky130_fd_pr__pfet_01v8_hvt
+ L=0.15 W=1 AS=0.365 AD=0.105 PS=1.73 PD=1.21
M$6409 \$8838 B|Y A1|B|Y VPB|VPWR sky130_fd_pr__pfet_01v8_hvt L=0.15 W=1
+ AS=0.105 AD=0.165 PS=1.21 PD=1.33
M$6410 A1|B|Y \$8646 VPB|VPWR VPB|VPWR sky130_fd_pr__pfet_01v8_hvt L=0.15 W=1
+ AS=0.165 AD=0.36 PS=1.33 PD=2.72
M$6413 VPB|VPWR A1|B|Y \$8648 VPB|VPWR sky130_fd_pr__pfet_01v8_hvt L=0.15 W=1
+ AS=0.3 AD=0.135 PS=2.6 PD=1.27
M$6414 \$8648 A|Y VPB|VPWR VPB|VPWR sky130_fd_pr__pfet_01v8_hvt L=0.15 W=1
+ AS=0.135 AD=0.365 PS=1.27 PD=1.73
M$6415 VPB|VPWR A|Y \$8842 VPB|VPWR sky130_fd_pr__pfet_01v8_hvt L=0.15 W=1
+ AS=0.365 AD=0.105 PS=1.73 PD=1.21
M$6416 \$8842 A1|B|Y A|C|Y VPB|VPWR sky130_fd_pr__pfet_01v8_hvt L=0.15 W=1
+ AS=0.105 AD=0.165 PS=1.21 PD=1.33
M$6417 A|C|Y \$8648 VPB|VPWR VPB|VPWR sky130_fd_pr__pfet_01v8_hvt L=0.15 W=1
+ AS=0.165 AD=0.36 PS=1.33 PD=2.72
M$6419 VPB|VPWR A3|B|X \$8651 VPB|VPWR sky130_fd_pr__pfet_01v8_hvt L=0.15 W=1
+ AS=0.3 AD=0.135 PS=2.6 PD=1.27
M$6420 \$8651 A|Y VPB|VPWR VPB|VPWR sky130_fd_pr__pfet_01v8_hvt L=0.15 W=1
+ AS=0.135 AD=0.365 PS=1.27 PD=1.73
M$6421 VPB|VPWR A|Y \$8844 VPB|VPWR sky130_fd_pr__pfet_01v8_hvt L=0.15 W=1
+ AS=0.365 AD=0.105 PS=1.73 PD=1.21
M$6422 \$8844 A3|B|X B|D|Y VPB|VPWR sky130_fd_pr__pfet_01v8_hvt L=0.15 W=1
+ AS=0.105 AD=0.165 PS=1.21 PD=1.33
M$6423 B|D|Y \$8651 VPB|VPWR VPB|VPWR sky130_fd_pr__pfet_01v8_hvt L=0.15 W=1
+ AS=0.165 AD=0.36 PS=1.33 PD=2.72
M$6425 \$8655 B|D|Y \$8847 VPB|VPWR sky130_fd_pr__pfet_01v8_hvt L=0.15 W=0.42
+ AS=0.1092 AD=0.0693 PS=1.36 PD=0.75
M$6426 \$8847 A|C|X \$8846 VPB|VPWR sky130_fd_pr__pfet_01v8_hvt L=0.15 W=0.42
+ AS=0.0693 AD=0.0441 PS=0.75 PD=0.63
M$6427 \$8846 A|B|B1|X \$8848 VPB|VPWR sky130_fd_pr__pfet_01v8_hvt L=0.15
+ W=0.42 AS=0.0441 AD=0.0693 PS=0.63 PD=0.75
M$6428 \$8848 A|B|Y VPB|VPWR VPB|VPWR sky130_fd_pr__pfet_01v8_hvt L=0.15 W=0.42
+ AS=0.0693 AD=0.14825 PS=0.75 PD=1.34
M$6429 VPB|VPWR \$8655 B|C|X VPB|VPWR sky130_fd_pr__pfet_01v8_hvt L=0.15 W=1
+ AS=0.14825 AD=0.27 PS=1.34 PD=2.54
M$6431 B|Y A|C|Y \$8850 VPB|VPWR sky130_fd_pr__pfet_01v8_hvt L=0.15 W=1 AS=0.26
+ AD=0.135 PS=2.52 PD=1.27
M$6432 \$8850 A|B|B1|X \$8849 VPB|VPWR sky130_fd_pr__pfet_01v8_hvt L=0.15 W=1
+ AS=0.135 AD=0.135 PS=1.27 PD=1.27
M$6433 \$8849 A|B|X VPB|VPWR VPB|VPWR sky130_fd_pr__pfet_01v8_hvt L=0.15 W=1
+ AS=0.135 AD=0.26 PS=1.27 PD=2.52
M$6436 VPB|VPWR A|A1|B|X \$8853 VPB|VPWR sky130_fd_pr__pfet_01v8_hvt L=0.15 W=1
+ AS=0.28 AD=0.175 PS=2.56 PD=1.35
M$6437 \$8853 A2|B|X \$8852 VPB|VPWR sky130_fd_pr__pfet_01v8_hvt L=0.15 W=1
+ AS=0.175 AD=0.135 PS=1.35 PD=1.27
M$6438 \$8852 A3|B1|C|SLEEP|Y \$8851 VPB|VPWR sky130_fd_pr__pfet_01v8_hvt
+ L=0.15 W=1 AS=0.135 AD=0.3125 PS=1.27 PD=1.625
M$6439 \$8851 A4|B|X B|Y VPB|VPWR sky130_fd_pr__pfet_01v8_hvt L=0.15 W=1
+ AS=0.3125 AD=0.135 PS=1.625 PD=1.27
M$6444 VPB|VPWR A|A1|Y \$8845 VPB|VPWR sky130_fd_pr__pfet_01v8_hvt L=0.15 W=1
+ AS=0.26 AD=0.1525 PS=2.52 PD=1.305
M$6445 \$8845 A2|B|X \$8665 VPB|VPWR sky130_fd_pr__pfet_01v8_hvt L=0.15 W=1
+ AS=0.1525 AD=0.195 PS=1.305 PD=1.39
M$6446 \$8665 A3|B1|C|SLEEP|Y VPB|VPWR VPB|VPWR sky130_fd_pr__pfet_01v8_hvt
+ L=0.15 W=1 AS=0.195 AD=0.3275 PS=1.39 PD=1.655
M$6447 VPB|VPWR \$8665 B|X VPB|VPWR sky130_fd_pr__pfet_01v8_hvt L=0.15 W=1
+ AS=0.3275 AD=0.28 PS=1.655 PD=2.56
M$6448 VPB|VPWR A4|B|X \$8667 VPB|VPWR sky130_fd_pr__pfet_01v8_hvt L=0.15 W=1
+ AS=0.3 AD=0.135 PS=2.6 PD=1.27
M$6449 \$8667 A|Y VPB|VPWR VPB|VPWR sky130_fd_pr__pfet_01v8_hvt L=0.15 W=1
+ AS=0.135 AD=0.365 PS=1.27 PD=1.73
M$6450 VPB|VPWR A|Y \$8841 VPB|VPWR sky130_fd_pr__pfet_01v8_hvt L=0.15 W=1
+ AS=0.365 AD=0.105 PS=1.73 PD=1.21
M$6451 \$8841 A4|B|X A3|B|Y VPB|VPWR sky130_fd_pr__pfet_01v8_hvt L=0.15 W=1
+ AS=0.105 AD=0.165 PS=1.21 PD=1.33
M$6452 A3|B|Y \$8667 VPB|VPWR VPB|VPWR sky130_fd_pr__pfet_01v8_hvt L=0.15 W=1
+ AS=0.165 AD=0.36 PS=1.33 PD=2.72
M$6453 \$8669 A2|B|Y \$8839 VPB|VPWR sky130_fd_pr__pfet_01v8_hvt L=0.15 W=1
+ AS=0.26 AD=0.135 PS=2.52 PD=1.27
M$6454 \$8839 A|A1|Y VPB|VPWR VPB|VPWR sky130_fd_pr__pfet_01v8_hvt L=0.15 W=1
+ AS=0.135 AD=0.135 PS=1.27 PD=1.27
M$6455 VPB|VPWR A|A1|Y \$8823 VPB|VPWR sky130_fd_pr__pfet_01v8_hvt L=0.15 W=1
+ AS=0.135 AD=0.135 PS=1.27 PD=1.27
M$6456 \$8823 A2|B|Y VPB|VPWR VPB|VPWR sky130_fd_pr__pfet_01v8_hvt L=0.15 W=1
+ AS=0.135 AD=0.26 PS=1.27 PD=2.52
M$6457 \$8823 \$8669 A2|X VPB|VPWR sky130_fd_pr__pfet_01v8_hvt L=0.15 W=1
+ AS=0.26 AD=0.3 PS=2.52 PD=2.6
M$6459 VPB|VPWR A|A1|B|X \$8833 VPB|VPWR sky130_fd_pr__pfet_01v8_hvt L=0.15 W=1
+ AS=0.26 AD=0.135 PS=2.52 PD=1.27
M$6460 \$8833 A2|X \$8831 VPB|VPWR sky130_fd_pr__pfet_01v8_hvt L=0.15 W=1
+ AS=0.135 AD=0.135 PS=1.27 PD=1.27
M$6461 \$8831 A2|A3|Y B|SLEEP|Y VPB|VPWR sky130_fd_pr__pfet_01v8_hvt L=0.15 W=1
+ AS=0.135 AD=0.3925 PS=1.27 PD=1.785
M$6464 VPB|VPWR A3|B|Y B1|Y VPB|VPWR sky130_fd_pr__pfet_01v8_hvt L=0.15 W=1
+ AS=0.26 AD=0.135 PS=2.52 PD=1.27
M$6467 VPB|VPWR A|A1|B|X \$8677 VPB|VPWR sky130_fd_pr__pfet_01v8_hvt L=0.15 W=1
+ AS=0.3 AD=0.135 PS=2.6 PD=1.27
M$6468 \$8677 A|B1|X VPB|VPWR VPB|VPWR sky130_fd_pr__pfet_01v8_hvt L=0.15 W=1
+ AS=0.135 AD=0.365 PS=1.27 PD=1.73
M$6469 VPB|VPWR A|B1|X \$8828 VPB|VPWR sky130_fd_pr__pfet_01v8_hvt L=0.15 W=1
+ AS=0.365 AD=0.105 PS=1.73 PD=1.21
M$6470 \$8828 A|A1|B|X B|Y VPB|VPWR sky130_fd_pr__pfet_01v8_hvt L=0.15 W=1
+ AS=0.105 AD=0.165 PS=1.21 PD=1.33
M$6471 B|Y \$8677 VPB|VPWR VPB|VPWR sky130_fd_pr__pfet_01v8_hvt L=0.15 W=1
+ AS=0.165 AD=0.36 PS=1.33 PD=2.72
M$6492 A1|Y A|B|C|Y \$8882 VPB|VPWR sky130_fd_pr__pfet_01v8_hvt L=0.15 W=1
+ AS=0.26 AD=0.105 PS=2.52 PD=1.21
M$6493 \$8882 A|B1|Y VPB|VPWR VPB|VPWR sky130_fd_pr__pfet_01v8_hvt L=0.15 W=1
+ AS=0.105 AD=0.26 PS=1.21 PD=2.52
M$6494 VPB|VPWR A1|Y \$8832 VPB|VPWR sky130_fd_pr__pfet_01v8_hvt L=0.15 W=0.64
+ AS=0.1696 AD=0.0768 PS=1.81 PD=0.88
M$6495 \$8832 A2|C|D|X A|A2|B|C|SLEEP|Y VPB|VPWR sky130_fd_pr__pfet_01v8_hvt
+ L=0.15 W=0.64 AS=0.0768 AD=0.0896 PS=0.88 PD=0.92
M$6496 A|A2|B|C|SLEEP|Y B1|Y VPB|VPWR VPB|VPWR sky130_fd_pr__pfet_01v8_hvt
+ L=0.15 W=0.64 AS=0.0896 AD=0.1824 PS=0.92 PD=1.85
M$6498 B|Y A|A2|B|Y \$8883 VPB|VPWR sky130_fd_pr__pfet_01v8_hvt L=0.15 W=0.64
+ AS=0.0896 AD=0.0768 PS=0.92 PD=0.88
M$6499 \$8883 A|A1|B1|Y VPB|VPWR VPB|VPWR sky130_fd_pr__pfet_01v8_hvt L=0.15
+ W=0.64 AS=0.0768 AD=0.1696 PS=0.88 PD=1.81
M$6502 VPB|VPWR B|Y A|B|B1|Y VPB|VPWR sky130_fd_pr__pfet_01v8_hvt L=0.15 W=1
+ AS=0.26 AD=0.135 PS=2.52 PD=1.27
M$6503 A|B|B1|Y A|A1|X VPB|VPWR VPB|VPWR sky130_fd_pr__pfet_01v8_hvt L=0.15 W=1
+ AS=0.135 AD=0.26 PS=1.27 PD=2.52
M$6505 VPB|VPWR A|A1|X \$8888 VPB|VPWR sky130_fd_pr__pfet_01v8_hvt L=0.15
+ W=0.64 AS=0.1696 AD=0.0768 PS=1.81 PD=0.88
M$6506 \$8888 A2|Y SLEEP|Y VPB|VPWR sky130_fd_pr__pfet_01v8_hvt L=0.15 W=0.64
+ AS=0.0768 AD=0.0896 PS=0.88 PD=0.92
M$6507 SLEEP|Y A|B|B1|Y VPB|VPWR VPB|VPWR sky130_fd_pr__pfet_01v8_hvt L=0.15
+ W=0.64 AS=0.0896 AD=0.1824 PS=0.92 PD=1.85
M$6508 VPB|VPWR A|B|B1|C|X A2|Y VPB|VPWR sky130_fd_pr__pfet_01v8_hvt L=0.15
+ W=0.64 AS=0.1824 AD=0.0896 PS=1.85 PD=0.92
M$6509 A2|Y A2|B|X \$8889 VPB|VPWR sky130_fd_pr__pfet_01v8_hvt L=0.15 W=0.64
+ AS=0.0896 AD=0.0768 PS=0.92 PD=0.88
M$6510 \$8889 A|A1|Y VPB|VPWR VPB|VPWR sky130_fd_pr__pfet_01v8_hvt L=0.15
+ W=0.64 AS=0.0768 AD=0.1696 PS=0.88 PD=1.81
M$6512 \$8862 A2|B|Y VPB|VPWR VPB|VPWR sky130_fd_pr__pfet_01v8_hvt L=0.15 W=1
+ AS=0.265 AD=0.1475 PS=2.53 PD=1.295
M$6513 VPB|VPWR A1|B|Y \$8862 VPB|VPWR sky130_fd_pr__pfet_01v8_hvt L=0.15 W=1
+ AS=0.1475 AD=0.14 PS=1.295 PD=1.28
M$6514 \$8862 B1|Y A|Y VPB|VPWR sky130_fd_pr__pfet_01v8_hvt L=0.15 W=1 AS=0.14
+ AD=0.265 PS=1.28 PD=2.53
M$6515 \$8863 A2|B|Y \$8892 VPB|VPWR sky130_fd_pr__pfet_01v8_hvt L=0.15 W=1
+ AS=0.26 AD=0.135 PS=2.52 PD=1.27
M$6516 \$8892 A|C|Y VPB|VPWR VPB|VPWR sky130_fd_pr__pfet_01v8_hvt L=0.15 W=1
+ AS=0.135 AD=0.135 PS=1.27 PD=1.27
M$6517 VPB|VPWR A|C|Y \$8864 VPB|VPWR sky130_fd_pr__pfet_01v8_hvt L=0.15 W=1
+ AS=0.135 AD=0.135 PS=1.27 PD=1.27
M$6518 \$8864 A2|B|Y VPB|VPWR VPB|VPWR sky130_fd_pr__pfet_01v8_hvt L=0.15 W=1
+ AS=0.135 AD=0.26 PS=1.27 PD=2.52
M$6519 \$8864 \$8863 A|C|X VPB|VPWR sky130_fd_pr__pfet_01v8_hvt L=0.15 W=1
+ AS=0.26 AD=0.3 PS=2.52 PD=2.6
M$6520 B1|Y A|C|X \$8894 VPB|VPWR sky130_fd_pr__pfet_01v8_hvt L=0.15 W=1
+ AS=0.26 AD=0.135 PS=2.52 PD=1.27
M$6521 \$8894 A2|A_N|B|X \$8893 VPB|VPWR sky130_fd_pr__pfet_01v8_hvt L=0.15 W=1
+ AS=0.135 AD=0.135 PS=1.27 PD=1.27
M$6522 \$8893 A|A1|B|Y VPB|VPWR VPB|VPWR sky130_fd_pr__pfet_01v8_hvt L=0.15 W=1
+ AS=0.135 AD=0.26 PS=1.27 PD=2.52
M$6524 A|Y A|C|Y \$8896 VPB|VPWR sky130_fd_pr__pfet_01v8_hvt L=0.15 W=1 AS=0.26
+ AD=0.135 PS=2.52 PD=1.27
M$6525 \$8896 A|B|B1|X \$8895 VPB|VPWR sky130_fd_pr__pfet_01v8_hvt L=0.15 W=1
+ AS=0.135 AD=0.135 PS=1.27 PD=1.27
M$6526 \$8895 A|B2|Y VPB|VPWR VPB|VPWR sky130_fd_pr__pfet_01v8_hvt L=0.15 W=1
+ AS=0.135 AD=0.26 PS=1.27 PD=2.52
M$6527 VPB|VPWR B|D|Y \$8867 VPB|VPWR sky130_fd_pr__pfet_01v8_hvt L=0.15 W=1
+ AS=0.3 AD=0.135 PS=2.6 PD=1.27
M$6528 \$8867 A|Y VPB|VPWR VPB|VPWR sky130_fd_pr__pfet_01v8_hvt L=0.15 W=1
+ AS=0.135 AD=0.365 PS=1.27 PD=1.73
M$6529 VPB|VPWR A|Y \$8897 VPB|VPWR sky130_fd_pr__pfet_01v8_hvt L=0.15 W=1
+ AS=0.365 AD=0.105 PS=1.73 PD=1.21
M$6530 \$8897 B|D|Y A|B|Y VPB|VPWR sky130_fd_pr__pfet_01v8_hvt L=0.15 W=1
+ AS=0.105 AD=0.165 PS=1.21 PD=1.33
M$6531 A|B|Y \$8867 VPB|VPWR VPB|VPWR sky130_fd_pr__pfet_01v8_hvt L=0.15 W=1
+ AS=0.165 AD=0.36 PS=1.33 PD=2.72
M$6534 VPB|VPWR B|Y A|B2|Y VPB|VPWR sky130_fd_pr__pfet_01v8_hvt L=0.15 W=1
+ AS=0.26 AD=0.135 PS=2.52 PD=1.27
M$6535 A|B2|Y A|X VPB|VPWR VPB|VPWR sky130_fd_pr__pfet_01v8_hvt L=0.15 W=1
+ AS=0.135 AD=0.26 PS=1.27 PD=2.52
M$6540 \$8869 A|A1|B|X \$8900 VPB|VPWR sky130_fd_pr__pfet_01v8_hvt L=0.15 W=1
+ AS=0.26 AD=0.135 PS=2.52 PD=1.27
M$6541 \$8900 A|B1|X VPB|VPWR VPB|VPWR sky130_fd_pr__pfet_01v8_hvt L=0.15 W=1
+ AS=0.135 AD=0.135 PS=1.27 PD=1.27
M$6542 VPB|VPWR A|B1|X \$8870 VPB|VPWR sky130_fd_pr__pfet_01v8_hvt L=0.15 W=1
+ AS=0.135 AD=0.135 PS=1.27 PD=1.27
M$6543 \$8870 A|A1|B|X VPB|VPWR VPB|VPWR sky130_fd_pr__pfet_01v8_hvt L=0.15 W=1
+ AS=0.135 AD=0.26 PS=1.27 PD=2.52
M$6546 \$8870 \$8869 A|A1|B|X VPB|VPWR sky130_fd_pr__pfet_01v8_hvt L=0.15 W=1
+ AS=0.26 AD=0.3 PS=2.52 PD=2.6
M$6548 VPB|VPWR A|B|Y \$8901 VPB|VPWR sky130_fd_pr__pfet_01v8_hvt L=0.15 W=1
+ AS=0.26 AD=0.105 PS=2.52 PD=1.21
M$6549 \$8901 A2|B|X A|A1|Y VPB|VPWR sky130_fd_pr__pfet_01v8_hvt L=0.15 W=1
+ AS=0.105 AD=0.26 PS=1.21 PD=2.52
M$6550 A2|B|Y B|X \$8902 VPB|VPWR sky130_fd_pr__pfet_01v8_hvt L=0.15 W=1
+ AS=0.26 AD=0.105 PS=2.52 PD=1.21
M$6551 \$8902 A|B1|Y VPB|VPWR VPB|VPWR sky130_fd_pr__pfet_01v8_hvt L=0.15 W=1
+ AS=0.105 AD=0.26 PS=1.21 PD=2.52
M$6555 B|SLEEP|Y A3|B|Y \$8904 VPB|VPWR sky130_fd_pr__pfet_01v8_hvt L=0.15 W=1
+ AS=0.3925 AD=0.135 PS=1.785 PD=1.27
M$6556 \$8904 A2|X \$8905 VPB|VPWR sky130_fd_pr__pfet_01v8_hvt L=0.15 W=1
+ AS=0.135 AD=0.135 PS=1.27 PD=1.27
M$6557 \$8905 A|A1|B|X VPB|VPWR VPB|VPWR sky130_fd_pr__pfet_01v8_hvt L=0.15 W=1
+ AS=0.135 AD=0.26 PS=1.27 PD=2.52
M$6558 VPB|VPWR A1|Y \$8903 VPB|VPWR sky130_fd_pr__pfet_01v8_hvt L=0.15 W=0.64
+ AS=0.1696 AD=0.0768 PS=1.81 PD=0.88
M$6559 \$8903 A2|X B|Y VPB|VPWR sky130_fd_pr__pfet_01v8_hvt L=0.15 W=0.64
+ AS=0.0768 AD=0.0896 PS=0.88 PD=0.92
M$6561 VPB|VPWR A3|B|Y \$8875 VPB|VPWR sky130_fd_pr__pfet_01v8_hvt L=0.15 W=1
+ AS=0.3 AD=0.135 PS=2.6 PD=1.27
M$6562 \$8875 A|B1|X VPB|VPWR VPB|VPWR sky130_fd_pr__pfet_01v8_hvt L=0.15 W=1
+ AS=0.135 AD=0.365 PS=1.27 PD=1.73
M$6563 VPB|VPWR A|B1|X \$8899 VPB|VPWR sky130_fd_pr__pfet_01v8_hvt L=0.15 W=1
+ AS=0.365 AD=0.105 PS=1.73 PD=1.21
M$6564 \$8899 A3|B|Y A2|A3|Y VPB|VPWR sky130_fd_pr__pfet_01v8_hvt L=0.15 W=1
+ AS=0.105 AD=0.165 PS=1.21 PD=1.33
M$6565 A2|A3|Y \$8875 VPB|VPWR VPB|VPWR sky130_fd_pr__pfet_01v8_hvt L=0.15 W=1
+ AS=0.165 AD=0.36 PS=1.33 PD=2.72
M$6567 VPB|VPWR B1|Y B|C|Y VPB|VPWR sky130_fd_pr__pfet_01v8_hvt L=0.15 W=0.64
+ AS=0.1824 AD=0.0896 PS=1.85 PD=0.92
M$6568 B|C|Y A2|A3|Y \$8829 VPB|VPWR sky130_fd_pr__pfet_01v8_hvt L=0.15 W=0.64
+ AS=0.0896 AD=0.0768 PS=0.92 PD=0.88
M$6569 \$8829 A|A1|Y VPB|VPWR VPB|VPWR sky130_fd_pr__pfet_01v8_hvt L=0.15
+ W=0.64 AS=0.0768 AD=0.1696 PS=0.88 PD=1.81
M$6570 A|A1|Y B|Y \$8891 VPB|VPWR sky130_fd_pr__pfet_01v8_hvt L=0.15 W=1
+ AS=0.26 AD=0.105 PS=2.52 PD=1.21
M$6571 \$8891 A|X VPB|VPWR VPB|VPWR sky130_fd_pr__pfet_01v8_hvt L=0.15 W=1
+ AS=0.105 AD=0.26 PS=1.21 PD=2.52
M$6572 \$8877 B|Y \$8890 VPB|VPWR sky130_fd_pr__pfet_01v8_hvt L=0.15 W=1
+ AS=0.26 AD=0.135 PS=2.52 PD=1.27
M$6573 \$8890 A|X VPB|VPWR VPB|VPWR sky130_fd_pr__pfet_01v8_hvt L=0.15 W=1
+ AS=0.135 AD=0.135 PS=1.27 PD=1.27
M$6574 VPB|VPWR A|X \$8878 VPB|VPWR sky130_fd_pr__pfet_01v8_hvt L=0.15 W=1
+ AS=0.135 AD=0.135 PS=1.27 PD=1.27
M$6575 \$8878 B|Y VPB|VPWR VPB|VPWR sky130_fd_pr__pfet_01v8_hvt L=0.15 W=1
+ AS=0.135 AD=0.26 PS=1.27 PD=2.52
M$6576 \$8878 \$8877 B|C|X VPB|VPWR sky130_fd_pr__pfet_01v8_hvt L=0.15 W=1
+ AS=0.26 AD=0.3 PS=2.52 PD=2.6
M$6598 VPB|VPWR A|B|Y \$8934 VPB|VPWR sky130_fd_pr__pfet_01v8_hvt L=0.15 W=1
+ AS=0.3 AD=0.135 PS=2.6 PD=1.27
M$6599 \$8934 A|X VPB|VPWR VPB|VPWR sky130_fd_pr__pfet_01v8_hvt L=0.15 W=1
+ AS=0.135 AD=0.365 PS=1.27 PD=1.73
M$6600 VPB|VPWR A|X \$9119 VPB|VPWR sky130_fd_pr__pfet_01v8_hvt L=0.15 W=1
+ AS=0.365 AD=0.105 PS=1.73 PD=1.21
M$6601 \$9119 A|B|Y A|A2|B|Y VPB|VPWR sky130_fd_pr__pfet_01v8_hvt L=0.15 W=1
+ AS=0.105 AD=0.165 PS=1.21 PD=1.33
M$6602 A|A2|B|Y \$8934 VPB|VPWR VPB|VPWR sky130_fd_pr__pfet_01v8_hvt L=0.15 W=1
+ AS=0.165 AD=0.36 PS=1.33 PD=2.72
M$6603 \$8936 B|Y \$9121 VPB|VPWR sky130_fd_pr__pfet_01v8_hvt L=0.15 W=1
+ AS=0.26 AD=0.135 PS=2.52 PD=1.27
M$6604 \$9121 A|B|C|Y VPB|VPWR VPB|VPWR sky130_fd_pr__pfet_01v8_hvt L=0.15 W=1
+ AS=0.135 AD=0.135 PS=1.27 PD=1.27
M$6605 VPB|VPWR A|B|C|Y \$9105 VPB|VPWR sky130_fd_pr__pfet_01v8_hvt L=0.15 W=1
+ AS=0.135 AD=0.135 PS=1.27 PD=1.27
M$6606 \$9105 B|Y VPB|VPWR VPB|VPWR sky130_fd_pr__pfet_01v8_hvt L=0.15 W=1
+ AS=0.135 AD=0.26 PS=1.27 PD=2.52
M$6607 \$9105 \$8936 A|B|B1|C|X VPB|VPWR sky130_fd_pr__pfet_01v8_hvt L=0.15 W=1
+ AS=0.26 AD=0.3 PS=2.52 PD=2.6
M$6609 \$8856 A|A2|B|C|SLEEP|Y \$8886 VPB|VPWR sky130_fd_pr__pfet_01v8_hvt
+ L=0.15 W=0.42 AS=0.1092 AD=0.0441 PS=1.36 PD=0.63
M$6610 \$8886 A|B|B1|C|X \$8887 VPB|VPWR sky130_fd_pr__pfet_01v8_hvt L=0.15
+ W=0.42 AS=0.0441 AD=0.0693 PS=0.63 PD=0.75
M$6611 VPB|VPWR A|B_N|SLEEP|Y \$8887 VPB|VPWR sky130_fd_pr__pfet_01v8_hvt
+ L=0.15 W=0.42 AS=0.14825 AD=0.0693 PS=1.34 PD=0.75
M$6612 VPB|VPWR \$8856 A2|A3|X VPB|VPWR sky130_fd_pr__pfet_01v8_hvt L=0.15 W=1
+ AS=0.14825 AD=0.28 PS=1.34 PD=2.56
M$6613 \$8937 A|B_N|SLEEP|Y VPB|VPWR VPB|VPWR sky130_fd_pr__pfet_01v8_hvt
+ L=0.15 W=0.42 AS=0.1092 AD=0.1573 PS=1.36 PD=1.39
M$6614 VPB|VPWR A|B1|C1|X \$9123 VPB|VPWR sky130_fd_pr__pfet_01v8_hvt L=0.15
+ W=1 AS=0.1573 AD=0.105 PS=1.39 PD=1.21
M$6615 \$9123 \$8937 A2|SLEEP|Y VPB|VPWR sky130_fd_pr__pfet_01v8_hvt L=0.15 W=1
+ AS=0.105 AD=0.26 PS=1.21 PD=2.52
M$6616 \$8939 A|B|B1|C|X \$9124 VPB|VPWR sky130_fd_pr__pfet_01v8_hvt L=0.15
+ W=0.42 AS=0.1092 AD=0.0441 PS=1.36 PD=0.63
M$6617 \$9124 A|A2|B|C|SLEEP|Y VPB|VPWR VPB|VPWR sky130_fd_pr__pfet_01v8_hvt
+ L=0.15 W=0.42 AS=0.0441 AD=0.14575 PS=0.63 PD=1.335
M$6618 VPB|VPWR \$8939 A4|X VPB|VPWR sky130_fd_pr__pfet_01v8_hvt L=0.15 W=1
+ AS=0.14575 AD=0.34 PS=1.335 PD=2.68
M$6619 VPB|VPWR A|A1|X \$9126 VPB|VPWR sky130_fd_pr__pfet_01v8_hvt L=0.15 W=1
+ AS=0.28 AD=0.175 PS=2.56 PD=1.35
M$6620 \$9126 A2|SLEEP|Y \$9127 VPB|VPWR sky130_fd_pr__pfet_01v8_hvt L=0.15 W=1
+ AS=0.175 AD=0.135 PS=1.35 PD=1.27
M$6621 \$9127 A1|A3|B|X \$9128 VPB|VPWR sky130_fd_pr__pfet_01v8_hvt L=0.15 W=1
+ AS=0.135 AD=0.3125 PS=1.27 PD=1.625
M$6622 \$9128 A4|X B|SLEEP|Y VPB|VPWR sky130_fd_pr__pfet_01v8_hvt L=0.15 W=1
+ AS=0.3125 AD=0.135 PS=1.625 PD=1.27
M$6624 \$8944 A|A1|X \$9130 VPB|VPWR sky130_fd_pr__pfet_01v8_hvt L=0.15 W=0.42
+ AS=0.1092 AD=0.0441 PS=1.36 PD=0.63
M$6625 \$9130 A2|SLEEP|Y VPB|VPWR VPB|VPWR sky130_fd_pr__pfet_01v8_hvt L=0.15
+ W=0.42 AS=0.0441 AD=0.14575 PS=0.63 PD=1.335
M$6626 VPB|VPWR \$8944 A2|B|X VPB|VPWR sky130_fd_pr__pfet_01v8_hvt L=0.15 W=1
+ AS=0.14575 AD=0.34 PS=1.335 PD=2.68
M$6627 A|Y A|B|B1|C|X \$9132 VPB|VPWR sky130_fd_pr__pfet_01v8_hvt L=0.15 W=1
+ AS=0.26 AD=0.135 PS=2.52 PD=1.27
M$6628 \$9132 A2|B|X \$9133 VPB|VPWR sky130_fd_pr__pfet_01v8_hvt L=0.15 W=1
+ AS=0.135 AD=0.135 PS=1.27 PD=1.27
M$6629 \$9133 A|A1|Y VPB|VPWR VPB|VPWR sky130_fd_pr__pfet_01v8_hvt L=0.15 W=1
+ AS=0.135 AD=0.26 PS=1.27 PD=2.52
M$6630 \$8946 A|Y \$9134 VPB|VPWR sky130_fd_pr__pfet_01v8_hvt L=0.15 W=0.42
+ AS=0.1092 AD=0.0441 PS=1.36 PD=0.63
M$6631 \$9134 SLEEP|Y VPB|VPWR VPB|VPWR sky130_fd_pr__pfet_01v8_hvt L=0.15
+ W=0.42 AS=0.0441 AD=0.14575 PS=0.63 PD=1.335
M$6632 VPB|VPWR \$8946 A2|A_N|B|X VPB|VPWR sky130_fd_pr__pfet_01v8_hvt L=0.15
+ W=1 AS=0.14575 AD=0.34 PS=1.335 PD=2.68
M$6635 VPB|VPWR A|Y \$9136 VPB|VPWR sky130_fd_pr__pfet_01v8_hvt L=0.15 W=1
+ AS=0.26 AD=0.105 PS=2.52 PD=1.21
M$6636 \$9136 A2|A_N|B|X A2|B|Y VPB|VPWR sky130_fd_pr__pfet_01v8_hvt L=0.15 W=1
+ AS=0.105 AD=0.26 PS=1.21 PD=2.52
M$6638 \$8949 B|X \$9138 VPB|VPWR sky130_fd_pr__pfet_01v8_hvt L=0.15 W=1
+ AS=0.26 AD=0.135 PS=2.52 PD=1.27
M$6639 \$9138 A|C|X VPB|VPWR VPB|VPWR sky130_fd_pr__pfet_01v8_hvt L=0.15 W=1
+ AS=0.135 AD=0.135 PS=1.27 PD=1.27
M$6640 VPB|VPWR A|C|X \$9106 VPB|VPWR sky130_fd_pr__pfet_01v8_hvt L=0.15 W=1
+ AS=0.135 AD=0.135 PS=1.27 PD=1.27
M$6641 \$9106 B|X VPB|VPWR VPB|VPWR sky130_fd_pr__pfet_01v8_hvt L=0.15 W=1
+ AS=0.135 AD=0.26 PS=1.27 PD=2.52
M$6642 \$9106 \$8949 B|X VPB|VPWR sky130_fd_pr__pfet_01v8_hvt L=0.15 W=1
+ AS=0.26 AD=0.3 PS=2.52 PD=2.6
M$6647 \$8952 A|B|Y \$9137 VPB|VPWR sky130_fd_pr__pfet_01v8_hvt L=0.15 W=1
+ AS=0.26 AD=0.135 PS=2.52 PD=1.27
M$6648 \$9137 A|Y VPB|VPWR VPB|VPWR sky130_fd_pr__pfet_01v8_hvt L=0.15 W=1
+ AS=0.135 AD=0.135 PS=1.27 PD=1.27
M$6649 VPB|VPWR A|Y \$9107 VPB|VPWR sky130_fd_pr__pfet_01v8_hvt L=0.15 W=1
+ AS=0.135 AD=0.135 PS=1.27 PD=1.27
M$6650 \$9107 A|B|Y VPB|VPWR VPB|VPWR sky130_fd_pr__pfet_01v8_hvt L=0.15 W=1
+ AS=0.135 AD=0.26 PS=1.27 PD=2.52
M$6651 \$9107 \$8952 A4|B|X VPB|VPWR sky130_fd_pr__pfet_01v8_hvt L=0.15 W=1
+ AS=0.26 AD=0.3 PS=2.52 PD=2.6
M$6654 B|C|Y A4|B|X \$9131 VPB|VPWR sky130_fd_pr__pfet_01v8_hvt L=0.15 W=1
+ AS=0.135 AD=0.3125 PS=1.27 PD=1.625
M$6655 \$9131 A3|B1|C|SLEEP|Y \$9129 VPB|VPWR sky130_fd_pr__pfet_01v8_hvt
+ L=0.15 W=1 AS=0.3125 AD=0.135 PS=1.625 PD=1.27
M$6656 \$9129 A2|B|X \$9125 VPB|VPWR sky130_fd_pr__pfet_01v8_hvt L=0.15 W=1
+ AS=0.135 AD=0.175 PS=1.27 PD=1.35
M$6657 \$9125 A|A1|B|X VPB|VPWR VPB|VPWR sky130_fd_pr__pfet_01v8_hvt L=0.15 W=1
+ AS=0.175 AD=0.28 PS=1.35 PD=2.56
M$6665 \$8958 A|B|SLEEP|X \$9120 VPB|VPWR sky130_fd_pr__pfet_01v8_hvt L=0.15
+ W=0.42 AS=0.1092 AD=0.0441 PS=1.36 PD=0.63
M$6666 \$9120 A3|B1|C|SLEEP|Y VPB|VPWR VPB|VPWR sky130_fd_pr__pfet_01v8_hvt
+ L=0.15 W=0.42 AS=0.0441 AD=0.14575 PS=0.63 PD=1.335
M$6667 VPB|VPWR \$8958 A2|X VPB|VPWR sky130_fd_pr__pfet_01v8_hvt L=0.15 W=1
+ AS=0.14575 AD=0.34 PS=1.335 PD=2.68
M$6668 \$8959 A3|B1|C|SLEEP|Y \$9118 VPB|VPWR sky130_fd_pr__pfet_01v8_hvt
+ L=0.15 W=0.42 AS=0.1092 AD=0.0441 PS=1.36 PD=0.63
M$6669 \$9118 A|B|SLEEP|X \$9117 VPB|VPWR sky130_fd_pr__pfet_01v8_hvt L=0.15
+ W=0.42 AS=0.0441 AD=0.0693 PS=0.63 PD=0.75
M$6670 \$9117 A|Y VPB|VPWR VPB|VPWR sky130_fd_pr__pfet_01v8_hvt L=0.15 W=0.42
+ AS=0.0693 AD=0.14825 PS=0.75 PD=1.34
M$6671 VPB|VPWR \$8959 A|B1|X VPB|VPWR sky130_fd_pr__pfet_01v8_hvt L=0.15 W=1
+ AS=0.14825 AD=0.28 PS=1.34 PD=2.56
M$6672 A1|Y A|B|SLEEP|X \$9116 VPB|VPWR sky130_fd_pr__pfet_01v8_hvt L=0.15 W=1
+ AS=0.26 AD=0.105 PS=2.52 PD=1.21
M$6673 \$9116 A|Y VPB|VPWR VPB|VPWR sky130_fd_pr__pfet_01v8_hvt L=0.15 W=1
+ AS=0.105 AD=0.26 PS=1.21 PD=2.52
M$6675 \$8963 A|B|Y \$9114 VPB|VPWR sky130_fd_pr__pfet_01v8_hvt L=0.15 W=0.42
+ AS=0.1092 AD=0.0441 PS=1.36 PD=0.63
M$6676 \$9114 A|B|SLEEP|X VPB|VPWR VPB|VPWR sky130_fd_pr__pfet_01v8_hvt L=0.15
+ W=0.42 AS=0.0441 AD=0.14575 PS=0.63 PD=1.335
M$6677 VPB|VPWR \$8963 A|X VPB|VPWR sky130_fd_pr__pfet_01v8_hvt L=0.15 W=1
+ AS=0.14575 AD=0.34 PS=1.335 PD=2.68
M$6678 \$8965 B|Y \$9113 VPB|VPWR sky130_fd_pr__pfet_01v8_hvt L=0.15 W=1
+ AS=0.26 AD=0.135 PS=2.52 PD=1.27
M$6679 \$9113 A|B|SLEEP|X VPB|VPWR VPB|VPWR sky130_fd_pr__pfet_01v8_hvt L=0.15
+ W=1 AS=0.135 AD=0.135 PS=1.27 PD=1.27
M$6680 VPB|VPWR A|B|SLEEP|X \$9108 VPB|VPWR sky130_fd_pr__pfet_01v8_hvt L=0.15
+ W=1 AS=0.135 AD=0.135 PS=1.27 PD=1.27
M$6681 \$9108 B|Y VPB|VPWR VPB|VPWR sky130_fd_pr__pfet_01v8_hvt L=0.15 W=1
+ AS=0.135 AD=0.26 PS=1.27 PD=2.52
M$6682 \$9108 \$8965 A2|B|X VPB|VPWR sky130_fd_pr__pfet_01v8_hvt L=0.15 W=1
+ AS=0.26 AD=0.3 PS=2.52 PD=2.6
M$6702 VPB|VPWR A|A2|B|Y \$9139 VPB|VPWR sky130_fd_pr__pfet_01v8_hvt L=0.15 W=1
+ AS=0.3 AD=0.135 PS=2.6 PD=1.27
M$6703 \$9139 A|A1|B1|Y VPB|VPWR VPB|VPWR sky130_fd_pr__pfet_01v8_hvt L=0.15
+ W=1 AS=0.135 AD=0.365 PS=1.27 PD=1.73
M$6704 VPB|VPWR A|A1|B1|Y \$9168 VPB|VPWR sky130_fd_pr__pfet_01v8_hvt L=0.15
+ W=1 AS=0.365 AD=0.105 PS=1.73 PD=1.21
M$6705 \$9168 A|A2|B|Y A|B_N|SLEEP|Y VPB|VPWR sky130_fd_pr__pfet_01v8_hvt
+ L=0.15 W=1 AS=0.105 AD=0.165 PS=1.21 PD=1.33
M$6706 A|B_N|SLEEP|Y \$9139 VPB|VPWR VPB|VPWR sky130_fd_pr__pfet_01v8_hvt
+ L=0.15 W=1 AS=0.165 AD=0.36 PS=1.33 PD=2.72
M$6709 VPB|VPWR A|B|B1|C|X B|Y VPB|VPWR sky130_fd_pr__pfet_01v8_hvt L=0.15
+ W=1.68 AS=0.3318 AD=0.3486 PS=3.31 PD=3.35
M$6712 VPB|VPWR A|B1|C1|X \$9140 VPB|VPWR sky130_fd_pr__pfet_01v8_hvt L=0.15
+ W=0.42 AS=0.1573 AD=0.1092 PS=1.39 PD=1.36
M$6713 VPB|VPWR A|B_N|SLEEP|Y \$9170 VPB|VPWR sky130_fd_pr__pfet_01v8_hvt
+ L=0.15 W=1 AS=0.1573 AD=0.105 PS=1.39 PD=1.21
M$6714 \$9170 \$9140 A|A1|X VPB|VPWR sky130_fd_pr__pfet_01v8_hvt L=0.15 W=1
+ AS=0.105 AD=0.26 PS=1.21 PD=2.52
M$6716 VPB|VPWR A2|B|X \$9141 VPB|VPWR sky130_fd_pr__pfet_01v8_hvt L=0.15 W=1
+ AS=0.3 AD=0.135 PS=2.6 PD=1.27
M$6717 \$9141 A|A1|Y VPB|VPWR VPB|VPWR sky130_fd_pr__pfet_01v8_hvt L=0.15 W=1
+ AS=0.135 AD=0.365 PS=1.27 PD=1.73
M$6718 VPB|VPWR A|A1|Y \$9172 VPB|VPWR sky130_fd_pr__pfet_01v8_hvt L=0.15 W=1
+ AS=0.365 AD=0.105 PS=1.73 PD=1.21
M$6719 \$9172 A2|B|X A|A1|B|Y VPB|VPWR sky130_fd_pr__pfet_01v8_hvt L=0.15 W=1
+ AS=0.105 AD=0.165 PS=1.21 PD=1.33
M$6720 A|A1|B|Y \$9141 VPB|VPWR VPB|VPWR sky130_fd_pr__pfet_01v8_hvt L=0.15 W=1
+ AS=0.165 AD=0.36 PS=1.33 PD=2.72
M$6721 VPB|VPWR \$9143 \$9142 VPB|VPWR sky130_fd_pr__pfet_01v8_hvt L=0.5 W=0.82
+ AS=0.15575 AD=0.2173 PS=1.325 PD=2.17
M$6722 A|B1|C1|X \$9142 VPB|VPWR VPB|VPWR sky130_fd_pr__pfet_01v8_hvt L=0.15
+ W=1 AS=0.355 AD=0.15575 PS=2.71 PD=1.325
M$6723 \$9143 \$9144 VPB|VPWR VPB|VPWR sky130_fd_pr__pfet_01v8_hvt L=0.5 W=0.82
+ AS=0.2173 AD=0.1701 PS=2.17 PD=1.36
M$6724 VPB|VPWR A|FINE_MUX[21] \$9144 VPB|VPWR sky130_fd_pr__pfet_01v8_hvt
+ L=0.15 W=1 AS=0.1701 AD=0.27 PS=1.36 PD=2.54
M$6732 A|Y A|A1|B|Y VPB|VPWR VPB|VPWR sky130_fd_pr__pfet_01v8_hvt L=0.15 W=1
+ AS=0.135 AD=0.26 PS=1.27 PD=2.52
M$6733 \$9148 A2|A_N|B|X \$9173 VPB|VPWR sky130_fd_pr__pfet_01v8_hvt L=0.15 W=1
+ AS=0.26 AD=0.135 PS=2.52 PD=1.27
M$6734 \$9173 A|Y VPB|VPWR VPB|VPWR sky130_fd_pr__pfet_01v8_hvt L=0.15 W=1
+ AS=0.135 AD=0.135 PS=1.27 PD=1.27
M$6735 VPB|VPWR A|Y \$9149 VPB|VPWR sky130_fd_pr__pfet_01v8_hvt L=0.15 W=1
+ AS=0.135 AD=0.135 PS=1.27 PD=1.27
M$6736 \$9149 A2|A_N|B|X VPB|VPWR VPB|VPWR sky130_fd_pr__pfet_01v8_hvt L=0.15
+ W=1 AS=0.135 AD=0.26 PS=1.27 PD=2.52
M$6737 \$9149 \$9148 A|B|B1|X VPB|VPWR sky130_fd_pr__pfet_01v8_hvt L=0.15 W=1
+ AS=0.26 AD=0.3 PS=2.52 PD=2.6
M$6738 VPB|VPWR A|A1|B|Y \$9174 VPB|VPWR sky130_fd_pr__pfet_01v8_hvt L=0.15 W=1
+ AS=0.26 AD=0.105 PS=2.52 PD=1.21
M$6739 \$9174 A2|A_N|B|X \$9150 VPB|VPWR sky130_fd_pr__pfet_01v8_hvt L=0.15 W=1
+ AS=0.105 AD=0.235 PS=1.21 PD=1.47
M$6740 \$9150 A|B2|Y \$9175 VPB|VPWR sky130_fd_pr__pfet_01v8_hvt L=0.15 W=1
+ AS=0.235 AD=0.1175 PS=1.47 PD=1.235
M$6741 \$9175 A|B|B1|X VPB|VPWR VPB|VPWR sky130_fd_pr__pfet_01v8_hvt L=0.15 W=1
+ AS=0.1175 AD=0.3725 PS=1.235 PD=1.745
M$6742 VPB|VPWR \$9150 B|X VPB|VPWR sky130_fd_pr__pfet_01v8_hvt L=0.15 W=1
+ AS=0.3725 AD=0.28 PS=1.745 PD=2.56
M$6744 A|Y A|B|B1|X \$9176 VPB|VPWR sky130_fd_pr__pfet_01v8_hvt L=0.15 W=1
+ AS=0.26 AD=0.105 PS=2.52 PD=1.21
M$6745 \$9176 A|B|Y VPB|VPWR VPB|VPWR sky130_fd_pr__pfet_01v8_hvt L=0.15 W=1
+ AS=0.105 AD=0.26 PS=1.21 PD=2.52
M$6746 VPB|VPWR A|B2|Y B|Y VPB|VPWR sky130_fd_pr__pfet_01v8_hvt L=0.15 W=1
+ AS=0.26 AD=0.135 PS=2.52 PD=1.27
M$6748 \$9153 B|Y \$9178 VPB|VPWR sky130_fd_pr__pfet_01v8_hvt L=0.15 W=1
+ AS=0.26 AD=0.135 PS=2.52 PD=1.27
M$6749 \$9178 A|B|B1|X VPB|VPWR VPB|VPWR sky130_fd_pr__pfet_01v8_hvt L=0.15 W=1
+ AS=0.135 AD=0.135 PS=1.27 PD=1.27
M$6750 VPB|VPWR A|B|B1|X \$9154 VPB|VPWR sky130_fd_pr__pfet_01v8_hvt L=0.15 W=1
+ AS=0.135 AD=0.135 PS=1.27 PD=1.27
M$6751 \$9154 B|Y VPB|VPWR VPB|VPWR sky130_fd_pr__pfet_01v8_hvt L=0.15 W=1
+ AS=0.135 AD=0.26 PS=1.27 PD=2.52
M$6752 \$9154 \$9153 A2|B|X VPB|VPWR sky130_fd_pr__pfet_01v8_hvt L=0.15 W=1
+ AS=0.26 AD=0.3 PS=2.52 PD=2.6
M$6753 VPB|VPWR B|X \$9155 VPB|VPWR sky130_fd_pr__pfet_01v8_hvt L=0.15 W=1
+ AS=0.3 AD=0.135 PS=2.6 PD=1.27
M$6754 \$9155 A|Y VPB|VPWR VPB|VPWR sky130_fd_pr__pfet_01v8_hvt L=0.15 W=1
+ AS=0.135 AD=0.365 PS=1.27 PD=1.73
M$6755 VPB|VPWR A|Y \$9179 VPB|VPWR sky130_fd_pr__pfet_01v8_hvt L=0.15 W=1
+ AS=0.365 AD=0.105 PS=1.73 PD=1.21
M$6756 \$9179 B|X A3|B1|C|SLEEP|Y VPB|VPWR sky130_fd_pr__pfet_01v8_hvt L=0.15
+ W=1 AS=0.105 AD=0.165 PS=1.21 PD=1.33
M$6757 A3|B1|C|SLEEP|Y \$9155 VPB|VPWR VPB|VPWR sky130_fd_pr__pfet_01v8_hvt
+ L=0.15 W=1 AS=0.165 AD=0.36 PS=1.33 PD=2.72
M$6761 \$9156 A|A1|B|X \$9180 VPB|VPWR sky130_fd_pr__pfet_01v8_hvt L=0.15 W=1
+ AS=0.26 AD=0.135 PS=2.52 PD=1.27
M$6762 \$9180 A|B1|X VPB|VPWR VPB|VPWR sky130_fd_pr__pfet_01v8_hvt L=0.15 W=1
+ AS=0.135 AD=0.135 PS=1.27 PD=1.27
M$6763 VPB|VPWR A|B1|X \$9157 VPB|VPWR sky130_fd_pr__pfet_01v8_hvt L=0.15 W=1
+ AS=0.135 AD=0.135 PS=1.27 PD=1.27
M$6764 \$9157 A|A1|B|X VPB|VPWR VPB|VPWR sky130_fd_pr__pfet_01v8_hvt L=0.15 W=1
+ AS=0.135 AD=0.26 PS=1.27 PD=2.52
M$6765 \$9157 \$9156 A|A1|B|X VPB|VPWR sky130_fd_pr__pfet_01v8_hvt L=0.15 W=1
+ AS=0.26 AD=0.3 PS=2.52 PD=2.6
M$6766 \$9159 A2|B|X \$9181 VPB|VPWR sky130_fd_pr__pfet_01v8_hvt L=0.15 W=1
+ AS=0.26 AD=0.135 PS=2.52 PD=1.27
M$6767 \$9181 A|Y VPB|VPWR VPB|VPWR sky130_fd_pr__pfet_01v8_hvt L=0.15 W=1
+ AS=0.135 AD=0.135 PS=1.27 PD=1.27
M$6768 VPB|VPWR A|Y \$9160 VPB|VPWR sky130_fd_pr__pfet_01v8_hvt L=0.15 W=1
+ AS=0.135 AD=0.135 PS=1.27 PD=1.27
M$6769 \$9160 A2|B|X VPB|VPWR VPB|VPWR sky130_fd_pr__pfet_01v8_hvt L=0.15 W=1
+ AS=0.135 AD=0.26 PS=1.27 PD=2.52
M$6770 \$9160 \$9159 A|B|SLEEP|X VPB|VPWR sky130_fd_pr__pfet_01v8_hvt L=0.15
+ W=1 AS=0.26 AD=0.3 PS=2.52 PD=2.6
M$6774 \$9162 A|A1|B|X \$9182 VPB|VPWR sky130_fd_pr__pfet_01v8_hvt L=0.15 W=1
+ AS=0.26 AD=0.135 PS=2.52 PD=1.27
M$6775 \$9182 A|B1|X VPB|VPWR VPB|VPWR sky130_fd_pr__pfet_01v8_hvt L=0.15 W=1
+ AS=0.135 AD=0.135 PS=1.27 PD=1.27
M$6776 VPB|VPWR A|B1|X \$9163 VPB|VPWR sky130_fd_pr__pfet_01v8_hvt L=0.15 W=1
+ AS=0.135 AD=0.135 PS=1.27 PD=1.27
M$6777 \$9163 A|A1|B|X VPB|VPWR VPB|VPWR sky130_fd_pr__pfet_01v8_hvt L=0.15 W=1
+ AS=0.135 AD=0.26 PS=1.27 PD=2.52
M$6778 \$9163 \$9162 A|A1|B|X VPB|VPWR sky130_fd_pr__pfet_01v8_hvt L=0.15 W=1
+ AS=0.26 AD=0.3 PS=2.52 PD=2.6
M$6795 \$9208 A|FINE_MUX[15] VPB|VPWR VPB|VPWR sky130_fd_pr__pfet_01v8_hvt
+ L=0.15 W=1 AS=0.27 AD=0.1701 PS=2.54 PD=1.36
M$6796 VPB|VPWR \$9208 \$9209 VPB|VPWR sky130_fd_pr__pfet_01v8_hvt L=0.5 W=0.82
+ AS=0.1701 AD=0.2173 PS=1.36 PD=2.17
M$6797 VPB|VPWR \$9209 \$9210 VPB|VPWR sky130_fd_pr__pfet_01v8_hvt L=0.5 W=0.82
+ AS=0.15575 AD=0.2173 PS=1.325 PD=2.17
M$6798 VPB|VPWR \$9210 A|B1|X VPB|VPWR sky130_fd_pr__pfet_01v8_hvt L=0.15 W=1
+ AS=0.15575 AD=0.355 PS=1.325 PD=2.71
M$6807 A|B1|X \$9211 VPB|VPWR VPB|VPWR sky130_fd_pr__pfet_01v8_hvt L=0.15 W=1
+ AS=0.355 AD=0.15575 PS=2.71 PD=1.325
M$6808 VPB|VPWR \$9212 \$9211 VPB|VPWR sky130_fd_pr__pfet_01v8_hvt L=0.5 W=0.82
+ AS=0.15575 AD=0.2173 PS=1.325 PD=2.17
M$6809 VPB|VPWR \$9213 \$9212 VPB|VPWR sky130_fd_pr__pfet_01v8_hvt L=0.5 W=0.82
+ AS=0.1701 AD=0.2173 PS=1.36 PD=2.17
M$6810 VPB|VPWR A|FINE_MUX[16] \$9213 VPB|VPWR sky130_fd_pr__pfet_01v8_hvt
+ L=0.15 W=1 AS=0.1701 AD=0.27 PS=1.36 PD=2.54
M$6812 A|X \$9214 VPB|VPWR VPB|VPWR sky130_fd_pr__pfet_01v8_hvt L=0.15 W=1
+ AS=0.355 AD=0.15575 PS=2.71 PD=1.325
M$6813 VPB|VPWR \$9215 \$9214 VPB|VPWR sky130_fd_pr__pfet_01v8_hvt L=0.5 W=0.82
+ AS=0.15575 AD=0.2173 PS=1.325 PD=2.17
M$6814 VPB|VPWR \$9216 \$9215 VPB|VPWR sky130_fd_pr__pfet_01v8_hvt L=0.5 W=0.82
+ AS=0.1701 AD=0.2173 PS=1.36 PD=2.17
M$6815 VPB|VPWR A|FINE_MUX[17] \$9216 VPB|VPWR sky130_fd_pr__pfet_01v8_hvt
+ L=0.15 W=1 AS=0.1701 AD=0.27 PS=1.36 PD=2.54
M$6818 A|B1|X \$9217 VPB|VPWR VPB|VPWR sky130_fd_pr__pfet_01v8_hvt L=0.15 W=1
+ AS=0.355 AD=0.15575 PS=2.71 PD=1.325
M$6819 VPB|VPWR \$9218 \$9217 VPB|VPWR sky130_fd_pr__pfet_01v8_hvt L=0.5 W=0.82
+ AS=0.15575 AD=0.2173 PS=1.325 PD=2.17
M$6820 VPB|VPWR \$9219 \$9218 VPB|VPWR sky130_fd_pr__pfet_01v8_hvt L=0.5 W=0.82
+ AS=0.1701 AD=0.2173 PS=1.36 PD=2.17
M$6821 VPB|VPWR A|FINE_MUX[18] \$9219 VPB|VPWR sky130_fd_pr__pfet_01v8_hvt
+ L=0.15 W=1 AS=0.1701 AD=0.27 PS=1.36 PD=2.54
M$6822 A|X \$9220 VPB|VPWR VPB|VPWR sky130_fd_pr__pfet_01v8_hvt L=0.15 W=1
+ AS=0.355 AD=0.15575 PS=2.71 PD=1.325
M$6823 VPB|VPWR \$9221 \$9220 VPB|VPWR sky130_fd_pr__pfet_01v8_hvt L=0.5 W=0.82
+ AS=0.15575 AD=0.2173 PS=1.325 PD=2.17
M$6824 VPB|VPWR \$9222 \$9221 VPB|VPWR sky130_fd_pr__pfet_01v8_hvt L=0.5 W=0.82
+ AS=0.1701 AD=0.2173 PS=1.36 PD=2.17
M$6825 VPB|VPWR A|FINE_MUX[19] \$9222 VPB|VPWR sky130_fd_pr__pfet_01v8_hvt
+ L=0.15 W=1 AS=0.1701 AD=0.27 PS=1.36 PD=2.54
M$6827 A|X \$9223 VPB|VPWR VPB|VPWR sky130_fd_pr__pfet_01v8_hvt L=0.15 W=1
+ AS=0.355 AD=0.15575 PS=2.71 PD=1.325
M$6828 VPB|VPWR \$9224 \$9223 VPB|VPWR sky130_fd_pr__pfet_01v8_hvt L=0.5 W=0.82
+ AS=0.15575 AD=0.2173 PS=1.325 PD=2.17
M$6829 VPB|VPWR \$9225 \$9224 VPB|VPWR sky130_fd_pr__pfet_01v8_hvt L=0.5 W=0.82
+ AS=0.1701 AD=0.2173 PS=1.36 PD=2.17
M$6830 VPB|VPWR A|FINE_MUX[20] \$9225 VPB|VPWR sky130_fd_pr__pfet_01v8_hvt
+ L=0.15 W=1 AS=0.1701 AD=0.27 PS=1.36 PD=2.54
M$6834 A|B1|X \$9226 VPB|VPWR VPB|VPWR sky130_fd_pr__pfet_01v8_hvt L=0.15 W=1
+ AS=0.355 AD=0.15575 PS=2.71 PD=1.325
M$6835 VPB|VPWR \$9227 \$9226 VPB|VPWR sky130_fd_pr__pfet_01v8_hvt L=0.5 W=0.82
+ AS=0.15575 AD=0.2173 PS=1.325 PD=2.17
M$6836 VPB|VPWR \$9228 \$9227 VPB|VPWR sky130_fd_pr__pfet_01v8_hvt L=0.5 W=0.82
+ AS=0.1701 AD=0.2173 PS=1.36 PD=2.17
M$6837 VPB|VPWR A|FINE_MUX[22] \$9228 VPB|VPWR sky130_fd_pr__pfet_01v8_hvt
+ L=0.15 W=1 AS=0.1701 AD=0.27 PS=1.36 PD=2.54
M$6840 A|B1|C1|X \$9229 VPB|VPWR VPB|VPWR sky130_fd_pr__pfet_01v8_hvt L=0.15
+ W=1 AS=0.355 AD=0.15575 PS=2.71 PD=1.325
M$6841 VPB|VPWR \$9230 \$9229 VPB|VPWR sky130_fd_pr__pfet_01v8_hvt L=0.5 W=0.82
+ AS=0.15575 AD=0.2173 PS=1.325 PD=2.17
M$6842 VPB|VPWR \$9231 \$9230 VPB|VPWR sky130_fd_pr__pfet_01v8_hvt L=0.5 W=0.82
+ AS=0.1701 AD=0.2173 PS=1.36 PD=2.17
M$6843 VPB|VPWR A|FINE_MUX[23] \$9231 VPB|VPWR sky130_fd_pr__pfet_01v8_hvt
+ L=0.15 W=1 AS=0.1701 AD=0.27 PS=1.36 PD=2.54
M$6844 A|B1|X \$9232 VPB|VPWR VPB|VPWR sky130_fd_pr__pfet_01v8_hvt L=0.15 W=1
+ AS=0.355 AD=0.15575 PS=2.71 PD=1.325
M$6845 VPB|VPWR \$9233 \$9232 VPB|VPWR sky130_fd_pr__pfet_01v8_hvt L=0.5 W=0.82
+ AS=0.15575 AD=0.2173 PS=1.325 PD=2.17
M$6846 VPB|VPWR \$9234 \$9233 VPB|VPWR sky130_fd_pr__pfet_01v8_hvt L=0.5 W=0.82
+ AS=0.1701 AD=0.2173 PS=1.36 PD=2.17
M$6847 VPB|VPWR A|FINE_MUX[24] \$9234 VPB|VPWR sky130_fd_pr__pfet_01v8_hvt
+ L=0.15 W=1 AS=0.1701 AD=0.27 PS=1.36 PD=2.54
M$6851 A|X \$9235 VPB|VPWR VPB|VPWR sky130_fd_pr__pfet_01v8_hvt L=0.15 W=1
+ AS=0.355 AD=0.15575 PS=2.71 PD=1.325
M$6852 VPB|VPWR \$9236 \$9235 VPB|VPWR sky130_fd_pr__pfet_01v8_hvt L=0.5 W=0.82
+ AS=0.15575 AD=0.2173 PS=1.325 PD=2.17
M$6853 VPB|VPWR \$9237 \$9236 VPB|VPWR sky130_fd_pr__pfet_01v8_hvt L=0.5 W=0.82
+ AS=0.1701 AD=0.2173 PS=1.36 PD=2.17
M$6854 VPB|VPWR A|FINE_MUX[25] \$9237 VPB|VPWR sky130_fd_pr__pfet_01v8_hvt
+ L=0.15 W=1 AS=0.1701 AD=0.27 PS=1.36 PD=2.54
M$6855 A|X \$9239 VPB|VPWR VPB|VPWR sky130_fd_pr__pfet_01v8_hvt L=0.15 W=1
+ AS=0.355 AD=0.15575 PS=2.71 PD=1.325
M$6856 VPB|VPWR \$9240 \$9239 VPB|VPWR sky130_fd_pr__pfet_01v8_hvt L=0.5 W=0.82
+ AS=0.15575 AD=0.2173 PS=1.325 PD=2.17
M$6857 VPB|VPWR \$9241 \$9240 VPB|VPWR sky130_fd_pr__pfet_01v8_hvt L=0.5 W=0.82
+ AS=0.1701 AD=0.2173 PS=1.36 PD=2.17
M$6858 VPB|VPWR A|FINE_MUX[26] \$9241 VPB|VPWR sky130_fd_pr__pfet_01v8_hvt
+ L=0.15 W=1 AS=0.1701 AD=0.27 PS=1.36 PD=2.54
M$6860 \$9242 A|FINE_MUX[27] VPB|VPWR VPB|VPWR sky130_fd_pr__pfet_01v8_hvt
+ L=0.15 W=1 AS=0.27 AD=0.1701 PS=2.54 PD=1.36
M$6861 VPB|VPWR \$9242 \$9243 VPB|VPWR sky130_fd_pr__pfet_01v8_hvt L=0.5 W=0.82
+ AS=0.1701 AD=0.2173 PS=1.36 PD=2.17
M$6862 VPB|VPWR \$9243 \$9244 VPB|VPWR sky130_fd_pr__pfet_01v8_hvt L=0.5 W=0.82
+ AS=0.15575 AD=0.2173 PS=1.325 PD=2.17
M$6863 VPB|VPWR \$9244 A|B1|X VPB|VPWR sky130_fd_pr__pfet_01v8_hvt L=0.15 W=1
+ AS=0.15575 AD=0.355 PS=1.325 PD=2.71
M$6865 A|B1|X \$9245 VPB|VPWR VPB|VPWR sky130_fd_pr__pfet_01v8_hvt L=0.15 W=1
+ AS=0.355 AD=0.15575 PS=2.71 PD=1.325
M$6866 VPB|VPWR \$9246 \$9245 VPB|VPWR sky130_fd_pr__pfet_01v8_hvt L=0.5 W=0.82
+ AS=0.15575 AD=0.2173 PS=1.325 PD=2.17
M$6867 VPB|VPWR \$9247 \$9246 VPB|VPWR sky130_fd_pr__pfet_01v8_hvt L=0.5 W=0.82
+ AS=0.1701 AD=0.2173 PS=1.36 PD=2.17
M$6868 VPB|VPWR A|FINE_MUX[28] \$9247 VPB|VPWR sky130_fd_pr__pfet_01v8_hvt
+ L=0.15 W=1 AS=0.1701 AD=0.27 PS=1.36 PD=2.54
M$6870 \$9248 A|FINE_MUX[29] VPB|VPWR VPB|VPWR sky130_fd_pr__pfet_01v8_hvt
+ L=0.15 W=1 AS=0.27 AD=0.1701 PS=2.54 PD=1.36
M$6871 VPB|VPWR \$9248 \$9249 VPB|VPWR sky130_fd_pr__pfet_01v8_hvt L=0.5 W=0.82
+ AS=0.1701 AD=0.2173 PS=1.36 PD=2.17
M$6872 VPB|VPWR \$9249 \$9250 VPB|VPWR sky130_fd_pr__pfet_01v8_hvt L=0.5 W=0.82
+ AS=0.15575 AD=0.2173 PS=1.325 PD=2.17
M$6873 VPB|VPWR \$9250 A|B1|X VPB|VPWR sky130_fd_pr__pfet_01v8_hvt L=0.15 W=1
+ AS=0.15575 AD=0.355 PS=1.325 PD=2.71
M$6875 \$9251 A|FINE_MUX[30] VPB|VPWR VPB|VPWR sky130_fd_pr__pfet_01v8_hvt
+ L=0.15 W=1 AS=0.27 AD=0.1701 PS=2.54 PD=1.36
M$6876 VPB|VPWR \$9251 \$9252 VPB|VPWR sky130_fd_pr__pfet_01v8_hvt L=0.5 W=0.82
+ AS=0.1701 AD=0.2173 PS=1.36 PD=2.17
M$6877 VPB|VPWR \$9252 \$9253 VPB|VPWR sky130_fd_pr__pfet_01v8_hvt L=0.5 W=0.82
+ AS=0.15575 AD=0.2173 PS=1.325 PD=2.17
M$6878 VPB|VPWR \$9253 A|B1|X VPB|VPWR sky130_fd_pr__pfet_01v8_hvt L=0.15 W=1
+ AS=0.15575 AD=0.355 PS=1.325 PD=2.71
M$6886 VGND VPB|VPWR VGND VGND sky130_fd_pr__nfet_01v8 L=4.73 W=660 AS=171.6
+ AD=171.6 PS=1944 PD=1944
M$6889 VGND VPB|VPWR VGND VGND sky130_fd_pr__nfet_01v8 L=1.97 W=92.4 AS=24.024
+ AD=24.024 PS=272.16 PD=272.16
M$6895 VGND VPB|VPWR VGND VGND sky130_fd_pr__nfet_01v8 L=1.05 W=92.95 AS=24.167
+ AD=24.167 PS=273.78 PD=273.78
M$6896 A|A1|B1|C_N|X \$17 VGND VGND sky130_fd_pr__nfet_01v8 L=0.15 W=0.42
+ AS=0.1491 AD=0.097 PS=1.55 PD=0.975
M$6897 VGND \$18 \$17 VGND sky130_fd_pr__nfet_01v8 L=0.5 W=0.65 AS=0.097
+ AD=0.17225 PS=0.975 PD=1.83
M$6898 VGND A|MID_MUX[14] \$19 VGND sky130_fd_pr__nfet_01v8 L=0.15 W=0.42
+ AS=0.10435 AD=0.1134 PS=1.01 PD=1.38
M$6899 \$18 \$19 VGND VGND sky130_fd_pr__nfet_01v8 L=0.5 W=0.65 AS=0.169
+ AD=0.10435 PS=1.82 PD=1.01
M$6902 A|X \$21 VGND VGND sky130_fd_pr__nfet_01v8 L=0.15 W=0.42 AS=0.1491
+ AD=0.097 PS=1.55 PD=0.975
M$6903 VGND \$22 \$21 VGND sky130_fd_pr__nfet_01v8 L=0.5 W=0.65 AS=0.097
+ AD=0.17225 PS=0.975 PD=1.83
M$6904 VGND A|MID_MUX[13] \$23 VGND sky130_fd_pr__nfet_01v8 L=0.15 W=0.42
+ AS=0.10435 AD=0.1134 PS=1.01 PD=1.38
M$6905 \$22 \$23 VGND VGND sky130_fd_pr__nfet_01v8 L=0.5 W=0.65 AS=0.169
+ AD=0.10435 PS=1.82 PD=1.01
M$6906 A|A1|B|B1|X \$25 VGND VGND sky130_fd_pr__nfet_01v8 L=0.15 W=0.42
+ AS=0.1491 AD=0.097 PS=1.55 PD=0.975
M$6907 VGND \$26 \$25 VGND sky130_fd_pr__nfet_01v8 L=0.5 W=0.65 AS=0.097
+ AD=0.17225 PS=0.975 PD=1.83
M$6908 VGND A|MID_MUX[12] \$27 VGND sky130_fd_pr__nfet_01v8 L=0.15 W=0.42
+ AS=0.10435 AD=0.1134 PS=1.01 PD=1.38
M$6909 \$26 \$27 VGND VGND sky130_fd_pr__nfet_01v8 L=0.5 W=0.65 AS=0.169
+ AD=0.10435 PS=1.82 PD=1.01
M$6911 A|B1|X \$29 VGND VGND sky130_fd_pr__nfet_01v8 L=0.15 W=0.42 AS=0.1491
+ AD=0.097 PS=1.55 PD=0.975
M$6912 VGND \$30 \$29 VGND sky130_fd_pr__nfet_01v8 L=0.5 W=0.65 AS=0.097
+ AD=0.17225 PS=0.975 PD=1.83
M$6913 VGND A|MID_MUX[11] \$31 VGND sky130_fd_pr__nfet_01v8 L=0.15 W=0.42
+ AS=0.10435 AD=0.1134 PS=1.01 PD=1.38
M$6914 \$30 \$31 VGND VGND sky130_fd_pr__nfet_01v8 L=0.5 W=0.65 AS=0.169
+ AD=0.10435 PS=1.82 PD=1.01
M$6916 A|B|B1|X \$33 VGND VGND sky130_fd_pr__nfet_01v8 L=0.15 W=0.42 AS=0.1491
+ AD=0.097 PS=1.55 PD=0.975
M$6917 VGND \$34 \$33 VGND sky130_fd_pr__nfet_01v8 L=0.5 W=0.65 AS=0.097
+ AD=0.17225 PS=0.975 PD=1.83
M$6918 VGND A|MID_MUX[10] \$35 VGND sky130_fd_pr__nfet_01v8 L=0.15 W=0.42
+ AS=0.10435 AD=0.1134 PS=1.01 PD=1.38
M$6919 \$34 \$35 VGND VGND sky130_fd_pr__nfet_01v8 L=0.5 W=0.65 AS=0.169
+ AD=0.10435 PS=1.82 PD=1.01
M$6920 A|B1|X \$37 VGND VGND sky130_fd_pr__nfet_01v8 L=0.15 W=0.42 AS=0.1491
+ AD=0.097 PS=1.55 PD=0.975
M$6921 VGND \$38 \$37 VGND sky130_fd_pr__nfet_01v8 L=0.5 W=0.65 AS=0.097
+ AD=0.17225 PS=0.975 PD=1.83
M$6922 VGND A|MID_MUX[9] \$39 VGND sky130_fd_pr__nfet_01v8 L=0.15 W=0.42
+ AS=0.10435 AD=0.1134 PS=1.01 PD=1.38
M$6923 \$38 \$39 VGND VGND sky130_fd_pr__nfet_01v8 L=0.5 W=0.65 AS=0.169
+ AD=0.10435 PS=1.82 PD=1.01
M$6924 A|X \$41 VGND VGND sky130_fd_pr__nfet_01v8 L=0.15 W=0.42 AS=0.1491
+ AD=0.097 PS=1.55 PD=0.975
M$6925 VGND \$42 \$41 VGND sky130_fd_pr__nfet_01v8 L=0.5 W=0.65 AS=0.097
+ AD=0.17225 PS=0.975 PD=1.83
M$6926 VGND A|MID_MUX[7] \$43 VGND sky130_fd_pr__nfet_01v8 L=0.15 W=0.42
+ AS=0.10435 AD=0.1134 PS=1.01 PD=1.38
M$6927 \$42 \$43 VGND VGND sky130_fd_pr__nfet_01v8 L=0.5 W=0.65 AS=0.169
+ AD=0.10435 PS=1.82 PD=1.01
M$6928 A|B|B1|X \$45 VGND VGND sky130_fd_pr__nfet_01v8 L=0.15 W=0.42 AS=0.1491
+ AD=0.097 PS=1.55 PD=0.975
M$6929 VGND \$46 \$45 VGND sky130_fd_pr__nfet_01v8 L=0.5 W=0.65 AS=0.097
+ AD=0.17225 PS=0.975 PD=1.83
M$6930 VGND A|MID_MUX[8] \$47 VGND sky130_fd_pr__nfet_01v8 L=0.15 W=0.42
+ AS=0.10435 AD=0.1134 PS=1.01 PD=1.38
M$6931 \$46 \$47 VGND VGND sky130_fd_pr__nfet_01v8 L=0.5 W=0.65 AS=0.169
+ AD=0.10435 PS=1.82 PD=1.01
M$6932 VGND VPB|VPWR VGND VGND sky130_fd_pr__nfet_01v8 L=2.89 W=129.8 AS=33.748
+ AD=33.748 PS=382.32 PD=382.32
M$6934 A|B|B1|X \$48 VGND VGND sky130_fd_pr__nfet_01v8 L=0.15 W=0.42 AS=0.1491
+ AD=0.097 PS=1.55 PD=0.975
M$6935 VGND \$49 \$48 VGND sky130_fd_pr__nfet_01v8 L=0.5 W=0.65 AS=0.097
+ AD=0.17225 PS=0.975 PD=1.83
M$6936 VGND A|MID_MUX[6] \$50 VGND sky130_fd_pr__nfet_01v8 L=0.15 W=0.42
+ AS=0.10435 AD=0.1134 PS=1.01 PD=1.38
M$6937 \$49 \$50 VGND VGND sky130_fd_pr__nfet_01v8 L=0.5 W=0.65 AS=0.169
+ AD=0.10435 PS=1.82 PD=1.01
M$6940 VGND VPB|VPWR VGND VGND sky130_fd_pr__nfet_01v8 L=0.59 W=68.75 AS=17.875
+ AD=17.875 PS=202.5 PD=202.5
M$6941 A|B|B1|X \$52 VGND VGND sky130_fd_pr__nfet_01v8 L=0.15 W=0.42 AS=0.1491
+ AD=0.097 PS=1.55 PD=0.975
M$6942 VGND \$53 \$52 VGND sky130_fd_pr__nfet_01v8 L=0.5 W=0.65 AS=0.097
+ AD=0.17225 PS=0.975 PD=1.83
M$6943 VGND A|MID_MUX[4] \$54 VGND sky130_fd_pr__nfet_01v8 L=0.15 W=0.42
+ AS=0.10435 AD=0.1134 PS=1.01 PD=1.38
M$6944 \$53 \$54 VGND VGND sky130_fd_pr__nfet_01v8 L=0.5 W=0.65 AS=0.169
+ AD=0.10435 PS=1.82 PD=1.01
M$6945 \$55 A|MID_MUX[3] VGND VGND sky130_fd_pr__nfet_01v8 L=0.15 W=0.42
+ AS=0.1134 AD=0.10435 PS=1.38 PD=1.01
M$6946 VGND \$55 \$56 VGND sky130_fd_pr__nfet_01v8 L=0.5 W=0.65 AS=0.10435
+ AD=0.169 PS=1.01 PD=1.82
M$6947 VGND \$57 A|A1|B1|X VGND sky130_fd_pr__nfet_01v8 L=0.15 W=0.42 AS=0.097
+ AD=0.1491 PS=0.975 PD=1.55
M$6948 \$57 \$56 VGND VGND sky130_fd_pr__nfet_01v8 L=0.5 W=0.65 AS=0.17225
+ AD=0.097 PS=1.83 PD=0.975
M$6951 A|B1|C|X \$59 VGND VGND sky130_fd_pr__nfet_01v8 L=0.15 W=0.42 AS=0.1491
+ AD=0.097 PS=1.55 PD=0.975
M$6952 VGND \$60 \$59 VGND sky130_fd_pr__nfet_01v8 L=0.5 W=0.65 AS=0.097
+ AD=0.17225 PS=0.975 PD=1.83
M$6953 VGND A|MID_MUX[2] \$61 VGND sky130_fd_pr__nfet_01v8 L=0.15 W=0.42
+ AS=0.10435 AD=0.1134 PS=1.01 PD=1.38
M$6954 \$60 \$61 VGND VGND sky130_fd_pr__nfet_01v8 L=0.5 W=0.65 AS=0.169
+ AD=0.10435 PS=1.82 PD=1.01
M$6955 VGND B|B1|X A|Y VGND sky130_fd_pr__nfet_01v8 L=0.15 W=0.65 AS=0.169
+ AD=0.08775 PS=1.82 PD=0.92
M$6956 A|Y A|A1|X VGND VGND sky130_fd_pr__nfet_01v8 L=0.15 W=1.95 AS=0.357
+ AD=0.3445 PS=3.725 PD=3.66
M$6957 B|B1|X \$62 VGND VGND sky130_fd_pr__nfet_01v8 L=0.15 W=0.42 AS=0.1491
+ AD=0.097 PS=1.55 PD=0.975
M$6958 VGND \$63 \$62 VGND sky130_fd_pr__nfet_01v8 L=0.5 W=0.65 AS=0.097
+ AD=0.17225 PS=0.975 PD=1.83
M$6959 VGND A|MID_MUX[1] \$64 VGND sky130_fd_pr__nfet_01v8 L=0.15 W=0.42
+ AS=0.10435 AD=0.1134 PS=1.01 PD=1.38
M$6960 \$63 \$64 VGND VGND sky130_fd_pr__nfet_01v8 L=0.5 W=0.65 AS=0.169
+ AD=0.10435 PS=1.82 PD=1.01
M$6963 VGND B|C|X \$147 VGND sky130_fd_pr__nfet_01v8 L=0.15 W=0.42 AS=0.1474
+ AD=0.0441 PS=1.215 PD=0.63
M$6964 \$147 A|B|C1|X \$66 VGND sky130_fd_pr__nfet_01v8 L=0.15 W=0.42 AS=0.0441
+ AD=0.0567 PS=0.63 PD=0.69
M$6965 \$66 A|B|C1|X \$144 VGND sky130_fd_pr__nfet_01v8 L=0.15 W=0.42 AS=0.0567
+ AD=0.0441 PS=0.69 PD=0.63
M$6966 \$144 A|X VGND VGND sky130_fd_pr__nfet_01v8 L=0.15 W=0.42 AS=0.0441
+ AD=0.0567 PS=0.63 PD=0.69
M$6967 VGND A|X \$140 VGND sky130_fd_pr__nfet_01v8 L=0.15 W=0.42 AS=0.0567
+ AD=0.0441 PS=0.69 PD=0.63
M$6968 \$140 B|C|X \$66 VGND sky130_fd_pr__nfet_01v8 L=0.15 W=0.42 AS=0.0441
+ AD=0.1092 PS=0.63 PD=1.36
M$6969 B|X \$66 VGND VGND sky130_fd_pr__nfet_01v8 L=0.15 W=0.65 AS=0.23725
+ AD=0.1474 PS=2.03 PD=1.215
M$6973 \$68 A|COARSE_MUX[9] VGND VGND sky130_fd_pr__nfet_01v8 L=0.15 W=0.42
+ AS=0.1134 AD=0.10435 PS=1.38 PD=1.01
M$6974 VGND \$68 \$69 VGND sky130_fd_pr__nfet_01v8 L=0.5 W=0.65 AS=0.10435
+ AD=0.169 PS=1.01 PD=1.82
M$6975 VGND \$70 A|X VGND sky130_fd_pr__nfet_01v8 L=0.15 W=0.42 AS=0.097
+ AD=0.1491 PS=0.975 PD=1.55
M$6976 \$70 \$69 VGND VGND sky130_fd_pr__nfet_01v8 L=0.5 W=0.65 AS=0.17225
+ AD=0.097 PS=1.83 PD=0.975
M$6977 A|A1|B|C1|X \$73 VGND VGND sky130_fd_pr__nfet_01v8 L=0.15 W=0.42
+ AS=0.1491 AD=0.097 PS=1.55 PD=0.975
M$6978 VGND \$74 \$73 VGND sky130_fd_pr__nfet_01v8 L=0.5 W=0.65 AS=0.097
+ AD=0.17225 PS=0.975 PD=1.83
M$6979 VGND A|COARSE_MUX[12] \$75 VGND sky130_fd_pr__nfet_01v8 L=0.15 W=0.42
+ AS=0.10435 AD=0.1134 PS=1.01 PD=1.38
M$6980 \$74 \$75 VGND VGND sky130_fd_pr__nfet_01v8 L=0.5 W=0.65 AS=0.169
+ AD=0.10435 PS=1.82 PD=1.01
M$6981 \$77 A|COARSE_MUX[10] VGND VGND sky130_fd_pr__nfet_01v8 L=0.15 W=0.42
+ AS=0.1134 AD=0.10435 PS=1.38 PD=1.01
M$6982 VGND \$77 \$78 VGND sky130_fd_pr__nfet_01v8 L=0.5 W=0.65 AS=0.10435
+ AD=0.169 PS=1.01 PD=1.82
M$6983 VGND \$79 A|X VGND sky130_fd_pr__nfet_01v8 L=0.15 W=0.42 AS=0.097
+ AD=0.1491 PS=0.975 PD=1.55
M$6984 \$79 \$78 VGND VGND sky130_fd_pr__nfet_01v8 L=0.5 W=0.65 AS=0.17225
+ AD=0.097 PS=1.83 PD=0.975
M$6986 A|B|C1|X \$81 VGND VGND sky130_fd_pr__nfet_01v8 L=0.15 W=0.42 AS=0.1491
+ AD=0.097 PS=1.55 PD=0.975
M$6987 VGND \$82 \$81 VGND sky130_fd_pr__nfet_01v8 L=0.5 W=0.65 AS=0.097
+ AD=0.17225 PS=0.975 PD=1.83
M$6988 VGND A|COARSE_MUX[14] \$83 VGND sky130_fd_pr__nfet_01v8 L=0.15 W=0.42
+ AS=0.10435 AD=0.1134 PS=1.01 PD=1.38
M$6989 \$82 \$83 VGND VGND sky130_fd_pr__nfet_01v8 L=0.5 W=0.65 AS=0.169
+ AD=0.10435 PS=1.82 PD=1.01
M$7002 VGND A1|B|C|SLEEP|X \$174 VGND sky130_fd_pr__nfet_01v8 L=0.15 W=0.42
+ AS=0.1165 AD=0.1785 PS=1.035 PD=1.69
M$7003 A1|B|C|X \$173 VGND VGND sky130_fd_pr__nfet_01v8 L=0.15 W=0.65 AS=0.169
+ AD=0.1165 PS=1.82 PD=1.035
M$7004 \$176 A1|B|C|SLEEP|X \$173 VGND sky130_fd_pr__nfet_01v8 L=0.15 W=0.64
+ AS=0.1728 AD=0.0928 PS=1.82 PD=0.93
M$7005 \$173 \$174 \$175 VGND sky130_fd_pr__nfet_01v8 L=0.15 W=0.64 AS=0.0928
+ AD=0.224 PS=0.93 PD=1.98
M$7006 VGND A|B|B1|X \$177 VGND sky130_fd_pr__nfet_01v8 L=0.15 W=0.65 AS=0.1885
+ AD=0.16515 PS=1.88 PD=1.82
M$7007 \$178 A|B|B1|X \$175 VGND sky130_fd_pr__nfet_01v8 L=0.15 W=0.64
+ AS=0.16275 AD=0.18205 PS=1.8 PD=1.245
M$7008 \$175 \$177 \$179 VGND sky130_fd_pr__nfet_01v8 L=0.15 W=0.42 AS=0.18205
+ AD=0.19265 PS=1.245 PD=1.285
M$7009 \$179 A|B|B1|X \$176 VGND sky130_fd_pr__nfet_01v8 L=0.15 W=0.64
+ AS=0.19265 AD=0.140825 PS=1.285 PD=1.1
M$7010 \$176 \$177 \$178 VGND sky130_fd_pr__nfet_01v8 L=0.15 W=0.6 AS=0.140825
+ AD=0.11 PS=1.1 PD=0.99
M$7011 \$178 A|Y VGND VGND sky130_fd_pr__nfet_01v8 L=0.15 W=0.64 AS=0.11
+ AD=0.0864 PS=0.99 PD=0.91
M$7012 VGND \$178 \$179 VGND sky130_fd_pr__nfet_01v8 L=0.15 W=0.64 AS=0.0864
+ AD=0.1824 PS=0.91 PD=1.85
M$7013 A|A1|Y \$182 \$276 VGND sky130_fd_pr__nfet_01v8 L=0.15 W=0.65 AS=0.195
+ AD=0.08775 PS=1.9 PD=0.92
M$7014 \$276 A1|B|C|SLEEP|X VGND VGND sky130_fd_pr__nfet_01v8 L=0.15 W=0.65
+ AS=0.08775 AD=0.169 PS=0.92 PD=1.82
M$7015 \$276 A|Y VGND VGND sky130_fd_pr__nfet_01v8 L=0.15 W=0.65 AS=0.169
+ AD=0.08775 PS=1.82 PD=0.92
M$7016 VGND A|Y \$282 VGND sky130_fd_pr__nfet_01v8 L=0.15 W=0.65 AS=0.08775
+ AD=0.06825 PS=0.92 PD=0.86
M$7017 \$282 A1|B|C|SLEEP|X \$182 VGND sky130_fd_pr__nfet_01v8 L=0.15 W=0.65
+ AS=0.06825 AD=0.169 PS=0.86 PD=1.82
M$7019 VGND A1|B|C|X \$184 VGND sky130_fd_pr__nfet_01v8 L=0.15 W=0.42 AS=0.1165
+ AD=0.1785 PS=1.035 PD=1.69
M$7020 A1|B|C|SLEEP|X \$183 VGND VGND sky130_fd_pr__nfet_01v8 L=0.15 W=0.65
+ AS=0.169 AD=0.1165 PS=1.82 PD=1.035
M$7021 \$186 A1|B|C|X \$183 VGND sky130_fd_pr__nfet_01v8 L=0.15 W=0.64
+ AS=0.1728 AD=0.0928 PS=1.82 PD=0.93
M$7022 \$183 \$184 \$185 VGND sky130_fd_pr__nfet_01v8 L=0.15 W=0.64 AS=0.0928
+ AD=0.224 PS=0.93 PD=1.98
M$7023 VGND A|B|B1|X \$187 VGND sky130_fd_pr__nfet_01v8 L=0.15 W=0.65 AS=0.1885
+ AD=0.16515 PS=1.88 PD=1.82
M$7024 \$188 A|B|B1|X \$185 VGND sky130_fd_pr__nfet_01v8 L=0.15 W=0.64
+ AS=0.16275 AD=0.18205 PS=1.8 PD=1.245
M$7025 \$185 \$187 \$189 VGND sky130_fd_pr__nfet_01v8 L=0.15 W=0.42 AS=0.18205
+ AD=0.19265 PS=1.245 PD=1.285
M$7026 \$189 A|B|B1|X \$186 VGND sky130_fd_pr__nfet_01v8 L=0.15 W=0.64
+ AS=0.19265 AD=0.140825 PS=1.285 PD=1.1
M$7027 \$186 \$187 \$188 VGND sky130_fd_pr__nfet_01v8 L=0.15 W=0.6 AS=0.140825
+ AD=0.11 PS=1.1 PD=0.99
M$7028 \$188 A|X VGND VGND sky130_fd_pr__nfet_01v8 L=0.15 W=0.64 AS=0.11
+ AD=0.0864 PS=0.99 PD=0.91
M$7029 VGND \$188 \$189 VGND sky130_fd_pr__nfet_01v8 L=0.15 W=0.64 AS=0.0864
+ AD=0.1824 PS=0.91 PD=1.85
M$7030 VGND B|C|X \$192 VGND sky130_fd_pr__nfet_01v8 L=0.15 W=0.42 AS=0.144125
+ AD=0.1764 PS=1.12 PD=1.68
M$7031 A1|B|C|X \$191 VGND VGND sky130_fd_pr__nfet_01v8 L=0.15 W=0.65 AS=0.169
+ AD=0.144125 PS=1.82 PD=1.12
M$7032 \$195 B|C|X \$191 VGND sky130_fd_pr__nfet_01v8 L=0.15 W=0.64 AS=0.1728
+ AD=0.128 PS=1.82 PD=1.04
M$7033 \$191 \$192 \$194 VGND sky130_fd_pr__nfet_01v8 L=0.15 W=0.64 AS=0.128
+ AD=0.3168 PS=1.04 PD=2.27
M$7034 VGND A|B|B1|X \$196 VGND sky130_fd_pr__nfet_01v8 L=0.15 W=0.65 AS=0.195
+ AD=0.1653 PS=1.9 PD=1.82
M$7035 \$197 A|B|B1|X \$195 VGND sky130_fd_pr__nfet_01v8 L=0.15 W=0.64
+ AS=0.1628 AD=0.18365 PS=1.8 PD=1.25
M$7036 \$195 \$196 \$198 VGND sky130_fd_pr__nfet_01v8 L=0.15 W=0.42 AS=0.18365
+ AD=0.19265 PS=1.25 PD=1.285
M$7037 \$198 A|B|B1|X \$194 VGND sky130_fd_pr__nfet_01v8 L=0.15 W=0.64
+ AS=0.19265 AD=0.140825 PS=1.285 PD=1.1
M$7038 \$194 \$196 \$197 VGND sky130_fd_pr__nfet_01v8 L=0.15 W=0.6 AS=0.140825
+ AD=0.11 PS=1.1 PD=0.99
M$7039 \$197 A|B1|X VGND VGND sky130_fd_pr__nfet_01v8 L=0.15 W=0.64 AS=0.11
+ AD=0.0864 PS=0.99 PD=0.91
M$7040 VGND \$197 \$198 VGND sky130_fd_pr__nfet_01v8 L=0.15 W=0.64 AS=0.0864
+ AD=0.1824 PS=0.91 PD=1.85
M$7041 VGND A|MID_MUX[5] \$202 VGND sky130_fd_pr__nfet_01v8 L=0.15 W=0.42
+ AS=0.10435 AD=0.1134 PS=1.01 PD=1.38
M$7042 VGND \$202 \$203 VGND sky130_fd_pr__nfet_01v8 L=0.5 W=0.65 AS=0.10435
+ AD=0.169 PS=1.01 PD=1.82
M$7043 \$204 \$203 VGND VGND sky130_fd_pr__nfet_01v8 L=0.5 W=0.65 AS=0.17225
+ AD=0.097 PS=1.83 PD=0.975
M$7044 VGND \$204 A|B1|X VGND sky130_fd_pr__nfet_01v8 L=0.15 W=0.42 AS=0.097
+ AD=0.1491 PS=0.975 PD=1.55
M$7045 A2|Y A|B1|X \$285 VGND sky130_fd_pr__nfet_01v8 L=0.15 W=0.65 AS=0.169
+ AD=0.08775 PS=1.82 PD=0.92
M$7046 \$285 B|C|X VGND VGND sky130_fd_pr__nfet_01v8 L=0.15 W=0.65 AS=0.08775
+ AD=0.169 PS=0.92 PD=1.82
M$7047 VGND A|A2|B|C|X \$207 VGND sky130_fd_pr__nfet_01v8 L=0.15 W=0.42
+ AS=0.144125 AD=0.1764 PS=1.12 PD=1.68
M$7048 B|C|X \$206 VGND VGND sky130_fd_pr__nfet_01v8 L=0.15 W=0.65 AS=0.169
+ AD=0.144125 PS=1.82 PD=1.12
M$7049 \$209 A|A2|B|C|X \$206 VGND sky130_fd_pr__nfet_01v8 L=0.15 W=0.64
+ AS=0.1728 AD=0.128 PS=1.82 PD=1.04
M$7050 \$206 \$207 \$208 VGND sky130_fd_pr__nfet_01v8 L=0.15 W=0.64 AS=0.128
+ AD=0.3168 PS=1.04 PD=2.27
M$7051 VGND A|B|B1|X \$210 VGND sky130_fd_pr__nfet_01v8 L=0.15 W=0.65 AS=0.195
+ AD=0.1653 PS=1.9 PD=1.82
M$7052 \$211 A|B|B1|X \$209 VGND sky130_fd_pr__nfet_01v8 L=0.15 W=0.64
+ AS=0.1628 AD=0.18365 PS=1.8 PD=1.25
M$7053 \$209 \$210 \$212 VGND sky130_fd_pr__nfet_01v8 L=0.15 W=0.42 AS=0.18365
+ AD=0.19265 PS=1.25 PD=1.285
M$7054 \$212 A|B|B1|X \$208 VGND sky130_fd_pr__nfet_01v8 L=0.15 W=0.64
+ AS=0.19265 AD=0.140825 PS=1.285 PD=1.1
M$7055 \$208 \$210 \$211 VGND sky130_fd_pr__nfet_01v8 L=0.15 W=0.6 AS=0.140825
+ AD=0.11 PS=1.1 PD=0.99
M$7056 \$211 A|A1|B1|X VGND VGND sky130_fd_pr__nfet_01v8 L=0.15 W=0.64 AS=0.11
+ AD=0.0864 PS=0.99 PD=0.91
M$7057 VGND \$211 \$212 VGND sky130_fd_pr__nfet_01v8 L=0.15 W=0.64 AS=0.0864
+ AD=0.1824 PS=0.91 PD=1.85
M$7059 VGND C|Y \$215 VGND sky130_fd_pr__nfet_01v8 L=0.15 W=0.42 AS=0.1165
+ AD=0.1785 PS=1.035 PD=1.69
M$7060 A2|A_N|B|B1|C|X \$213 VGND VGND sky130_fd_pr__nfet_01v8 L=0.15 W=0.65
+ AS=0.169 AD=0.1165 PS=1.82 PD=1.035
M$7061 \$217 C|Y \$213 VGND sky130_fd_pr__nfet_01v8 L=0.15 W=0.64 AS=0.1728
+ AD=0.0928 PS=1.82 PD=0.93
M$7062 \$213 \$215 \$216 VGND sky130_fd_pr__nfet_01v8 L=0.15 W=0.64 AS=0.0928
+ AD=0.224 PS=0.93 PD=1.98
M$7063 VGND B|X \$218 VGND sky130_fd_pr__nfet_01v8 L=0.15 W=0.65 AS=0.1885
+ AD=0.16515 PS=1.88 PD=1.82
M$7064 \$219 B|X \$216 VGND sky130_fd_pr__nfet_01v8 L=0.15 W=0.64 AS=0.16275
+ AD=0.18205 PS=1.8 PD=1.245
M$7065 \$216 \$218 \$220 VGND sky130_fd_pr__nfet_01v8 L=0.15 W=0.42 AS=0.18205
+ AD=0.19265 PS=1.245 PD=1.285
M$7066 \$220 B|X \$217 VGND sky130_fd_pr__nfet_01v8 L=0.15 W=0.64 AS=0.19265
+ AD=0.140825 PS=1.285 PD=1.1
M$7067 \$217 \$218 \$219 VGND sky130_fd_pr__nfet_01v8 L=0.15 W=0.6 AS=0.140825
+ AD=0.11 PS=1.1 PD=0.99
M$7068 \$219 A|Y VGND VGND sky130_fd_pr__nfet_01v8 L=0.15 W=0.64 AS=0.11
+ AD=0.0864 PS=0.99 PD=0.91
M$7069 VGND \$219 \$220 VGND sky130_fd_pr__nfet_01v8 L=0.15 W=0.64 AS=0.0864
+ AD=0.1824 PS=0.91 PD=1.85
M$7070 B|C|Y \$222 \$277 VGND sky130_fd_pr__nfet_01v8 L=0.15 W=0.65 AS=0.195
+ AD=0.08775 PS=1.9 PD=0.92
M$7071 \$277 B|X VGND VGND sky130_fd_pr__nfet_01v8 L=0.15 W=0.65 AS=0.08775
+ AD=0.169 PS=0.92 PD=1.82
M$7072 \$277 A|Y VGND VGND sky130_fd_pr__nfet_01v8 L=0.15 W=0.65 AS=0.169
+ AD=0.08775 PS=1.82 PD=0.92
M$7073 VGND A|Y \$287 VGND sky130_fd_pr__nfet_01v8 L=0.15 W=0.65 AS=0.08775
+ AD=0.06825 PS=0.92 PD=0.86
M$7074 \$287 B|X \$222 VGND sky130_fd_pr__nfet_01v8 L=0.15 W=0.65 AS=0.06825
+ AD=0.169 PS=0.86 PD=1.82
M$7075 VGND A|B1|C|X \$224 VGND sky130_fd_pr__nfet_01v8 L=0.15 W=0.42 AS=0.1165
+ AD=0.1785 PS=1.035 PD=1.69
M$7076 A|A2|B|C|X \$223 VGND VGND sky130_fd_pr__nfet_01v8 L=0.15 W=0.65
+ AS=0.169 AD=0.1165 PS=1.82 PD=1.035
M$7077 \$226 A|B1|C|X \$223 VGND sky130_fd_pr__nfet_01v8 L=0.15 W=0.64
+ AS=0.1728 AD=0.0928 PS=1.82 PD=0.93
M$7078 \$223 \$224 \$225 VGND sky130_fd_pr__nfet_01v8 L=0.15 W=0.64 AS=0.0928
+ AD=0.224 PS=0.93 PD=1.98
M$7079 VGND B|B1|X \$227 VGND sky130_fd_pr__nfet_01v8 L=0.15 W=0.65 AS=0.1885
+ AD=0.16515 PS=1.88 PD=1.82
M$7080 \$228 B|B1|X \$225 VGND sky130_fd_pr__nfet_01v8 L=0.15 W=0.64 AS=0.16275
+ AD=0.18205 PS=1.8 PD=1.245
M$7081 \$225 \$227 \$229 VGND sky130_fd_pr__nfet_01v8 L=0.15 W=0.42 AS=0.18205
+ AD=0.19265 PS=1.245 PD=1.285
M$7082 \$229 B|B1|X \$226 VGND sky130_fd_pr__nfet_01v8 L=0.15 W=0.64 AS=0.19265
+ AD=0.140825 PS=1.285 PD=1.1
M$7083 \$226 \$227 \$228 VGND sky130_fd_pr__nfet_01v8 L=0.15 W=0.6 AS=0.140825
+ AD=0.11 PS=1.1 PD=0.99
M$7084 \$228 A|A1|X VGND VGND sky130_fd_pr__nfet_01v8 L=0.15 W=0.64 AS=0.11
+ AD=0.0864 PS=0.99 PD=0.91
M$7085 VGND \$228 \$229 VGND sky130_fd_pr__nfet_01v8 L=0.15 W=0.64 AS=0.0864
+ AD=0.1824 PS=0.91 PD=1.85
M$7087 VGND B|C|X \$231 VGND sky130_fd_pr__nfet_01v8 L=0.15 W=0.42 AS=0.1165
+ AD=0.1785 PS=1.035 PD=1.69
M$7088 B|X \$230 VGND VGND sky130_fd_pr__nfet_01v8 L=0.15 W=0.65 AS=0.169
+ AD=0.1165 PS=1.82 PD=1.035
M$7089 \$233 B|C|X \$230 VGND sky130_fd_pr__nfet_01v8 L=0.15 W=0.64 AS=0.1728
+ AD=0.0928 PS=1.82 PD=0.93
M$7090 \$230 \$231 \$232 VGND sky130_fd_pr__nfet_01v8 L=0.15 W=0.64 AS=0.0928
+ AD=0.224 PS=0.93 PD=1.98
M$7091 VGND A|B|C1|X \$234 VGND sky130_fd_pr__nfet_01v8 L=0.15 W=0.65 AS=0.1885
+ AD=0.16515 PS=1.88 PD=1.82
M$7092 \$235 A|B|C1|X \$232 VGND sky130_fd_pr__nfet_01v8 L=0.15 W=0.64
+ AS=0.16275 AD=0.18205 PS=1.8 PD=1.245
M$7093 \$232 \$234 \$236 VGND sky130_fd_pr__nfet_01v8 L=0.15 W=0.42 AS=0.18205
+ AD=0.19265 PS=1.245 PD=1.285
M$7094 \$236 A|B|C1|X \$233 VGND sky130_fd_pr__nfet_01v8 L=0.15 W=0.64
+ AS=0.19265 AD=0.140825 PS=1.285 PD=1.1
M$7095 \$233 \$234 \$235 VGND sky130_fd_pr__nfet_01v8 L=0.15 W=0.6 AS=0.140825
+ AD=0.11 PS=1.1 PD=0.99
M$7096 \$235 A|B1|Y VGND VGND sky130_fd_pr__nfet_01v8 L=0.15 W=0.64 AS=0.11
+ AD=0.0864 PS=0.99 PD=0.91
M$7097 VGND \$235 \$236 VGND sky130_fd_pr__nfet_01v8 L=0.15 W=0.64 AS=0.0864
+ AD=0.1824 PS=0.91 PD=1.85
M$7099 VGND A2|B|C|X \$238 VGND sky130_fd_pr__nfet_01v8 L=0.15 W=0.42
+ AS=0.144125 AD=0.1764 PS=1.12 PD=1.68
M$7100 B|C|X \$237 VGND VGND sky130_fd_pr__nfet_01v8 L=0.15 W=0.65 AS=0.169
+ AD=0.144125 PS=1.82 PD=1.12
M$7101 \$240 A2|B|C|X \$237 VGND sky130_fd_pr__nfet_01v8 L=0.15 W=0.64
+ AS=0.1728 AD=0.128 PS=1.82 PD=1.04
M$7102 \$237 \$238 \$239 VGND sky130_fd_pr__nfet_01v8 L=0.15 W=0.64 AS=0.128
+ AD=0.3168 PS=1.04 PD=2.27
M$7103 VGND A|A1|B|C1|X \$241 VGND sky130_fd_pr__nfet_01v8 L=0.15 W=0.65
+ AS=0.195 AD=0.1653 PS=1.9 PD=1.82
M$7104 \$242 A|A1|B|C1|X \$240 VGND sky130_fd_pr__nfet_01v8 L=0.15 W=0.64
+ AS=0.1628 AD=0.18365 PS=1.8 PD=1.25
M$7105 \$240 \$241 \$243 VGND sky130_fd_pr__nfet_01v8 L=0.15 W=0.42 AS=0.18365
+ AD=0.19265 PS=1.25 PD=1.285
M$7106 \$243 A|A1|B|C1|X \$239 VGND sky130_fd_pr__nfet_01v8 L=0.15 W=0.64
+ AS=0.19265 AD=0.140825 PS=1.285 PD=1.1
M$7107 \$239 \$241 \$242 VGND sky130_fd_pr__nfet_01v8 L=0.15 W=0.6 AS=0.140825
+ AD=0.11 PS=1.1 PD=0.99
M$7108 \$242 A|A1|X VGND VGND sky130_fd_pr__nfet_01v8 L=0.15 W=0.64 AS=0.11
+ AD=0.0864 PS=0.99 PD=0.91
M$7109 VGND \$242 \$243 VGND sky130_fd_pr__nfet_01v8 L=0.15 W=0.64 AS=0.0864
+ AD=0.1824 PS=0.91 PD=1.85
M$7110 VGND B|C|X \$246 VGND sky130_fd_pr__nfet_01v8 L=0.15 W=0.42 AS=0.1165
+ AD=0.1785 PS=1.035 PD=1.69
M$7111 A2|B|C|X \$245 VGND VGND sky130_fd_pr__nfet_01v8 L=0.15 W=0.65 AS=0.169
+ AD=0.1165 PS=1.82 PD=1.035
M$7112 \$248 B|C|X \$245 VGND sky130_fd_pr__nfet_01v8 L=0.15 W=0.64 AS=0.1728
+ AD=0.0928 PS=1.82 PD=0.93
M$7113 \$245 \$246 \$247 VGND sky130_fd_pr__nfet_01v8 L=0.15 W=0.64 AS=0.0928
+ AD=0.224 PS=0.93 PD=1.98
M$7114 VGND A|B|Y \$249 VGND sky130_fd_pr__nfet_01v8 L=0.15 W=0.65 AS=0.1885
+ AD=0.16515 PS=1.88 PD=1.82
M$7115 \$250 A|B|Y \$247 VGND sky130_fd_pr__nfet_01v8 L=0.15 W=0.64 AS=0.16275
+ AD=0.18205 PS=1.8 PD=1.245
M$7116 \$247 \$249 \$251 VGND sky130_fd_pr__nfet_01v8 L=0.15 W=0.42 AS=0.18205
+ AD=0.19265 PS=1.245 PD=1.285
M$7117 \$251 A|B|Y \$248 VGND sky130_fd_pr__nfet_01v8 L=0.15 W=0.64 AS=0.19265
+ AD=0.140825 PS=1.285 PD=1.1
M$7118 \$248 \$249 \$250 VGND sky130_fd_pr__nfet_01v8 L=0.15 W=0.6 AS=0.140825
+ AD=0.11 PS=1.1 PD=0.99
M$7119 \$250 A|B|Y VGND VGND sky130_fd_pr__nfet_01v8 L=0.15 W=0.64 AS=0.11
+ AD=0.0864 PS=0.99 PD=0.91
M$7120 VGND \$250 \$251 VGND sky130_fd_pr__nfet_01v8 L=0.15 W=0.64 AS=0.0864
+ AD=0.1824 PS=0.91 PD=1.85
M$7121 VGND \$253 A|A1|X VGND sky130_fd_pr__nfet_01v8 L=0.15 W=0.42 AS=0.097
+ AD=0.1491 PS=0.975 PD=1.55
M$7122 VGND \$254 \$253 VGND sky130_fd_pr__nfet_01v8 L=0.5 W=0.65 AS=0.097
+ AD=0.17225 PS=0.975 PD=1.83
M$7123 \$254 \$255 VGND VGND sky130_fd_pr__nfet_01v8 L=0.5 W=0.65 AS=0.169
+ AD=0.10435 PS=1.82 PD=1.01
M$7124 VGND A|COARSE_MUX[11] \$255 VGND sky130_fd_pr__nfet_01v8 L=0.15 W=0.42
+ AS=0.10435 AD=0.1134 PS=1.01 PD=1.38
M$7135 A|A2|B|X \$289 VGND VGND sky130_fd_pr__nfet_01v8 L=0.15 W=0.65 AS=0.169
+ AD=0.1165 PS=1.82 PD=1.035
M$7136 VGND A1|B|C|X \$290 VGND sky130_fd_pr__nfet_01v8 L=0.15 W=0.42 AS=0.1165
+ AD=0.1785 PS=1.035 PD=1.69
M$7137 VGND A|A1|B|B1|X \$293 VGND sky130_fd_pr__nfet_01v8 L=0.15 W=0.65
+ AS=0.1885 AD=0.16515 PS=1.88 PD=1.82
M$7138 \$292 \$293 \$295 VGND sky130_fd_pr__nfet_01v8 L=0.15 W=0.42 AS=0.18205
+ AD=0.19265 PS=1.245 PD=1.285
M$7139 \$291 \$293 \$294 VGND sky130_fd_pr__nfet_01v8 L=0.15 W=0.6 AS=0.140825
+ AD=0.11 PS=1.1 PD=0.99
M$7140 \$294 A|Y VGND VGND sky130_fd_pr__nfet_01v8 L=0.15 W=0.64 AS=0.11
+ AD=0.0864 PS=0.99 PD=0.91
M$7141 VGND \$294 \$295 VGND sky130_fd_pr__nfet_01v8 L=0.15 W=0.64 AS=0.0864
+ AD=0.1824 PS=0.91 PD=1.85
M$7142 \$294 A|A1|B|B1|X \$292 VGND sky130_fd_pr__nfet_01v8 L=0.15 W=0.64
+ AS=0.16275 AD=0.18205 PS=1.8 PD=1.245
M$7143 \$291 A|A1|B|B1|X \$295 VGND sky130_fd_pr__nfet_01v8 L=0.15 W=0.64
+ AS=0.140825 AD=0.19265 PS=1.1 PD=1.285
M$7144 VGND A|B1|X A|Y VGND sky130_fd_pr__nfet_01v8 L=0.15 W=2.14 AS=0.58065
+ AD=0.39715 PS=6.47 PD=4.57
M$7146 VGND A|B|C|X \$388 VGND sky130_fd_pr__nfet_01v8 L=0.15 W=0.42 AS=0.1474
+ AD=0.0441 PS=1.215 PD=0.63
M$7147 \$388 A|B|Y \$297 VGND sky130_fd_pr__nfet_01v8 L=0.15 W=0.42 AS=0.0441
+ AD=0.0567 PS=0.63 PD=0.69
M$7148 \$297 A|B|Y \$390 VGND sky130_fd_pr__nfet_01v8 L=0.15 W=0.42 AS=0.0567
+ AD=0.0441 PS=0.69 PD=0.63
M$7149 \$390 A|Y VGND VGND sky130_fd_pr__nfet_01v8 L=0.15 W=0.42 AS=0.0441
+ AD=0.0567 PS=0.63 PD=0.69
M$7150 VGND A|Y \$389 VGND sky130_fd_pr__nfet_01v8 L=0.15 W=0.42 AS=0.0567
+ AD=0.0441 PS=0.69 PD=0.63
M$7151 \$389 A|B|C|X \$297 VGND sky130_fd_pr__nfet_01v8 L=0.15 W=0.42 AS=0.0441
+ AD=0.1092 PS=0.63 PD=1.36
M$7152 B|C|X \$297 VGND VGND sky130_fd_pr__nfet_01v8 L=0.15 W=0.65 AS=0.23725
+ AD=0.1474 PS=2.03 PD=1.215
M$7153 VGND A1|B|C|SLEEP|X A|Y VGND sky130_fd_pr__nfet_01v8 L=0.15 W=0.65
+ AS=0.169 AD=0.08775 PS=1.82 PD=0.92
M$7154 A|Y A|Y VGND VGND sky130_fd_pr__nfet_01v8 L=0.15 W=6.5 AS=1.29625
+ AD=1.2025 PS=13.765 PD=12.8
M$7156 VGND A|A1|Y B|Y VGND sky130_fd_pr__nfet_01v8 L=0.15 W=0.42 AS=0.1197
+ AD=0.1092 PS=1.41 PD=1.36
M$7157 VGND A|B|Y \$398 VGND sky130_fd_pr__nfet_01v8 L=0.15 W=0.65 AS=0.169
+ AD=0.08775 PS=1.82 PD=0.92
M$7158 \$398 A|B2|X C|Y VGND sky130_fd_pr__nfet_01v8 L=0.15 W=0.65 AS=0.08775
+ AD=0.169 PS=0.92 PD=1.82
M$7159 VGND A|Y \$299 VGND sky130_fd_pr__nfet_01v8 L=0.15 W=0.42 AS=0.1092
+ AD=0.0567 PS=1.36 PD=0.69
M$7160 \$299 A1|B|C|SLEEP|X VGND VGND sky130_fd_pr__nfet_01v8 L=0.15 W=0.42
+ AS=0.0567 AD=0.10025 PS=0.69 PD=0.985
M$7161 VGND \$299 A|B2|X VGND sky130_fd_pr__nfet_01v8 L=0.15 W=0.65 AS=0.10025
+ AD=0.169 PS=0.985 PD=1.82
M$7164 VGND A1|B|C|X \$411 VGND sky130_fd_pr__nfet_01v8 L=0.15 W=0.65 AS=0.169
+ AD=0.08775 PS=1.82 PD=0.92
M$7165 \$411 A|X A|Y VGND sky130_fd_pr__nfet_01v8 L=0.15 W=0.65 AS=0.08775
+ AD=0.169 PS=0.92 PD=1.82
M$7166 A|B|Y \$488 \$302 VGND sky130_fd_pr__nfet_01v8 L=0.15 W=0.65 AS=0.195
+ AD=0.08775 PS=1.9 PD=0.92
M$7167 \$302 A1|B|C|X VGND VGND sky130_fd_pr__nfet_01v8 L=0.15 W=0.65
+ AS=0.08775 AD=0.169 PS=0.92 PD=1.82
M$7168 \$302 A|B1|Y VGND VGND sky130_fd_pr__nfet_01v8 L=0.15 W=0.65 AS=0.169
+ AD=0.08775 PS=1.82 PD=0.92
M$7169 VGND A|B1|Y \$413 VGND sky130_fd_pr__nfet_01v8 L=0.15 W=0.65 AS=0.08775
+ AD=0.06825 PS=0.92 PD=0.86
M$7170 \$413 A1|B|C|X \$488 VGND sky130_fd_pr__nfet_01v8 L=0.15 W=0.65
+ AS=0.06825 AD=0.169 PS=0.86 PD=1.82
M$7171 A|B1|Y A|X VGND VGND sky130_fd_pr__nfet_01v8 L=0.15 W=1.49 AS=0.3874
+ AD=0.32715 PS=4.54 PD=3.74
M$7172 VGND A2|Y \$416 VGND sky130_fd_pr__nfet_01v8 L=0.15 W=0.65 AS=0.17225
+ AD=0.095875 PS=1.83 PD=0.945
M$7173 \$416 A1|B|C|X B|B2|Y VGND sky130_fd_pr__nfet_01v8 L=0.15 W=0.65
+ AS=0.095875 AD=0.091 PS=0.945 PD=0.93
M$7174 B|B2|Y A|B1|Y VGND VGND sky130_fd_pr__nfet_01v8 L=0.15 W=0.65 AS=0.091
+ AD=0.17225 PS=0.93 PD=1.83
M$7176 A|B|C|X \$304 VGND VGND sky130_fd_pr__nfet_01v8 L=0.15 W=0.65 AS=0.169
+ AD=0.1165 PS=1.82 PD=1.035
M$7177 VGND A2|A_N|B|B1|C|X \$305 VGND sky130_fd_pr__nfet_01v8 L=0.15 W=0.42
+ AS=0.1165 AD=0.1785 PS=1.035 PD=1.69
M$7178 A|B2|X \$200 VGND VGND sky130_fd_pr__nfet_01v8 L=0.15 W=0.42 AS=0.1113
+ AD=0.0966 PS=1.37 PD=0.88
M$7179 VGND B|C|X \$284 VGND sky130_fd_pr__nfet_01v8 L=0.15 W=0.42 AS=0.0966
+ AD=0.0441 PS=0.88 PD=0.63
M$7180 \$284 A|B1|X \$200 VGND sky130_fd_pr__nfet_01v8 L=0.15 W=0.42 AS=0.0441
+ AD=0.1113 PS=0.63 PD=1.37
M$7181 VGND B|Y \$308 VGND sky130_fd_pr__nfet_01v8 L=0.15 W=0.65 AS=0.1885
+ AD=0.16515 PS=1.88 PD=1.82
M$7182 \$307 \$308 \$310 VGND sky130_fd_pr__nfet_01v8 L=0.15 W=0.42 AS=0.18205
+ AD=0.19265 PS=1.245 PD=1.285
M$7183 \$306 \$308 \$309 VGND sky130_fd_pr__nfet_01v8 L=0.15 W=0.6 AS=0.140825
+ AD=0.11 PS=1.1 PD=0.99
M$7184 \$309 A|A1|Y VGND VGND sky130_fd_pr__nfet_01v8 L=0.15 W=0.64 AS=0.11
+ AD=0.0864 PS=0.99 PD=0.91
M$7185 VGND \$309 \$310 VGND sky130_fd_pr__nfet_01v8 L=0.15 W=0.64 AS=0.0864
+ AD=0.1824 PS=0.91 PD=1.85
M$7186 \$309 B|Y \$307 VGND sky130_fd_pr__nfet_01v8 L=0.15 W=0.64 AS=0.16275
+ AD=0.18205 PS=1.8 PD=1.245
M$7187 \$306 B|Y \$310 VGND sky130_fd_pr__nfet_01v8 L=0.15 W=0.64 AS=0.140825
+ AD=0.19265 PS=1.1 PD=1.285
M$7188 VGND A2|Y \$432 VGND sky130_fd_pr__nfet_01v8 L=0.15 W=0.65 AS=0.17225
+ AD=0.095875 PS=1.83 PD=0.945
M$7189 \$432 A|A1|Y B|Y VGND sky130_fd_pr__nfet_01v8 L=0.15 W=0.65 AS=0.095875
+ AD=0.091 PS=0.945 PD=0.93
M$7190 B|Y A2|A_N|B|B1|C|X VGND VGND sky130_fd_pr__nfet_01v8 L=0.15 W=0.65
+ AS=0.091 AD=0.17225 PS=0.93 PD=1.83
M$7192 A|A1|Y A|B|B1|X \$437 VGND sky130_fd_pr__nfet_01v8 L=0.15 W=0.65
+ AS=0.169 AD=0.08775 PS=1.82 PD=0.92
M$7193 \$437 B|C|X VGND VGND sky130_fd_pr__nfet_01v8 L=0.15 W=0.65 AS=0.08775
+ AD=0.169 PS=0.92 PD=1.82
M$7194 VGND \$314 B|C|X VGND sky130_fd_pr__nfet_01v8 L=0.15 W=0.65 AS=0.208
+ AD=0.25025 PS=1.94 PD=1.42
M$7195 B|C|X A|A2|B|C|X \$441 VGND sky130_fd_pr__nfet_01v8 L=0.15 W=0.65
+ AS=0.25025 AD=0.08775 PS=1.42 PD=0.92
M$7196 \$441 A|A1|B1|X VGND VGND sky130_fd_pr__nfet_01v8 L=0.15 W=0.65
+ AS=0.08775 AD=0.08775 PS=0.92 PD=0.92
M$7197 VGND A|A1|B1|X \$314 VGND sky130_fd_pr__nfet_01v8 L=0.15 W=0.65
+ AS=0.08775 AD=0.08775 PS=0.92 PD=0.92
M$7198 \$314 A|A2|B|C|X VGND VGND sky130_fd_pr__nfet_01v8 L=0.15 W=0.65
+ AS=0.08775 AD=0.169 PS=0.92 PD=1.82
M$7200 VGND B|C|Y \$450 VGND sky130_fd_pr__nfet_01v8 L=0.15 W=0.42 AS=0.13165
+ AD=0.0441 PS=1.14 PD=0.63
M$7201 \$450 A|A2|B|C|X \$449 VGND sky130_fd_pr__nfet_01v8 L=0.15 W=0.42
+ AS=0.0441 AD=0.0441 PS=0.63 PD=0.63
M$7202 \$449 A|A1|B1|X \$316 VGND sky130_fd_pr__nfet_01v8 L=0.15 W=0.42
+ AS=0.0441 AD=0.1092 PS=0.63 PD=1.36
M$7203 A|X \$316 VGND VGND sky130_fd_pr__nfet_01v8 L=0.15 W=0.65 AS=0.169
+ AD=0.13165 PS=1.82 PD=1.14
M$7204 VGND A|A2|B|C|X \$453 VGND sky130_fd_pr__nfet_01v8 L=0.15 W=0.42
+ AS=0.1113 AD=0.0441 PS=1.37 PD=0.63
M$7205 \$453 A|A1|B1|X C|Y VGND sky130_fd_pr__nfet_01v8 L=0.15 W=0.42 AS=0.0441
+ AD=0.1113 PS=0.63 PD=0.95
M$7206 C|Y \$318 VGND VGND sky130_fd_pr__nfet_01v8 L=0.15 W=0.42 AS=0.1113
+ AD=0.1302 PS=0.95 PD=1.04
M$7207 VGND B|B1_N|Y \$318 VGND sky130_fd_pr__nfet_01v8 L=0.15 W=0.42 AS=0.1302
+ AD=0.1113 PS=1.04 PD=1.37
M$7209 VGND B|C|Y \$460 VGND sky130_fd_pr__nfet_01v8 L=0.15 W=0.65 AS=0.169
+ AD=0.08775 PS=1.82 PD=0.92
M$7210 \$460 A|B|Y A1|Y VGND sky130_fd_pr__nfet_01v8 L=0.15 W=0.65 AS=0.08775
+ AD=0.169 PS=0.92 PD=1.82
M$7211 \$320 A|C|Y \$462 VGND sky130_fd_pr__nfet_01v8 L=0.15 W=0.42 AS=0.1092
+ AD=0.0441 PS=1.36 PD=0.63
M$7212 \$462 A|Y VGND VGND sky130_fd_pr__nfet_01v8 L=0.15 W=0.42 AS=0.0441
+ AD=0.0567 PS=0.63 PD=0.69
M$7213 VGND A|Y \$464 VGND sky130_fd_pr__nfet_01v8 L=0.15 W=0.42 AS=0.0567
+ AD=0.0441 PS=0.69 PD=0.63
M$7214 \$464 B|B1_N|Y \$320 VGND sky130_fd_pr__nfet_01v8 L=0.15 W=0.42
+ AS=0.0441 AD=0.0567 PS=0.63 PD=0.69
M$7215 \$320 B|B1_N|Y \$465 VGND sky130_fd_pr__nfet_01v8 L=0.15 W=0.42
+ AS=0.0567 AD=0.0441 PS=0.69 PD=0.63
M$7216 \$465 A|C|Y VGND VGND sky130_fd_pr__nfet_01v8 L=0.15 W=0.42 AS=0.0441
+ AD=0.1474 PS=0.63 PD=1.215
M$7217 VGND \$320 A|X VGND sky130_fd_pr__nfet_01v8 L=0.15 W=0.65 AS=0.1474
+ AD=0.23725 PS=1.215 PD=2.03
M$7218 A|B|Y \$492 \$323 VGND sky130_fd_pr__nfet_01v8 L=0.15 W=0.65 AS=0.195
+ AD=0.08775 PS=1.9 PD=0.92
M$7219 \$323 B|B1|X VGND VGND sky130_fd_pr__nfet_01v8 L=0.15 W=0.65 AS=0.08775
+ AD=0.169 PS=0.92 PD=1.82
M$7220 \$323 A|A1|X VGND VGND sky130_fd_pr__nfet_01v8 L=0.15 W=0.65 AS=0.169
+ AD=0.08775 PS=1.82 PD=0.92
M$7221 VGND A|A1|X \$471 VGND sky130_fd_pr__nfet_01v8 L=0.15 W=0.65 AS=0.08775
+ AD=0.06825 PS=0.92 PD=0.86
M$7222 \$471 B|B1|X \$492 VGND sky130_fd_pr__nfet_01v8 L=0.15 W=0.65 AS=0.06825
+ AD=0.169 PS=0.86 PD=1.82
M$7225 A|C|Y \$493 \$324 VGND sky130_fd_pr__nfet_01v8 L=0.15 W=0.65 AS=0.195
+ AD=0.08775 PS=1.9 PD=0.92
M$7226 \$324 A|B|Y VGND VGND sky130_fd_pr__nfet_01v8 L=0.15 W=0.65 AS=0.08775
+ AD=0.169 PS=0.92 PD=1.82
M$7227 \$324 A|B|C1|X VGND VGND sky130_fd_pr__nfet_01v8 L=0.15 W=0.65 AS=0.169
+ AD=0.08775 PS=1.82 PD=0.92
M$7228 VGND A|B|C1|X \$478 VGND sky130_fd_pr__nfet_01v8 L=0.15 W=0.65
+ AS=0.08775 AD=0.06825 PS=0.92 PD=0.86
M$7229 \$478 A|B|Y \$493 VGND sky130_fd_pr__nfet_01v8 L=0.15 W=0.65 AS=0.06825
+ AD=0.169 PS=0.86 PD=1.82
M$7231 A2|B|Y \$495 \$325 VGND sky130_fd_pr__nfet_01v8 L=0.15 W=0.65 AS=0.195
+ AD=0.08775 PS=1.9 PD=0.92
M$7232 \$325 B|X VGND VGND sky130_fd_pr__nfet_01v8 L=0.15 W=0.65 AS=0.08775
+ AD=0.169 PS=0.92 PD=1.82
M$7233 \$325 A|B|C|Y VGND VGND sky130_fd_pr__nfet_01v8 L=0.15 W=0.65 AS=0.169
+ AD=0.08775 PS=1.82 PD=0.92
M$7234 VGND A|B|C|Y \$476 VGND sky130_fd_pr__nfet_01v8 L=0.15 W=0.65 AS=0.08775
+ AD=0.06825 PS=0.92 PD=0.86
M$7235 \$476 B|X \$495 VGND sky130_fd_pr__nfet_01v8 L=0.15 W=0.65 AS=0.06825
+ AD=0.169 PS=0.86 PD=1.82
M$7236 A|B|Y \$497 \$326 VGND sky130_fd_pr__nfet_01v8 L=0.15 W=0.65 AS=0.195
+ AD=0.08775 PS=1.9 PD=0.92
M$7237 \$326 B|C|X VGND VGND sky130_fd_pr__nfet_01v8 L=0.15 W=0.65 AS=0.08775
+ AD=0.169 PS=0.92 PD=1.82
M$7238 \$326 A|B1|Y VGND VGND sky130_fd_pr__nfet_01v8 L=0.15 W=0.65 AS=0.169
+ AD=0.08775 PS=1.82 PD=0.92
M$7239 VGND A|B1|Y \$458 VGND sky130_fd_pr__nfet_01v8 L=0.15 W=0.65 AS=0.08775
+ AD=0.06825 PS=0.92 PD=0.86
M$7240 \$458 B|C|X \$497 VGND sky130_fd_pr__nfet_01v8 L=0.15 W=0.65 AS=0.06825
+ AD=0.169 PS=0.86 PD=1.82
M$7243 A|B|Y \$498 \$327 VGND sky130_fd_pr__nfet_01v8 L=0.15 W=0.65 AS=0.195
+ AD=0.08775 PS=1.9 PD=0.92
M$7244 \$327 A|B|B1_N|X VGND VGND sky130_fd_pr__nfet_01v8 L=0.15 W=0.65
+ AS=0.08775 AD=0.169 PS=0.92 PD=1.82
M$7245 \$327 A|A1|B|C1|X VGND VGND sky130_fd_pr__nfet_01v8 L=0.15 W=0.65
+ AS=0.169 AD=0.08775 PS=1.82 PD=0.92
M$7246 VGND A|A1|B|C1|X \$428 VGND sky130_fd_pr__nfet_01v8 L=0.15 W=0.65
+ AS=0.08775 AD=0.06825 PS=0.92 PD=0.86
M$7247 \$428 A|B|B1_N|X \$498 VGND sky130_fd_pr__nfet_01v8 L=0.15 W=0.65
+ AS=0.06825 AD=0.169 PS=0.86 PD=1.82
M$7249 VGND \$328 A|B|B1_N|X VGND sky130_fd_pr__nfet_01v8 L=0.15 W=0.65
+ AS=0.208 AD=0.25025 PS=1.94 PD=1.42
M$7250 A|B|B1_N|X A2|B|C|X \$408 VGND sky130_fd_pr__nfet_01v8 L=0.15 W=0.65
+ AS=0.25025 AD=0.08775 PS=1.42 PD=0.92
M$7251 \$408 A|A1|X VGND VGND sky130_fd_pr__nfet_01v8 L=0.15 W=0.65 AS=0.08775
+ AD=0.08775 PS=0.92 PD=0.92
M$7252 VGND A|A1|X \$328 VGND sky130_fd_pr__nfet_01v8 L=0.15 W=0.65 AS=0.08775
+ AD=0.08775 PS=0.92 PD=0.92
M$7253 \$328 A2|B|C|X VGND VGND sky130_fd_pr__nfet_01v8 L=0.15 W=0.65
+ AS=0.08775 AD=0.169 PS=0.92 PD=1.82
M$7255 A|A1|X \$329 VGND VGND sky130_fd_pr__nfet_01v8 L=0.15 W=0.42 AS=0.1491
+ AD=0.097 PS=1.55 PD=0.975
M$7256 VGND \$330 \$329 VGND sky130_fd_pr__nfet_01v8 L=0.5 W=0.65 AS=0.097
+ AD=0.17225 PS=0.975 PD=1.83
M$7257 VGND A|MID_MUX[0] \$331 VGND sky130_fd_pr__nfet_01v8 L=0.15 W=0.42
+ AS=0.10435 AD=0.1134 PS=1.01 PD=1.38
M$7258 \$330 \$331 VGND VGND sky130_fd_pr__nfet_01v8 L=0.5 W=0.65 AS=0.169
+ AD=0.10435 PS=1.82 PD=1.01
M$7259 \$333 A|COARSE_MUX[7] VGND VGND sky130_fd_pr__nfet_01v8 L=0.15 W=0.42
+ AS=0.1134 AD=0.10435 PS=1.38 PD=1.01
M$7260 VGND \$333 \$334 VGND sky130_fd_pr__nfet_01v8 L=0.5 W=0.65 AS=0.10435
+ AD=0.169 PS=1.01 PD=1.82
M$7261 VGND \$335 A|X VGND sky130_fd_pr__nfet_01v8 L=0.15 W=0.42 AS=0.097
+ AD=0.1491 PS=0.975 PD=1.55
M$7262 \$335 \$334 VGND VGND sky130_fd_pr__nfet_01v8 L=0.5 W=0.65 AS=0.17225
+ AD=0.097 PS=1.83 PD=0.975
M$7263 A|B|Y A|X VGND VGND sky130_fd_pr__nfet_01v8 L=0.15 W=0.84 AS=0.2184
+ AD=0.2394 PS=2.72 PD=2.82
M$7264 VGND C|Y \$361 VGND sky130_fd_pr__nfet_01v8 L=0.15 W=0.42 AS=0.1474
+ AD=0.0441 PS=1.215 PD=0.63
M$7265 \$361 A|B|Y \$338 VGND sky130_fd_pr__nfet_01v8 L=0.15 W=0.42 AS=0.0441
+ AD=0.0567 PS=0.63 PD=0.69
M$7266 \$338 A|B|Y \$357 VGND sky130_fd_pr__nfet_01v8 L=0.15 W=0.42 AS=0.0567
+ AD=0.0441 PS=0.69 PD=0.63
M$7267 \$357 A|Y VGND VGND sky130_fd_pr__nfet_01v8 L=0.15 W=0.42 AS=0.0441
+ AD=0.0567 PS=0.63 PD=0.69
M$7268 VGND A|Y \$360 VGND sky130_fd_pr__nfet_01v8 L=0.15 W=0.42 AS=0.0567
+ AD=0.0441 PS=0.69 PD=0.63
M$7269 \$360 C|Y \$338 VGND sky130_fd_pr__nfet_01v8 L=0.15 W=0.42 AS=0.0441
+ AD=0.1092 PS=0.63 PD=1.36
M$7270 A2|B|X \$338 VGND VGND sky130_fd_pr__nfet_01v8 L=0.15 W=0.65 AS=0.23725
+ AD=0.1474 PS=2.03 PD=1.215
M$7272 A|Y A|B|X VGND VGND sky130_fd_pr__nfet_01v8 L=0.15 W=2.14 AS=0.4064
+ AD=0.49615 PS=4.625 PD=5.56
M$7293 B|X \$616 VGND VGND sky130_fd_pr__nfet_01v8 L=0.15 W=0.65 AS=0.169
+ AD=0.25675 PS=1.82 PD=1.44
M$7294 VGND A|B1|Y \$616 VGND sky130_fd_pr__nfet_01v8 L=0.15 W=0.65 AS=0.25675
+ AD=0.089375 PS=1.44 PD=0.925
M$7295 \$616 A|A1|B|B1|X \$703 VGND sky130_fd_pr__nfet_01v8 L=0.15 W=0.65
+ AS=0.089375 AD=0.091 PS=0.925 PD=0.93
M$7296 \$703 A2|B|Y VGND VGND sky130_fd_pr__nfet_01v8 L=0.15 W=0.65 AS=0.091
+ AD=0.17225 PS=0.93 PD=1.83
M$7297 \$291 A1|B|C|X \$289 VGND sky130_fd_pr__nfet_01v8 L=0.15 W=0.64
+ AS=0.1728 AD=0.0928 PS=1.82 PD=0.93
M$7298 \$289 \$290 \$292 VGND sky130_fd_pr__nfet_01v8 L=0.15 W=0.64 AS=0.0928
+ AD=0.224 PS=0.93 PD=1.98
M$7300 VGND A1|B|C|X A|B1|Y VGND sky130_fd_pr__nfet_01v8 L=0.15 W=0.65 AS=0.169
+ AD=0.08775 PS=1.82 PD=0.92
M$7301 A|B1|Y A|Y VGND VGND sky130_fd_pr__nfet_01v8 L=0.15 W=1.3 AS=0.25675
+ AD=0.25675 PS=2.74 PD=2.74
M$7302 \$537 A1|B|C|X \$612 VGND sky130_fd_pr__nfet_01v8 L=0.15 W=0.65 AS=0.169
+ AD=0.06825 PS=1.82 PD=0.86
M$7303 \$612 A|Y VGND VGND sky130_fd_pr__nfet_01v8 L=0.15 W=0.65 AS=0.06825
+ AD=0.08775 PS=0.86 PD=0.92
M$7304 VGND A|Y \$589 VGND sky130_fd_pr__nfet_01v8 L=0.15 W=0.65 AS=0.08775
+ AD=0.169 PS=0.92 PD=1.82
M$7305 VGND A|A1|Y A2|B|Y VGND sky130_fd_pr__nfet_01v8 L=0.15 W=0.42 AS=0.1197
+ AD=0.1092 PS=1.41 PD=1.36
M$7306 VGND A1|B|C|X \$589 VGND sky130_fd_pr__nfet_01v8 L=0.15 W=0.65 AS=0.169
+ AD=0.08775 PS=1.82 PD=0.92
M$7307 \$589 \$537 A|A1|Y VGND sky130_fd_pr__nfet_01v8 L=0.15 W=0.65 AS=0.08775
+ AD=0.195 PS=0.92 PD=1.9
M$7310 VGND C|Y \$540 VGND sky130_fd_pr__nfet_01v8 L=0.15 W=0.42 AS=0.144125
+ AD=0.1764 PS=1.12 PD=1.68
M$7311 A|B|C|X \$539 VGND VGND sky130_fd_pr__nfet_01v8 L=0.15 W=0.65 AS=0.169
+ AD=0.144125 PS=1.82 PD=1.12
M$7312 \$542 C|Y \$539 VGND sky130_fd_pr__nfet_01v8 L=0.15 W=0.64 AS=0.1728
+ AD=0.128 PS=1.82 PD=1.04
M$7313 \$539 \$540 \$541 VGND sky130_fd_pr__nfet_01v8 L=0.15 W=0.64 AS=0.128
+ AD=0.3168 PS=1.04 PD=2.27
M$7315 VGND A|B|C|X \$543 VGND sky130_fd_pr__nfet_01v8 L=0.15 W=0.65 AS=0.195
+ AD=0.1653 PS=1.9 PD=1.82
M$7316 \$544 A|B|C|X \$542 VGND sky130_fd_pr__nfet_01v8 L=0.15 W=0.64 AS=0.1628
+ AD=0.18365 PS=1.8 PD=1.25
M$7317 \$542 \$543 \$545 VGND sky130_fd_pr__nfet_01v8 L=0.15 W=0.42 AS=0.18365
+ AD=0.19265 PS=1.25 PD=1.285
M$7318 \$545 A|B|C|X \$541 VGND sky130_fd_pr__nfet_01v8 L=0.15 W=0.64
+ AS=0.19265 AD=0.140825 PS=1.285 PD=1.1
M$7319 \$541 \$543 \$544 VGND sky130_fd_pr__nfet_01v8 L=0.15 W=0.6 AS=0.140825
+ AD=0.11 PS=1.1 PD=0.99
M$7320 \$544 A|B|Y VGND VGND sky130_fd_pr__nfet_01v8 L=0.15 W=0.64 AS=0.11
+ AD=0.0864 PS=0.99 PD=0.91
M$7321 VGND \$544 \$545 VGND sky130_fd_pr__nfet_01v8 L=0.15 W=0.64 AS=0.0864
+ AD=0.1824 PS=0.91 PD=1.85
M$7323 A_N|B|Y \$618 \$619 VGND sky130_fd_pr__nfet_01v8 L=0.15 W=0.65 AS=0.195
+ AD=0.08775 PS=1.9 PD=0.92
M$7324 \$619 A|B|C|X VGND VGND sky130_fd_pr__nfet_01v8 L=0.15 W=0.65 AS=0.08775
+ AD=0.169 PS=0.92 PD=1.82
M$7325 \$619 A|B|Y VGND VGND sky130_fd_pr__nfet_01v8 L=0.15 W=0.65 AS=0.169
+ AD=0.08775 PS=1.82 PD=0.92
M$7326 VGND A|B|Y \$721 VGND sky130_fd_pr__nfet_01v8 L=0.15 W=0.65 AS=0.08775
+ AD=0.06825 PS=0.92 PD=0.86
M$7327 \$721 A|B|C|X \$618 VGND sky130_fd_pr__nfet_01v8 L=0.15 W=0.65
+ AS=0.06825 AD=0.169 PS=0.86 PD=1.82
M$7329 VGND B|Y \$614 VGND sky130_fd_pr__nfet_01v8 L=0.15 W=0.65 AS=0.169
+ AD=0.08775 PS=1.82 PD=0.92
M$7330 \$614 A|B|B1|X A|B|Y VGND sky130_fd_pr__nfet_01v8 L=0.15 W=0.65
+ AS=0.08775 AD=0.169 PS=0.92 PD=1.82
M$7332 VGND A1|B|C|SLEEP|X \$620 VGND sky130_fd_pr__nfet_01v8 L=0.15 W=0.65
+ AS=0.169 AD=0.08775 PS=1.82 PD=0.92
M$7333 \$620 A2|B1|Y VGND VGND sky130_fd_pr__nfet_01v8 L=0.15 W=0.65 AS=0.08775
+ AD=0.08775 PS=0.92 PD=0.92
M$7334 VGND A2|A3|B|X \$620 VGND sky130_fd_pr__nfet_01v8 L=0.15 W=0.65
+ AS=0.08775 AD=0.19825 PS=0.92 PD=1.26
M$7335 \$620 A|B1|X B|C|Y VGND sky130_fd_pr__nfet_01v8 L=0.15 W=0.65 AS=0.19825
+ AD=0.221 PS=1.26 PD=1.98
M$7337 \$624 A2|B1|Y A|Y VGND sky130_fd_pr__nfet_01v8 L=0.15 W=0.65 AS=0.169
+ AD=0.092625 PS=1.82 PD=0.935
M$7338 A|Y A|B2|X \$624 VGND sky130_fd_pr__nfet_01v8 L=0.15 W=0.65 AS=0.092625
+ AD=0.115375 PS=0.935 PD=1.005
M$7339 \$624 A|A2|B|Y VGND VGND sky130_fd_pr__nfet_01v8 L=0.15 W=0.65
+ AS=0.115375 AD=0.08775 PS=1.005 PD=0.92
M$7340 VGND A1|B|Y \$624 VGND sky130_fd_pr__nfet_01v8 L=0.15 W=0.65 AS=0.08775
+ AD=0.169 PS=0.92 PD=1.82
M$7341 VGND A1|B|Y \$611 VGND sky130_fd_pr__nfet_01v8 L=0.15 W=0.65 AS=0.169
+ AD=0.08775 PS=1.82 PD=0.92
M$7342 \$611 A|Y A|B|Y VGND sky130_fd_pr__nfet_01v8 L=0.15 W=0.65 AS=0.08775
+ AD=0.169 PS=0.92 PD=1.82
M$7345 VGND A|Y B|Y VGND sky130_fd_pr__nfet_01v8 L=0.15 W=3.25 AS=0.61375
+ AD=0.60125 PS=6.465 PD=6.4
M$7346 B|Y A|A2|B|Y VGND VGND sky130_fd_pr__nfet_01v8 L=0.15 W=1.3 AS=0.1755
+ AD=0.338 PS=1.84 PD=3.64
M$7347 A1|B|Y A|B|B1|X \$610 VGND sky130_fd_pr__nfet_01v8 L=0.15 W=0.65
+ AS=0.169 AD=0.08775 PS=1.82 PD=0.92
M$7348 \$610 A|B|Y VGND VGND sky130_fd_pr__nfet_01v8 L=0.15 W=0.65 AS=0.08775
+ AD=0.169 PS=0.92 PD=1.82
M$7350 A1|Y A|B|Y \$746 VGND sky130_fd_pr__nfet_01v8 L=0.15 W=0.65 AS=0.169
+ AD=0.10725 PS=1.82 PD=0.98
M$7351 \$746 A|B|C|X \$744 VGND sky130_fd_pr__nfet_01v8 L=0.15 W=0.65
+ AS=0.10725 AD=0.08775 PS=0.98 PD=0.92
M$7352 \$744 A|A1|B|C|Y VGND VGND sky130_fd_pr__nfet_01v8 L=0.15 W=0.65
+ AS=0.08775 AD=0.169 PS=0.92 PD=1.82
M$7353 VGND A|A2|B|Y A2|Y VGND sky130_fd_pr__nfet_01v8 L=0.15 W=0.65 AS=0.169
+ AD=0.08775 PS=1.82 PD=0.92
M$7354 A2|Y A|B|Y VGND VGND sky130_fd_pr__nfet_01v8 L=0.15 W=0.65 AS=0.08775
+ AD=0.169 PS=0.92 PD=1.82
M$7355 A|A2|B|Y A|B|C|X \$751 VGND sky130_fd_pr__nfet_01v8 L=0.15 W=0.65
+ AS=0.169 AD=0.08775 PS=1.82 PD=0.92
M$7356 \$751 A|A1|B|C|Y VGND VGND sky130_fd_pr__nfet_01v8 L=0.15 W=0.65
+ AS=0.08775 AD=0.169 PS=0.92 PD=1.82
M$7359 \$547 B|C|X \$609 VGND sky130_fd_pr__nfet_01v8 L=0.15 W=0.65 AS=0.169
+ AD=0.06825 PS=1.82 PD=0.86
M$7360 \$609 A|B1|X VGND VGND sky130_fd_pr__nfet_01v8 L=0.15 W=0.65 AS=0.06825
+ AD=0.08775 PS=0.86 PD=0.92
M$7361 VGND A|B1|X \$590 VGND sky130_fd_pr__nfet_01v8 L=0.15 W=0.65 AS=0.08775
+ AD=0.169 PS=0.92 PD=1.82
M$7362 \$629 A|B|B1|X VGND VGND sky130_fd_pr__nfet_01v8 L=0.15 W=0.42 AS=0.1092
+ AD=0.10025 PS=1.36 PD=0.985
M$7363 VGND A|SLEEP|Y A|B|X VGND sky130_fd_pr__nfet_01v8 L=0.15 W=0.65
+ AS=0.10025 AD=0.08775 PS=0.985 PD=0.92
M$7364 A|B|X \$629 VGND VGND sky130_fd_pr__nfet_01v8 L=0.15 W=0.65 AS=0.08775
+ AD=0.169 PS=0.92 PD=1.82
M$7365 VGND B|C|X \$590 VGND sky130_fd_pr__nfet_01v8 L=0.15 W=0.65 AS=0.169
+ AD=0.08775 PS=1.82 PD=0.92
M$7366 \$590 \$547 A|SLEEP|Y VGND sky130_fd_pr__nfet_01v8 L=0.15 W=0.65
+ AS=0.08775 AD=0.195 PS=0.92 PD=1.9
M$7368 \$306 A2|A_N|B|B1|C|X \$304 VGND sky130_fd_pr__nfet_01v8 L=0.15 W=0.64
+ AS=0.1728 AD=0.0928 PS=1.82 PD=0.93
M$7369 \$304 \$305 \$307 VGND sky130_fd_pr__nfet_01v8 L=0.15 W=0.64 AS=0.0928
+ AD=0.224 PS=0.93 PD=1.98
M$7370 VGND A|B2|X B|Y VGND sky130_fd_pr__nfet_01v8 L=0.15 W=0.65 AS=0.169
+ AD=0.08775 PS=1.82 PD=0.92
M$7371 B|Y A|B|X VGND VGND sky130_fd_pr__nfet_01v8 L=0.15 W=4.97 AS=0.89645
+ AD=1.04845 PS=9.65 PD=11.4
M$7373 A|A1|B|C|Y \$630 \$631 VGND sky130_fd_pr__nfet_01v8 L=0.15 W=0.65
+ AS=0.195 AD=0.08775 PS=1.9 PD=0.92
M$7374 \$631 B|Y VGND VGND sky130_fd_pr__nfet_01v8 L=0.15 W=0.65 AS=0.08775
+ AD=0.169 PS=0.92 PD=1.82
M$7375 \$631 A|A3|B|Y VGND VGND sky130_fd_pr__nfet_01v8 L=0.15 W=0.65 AS=0.169
+ AD=0.08775 PS=1.82 PD=0.92
M$7376 VGND A|A3|B|Y \$769 VGND sky130_fd_pr__nfet_01v8 L=0.15 W=0.65
+ AS=0.08775 AD=0.06825 PS=0.92 PD=0.86
M$7377 \$769 B|Y \$630 VGND sky130_fd_pr__nfet_01v8 L=0.15 W=0.65 AS=0.06825
+ AD=0.169 PS=0.86 PD=1.82
M$7378 A|A2|B|SLEEP|Y \$634 \$635 VGND sky130_fd_pr__nfet_01v8 L=0.15 W=0.65
+ AS=0.195 AD=0.08775 PS=1.9 PD=0.92
M$7379 \$635 A2|A_N|B|B1|C|X VGND VGND sky130_fd_pr__nfet_01v8 L=0.15 W=0.65
+ AS=0.08775 AD=0.169 PS=0.92 PD=1.82
M$7380 \$635 A|A1|Y VGND VGND sky130_fd_pr__nfet_01v8 L=0.15 W=0.65 AS=0.169
+ AD=0.08775 PS=1.82 PD=0.92
M$7381 VGND A|A1|Y \$774 VGND sky130_fd_pr__nfet_01v8 L=0.15 W=0.65 AS=0.08775
+ AD=0.06825 PS=0.92 PD=0.86
M$7382 \$774 A2|A_N|B|B1|C|X \$634 VGND sky130_fd_pr__nfet_01v8 L=0.15 W=0.65
+ AS=0.06825 AD=0.169 PS=0.86 PD=1.82
M$7386 VGND A|A1|Y \$636 VGND sky130_fd_pr__nfet_01v8 L=0.15 W=0.65 AS=0.169
+ AD=0.08775 PS=1.82 PD=0.92
M$7387 \$636 A2|A_N|B|B1|C|X VGND VGND sky130_fd_pr__nfet_01v8 L=0.15 W=0.65
+ AS=0.08775 AD=0.08775 PS=0.92 PD=0.92
M$7388 VGND A|A3|B|Y \$636 VGND sky130_fd_pr__nfet_01v8 L=0.15 W=0.65
+ AS=0.08775 AD=0.19825 PS=0.92 PD=1.26
M$7389 \$636 B1|Y A|Y VGND sky130_fd_pr__nfet_01v8 L=0.15 W=0.65 AS=0.19825
+ AD=0.221 PS=1.26 PD=1.98
M$7390 B1|Y A|X \$782 VGND sky130_fd_pr__nfet_01v8 L=0.15 W=0.65 AS=0.169
+ AD=0.08775 PS=1.82 PD=0.92
M$7391 \$782 B|C|X VGND VGND sky130_fd_pr__nfet_01v8 L=0.15 W=0.65 AS=0.08775
+ AD=0.169 PS=0.92 PD=1.82
M$7392 A|A3|B|Y \$640 \$641 VGND sky130_fd_pr__nfet_01v8 L=0.15 W=0.65 AS=0.195
+ AD=0.08775 PS=1.9 PD=0.92
M$7393 \$641 B|C|X VGND VGND sky130_fd_pr__nfet_01v8 L=0.15 W=0.65 AS=0.08775
+ AD=0.169 PS=0.92 PD=1.82
M$7395 \$641 A|X VGND VGND sky130_fd_pr__nfet_01v8 L=0.15 W=0.65 AS=0.169
+ AD=0.08775 PS=1.82 PD=0.92
M$7396 VGND A|X \$788 VGND sky130_fd_pr__nfet_01v8 L=0.15 W=0.65 AS=0.08775
+ AD=0.06825 PS=0.92 PD=0.86
M$7397 \$788 B|C|X \$640 VGND sky130_fd_pr__nfet_01v8 L=0.15 W=0.65 AS=0.06825
+ AD=0.169 PS=0.86 PD=1.82
M$7398 A1|Y A|A2|B|C|X \$607 VGND sky130_fd_pr__nfet_01v8 L=0.15 W=0.65
+ AS=0.169 AD=0.10725 PS=1.82 PD=0.98
M$7399 \$607 B|C|Y \$606 VGND sky130_fd_pr__nfet_01v8 L=0.15 W=0.65 AS=0.10725
+ AD=0.08775 PS=0.98 PD=0.92
M$7400 \$606 B|C|X VGND VGND sky130_fd_pr__nfet_01v8 L=0.15 W=0.65 AS=0.08775
+ AD=0.169 PS=0.92 PD=1.82
M$7404 VGND \$642 B|C|X VGND sky130_fd_pr__nfet_01v8 L=0.15 W=0.65 AS=0.208
+ AD=0.25025 PS=1.94 PD=1.42
M$7405 B|C|X A2|B|Y \$799 VGND sky130_fd_pr__nfet_01v8 L=0.15 W=0.65 AS=0.25025
+ AD=0.08775 PS=1.42 PD=0.92
M$7406 \$799 A|X VGND VGND sky130_fd_pr__nfet_01v8 L=0.15 W=0.65 AS=0.08775
+ AD=0.08775 PS=0.92 PD=0.92
M$7407 VGND A|X \$642 VGND sky130_fd_pr__nfet_01v8 L=0.15 W=0.65 AS=0.08775
+ AD=0.08775 PS=0.92 PD=0.92
M$7408 \$642 A2|B|Y VGND VGND sky130_fd_pr__nfet_01v8 L=0.15 W=0.65 AS=0.08775
+ AD=0.169 PS=0.92 PD=1.82
M$7409 B|X \$551 VGND VGND sky130_fd_pr__nfet_01v8 L=0.15 W=0.65 AS=0.234
+ AD=0.12675 PS=2.02 PD=1.04
M$7410 VGND A1|Y \$591 VGND sky130_fd_pr__nfet_01v8 L=0.15 W=0.65 AS=0.12675
+ AD=0.08775 PS=1.04 PD=0.92
M$7411 \$591 A2|B|Y VGND VGND sky130_fd_pr__nfet_01v8 L=0.15 W=0.65 AS=0.08775
+ AD=0.10725 PS=0.92 PD=0.98
M$7412 VGND A3|B|X \$591 VGND sky130_fd_pr__nfet_01v8 L=0.15 W=0.65 AS=0.10725
+ AD=0.10725 PS=0.98 PD=0.98
M$7413 \$591 A|B1|C|X \$551 VGND sky130_fd_pr__nfet_01v8 L=0.15 W=0.65
+ AS=0.10725 AD=0.2015 PS=0.98 PD=1.92
M$7414 VGND A2|B|Y A|Y VGND sky130_fd_pr__nfet_01v8 L=0.15 W=1.95 AS=0.3445
+ AD=0.3445 PS=3.66 PD=3.66
M$7415 A|Y A|X VGND VGND sky130_fd_pr__nfet_01v8 L=0.15 W=4.55 AS=0.93925
+ AD=0.858 PS=10.04 PD=9.14
M$7417 B|B1_N|Y A|B1|C|X \$604 VGND sky130_fd_pr__nfet_01v8 L=0.15 W=0.65
+ AS=0.169 AD=0.08775 PS=1.82 PD=0.92
M$7418 \$604 A|B|Y VGND VGND sky130_fd_pr__nfet_01v8 L=0.15 W=0.65 AS=0.08775
+ AD=0.169 PS=0.92 PD=1.82
M$7422 VGND A|C|Y \$554 VGND sky130_fd_pr__nfet_01v8 L=0.15 W=0.42 AS=0.101875
+ AD=0.0567 PS=0.99 PD=0.69
M$7423 \$554 A2|B|Y VGND VGND sky130_fd_pr__nfet_01v8 L=0.15 W=0.42 AS=0.0567
+ AD=0.0567 PS=0.69 PD=0.69
M$7424 VGND A2|B|C|SLEEP|Y \$554 VGND sky130_fd_pr__nfet_01v8 L=0.15 W=0.42
+ AS=0.0567 AD=0.1092 PS=0.69 PD=1.36
M$7425 A2|B|X \$554 VGND VGND sky130_fd_pr__nfet_01v8 L=0.15 W=0.65 AS=0.182
+ AD=0.101875 PS=1.86 PD=0.99
M$7426 VGND \$644 A3|B|X VGND sky130_fd_pr__nfet_01v8 L=0.15 W=0.65 AS=0.208
+ AD=0.25025 PS=1.94 PD=1.42
M$7427 A3|B|X A2|B|C|SLEEP|Y \$790 VGND sky130_fd_pr__nfet_01v8 L=0.15 W=0.65
+ AS=0.25025 AD=0.08775 PS=1.42 PD=0.92
M$7428 \$790 A|X VGND VGND sky130_fd_pr__nfet_01v8 L=0.15 W=0.65 AS=0.08775
+ AD=0.08775 PS=0.92 PD=0.92
M$7429 VGND A|X \$644 VGND sky130_fd_pr__nfet_01v8 L=0.15 W=0.65 AS=0.08775
+ AD=0.08775 PS=0.92 PD=0.92
M$7430 \$644 A2|B|C|SLEEP|Y VGND VGND sky130_fd_pr__nfet_01v8 L=0.15 W=0.65
+ AS=0.08775 AD=0.169 PS=0.92 PD=1.82
M$7432 A|X \$557 VGND VGND sky130_fd_pr__nfet_01v8 L=0.15 W=0.65 AS=0.169
+ AD=0.13165 PS=1.82 PD=1.14
M$7433 VGND A|B|C|Y \$603 VGND sky130_fd_pr__nfet_01v8 L=0.15 W=0.42 AS=0.13165
+ AD=0.0441 PS=1.14 PD=0.63
M$7434 \$603 A|B|Y \$602 VGND sky130_fd_pr__nfet_01v8 L=0.15 W=0.42 AS=0.0441
+ AD=0.0441 PS=0.63 PD=0.63
M$7435 \$602 A|B|C1|X \$557 VGND sky130_fd_pr__nfet_01v8 L=0.15 W=0.42
+ AS=0.0441 AD=0.1092 PS=0.63 PD=1.36
M$7437 A1|Y A|B|Y \$601 VGND sky130_fd_pr__nfet_01v8 L=0.15 W=0.65 AS=0.169
+ AD=0.08775 PS=1.82 PD=0.92
M$7438 \$601 A|B|C|Y VGND VGND sky130_fd_pr__nfet_01v8 L=0.15 W=0.65 AS=0.08775
+ AD=0.169 PS=0.92 PD=1.82
M$7442 VGND A|B1|Y A|B1_N|Y VGND sky130_fd_pr__nfet_01v8 L=0.15 W=0.65 AS=0.169
+ AD=0.08775 PS=1.82 PD=0.92
M$7443 A|B1_N|Y A|B|Y VGND VGND sky130_fd_pr__nfet_01v8 L=0.15 W=0.65
+ AS=0.08775 AD=0.08775 PS=0.92 PD=0.92
M$7444 VGND A1|B|C|X A|B1_N|Y VGND sky130_fd_pr__nfet_01v8 L=0.15 W=0.65
+ AS=0.08775 AD=0.169 PS=0.92 PD=1.82
M$7445 VGND A|B|Y A3|B|Y VGND sky130_fd_pr__nfet_01v8 L=0.15 W=0.65 AS=0.169
+ AD=0.08775 PS=1.82 PD=0.92
M$7446 A3|B|Y A1|B|C|X VGND VGND sky130_fd_pr__nfet_01v8 L=0.15 W=0.65
+ AS=0.08775 AD=0.169 PS=0.92 PD=1.82
M$7447 VGND A1|S|Y \$646 VGND sky130_fd_pr__nfet_01v8 L=0.15 W=0.65 AS=0.169
+ AD=0.169 PS=1.82 PD=1.82
M$7448 \$647 A1|S|Y VGND VGND sky130_fd_pr__nfet_01v8 L=0.15 W=0.65 AS=0.169
+ AD=0.08775 PS=1.82 PD=0.92
M$7449 VGND \$646 \$648 VGND sky130_fd_pr__nfet_01v8 L=0.15 W=0.65 AS=0.08775
+ AD=0.169 PS=0.92 PD=1.82
M$7451 \$647 A1|B|C|X A|B|C|Y VGND sky130_fd_pr__nfet_01v8 L=0.15 W=0.65
+ AS=0.182 AD=0.08775 PS=1.86 PD=0.92
M$7452 A|B|C|Y A0|Y \$648 VGND sky130_fd_pr__nfet_01v8 L=0.15 W=0.65 AS=0.08775
+ AD=0.169 PS=0.92 PD=1.82
M$7453 A1|S|Y A|A1|B|C1|X \$599 VGND sky130_fd_pr__nfet_01v8 L=0.15 W=0.65
+ AS=0.169 AD=0.08775 PS=1.82 PD=0.92
M$7454 \$599 A|B|B1_N|X VGND VGND sky130_fd_pr__nfet_01v8 L=0.15 W=0.65
+ AS=0.08775 AD=0.169 PS=0.92 PD=1.82
M$7457 A1|B|C|X \$650 VGND VGND sky130_fd_pr__nfet_01v8 L=0.15 W=0.65 AS=0.169
+ AD=0.1165 PS=1.82 PD=1.035
M$7458 VGND A2|B|C|D|X \$652 VGND sky130_fd_pr__nfet_01v8 L=0.15 W=0.42
+ AS=0.1165 AD=0.1785 PS=1.035 PD=1.69
M$7459 A1|B|Y A|A1|X \$598 VGND sky130_fd_pr__nfet_01v8 L=0.15 W=0.65 AS=0.169
+ AD=0.08775 PS=1.82 PD=0.92
M$7460 \$598 A2|B|C|X VGND VGND sky130_fd_pr__nfet_01v8 L=0.15 W=0.65
+ AS=0.08775 AD=0.169 PS=0.92 PD=1.82
M$7461 VGND A1|B|Y \$655 VGND sky130_fd_pr__nfet_01v8 L=0.15 W=0.65 AS=0.1885
+ AD=0.16515 PS=1.88 PD=1.82
M$7463 \$654 \$655 \$657 VGND sky130_fd_pr__nfet_01v8 L=0.15 W=0.42 AS=0.18205
+ AD=0.19265 PS=1.245 PD=1.285
M$7464 \$653 \$655 \$656 VGND sky130_fd_pr__nfet_01v8 L=0.15 W=0.6 AS=0.140825
+ AD=0.11 PS=1.1 PD=0.99
M$7465 \$656 A|A1|B|X VGND VGND sky130_fd_pr__nfet_01v8 L=0.15 W=0.64 AS=0.11
+ AD=0.0864 PS=0.99 PD=0.91
M$7466 VGND \$656 \$657 VGND sky130_fd_pr__nfet_01v8 L=0.15 W=0.64 AS=0.0864
+ AD=0.1824 PS=0.91 PD=1.85
M$7467 \$656 A1|B|Y \$654 VGND sky130_fd_pr__nfet_01v8 L=0.15 W=0.64 AS=0.16275
+ AD=0.18205 PS=1.8 PD=1.245
M$7468 \$653 A1|B|Y \$657 VGND sky130_fd_pr__nfet_01v8 L=0.15 W=0.64
+ AS=0.140825 AD=0.19265 PS=1.1 PD=1.285
M$7469 \$563 B|C|X \$597 VGND sky130_fd_pr__nfet_01v8 L=0.15 W=0.65 AS=0.169
+ AD=0.06825 PS=1.82 PD=0.86
M$7470 \$597 A|B|Y VGND VGND sky130_fd_pr__nfet_01v8 L=0.15 W=0.65 AS=0.06825
+ AD=0.08775 PS=0.86 PD=0.92
M$7471 VGND A|B|Y \$593 VGND sky130_fd_pr__nfet_01v8 L=0.15 W=0.65 AS=0.08775
+ AD=0.169 PS=0.92 PD=1.82
M$7472 A0|Y \$659 \$660 VGND sky130_fd_pr__nfet_01v8 L=0.15 W=0.65 AS=0.195
+ AD=0.08775 PS=1.9 PD=0.92
M$7473 \$660 A2|B|C|D|X VGND VGND sky130_fd_pr__nfet_01v8 L=0.15 W=0.65
+ AS=0.08775 AD=0.169 PS=0.92 PD=1.82
M$7474 VGND B|C|X \$593 VGND sky130_fd_pr__nfet_01v8 L=0.15 W=0.65 AS=0.169
+ AD=0.08775 PS=1.82 PD=0.92
M$7475 \$593 \$563 B|SLEEP|Y VGND sky130_fd_pr__nfet_01v8 L=0.15 W=0.65
+ AS=0.08775 AD=0.195 PS=0.92 PD=1.9
M$7476 \$660 A|A1|B|X VGND VGND sky130_fd_pr__nfet_01v8 L=0.15 W=0.65 AS=0.169
+ AD=0.08775 PS=1.82 PD=0.92
M$7477 VGND A|A1|B|X \$702 VGND sky130_fd_pr__nfet_01v8 L=0.15 W=0.65
+ AS=0.08775 AD=0.06825 PS=0.92 PD=0.86
M$7478 \$702 A2|B|C|D|X \$659 VGND sky130_fd_pr__nfet_01v8 L=0.15 W=0.65
+ AS=0.06825 AD=0.169 PS=0.86 PD=1.82
M$7479 VGND B|C|X \$566 VGND sky130_fd_pr__nfet_01v8 L=0.15 W=0.42 AS=0.1165
+ AD=0.1785 PS=1.035 PD=1.69
M$7480 B|C|X \$565 VGND VGND sky130_fd_pr__nfet_01v8 L=0.15 W=0.65 AS=0.169
+ AD=0.1165 PS=1.82 PD=1.035
M$7481 VGND B|SLEEP|Y A|A1|Y VGND sky130_fd_pr__nfet_01v8 L=0.15 W=0.65
+ AS=0.169 AD=0.08775 PS=1.82 PD=0.92
M$7482 A|A1|Y A|B|Y VGND VGND sky130_fd_pr__nfet_01v8 L=0.15 W=1.95 AS=0.3445
+ AD=0.42575 PS=3.66 PD=4.56
M$7483 \$569 B|C|X \$565 VGND sky130_fd_pr__nfet_01v8 L=0.15 W=0.64 AS=0.1728
+ AD=0.0928 PS=1.82 PD=0.93
M$7484 \$565 \$566 \$567 VGND sky130_fd_pr__nfet_01v8 L=0.15 W=0.64 AS=0.0928
+ AD=0.224 PS=0.93 PD=1.98
M$7485 C|Y A|B|Y \$687 VGND sky130_fd_pr__nfet_01v8 L=0.15 W=0.65 AS=0.169
+ AD=0.08775 PS=1.82 PD=0.92
M$7486 \$687 B|SLEEP|Y VGND VGND sky130_fd_pr__nfet_01v8 L=0.15 W=0.65
+ AS=0.08775 AD=0.169 PS=0.92 PD=1.82
M$7487 VGND A|B|X \$570 VGND sky130_fd_pr__nfet_01v8 L=0.15 W=0.65 AS=0.1885
+ AD=0.16515 PS=1.88 PD=1.82
M$7488 \$571 A|B|X \$567 VGND sky130_fd_pr__nfet_01v8 L=0.15 W=0.64 AS=0.16275
+ AD=0.18205 PS=1.8 PD=1.245
M$7489 \$567 \$570 \$572 VGND sky130_fd_pr__nfet_01v8 L=0.15 W=0.42 AS=0.18205
+ AD=0.19265 PS=1.245 PD=1.285
M$7490 \$572 A|B|X \$569 VGND sky130_fd_pr__nfet_01v8 L=0.15 W=0.64 AS=0.19265
+ AD=0.140825 PS=1.285 PD=1.1
M$7491 \$569 \$570 \$571 VGND sky130_fd_pr__nfet_01v8 L=0.15 W=0.6 AS=0.140825
+ AD=0.11 PS=1.1 PD=0.99
M$7492 \$571 A|X VGND VGND sky130_fd_pr__nfet_01v8 L=0.15 W=0.64 AS=0.11
+ AD=0.0864 PS=0.99 PD=0.91
M$7493 VGND \$571 \$572 VGND sky130_fd_pr__nfet_01v8 L=0.15 W=0.64 AS=0.0864
+ AD=0.1824 PS=0.91 PD=1.85
M$7494 A|B|X \$662 VGND VGND sky130_fd_pr__nfet_01v8 L=0.15 W=0.42 AS=0.1491
+ AD=0.097 PS=1.55 PD=0.975
M$7495 VGND \$663 \$662 VGND sky130_fd_pr__nfet_01v8 L=0.5 W=0.65 AS=0.097
+ AD=0.17225 PS=0.975 PD=1.83
M$7496 VGND A|COARSE_MUX[8] \$664 VGND sky130_fd_pr__nfet_01v8 L=0.15 W=0.42
+ AS=0.10435 AD=0.1134 PS=1.01 PD=1.38
M$7497 \$663 \$664 VGND VGND sky130_fd_pr__nfet_01v8 L=0.5 W=0.65 AS=0.169
+ AD=0.10435 PS=1.82 PD=1.01
M$7506 C|X \$847 VGND VGND sky130_fd_pr__nfet_01v8 L=0.15 W=0.65 AS=0.234
+ AD=0.12675 PS=2.02 PD=1.04
M$7507 VGND A|A1|Y \$933 VGND sky130_fd_pr__nfet_01v8 L=0.15 W=0.65 AS=0.12675
+ AD=0.08775 PS=1.04 PD=0.92
M$7508 \$933 A|A2|B|X VGND VGND sky130_fd_pr__nfet_01v8 L=0.15 W=0.65
+ AS=0.08775 AD=0.10725 PS=0.92 PD=0.98
M$7509 VGND A|A3|B|Y \$933 VGND sky130_fd_pr__nfet_01v8 L=0.15 W=0.65
+ AS=0.10725 AD=0.10725 PS=0.98 PD=0.98
M$7510 \$933 B1|Y \$847 VGND sky130_fd_pr__nfet_01v8 L=0.15 W=0.65 AS=0.10725
+ AD=0.2015 PS=0.98 PD=1.92
M$7511 A|A3|B|Y \$849 \$934 VGND sky130_fd_pr__nfet_01v8 L=0.15 W=0.65 AS=0.195
+ AD=0.08775 PS=1.9 PD=0.92
M$7512 \$934 B|X VGND VGND sky130_fd_pr__nfet_01v8 L=0.15 W=0.65 AS=0.08775
+ AD=0.169 PS=0.92 PD=1.82
M$7513 \$934 A|B|C|X VGND VGND sky130_fd_pr__nfet_01v8 L=0.15 W=0.65 AS=0.169
+ AD=0.08775 PS=1.82 PD=0.92
M$7514 VGND A|B|C|X \$955 VGND sky130_fd_pr__nfet_01v8 L=0.15 W=0.65 AS=0.08775
+ AD=0.06825 PS=0.92 PD=0.86
M$7515 \$955 B|X \$849 VGND sky130_fd_pr__nfet_01v8 L=0.15 W=0.65 AS=0.06825
+ AD=0.169 PS=0.86 PD=1.82
M$7516 VGND A|B|C|X \$956 VGND sky130_fd_pr__nfet_01v8 L=0.15 W=0.65 AS=0.169
+ AD=0.08775 PS=1.82 PD=0.92
M$7517 \$956 A2|B|Y \$957 VGND sky130_fd_pr__nfet_01v8 L=0.15 W=0.65 AS=0.08775
+ AD=0.10725 PS=0.92 PD=0.98
M$7518 \$957 A|A1|B|B1|X B1|Y VGND sky130_fd_pr__nfet_01v8 L=0.15 W=0.65
+ AS=0.10725 AD=0.169 PS=0.98 PD=1.82
M$7519 B|Y A|B1|Y \$958 VGND sky130_fd_pr__nfet_01v8 L=0.15 W=0.65 AS=0.169
+ AD=0.08775 PS=1.82 PD=0.92
M$7520 \$958 A|B|C|X VGND VGND sky130_fd_pr__nfet_01v8 L=0.15 W=0.65 AS=0.08775
+ AD=0.169 PS=0.92 PD=1.82
M$7523 VGND \$922 A2|X VGND sky130_fd_pr__nfet_01v8 L=0.15 W=0.65 AS=0.208
+ AD=0.25025 PS=1.94 PD=1.42
M$7524 A2|X B|C|X \$960 VGND sky130_fd_pr__nfet_01v8 L=0.15 W=0.65 AS=0.25025
+ AD=0.08775 PS=1.42 PD=0.92
M$7525 \$960 A|B|X VGND VGND sky130_fd_pr__nfet_01v8 L=0.15 W=0.65 AS=0.08775
+ AD=0.08775 PS=0.92 PD=0.92
M$7526 VGND A|B|X \$922 VGND sky130_fd_pr__nfet_01v8 L=0.15 W=0.65 AS=0.08775
+ AD=0.08775 PS=0.92 PD=0.92
M$7527 \$922 B|C|X VGND VGND sky130_fd_pr__nfet_01v8 L=0.15 W=0.65 AS=0.08775
+ AD=0.169 PS=0.92 PD=1.82
M$7528 VGND A_N|B|Y A|A1|Y VGND sky130_fd_pr__nfet_01v8 L=0.15 W=0.65 AS=0.169
+ AD=0.08775 PS=1.82 PD=0.92
M$7530 \$854 A_N|B|Y VGND VGND sky130_fd_pr__nfet_01v8 L=0.15 W=0.42 AS=0.1092
+ AD=0.10025 PS=1.36 PD=0.985
M$7531 VGND A|B|X \$962 VGND sky130_fd_pr__nfet_01v8 L=0.15 W=0.65 AS=0.10025
+ AD=0.08775 PS=0.985 PD=0.92
M$7532 \$962 \$854 A2|B1|Y VGND sky130_fd_pr__nfet_01v8 L=0.15 W=0.65
+ AS=0.08775 AD=0.169 PS=0.92 PD=1.82
M$7533 B|C|X \$856 VGND VGND sky130_fd_pr__nfet_01v8 L=0.15 W=0.65 AS=0.234
+ AD=0.12675 PS=2.02 PD=1.04
M$7534 VGND A|A1|Y \$936 VGND sky130_fd_pr__nfet_01v8 L=0.15 W=0.65 AS=0.12675
+ AD=0.08775 PS=1.04 PD=0.92
M$7535 \$936 A2|B1|Y VGND VGND sky130_fd_pr__nfet_01v8 L=0.15 W=0.65 AS=0.08775
+ AD=0.10725 PS=0.92 PD=0.98
M$7536 VGND A3|A_N|B|C|X \$936 VGND sky130_fd_pr__nfet_01v8 L=0.15 W=0.65
+ AS=0.10725 AD=0.10725 PS=0.98 PD=0.98
M$7537 \$936 A|B|B1|X \$856 VGND sky130_fd_pr__nfet_01v8 L=0.15 W=0.65
+ AS=0.10725 AD=0.2015 PS=0.98 PD=1.92
M$7538 VGND \$924 A3|A_N|B|C|X VGND sky130_fd_pr__nfet_01v8 L=0.15 W=0.65
+ AS=0.208 AD=0.25025 PS=1.94 PD=1.42
M$7539 A3|A_N|B|C|X A2|A3|B|X \$965 VGND sky130_fd_pr__nfet_01v8 L=0.15 W=0.65
+ AS=0.25025 AD=0.08775 PS=1.42 PD=0.92
M$7540 \$965 A|Y VGND VGND sky130_fd_pr__nfet_01v8 L=0.15 W=0.65 AS=0.08775
+ AD=0.08775 PS=0.92 PD=0.92
M$7541 VGND A|Y \$924 VGND sky130_fd_pr__nfet_01v8 L=0.15 W=0.65 AS=0.08775
+ AD=0.08775 PS=0.92 PD=0.92
M$7542 \$924 A2|A3|B|X VGND VGND sky130_fd_pr__nfet_01v8 L=0.15 W=0.65
+ AS=0.08775 AD=0.169 PS=0.92 PD=1.82
M$7544 VGND \$925 A2|A3|B|X VGND sky130_fd_pr__nfet_01v8 L=0.15 W=0.65 AS=0.208
+ AD=0.25025 PS=1.94 PD=1.42
M$7545 A2|A3|B|X B|Y \$967 VGND sky130_fd_pr__nfet_01v8 L=0.15 W=0.65
+ AS=0.25025 AD=0.08775 PS=1.42 PD=0.92
M$7546 \$967 A|B|Y VGND VGND sky130_fd_pr__nfet_01v8 L=0.15 W=0.65 AS=0.08775
+ AD=0.08775 PS=0.92 PD=0.92
M$7547 VGND A|B|Y \$925 VGND sky130_fd_pr__nfet_01v8 L=0.15 W=0.65 AS=0.08775
+ AD=0.08775 PS=0.92 PD=0.92
M$7548 \$925 B|Y VGND VGND sky130_fd_pr__nfet_01v8 L=0.15 W=0.65 AS=0.08775
+ AD=0.169 PS=0.92 PD=1.82
M$7550 A1|Y A|A1|B|C|Y \$971 VGND sky130_fd_pr__nfet_01v8 L=0.15 W=0.65
+ AS=0.169 AD=0.08775 PS=1.82 PD=0.92
M$7551 \$971 B|Y VGND VGND sky130_fd_pr__nfet_01v8 L=0.15 W=0.65 AS=0.08775
+ AD=0.169 PS=0.92 PD=1.82
M$7552 VGND \$861 A2|B|X VGND sky130_fd_pr__nfet_01v8 L=0.15 W=0.65 AS=0.169
+ AD=0.08775 PS=1.82 PD=0.92
M$7553 A2|B|X A|A2|B|SLEEP|Y VGND VGND sky130_fd_pr__nfet_01v8 L=0.15 W=0.65
+ AS=0.08775 AD=0.10025 PS=0.92 PD=0.985
M$7554 VGND A|B|X \$861 VGND sky130_fd_pr__nfet_01v8 L=0.15 W=0.42 AS=0.10025
+ AD=0.1092 PS=0.985 PD=1.36
M$7555 VGND A2|B|X \$973 VGND sky130_fd_pr__nfet_01v8 L=0.15 W=0.65 AS=0.234
+ AD=0.06825 PS=2.02 PD=0.86
M$7556 \$973 A|A1|B|C|Y A|Y VGND sky130_fd_pr__nfet_01v8 L=0.15 W=0.65
+ AS=0.06825 AD=0.169 PS=0.86 PD=1.82
M$7557 A|Y B1|Y \$974 VGND sky130_fd_pr__nfet_01v8 L=0.15 W=0.65 AS=0.169
+ AD=0.07475 PS=1.82 PD=0.88
M$7558 \$974 A|B2|X VGND VGND sky130_fd_pr__nfet_01v8 L=0.15 W=0.65 AS=0.07475
+ AD=0.169 PS=0.88 PD=1.82
M$7559 VGND A|SLEEP|Y B|Y VGND sky130_fd_pr__nfet_01v8 L=0.15 W=0.65 AS=0.169
+ AD=0.08775 PS=1.82 PD=0.92
M$7560 B|Y A|A2|B|SLEEP|Y VGND VGND sky130_fd_pr__nfet_01v8 L=0.15 W=0.65
+ AS=0.08775 AD=0.169 PS=0.92 PD=1.82
M$7562 VGND A|A3|B|Y B1|Y VGND sky130_fd_pr__nfet_01v8 L=0.15 W=0.65 AS=0.169
+ AD=0.08775 PS=1.82 PD=0.92
M$7563 B1|Y A|A2|B|SLEEP|Y VGND VGND sky130_fd_pr__nfet_01v8 L=0.15 W=0.65
+ AS=0.08775 AD=0.169 PS=0.92 PD=1.82
M$7564 A2|B|Y A|B1|X \$939 VGND sky130_fd_pr__nfet_01v8 L=0.15 W=0.65 AS=0.169
+ AD=0.203125 PS=1.82 PD=1.275
M$7565 \$939 A2|A4|B|X VGND VGND sky130_fd_pr__nfet_01v8 L=0.15 W=0.65
+ AS=0.203125 AD=0.08775 PS=1.275 PD=0.92
M$7566 VGND A|A3|B|Y \$939 VGND sky130_fd_pr__nfet_01v8 L=0.15 W=0.65
+ AS=0.08775 AD=0.08775 PS=0.92 PD=0.92
M$7567 \$939 A|A2|B|SLEEP|Y VGND VGND sky130_fd_pr__nfet_01v8 L=0.15 W=0.65
+ AS=0.08775 AD=0.11375 PS=0.92 PD=1
M$7568 VGND A1|Y \$939 VGND sky130_fd_pr__nfet_01v8 L=0.15 W=0.65 AS=0.11375
+ AD=0.182 PS=1 PD=1.86
M$7569 A1|Y \$867 \$940 VGND sky130_fd_pr__nfet_01v8 L=0.15 W=0.65 AS=0.195
+ AD=0.08775 PS=1.9 PD=0.92
M$7570 \$940 B|C|X VGND VGND sky130_fd_pr__nfet_01v8 L=0.15 W=0.65 AS=0.08775
+ AD=0.169 PS=0.92 PD=1.82
M$7571 \$940 A|B|B1|X VGND VGND sky130_fd_pr__nfet_01v8 L=0.15 W=0.65 AS=0.169
+ AD=0.08775 PS=1.82 PD=0.92
M$7572 VGND A|B|B1|X \$972 VGND sky130_fd_pr__nfet_01v8 L=0.15 W=0.65
+ AS=0.08775 AD=0.06825 PS=0.92 PD=0.86
M$7573 \$972 B|C|X \$867 VGND sky130_fd_pr__nfet_01v8 L=0.15 W=0.65 AS=0.06825
+ AD=0.169 PS=0.86 PD=1.82
M$7574 VGND \$928 A2|A4|B|X VGND sky130_fd_pr__nfet_01v8 L=0.15 W=0.65 AS=0.208
+ AD=0.25025 PS=1.94 PD=1.42
M$7575 A2|A4|B|X A1|A2|B|X \$970 VGND sky130_fd_pr__nfet_01v8 L=0.15 W=0.65
+ AS=0.25025 AD=0.08775 PS=1.42 PD=0.92
M$7576 \$970 A|Y VGND VGND sky130_fd_pr__nfet_01v8 L=0.15 W=0.65 AS=0.08775
+ AD=0.08775 PS=0.92 PD=0.92
M$7577 VGND A|Y \$928 VGND sky130_fd_pr__nfet_01v8 L=0.15 W=0.65 AS=0.08775
+ AD=0.08775 PS=0.92 PD=0.92
M$7578 \$928 A1|A2|B|X VGND VGND sky130_fd_pr__nfet_01v8 L=0.15 W=0.65
+ AS=0.08775 AD=0.169 PS=0.92 PD=1.82
M$7579 VGND A2|A_N|B|B1|C|X \$929 VGND sky130_fd_pr__nfet_01v8 L=0.15 W=0.42
+ AS=0.10025 AD=0.1092 PS=0.985 PD=1.36
M$7580 A2|Y \$929 \$968 VGND sky130_fd_pr__nfet_01v8 L=0.15 W=0.65 AS=0.182
+ AD=0.125125 PS=1.86 PD=1.035
M$7581 \$968 B|C|X \$966 VGND sky130_fd_pr__nfet_01v8 L=0.15 W=0.65 AS=0.125125
+ AD=0.08775 PS=1.035 PD=0.92
M$7582 \$966 B|C|X VGND VGND sky130_fd_pr__nfet_01v8 L=0.15 W=0.65 AS=0.08775
+ AD=0.10025 PS=0.92 PD=0.985
M$7584 VGND \$930 A1|A2|B|X VGND sky130_fd_pr__nfet_01v8 L=0.15 W=0.65 AS=0.208
+ AD=0.25025 PS=1.94 PD=1.42
M$7585 A1|A2|B|X A3|B|X \$963 VGND sky130_fd_pr__nfet_01v8 L=0.15 W=0.65
+ AS=0.25025 AD=0.08775 PS=1.42 PD=0.92
M$7586 \$963 A|Y VGND VGND sky130_fd_pr__nfet_01v8 L=0.15 W=0.65 AS=0.08775
+ AD=0.08775 PS=0.92 PD=0.92
M$7587 VGND A|Y \$930 VGND sky130_fd_pr__nfet_01v8 L=0.15 W=0.65 AS=0.08775
+ AD=0.08775 PS=0.92 PD=0.92
M$7588 \$930 A3|B|X VGND VGND sky130_fd_pr__nfet_01v8 L=0.15 W=0.65 AS=0.08775
+ AD=0.169 PS=0.92 PD=1.82
M$7590 VGND A2|B|X \$961 VGND sky130_fd_pr__nfet_01v8 L=0.15 W=0.65 AS=0.169
+ AD=0.08775 PS=1.82 PD=0.92
M$7591 \$961 A|A1|X A|Y VGND sky130_fd_pr__nfet_01v8 L=0.15 W=0.65 AS=0.08775
+ AD=0.169 PS=0.92 PD=1.82
M$7592 A2|B|C|X \$874 VGND VGND sky130_fd_pr__nfet_01v8 L=0.15 W=0.65 AS=0.169
+ AD=0.169 PS=1.82 PD=1.82
M$7593 \$874 B|B1|X \$942 VGND sky130_fd_pr__nfet_01v8 L=0.15 W=0.65 AS=0.169
+ AD=0.10075 PS=1.82 PD=0.96
M$7594 \$942 A2|B|X VGND VGND sky130_fd_pr__nfet_01v8 L=0.15 W=0.65 AS=0.10075
+ AD=0.08775 PS=0.96 PD=0.92
M$7595 VGND A|A1|X \$942 VGND sky130_fd_pr__nfet_01v8 L=0.15 W=0.65 AS=0.08775
+ AD=0.169 PS=0.92 PD=1.82
M$7597 VGND A|X \$876 VGND sky130_fd_pr__nfet_01v8 L=0.15 W=0.42 AS=0.10025
+ AD=0.1092 PS=0.985 PD=1.36
M$7598 VGND A2|B|C|SLEEP|Y A|X VGND sky130_fd_pr__nfet_01v8 L=0.15 W=0.65
+ AS=0.10025 AD=0.08775 PS=0.985 PD=0.92
M$7599 A|X \$876 VGND VGND sky130_fd_pr__nfet_01v8 L=0.15 W=0.65 AS=0.08775
+ AD=0.169 PS=0.92 PD=1.82
M$7602 VGND A|B1_N|Y \$878 VGND sky130_fd_pr__nfet_01v8 L=0.15 W=0.42 AS=0.1092
+ AD=0.1092 PS=1.36 PD=1.36
M$7603 B|Y \$878 \$945 VGND sky130_fd_pr__nfet_01v8 L=0.15 W=0.65 AS=0.169
+ AD=0.10075 PS=1.82 PD=0.96
M$7604 \$945 A1|A2|Y VGND VGND sky130_fd_pr__nfet_01v8 L=0.15 W=0.65 AS=0.10075
+ AD=0.08775 PS=0.96 PD=0.92
M$7605 VGND A1|S|Y \$945 VGND sky130_fd_pr__nfet_01v8 L=0.15 W=0.65 AS=0.08775
+ AD=0.169 PS=0.92 PD=1.82
M$7608 VGND B1|Y B|Y VGND sky130_fd_pr__nfet_01v8 L=0.15 W=1.95 AS=0.450125
+ AD=0.3575 PS=4.635 PD=3.7
M$7609 B|Y A1|B|Y \$952 VGND sky130_fd_pr__nfet_01v8 L=0.15 W=0.65 AS=0.091
+ AD=0.095875 PS=0.93 PD=0.945
M$7610 \$952 A1|A2|Y VGND VGND sky130_fd_pr__nfet_01v8 L=0.15 W=0.65
+ AS=0.095875 AD=0.17225 PS=0.945 PD=1.83
M$7611 \$653 A2|B|C|D|X \$650 VGND sky130_fd_pr__nfet_01v8 L=0.15 W=0.64
+ AS=0.1728 AD=0.0928 PS=1.82 PD=0.93
M$7612 \$650 \$652 \$654 VGND sky130_fd_pr__nfet_01v8 L=0.15 W=0.64 AS=0.0928
+ AD=0.224 PS=0.93 PD=1.98
M$7615 A|A1|B|X \$883 VGND VGND sky130_fd_pr__nfet_01v8 L=0.15 W=0.65 AS=0.169
+ AD=0.10025 PS=1.82 PD=0.985
M$7616 VGND B|SLEEP|Y \$883 VGND sky130_fd_pr__nfet_01v8 L=0.15 W=0.42
+ AS=0.10025 AD=0.0567 PS=0.985 PD=0.69
M$7617 \$883 A|B|Y VGND VGND sky130_fd_pr__nfet_01v8 L=0.15 W=0.42 AS=0.0567
+ AD=0.1092 PS=0.69 PD=1.36
M$7618 \$884 B|C|X \$951 VGND sky130_fd_pr__nfet_01v8 L=0.15 W=0.65 AS=0.169
+ AD=0.06825 PS=1.82 PD=0.86
M$7619 \$951 A|X VGND VGND sky130_fd_pr__nfet_01v8 L=0.15 W=0.65 AS=0.06825
+ AD=0.08775 PS=0.86 PD=0.92
M$7620 VGND A|X \$948 VGND sky130_fd_pr__nfet_01v8 L=0.15 W=0.65 AS=0.08775
+ AD=0.169 PS=0.92 PD=1.82
M$7621 VGND B|C|X \$948 VGND sky130_fd_pr__nfet_01v8 L=0.15 W=0.65 AS=0.169
+ AD=0.08775 PS=1.82 PD=0.92
M$7622 \$948 \$884 C|Y VGND sky130_fd_pr__nfet_01v8 L=0.15 W=0.65 AS=0.08775
+ AD=0.195 PS=0.92 PD=1.9
M$7623 VGND \$885 A|X VGND sky130_fd_pr__nfet_01v8 L=0.15 W=0.42 AS=0.097
+ AD=0.1491 PS=0.975 PD=1.55
M$7624 VGND \$886 \$885 VGND sky130_fd_pr__nfet_01v8 L=0.5 W=0.65 AS=0.097
+ AD=0.17225 PS=0.975 PD=1.83
M$7625 \$886 \$887 VGND VGND sky130_fd_pr__nfet_01v8 L=0.5 W=0.65 AS=0.169
+ AD=0.10435 PS=1.82 PD=1.01
M$7626 VGND A|COARSE_MUX[13] \$887 VGND sky130_fd_pr__nfet_01v8 L=0.15 W=0.42
+ AS=0.10435 AD=0.1134 PS=1.01 PD=1.38
M$7635 B|C|X \$975 VGND VGND sky130_fd_pr__nfet_01v8 L=0.15 W=0.65 AS=0.169
+ AD=0.1165 PS=1.82 PD=1.035
M$7636 VGND C|X \$976 VGND sky130_fd_pr__nfet_01v8 L=0.15 W=0.42 AS=0.1165
+ AD=0.1785 PS=1.035 PD=1.69
M$7637 \$977 C|X \$975 VGND sky130_fd_pr__nfet_01v8 L=0.15 W=0.64 AS=0.1728
+ AD=0.0928 PS=1.82 PD=0.93
M$7638 \$975 \$976 \$978 VGND sky130_fd_pr__nfet_01v8 L=0.15 W=0.64 AS=0.0928
+ AD=0.224 PS=0.93 PD=1.98
M$7639 VGND B|Y \$979 VGND sky130_fd_pr__nfet_01v8 L=0.15 W=0.65 AS=0.1885
+ AD=0.16515 PS=1.88 PD=1.82
M$7640 \$978 \$979 \$981 VGND sky130_fd_pr__nfet_01v8 L=0.15 W=0.42 AS=0.18205
+ AD=0.19265 PS=1.245 PD=1.285
M$7641 \$977 \$979 \$980 VGND sky130_fd_pr__nfet_01v8 L=0.15 W=0.6 AS=0.140825
+ AD=0.11 PS=1.1 PD=0.99
M$7642 \$980 A|A2|SLEEP|X VGND VGND sky130_fd_pr__nfet_01v8 L=0.15 W=0.64
+ AS=0.11 AD=0.0864 PS=0.99 PD=0.91
M$7643 VGND \$980 \$981 VGND sky130_fd_pr__nfet_01v8 L=0.15 W=0.64 AS=0.0864
+ AD=0.1824 PS=0.91 PD=1.85
M$7644 \$980 B|Y \$978 VGND sky130_fd_pr__nfet_01v8 L=0.15 W=0.64 AS=0.16275
+ AD=0.18205 PS=1.8 PD=1.245
M$7645 \$977 B|Y \$981 VGND sky130_fd_pr__nfet_01v8 L=0.15 W=0.64 AS=0.140825
+ AD=0.19265 PS=1.1 PD=1.285
M$7646 \$983 A|A2|SLEEP|X \$1066 VGND sky130_fd_pr__nfet_01v8 L=0.15 W=0.42
+ AS=0.1113 AD=0.0441 PS=1.37 PD=0.63
M$7647 \$1066 B|Y VGND VGND sky130_fd_pr__nfet_01v8 L=0.15 W=0.42 AS=0.0441
+ AD=0.0966 PS=0.63 PD=0.88
M$7648 VGND \$983 B|X VGND sky130_fd_pr__nfet_01v8 L=0.15 W=0.42 AS=0.0966
+ AD=0.1113 PS=0.88 PD=1.37
M$7649 VGND A|A2|SLEEP|X A|B1|Y VGND sky130_fd_pr__nfet_01v8 L=0.15 W=0.65
+ AS=0.169 AD=0.08775 PS=1.82 PD=0.92
M$7650 A|B1|Y B|Y VGND VGND sky130_fd_pr__nfet_01v8 L=0.15 W=1.95 AS=0.26325
+ AD=0.507 PS=2.76 PD=5.46
M$7653 A|C|X \$989 VGND VGND sky130_fd_pr__nfet_01v8 L=0.15 W=0.65 AS=0.234
+ AD=0.12675 PS=2.02 PD=1.04
M$7654 VGND A|A1|Y \$987 VGND sky130_fd_pr__nfet_01v8 L=0.15 W=0.65 AS=0.12675
+ AD=0.08775 PS=1.04 PD=0.92
M$7655 \$987 A|A2|SLEEP|X VGND VGND sky130_fd_pr__nfet_01v8 L=0.15 W=0.65
+ AS=0.08775 AD=0.10725 PS=0.92 PD=0.98
M$7656 VGND A3|Y \$987 VGND sky130_fd_pr__nfet_01v8 L=0.15 W=0.65 AS=0.10725
+ AD=0.10725 PS=0.98 PD=0.98
M$7657 \$987 A|A1|B|B1|X \$989 VGND sky130_fd_pr__nfet_01v8 L=0.15 W=0.65
+ AS=0.10725 AD=0.2015 PS=0.98 PD=1.92
M$7658 A3|Y \$990 \$1082 VGND sky130_fd_pr__nfet_01v8 L=0.15 W=0.65 AS=0.169
+ AD=0.08775 PS=1.82 PD=0.92
M$7659 \$1082 A|B|C|X VGND VGND sky130_fd_pr__nfet_01v8 L=0.15 W=0.65
+ AS=0.08775 AD=0.10025 PS=0.92 PD=0.985
M$7660 VGND A3|A_N|B|C|X \$990 VGND sky130_fd_pr__nfet_01v8 L=0.15 W=0.42
+ AS=0.10025 AD=0.1092 PS=0.985 PD=1.36
M$7661 A|A2|SLEEP|X \$991 VGND VGND sky130_fd_pr__nfet_01v8 L=0.15 W=0.65
+ AS=0.169 AD=0.1165 PS=1.82 PD=1.035
M$7662 VGND B|C|X \$992 VGND sky130_fd_pr__nfet_01v8 L=0.15 W=0.42 AS=0.1165
+ AD=0.1785 PS=1.035 PD=1.69
M$7663 \$993 B|C|X \$991 VGND sky130_fd_pr__nfet_01v8 L=0.15 W=0.64 AS=0.1728
+ AD=0.0928 PS=1.82 PD=0.93
M$7664 \$991 \$992 \$994 VGND sky130_fd_pr__nfet_01v8 L=0.15 W=0.64 AS=0.0928
+ AD=0.224 PS=0.93 PD=1.98
M$7665 VGND A|B|X \$995 VGND sky130_fd_pr__nfet_01v8 L=0.15 W=0.65 AS=0.1885
+ AD=0.16515 PS=1.88 PD=1.82
M$7666 \$994 \$995 \$997 VGND sky130_fd_pr__nfet_01v8 L=0.15 W=0.42 AS=0.18205
+ AD=0.19265 PS=1.245 PD=1.285
M$7667 \$993 \$995 \$996 VGND sky130_fd_pr__nfet_01v8 L=0.15 W=0.6 AS=0.140825
+ AD=0.11 PS=1.1 PD=0.99
M$7668 \$996 A|A1|Y VGND VGND sky130_fd_pr__nfet_01v8 L=0.15 W=0.64 AS=0.11
+ AD=0.0864 PS=0.99 PD=0.91
M$7669 VGND \$996 \$997 VGND sky130_fd_pr__nfet_01v8 L=0.15 W=0.64 AS=0.0864
+ AD=0.1824 PS=0.91 PD=1.85
M$7670 \$996 A|B|X \$994 VGND sky130_fd_pr__nfet_01v8 L=0.15 W=0.64 AS=0.16275
+ AD=0.18205 PS=1.8 PD=1.245
M$7671 \$993 A|B|X \$997 VGND sky130_fd_pr__nfet_01v8 L=0.15 W=0.64 AS=0.140825
+ AD=0.19265 PS=1.1 PD=1.285
M$7675 \$937 A1|Y VGND VGND sky130_fd_pr__nfet_01v8 L=0.15 W=0.42 AS=0.1113
+ AD=0.0588 PS=1.37 PD=0.7
M$7676 VGND A2|A3|B|X \$937 VGND sky130_fd_pr__nfet_01v8 L=0.15 W=0.42
+ AS=0.0588 AD=0.0588 PS=0.7 PD=0.7
M$7677 \$937 A|B|B1|X B|C|Y VGND sky130_fd_pr__nfet_01v8 L=0.15 W=0.42
+ AS=0.0588 AD=0.1113 PS=0.7 PD=1.37
M$7679 VGND \$998 A|B|X VGND sky130_fd_pr__nfet_01v8 L=0.15 W=0.65 AS=0.208
+ AD=0.25025 PS=1.94 PD=1.42
M$7680 A|B|X A2|B|X \$1112 VGND sky130_fd_pr__nfet_01v8 L=0.15 W=0.65
+ AS=0.25025 AD=0.08775 PS=1.42 PD=0.92
M$7681 \$1112 A|A1|B|C|Y VGND VGND sky130_fd_pr__nfet_01v8 L=0.15 W=0.65
+ AS=0.08775 AD=0.08775 PS=0.92 PD=0.92
M$7682 VGND A|A1|B|C|Y \$998 VGND sky130_fd_pr__nfet_01v8 L=0.15 W=0.65
+ AS=0.08775 AD=0.08775 PS=0.92 PD=0.92
M$7683 \$998 A2|B|X VGND VGND sky130_fd_pr__nfet_01v8 L=0.15 W=0.65 AS=0.08775
+ AD=0.169 PS=0.92 PD=1.82
M$7684 \$999 A1|Y VGND VGND sky130_fd_pr__nfet_01v8 L=0.15 W=0.65 AS=0.169
+ AD=0.08775 PS=1.82 PD=0.92
M$7685 VGND A2|A4|B|X \$999 VGND sky130_fd_pr__nfet_01v8 L=0.15 W=0.65
+ AS=0.08775 AD=0.10075 PS=0.92 PD=0.96
M$7686 \$999 A|B|B1|X \$1000 VGND sky130_fd_pr__nfet_01v8 L=0.15 W=0.65
+ AS=0.10075 AD=0.169 PS=0.96 PD=1.82
M$7687 VGND \$1000 A2|B|C|X VGND sky130_fd_pr__nfet_01v8 L=0.15 W=0.65 AS=0.169
+ AD=0.169 PS=1.82 PD=1.82
M$7688 A|B|Y \$1002 \$1003 VGND sky130_fd_pr__nfet_01v8 L=0.15 W=0.65 AS=0.195
+ AD=0.08775 PS=1.9 PD=0.92
M$7689 \$1003 A2|A4|B|X VGND VGND sky130_fd_pr__nfet_01v8 L=0.15 W=0.65
+ AS=0.08775 AD=0.169 PS=0.92 PD=1.82
M$7690 \$1003 A|Y VGND VGND sky130_fd_pr__nfet_01v8 L=0.15 W=0.65 AS=0.169
+ AD=0.08775 PS=1.82 PD=0.92
M$7691 VGND A|Y \$1124 VGND sky130_fd_pr__nfet_01v8 L=0.15 W=0.65 AS=0.08775
+ AD=0.06825 PS=0.92 PD=0.86
M$7692 \$1124 A2|A4|B|X \$1002 VGND sky130_fd_pr__nfet_01v8 L=0.15 W=0.65
+ AS=0.06825 AD=0.169 PS=0.86 PD=1.82
M$7696 A_N|C|Y A|B|B1|X \$1005 VGND sky130_fd_pr__nfet_01v8 L=0.15 W=0.42
+ AS=0.1113 AD=0.0588 PS=1.37 PD=0.7
M$7697 \$1005 A2|Y VGND VGND sky130_fd_pr__nfet_01v8 L=0.15 W=0.42 AS=0.0588
+ AD=0.0588 PS=0.7 PD=0.7
M$7698 VGND A1|A2|B|X \$1005 VGND sky130_fd_pr__nfet_01v8 L=0.15 W=0.42
+ AS=0.0588 AD=0.1113 PS=0.7 PD=1.37
M$7700 \$941 A1|Y VGND VGND sky130_fd_pr__nfet_01v8 L=0.15 W=0.42 AS=0.1113
+ AD=0.0588 PS=1.37 PD=0.7
M$7701 VGND A1|A2|B|X \$941 VGND sky130_fd_pr__nfet_01v8 L=0.15 W=0.42
+ AS=0.0588 AD=0.0588 PS=0.7 PD=0.7
M$7702 \$941 A|A1|B1|X B|SLEEP|Y VGND sky130_fd_pr__nfet_01v8 L=0.15 W=0.42
+ AS=0.0588 AD=0.1113 PS=0.7 PD=1.37
M$7705 A|A1|Y \$1007 \$1008 VGND sky130_fd_pr__nfet_01v8 L=0.15 W=0.65 AS=0.195
+ AD=0.08775 PS=1.9 PD=0.92
M$7706 \$1008 A2|A2_N|B|D|X VGND VGND sky130_fd_pr__nfet_01v8 L=0.15 W=0.65
+ AS=0.08775 AD=0.169 PS=0.92 PD=1.82
M$7707 \$1008 A|Y VGND VGND sky130_fd_pr__nfet_01v8 L=0.15 W=0.65 AS=0.169
+ AD=0.08775 PS=1.82 PD=0.92
M$7708 VGND A|Y \$1160 VGND sky130_fd_pr__nfet_01v8 L=0.15 W=0.65 AS=0.08775
+ AD=0.06825 PS=0.92 PD=0.86
M$7709 \$1160 A2|A2_N|B|D|X \$1007 VGND sky130_fd_pr__nfet_01v8 L=0.15 W=0.65
+ AS=0.06825 AD=0.169 PS=0.86 PD=1.82
M$7711 \$875 A|A1|X \$959 VGND sky130_fd_pr__nfet_01v8 L=0.15 W=0.42 AS=0.1113
+ AD=0.0441 PS=1.37 PD=0.63
M$7712 \$959 A2|B|X VGND VGND sky130_fd_pr__nfet_01v8 L=0.15 W=0.42 AS=0.0441
+ AD=0.0966 PS=0.63 PD=0.88
M$7713 VGND \$875 A1|A1_N|C|X VGND sky130_fd_pr__nfet_01v8 L=0.15 W=0.42
+ AS=0.0966 AD=0.1113 PS=0.88 PD=1.37
M$7714 VGND \$1010 A2|A2_N|B|D|X VGND sky130_fd_pr__nfet_01v8 L=0.15 W=0.65
+ AS=0.208 AD=0.25025 PS=1.94 PD=1.42
M$7715 A2|A2_N|B|D|X A3|B|Y \$1154 VGND sky130_fd_pr__nfet_01v8 L=0.15 W=0.65
+ AS=0.25025 AD=0.08775 PS=1.42 PD=0.92
M$7716 \$1154 A|X VGND VGND sky130_fd_pr__nfet_01v8 L=0.15 W=0.65 AS=0.08775
+ AD=0.08775 PS=0.92 PD=0.92
M$7717 VGND A|X \$1010 VGND sky130_fd_pr__nfet_01v8 L=0.15 W=0.65 AS=0.08775
+ AD=0.08775 PS=0.92 PD=0.92
M$7718 \$1010 A3|B|Y VGND VGND sky130_fd_pr__nfet_01v8 L=0.15 W=0.65 AS=0.08775
+ AD=0.169 PS=0.92 PD=1.82
M$7719 A|A1|A_N|B1|X \$1013 VGND VGND sky130_fd_pr__nfet_01v8 L=0.15 W=0.65
+ AS=0.169 AD=0.203125 PS=1.82 PD=1.275
M$7720 VGND A1|Y \$1014 VGND sky130_fd_pr__nfet_01v8 L=0.15 W=0.65 AS=0.203125
+ AD=0.117 PS=1.275 PD=1.01
M$7721 \$1014 A2|B|C|SLEEP|Y VGND VGND sky130_fd_pr__nfet_01v8 L=0.15 W=0.65
+ AS=0.117 AD=0.1365 PS=1.01 PD=1.07
M$7722 VGND A3|B|Y \$1014 VGND sky130_fd_pr__nfet_01v8 L=0.15 W=0.65 AS=0.1365
+ AD=0.118625 PS=1.07 PD=1.015
M$7723 \$1014 B|B1|SLEEP|Y \$1132 VGND sky130_fd_pr__nfet_01v8 L=0.15 W=0.65
+ AS=0.118625 AD=0.06825 PS=1.015 PD=0.86
M$7724 \$1132 A|B|C1|X \$1013 VGND sky130_fd_pr__nfet_01v8 L=0.15 W=0.65
+ AS=0.06825 AD=0.169 PS=0.86 PD=1.82
M$7726 A2|B|C|SLEEP|Y \$1015 \$1016 VGND sky130_fd_pr__nfet_01v8 L=0.15 W=0.65
+ AS=0.195 AD=0.08775 PS=1.9 PD=0.92
M$7727 \$1016 B|Y VGND VGND sky130_fd_pr__nfet_01v8 L=0.15 W=0.65 AS=0.08775
+ AD=0.169 PS=0.92 PD=1.82
M$7728 \$1016 A|B|Y VGND VGND sky130_fd_pr__nfet_01v8 L=0.15 W=0.65 AS=0.169
+ AD=0.08775 PS=1.82 PD=0.92
M$7729 VGND A|B|Y \$1111 VGND sky130_fd_pr__nfet_01v8 L=0.15 W=0.65 AS=0.08775
+ AD=0.06825 PS=0.92 PD=0.86
M$7730 \$1111 B|Y \$1015 VGND sky130_fd_pr__nfet_01v8 L=0.15 W=0.65 AS=0.06825
+ AD=0.169 PS=0.86 PD=1.82
M$7731 A|Y A|B1_N|Y \$1105 VGND sky130_fd_pr__nfet_01v8 L=0.15 W=0.65 AS=0.169
+ AD=0.08775 PS=1.82 PD=0.92
M$7732 \$1105 A|B|Y VGND VGND sky130_fd_pr__nfet_01v8 L=0.15 W=0.65 AS=0.08775
+ AD=0.169 PS=0.92 PD=1.82
M$7735 \$1019 A1|A2|Y VGND VGND sky130_fd_pr__nfet_01v8 L=0.15 W=0.65 AS=0.169
+ AD=0.08775 PS=1.82 PD=0.92
M$7736 VGND A2|Y \$1019 VGND sky130_fd_pr__nfet_01v8 L=0.15 W=0.65 AS=0.08775
+ AD=0.10075 PS=0.92 PD=0.96
M$7737 \$1019 \$1020 A2|B1|Y VGND sky130_fd_pr__nfet_01v8 L=0.15 W=0.65
+ AS=0.10075 AD=0.169 PS=0.96 PD=1.82
M$7738 A2|Y A2|B|B1|C|Y \$946 VGND sky130_fd_pr__nfet_01v8 L=0.15 W=0.42
+ AS=0.1113 AD=0.0588 PS=1.37 PD=0.7
M$7739 \$946 A2|B|C|X VGND VGND sky130_fd_pr__nfet_01v8 L=0.15 W=0.42 AS=0.0588
+ AD=0.0588 PS=0.7 PD=0.7
M$7740 VGND A|A1|X \$946 VGND sky130_fd_pr__nfet_01v8 L=0.15 W=0.42 AS=0.0588
+ AD=0.1113 PS=0.7 PD=1.37
M$7741 VGND A2|B|B1|C|Y B1|Y VGND sky130_fd_pr__nfet_01v8 L=0.15 W=0.65
+ AS=0.169 AD=0.08775 PS=1.82 PD=0.92
M$7742 B1|Y A|A1|C1|Y VGND VGND sky130_fd_pr__nfet_01v8 L=0.15 W=0.65
+ AS=0.08775 AD=0.169 PS=0.92 PD=1.82
M$7743 A1|A2|Y \$1022 \$1023 VGND sky130_fd_pr__nfet_01v8 L=0.15 W=0.65
+ AS=0.195 AD=0.08775 PS=1.9 PD=0.92
M$7744 \$1023 A2|B|C|D|X VGND VGND sky130_fd_pr__nfet_01v8 L=0.15 W=0.65
+ AS=0.08775 AD=0.169 PS=0.92 PD=1.82
M$7745 \$1023 A|A1|Y VGND VGND sky130_fd_pr__nfet_01v8 L=0.15 W=0.65 AS=0.169
+ AD=0.08775 PS=1.82 PD=0.92
M$7746 VGND A|A1|Y \$1067 VGND sky130_fd_pr__nfet_01v8 L=0.15 W=0.65 AS=0.08775
+ AD=0.06825 PS=0.92 PD=0.86
M$7747 \$1067 A2|B|C|D|X \$1022 VGND sky130_fd_pr__nfet_01v8 L=0.15 W=0.65
+ AS=0.06825 AD=0.169 PS=0.86 PD=1.82
M$7749 A|A1|C1|Y A|A1|X \$1056 VGND sky130_fd_pr__nfet_01v8 L=0.15 W=0.65
+ AS=0.195 AD=0.10725 PS=1.9 PD=0.98
M$7750 \$1056 A|A1|B|X \$1052 VGND sky130_fd_pr__nfet_01v8 L=0.15 W=0.65
+ AS=0.10725 AD=0.08775 PS=0.98 PD=0.92
M$7751 \$1052 C|Y \$1048 VGND sky130_fd_pr__nfet_01v8 L=0.15 W=0.65 AS=0.08775
+ AD=0.08775 PS=0.92 PD=0.92
M$7752 \$1048 A2|B|C|D|X VGND VGND sky130_fd_pr__nfet_01v8 L=0.15 W=0.65
+ AS=0.08775 AD=0.169 PS=0.92 PD=1.82
M$7769 VGND A|A2|B|X B1|Y VGND sky130_fd_pr__nfet_01v8 L=0.15 W=0.65 AS=0.169
+ AD=0.08775 PS=1.82 PD=0.92
M$7770 B1|Y A|A1|Y VGND VGND sky130_fd_pr__nfet_01v8 L=0.15 W=0.65 AS=0.08775
+ AD=0.169 PS=0.92 PD=1.82
M$7775 VGND A|X A|A1|Y VGND sky130_fd_pr__nfet_01v8 L=0.15 W=1.07 AS=0.20745
+ AD=0.2782 PS=2.33 PD=3.18
M$7776 A|Y C|X VGND VGND sky130_fd_pr__nfet_01v8 L=0.15 W=0.65 AS=0.169
+ AD=0.08775 PS=1.82 PD=0.92
M$7777 VGND B|X A|Y VGND sky130_fd_pr__nfet_01v8 L=0.15 W=3.25 AS=0.52
+ AD=0.6825 PS=5.5 PD=7.3
M$7778 A|Y A|B1|Y VGND VGND sky130_fd_pr__nfet_01v8 L=0.15 W=6.27 AS=1.24745
+ AD=1.3182 PS=13.33 PD=14.18
M$7779 VGND \$1245 A|A0|X VGND sky130_fd_pr__nfet_01v8 L=0.15 W=0.65 AS=0.208
+ AD=0.25025 PS=1.94 PD=1.42
M$7780 A|A0|X A3|A_N|B|C|X \$1328 VGND sky130_fd_pr__nfet_01v8 L=0.15 W=0.65
+ AS=0.25025 AD=0.08775 PS=1.42 PD=0.92
M$7781 \$1328 A|B|Y VGND VGND sky130_fd_pr__nfet_01v8 L=0.15 W=0.65 AS=0.08775
+ AD=0.08775 PS=0.92 PD=0.92
M$7782 VGND A|B|Y \$1245 VGND sky130_fd_pr__nfet_01v8 L=0.15 W=0.65 AS=0.08775
+ AD=0.08775 PS=0.92 PD=0.92
M$7783 \$1245 A3|A_N|B|C|X VGND VGND sky130_fd_pr__nfet_01v8 L=0.15 W=0.65
+ AS=0.08775 AD=0.169 PS=0.92 PD=1.82
M$7786 VGND A|B1|Y A|B|Y VGND sky130_fd_pr__nfet_01v8 L=0.15 W=0.65 AS=0.17225
+ AD=0.091 PS=1.83 PD=0.93
M$7787 A|B|Y A|A1|Y \$1240 VGND sky130_fd_pr__nfet_01v8 L=0.15 W=0.65 AS=0.091
+ AD=0.095875 PS=0.93 PD=0.945
M$7788 \$1240 A2|X VGND VGND sky130_fd_pr__nfet_01v8 L=0.15 W=0.65 AS=0.095875
+ AD=0.17225 PS=0.945 PD=1.83
M$7790 VGND A1|B|C|X \$1229 VGND sky130_fd_pr__nfet_01v8 L=0.15 W=0.65 AS=0.169
+ AD=0.08775 PS=1.82 PD=0.92
M$7791 \$1229 A|A2|SLEEP|X VGND VGND sky130_fd_pr__nfet_01v8 L=0.15 W=0.65
+ AS=0.08775 AD=0.08775 PS=0.92 PD=0.92
M$7792 VGND A3|Y \$1229 VGND sky130_fd_pr__nfet_01v8 L=0.15 W=0.65 AS=0.08775
+ AD=0.19825 PS=0.92 PD=1.26
M$7793 \$1229 A|B1|X B|Y VGND sky130_fd_pr__nfet_01v8 L=0.15 W=0.65 AS=0.19825
+ AD=0.221 PS=1.26 PD=1.98
M$7794 \$1196 A|B1|X \$1230 VGND sky130_fd_pr__nfet_01v8 L=0.15 W=0.65
+ AS=0.2015 AD=0.10725 PS=1.92 PD=0.98
M$7795 \$1230 A3|Y VGND VGND sky130_fd_pr__nfet_01v8 L=0.15 W=0.65 AS=0.10725
+ AD=0.10725 PS=0.98 PD=0.98
M$7796 VGND A|A2|SLEEP|X \$1230 VGND sky130_fd_pr__nfet_01v8 L=0.15 W=0.65
+ AS=0.10725 AD=0.08775 PS=0.98 PD=0.92
M$7797 \$1230 A1|B|C|X VGND VGND sky130_fd_pr__nfet_01v8 L=0.15 W=0.65
+ AS=0.08775 AD=0.12675 PS=0.92 PD=1.04
M$7798 VGND \$1196 C|X VGND sky130_fd_pr__nfet_01v8 L=0.15 W=0.65 AS=0.12675
+ AD=0.234 PS=1.04 PD=2.02
M$7801 VGND C|X \$1347 VGND sky130_fd_pr__nfet_01v8 L=0.15 W=0.42 AS=0.1474
+ AD=0.0441 PS=1.215 PD=0.63
M$7802 \$1347 B|C|X \$1247 VGND sky130_fd_pr__nfet_01v8 L=0.15 W=0.42 AS=0.0441
+ AD=0.0567 PS=0.63 PD=0.69
M$7803 \$1247 B|C|X \$1349 VGND sky130_fd_pr__nfet_01v8 L=0.15 W=0.42 AS=0.0567
+ AD=0.0441 PS=0.69 PD=0.63
M$7804 \$1349 A|X VGND VGND sky130_fd_pr__nfet_01v8 L=0.15 W=0.42 AS=0.0441
+ AD=0.0567 PS=0.63 PD=0.69
M$7805 VGND A|X \$1351 VGND sky130_fd_pr__nfet_01v8 L=0.15 W=0.42 AS=0.0567
+ AD=0.0441 PS=0.69 PD=0.63
M$7806 \$1351 C|X \$1247 VGND sky130_fd_pr__nfet_01v8 L=0.15 W=0.42 AS=0.0441
+ AD=0.1092 PS=0.63 PD=1.36
M$7807 B|X \$1247 VGND VGND sky130_fd_pr__nfet_01v8 L=0.15 W=0.65 AS=0.23725
+ AD=0.1474 PS=2.03 PD=1.215
M$7810 \$1249 A|X \$1355 VGND sky130_fd_pr__nfet_01v8 L=0.15 W=0.42 AS=0.1113
+ AD=0.0441 PS=1.37 PD=0.63
M$7811 \$1355 B|C|X VGND VGND sky130_fd_pr__nfet_01v8 L=0.15 W=0.42 AS=0.0441
+ AD=0.0966 PS=0.63 PD=0.88
M$7812 VGND \$1249 A|A1|X VGND sky130_fd_pr__nfet_01v8 L=0.15 W=0.42 AS=0.0966
+ AD=0.1113 PS=0.88 PD=1.37
M$7817 A|Y B|C|Y VGND VGND sky130_fd_pr__nfet_01v8 L=0.15 W=2.6 AS=0.5135
+ AD=0.5135 PS=5.48 PD=5.48
M$7818 A|X \$1253 VGND VGND sky130_fd_pr__nfet_01v8 L=0.15 W=0.65 AS=0.169
+ AD=0.144125 PS=1.82 PD=1.12
M$7819 VGND B|C|Y \$1255 VGND sky130_fd_pr__nfet_01v8 L=0.15 W=0.42 AS=0.144125
+ AD=0.1764 PS=1.12 PD=1.68
M$7821 VGND B|B2|Y \$1258 VGND sky130_fd_pr__nfet_01v8 L=0.15 W=0.65 AS=0.195
+ AD=0.1653 PS=1.9 PD=1.82
M$7823 \$1256 \$1258 \$1260 VGND sky130_fd_pr__nfet_01v8 L=0.15 W=0.42
+ AS=0.18365 AD=0.19265 PS=1.25 PD=1.285
M$7824 \$1257 \$1258 \$1259 VGND sky130_fd_pr__nfet_01v8 L=0.15 W=0.6
+ AS=0.140825 AD=0.11 PS=1.1 PD=0.99
M$7825 \$1259 A|B1|X VGND VGND sky130_fd_pr__nfet_01v8 L=0.15 W=0.64 AS=0.11
+ AD=0.0864 PS=0.99 PD=0.91
M$7826 VGND \$1259 \$1260 VGND sky130_fd_pr__nfet_01v8 L=0.15 W=0.64 AS=0.0864
+ AD=0.1824 PS=0.91 PD=1.85
M$7827 \$1259 B|B2|Y \$1256 VGND sky130_fd_pr__nfet_01v8 L=0.15 W=0.64
+ AS=0.1628 AD=0.18365 PS=1.8 PD=1.25
M$7828 \$1257 B|B2|Y \$1260 VGND sky130_fd_pr__nfet_01v8 L=0.15 W=0.64
+ AS=0.140825 AD=0.19265 PS=1.1 PD=1.285
M$7834 VGND \$1262 A|A1|X VGND sky130_fd_pr__nfet_01v8 L=0.15 W=0.65 AS=0.208
+ AD=0.25025 PS=1.94 PD=1.42
M$7835 A|A1|X A2|B|Y \$1382 VGND sky130_fd_pr__nfet_01v8 L=0.15 W=0.65
+ AS=0.25025 AD=0.08775 PS=1.42 PD=0.92
M$7836 \$1382 A|A1|X VGND VGND sky130_fd_pr__nfet_01v8 L=0.15 W=0.65 AS=0.08775
+ AD=0.08775 PS=0.92 PD=0.92
M$7837 VGND A|A1|X \$1262 VGND sky130_fd_pr__nfet_01v8 L=0.15 W=0.65 AS=0.08775
+ AD=0.08775 PS=0.92 PD=0.92
M$7838 \$1262 A2|B|Y VGND VGND sky130_fd_pr__nfet_01v8 L=0.15 W=0.65 AS=0.08775
+ AD=0.169 PS=0.92 PD=1.82
M$7842 A|A1|X \$1264 VGND VGND sky130_fd_pr__nfet_01v8 L=0.15 W=0.65 AS=0.169
+ AD=0.144125 PS=1.82 PD=1.12
M$7843 VGND A_N|C|Y \$1265 VGND sky130_fd_pr__nfet_01v8 L=0.15 W=0.42
+ AS=0.144125 AD=0.1764 PS=1.12 PD=1.68
M$7844 VGND B|SLEEP|Y \$1268 VGND sky130_fd_pr__nfet_01v8 L=0.15 W=0.65
+ AS=0.195 AD=0.1653 PS=1.9 PD=1.82
M$7846 \$1266 \$1268 \$1270 VGND sky130_fd_pr__nfet_01v8 L=0.15 W=0.42
+ AS=0.18365 AD=0.19265 PS=1.25 PD=1.285
M$7847 \$1267 \$1268 \$1269 VGND sky130_fd_pr__nfet_01v8 L=0.15 W=0.6
+ AS=0.140825 AD=0.11 PS=1.1 PD=0.99
M$7848 \$1269 A|Y VGND VGND sky130_fd_pr__nfet_01v8 L=0.15 W=0.64 AS=0.11
+ AD=0.0864 PS=0.99 PD=0.91
M$7849 VGND \$1269 \$1270 VGND sky130_fd_pr__nfet_01v8 L=0.15 W=0.64 AS=0.0864
+ AD=0.1824 PS=0.91 PD=1.85
M$7850 \$1269 B|SLEEP|Y \$1266 VGND sky130_fd_pr__nfet_01v8 L=0.15 W=0.64
+ AS=0.1628 AD=0.18365 PS=1.8 PD=1.25
M$7851 \$1267 B|SLEEP|Y \$1270 VGND sky130_fd_pr__nfet_01v8 L=0.15 W=0.64
+ AS=0.140825 AD=0.19265 PS=1.1 PD=1.285
M$7854 A|Y \$1273 \$1274 VGND sky130_fd_pr__nfet_01v8 L=0.15 W=0.65 AS=0.195
+ AD=0.08775 PS=1.9 PD=0.92
M$7855 \$1274 B|X VGND VGND sky130_fd_pr__nfet_01v8 L=0.15 W=0.65 AS=0.08775
+ AD=0.169 PS=0.92 PD=1.82
M$7856 \$1274 A|X VGND VGND sky130_fd_pr__nfet_01v8 L=0.15 W=0.65 AS=0.169
+ AD=0.08775 PS=1.82 PD=0.92
M$7857 VGND A|X \$1401 VGND sky130_fd_pr__nfet_01v8 L=0.15 W=0.65 AS=0.08775
+ AD=0.06825 PS=0.92 PD=0.86
M$7858 \$1401 B|X \$1273 VGND sky130_fd_pr__nfet_01v8 L=0.15 W=0.65 AS=0.06825
+ AD=0.169 PS=0.86 PD=1.82
M$7861 VGND A2|B|C|X \$1199 VGND sky130_fd_pr__nfet_01v8 L=0.15 W=0.42
+ AS=0.1165 AD=0.1785 PS=1.035 PD=1.69
M$7862 A|X \$1198 VGND VGND sky130_fd_pr__nfet_01v8 L=0.15 W=0.65 AS=0.169
+ AD=0.1165 PS=1.82 PD=1.035
M$7863 \$1201 A2|B|C|X \$1198 VGND sky130_fd_pr__nfet_01v8 L=0.15 W=0.64
+ AS=0.1728 AD=0.0928 PS=1.82 PD=0.93
M$7864 \$1198 \$1199 \$1200 VGND sky130_fd_pr__nfet_01v8 L=0.15 W=0.64
+ AS=0.0928 AD=0.224 PS=0.93 PD=1.98
M$7865 VGND A2|A2_N|B|D|X \$1202 VGND sky130_fd_pr__nfet_01v8 L=0.15 W=0.65
+ AS=0.1885 AD=0.16515 PS=1.88 PD=1.82
M$7866 \$1203 A2|A2_N|B|D|X \$1200 VGND sky130_fd_pr__nfet_01v8 L=0.15 W=0.64
+ AS=0.16275 AD=0.18205 PS=1.8 PD=1.245
M$7867 \$1200 \$1202 \$1204 VGND sky130_fd_pr__nfet_01v8 L=0.15 W=0.42
+ AS=0.18205 AD=0.19265 PS=1.245 PD=1.285
M$7868 \$1204 A2|A2_N|B|D|X \$1201 VGND sky130_fd_pr__nfet_01v8 L=0.15 W=0.64
+ AS=0.19265 AD=0.140825 PS=1.285 PD=1.1
M$7869 \$1201 \$1202 \$1203 VGND sky130_fd_pr__nfet_01v8 L=0.15 W=0.6
+ AS=0.140825 AD=0.11 PS=1.1 PD=0.99
M$7870 \$1203 A|Y VGND VGND sky130_fd_pr__nfet_01v8 L=0.15 W=0.64 AS=0.11
+ AD=0.0864 PS=0.99 PD=0.91
M$7871 VGND \$1203 \$1204 VGND sky130_fd_pr__nfet_01v8 L=0.15 W=0.64 AS=0.0864
+ AD=0.1824 PS=0.91 PD=1.85
M$7875 A|B1|C|Y \$1275 \$1416 VGND sky130_fd_pr__nfet_01v8 L=0.15 W=0.65
+ AS=0.2275 AD=0.12675 PS=2 PD=1.04
M$7876 \$1416 A3|B|X \$1415 VGND sky130_fd_pr__nfet_01v8 L=0.15 W=0.65
+ AS=0.12675 AD=0.125125 PS=1.04 PD=1.035
M$7877 \$1415 A1|A1_N|C|X \$1413 VGND sky130_fd_pr__nfet_01v8 L=0.15 W=0.65
+ AS=0.125125 AD=0.08775 PS=1.035 PD=0.92
M$7878 \$1413 A2|A2_N|B|D|X VGND VGND sky130_fd_pr__nfet_01v8 L=0.15 W=0.65
+ AS=0.08775 AD=0.118125 PS=0.92 PD=1.04
M$7879 VGND A|A1|A_N|B1|X \$1275 VGND sky130_fd_pr__nfet_01v8 L=0.15 W=0.42
+ AS=0.118125 AD=0.1113 PS=1.04 PD=1.37
M$7880 VGND A1|A1_N|C|X \$1239 VGND sky130_fd_pr__nfet_01v8 L=0.15 W=0.65
+ AS=0.17875 AD=0.06825 PS=1.85 PD=0.86
M$7881 \$1239 A2|A2_N|B|D|X \$1205 VGND sky130_fd_pr__nfet_01v8 L=0.15 W=0.65
+ AS=0.06825 AD=0.2405 PS=0.86 PD=2.04
M$7882 B2|D|Y \$1205 \$1231 VGND sky130_fd_pr__nfet_01v8 L=0.15 W=0.65 AS=0.169
+ AD=0.08775 PS=1.82 PD=0.92
M$7883 \$1231 B2|Y VGND VGND sky130_fd_pr__nfet_01v8 L=0.15 W=0.65 AS=0.08775
+ AD=0.08775 PS=0.92 PD=0.92
M$7884 VGND A|A1|A_N|B1|X \$1231 VGND sky130_fd_pr__nfet_01v8 L=0.15 W=0.65
+ AS=0.08775 AD=0.169 PS=0.92 PD=1.82
M$7886 VGND B|B1|SLEEP|Y \$1277 VGND sky130_fd_pr__nfet_01v8 L=0.15 W=0.42
+ AS=0.10025 AD=0.0567 PS=0.985 PD=0.69
M$7887 \$1277 A|B|C1|X VGND VGND sky130_fd_pr__nfet_01v8 L=0.15 W=0.42
+ AS=0.0567 AD=0.1092 PS=0.69 PD=1.36
M$7888 A3|B|X \$1277 VGND VGND sky130_fd_pr__nfet_01v8 L=0.15 W=0.65 AS=0.169
+ AD=0.10025 PS=1.82 PD=0.985
M$7889 VGND B|B1|SLEEP|Y B2|Y VGND sky130_fd_pr__nfet_01v8 L=0.15 W=0.65
+ AS=0.169 AD=0.08775 PS=1.82 PD=0.92
M$7890 B2|Y A|B|C1|X VGND VGND sky130_fd_pr__nfet_01v8 L=0.15 W=0.65 AS=0.08775
+ AD=0.169 PS=0.92 PD=1.82
M$7893 \$1279 A0|Y B|B1|SLEEP|Y VGND sky130_fd_pr__nfet_01v8 L=0.15 W=0.65
+ AS=0.169 AD=0.08775 PS=1.82 PD=0.92
M$7894 B|B1|SLEEP|Y A1|B|Y \$1281 VGND sky130_fd_pr__nfet_01v8 L=0.15 W=0.65
+ AS=0.08775 AD=0.182 PS=0.92 PD=1.86
M$7895 \$1279 \$1282 VGND VGND sky130_fd_pr__nfet_01v8 L=0.15 W=0.65 AS=0.169
+ AD=0.08775 PS=1.82 PD=0.92
M$7896 VGND A|S|X \$1281 VGND sky130_fd_pr__nfet_01v8 L=0.15 W=0.65 AS=0.08775
+ AD=0.169 PS=0.92 PD=1.82
M$7897 VGND A|X A0|Y VGND sky130_fd_pr__nfet_01v8 L=0.15 W=0.65 AS=0.169
+ AD=0.08775 PS=1.82 PD=0.92
M$7898 A0|Y A3|B|Y VGND VGND sky130_fd_pr__nfet_01v8 L=0.15 W=0.65 AS=0.08775
+ AD=0.169 PS=0.92 PD=1.82
M$7899 \$1282 A|S|X VGND VGND sky130_fd_pr__nfet_01v8 L=0.15 W=0.65 AS=0.169
+ AD=0.169 PS=1.82 PD=1.82
M$7900 A3|B|Y \$1208 \$1232 VGND sky130_fd_pr__nfet_01v8 L=0.15 W=0.65 AS=0.195
+ AD=0.08775 PS=1.9 PD=0.92
M$7901 \$1232 B|Y VGND VGND sky130_fd_pr__nfet_01v8 L=0.15 W=0.65 AS=0.08775
+ AD=0.169 PS=0.92 PD=1.82
M$7902 VGND A|B1|Y A1|B|Y VGND sky130_fd_pr__nfet_01v8 L=0.15 W=0.65 AS=0.1755
+ AD=0.105625 PS=1.84 PD=0.975
M$7903 A1|B|Y A1|D|X \$1372 VGND sky130_fd_pr__nfet_01v8 L=0.15 W=0.65
+ AS=0.105625 AD=0.118625 PS=0.975 PD=1.015
M$7904 \$1372 A2|B1|Y \$1369 VGND sky130_fd_pr__nfet_01v8 L=0.15 W=0.65
+ AS=0.118625 AD=0.06825 PS=1.015 PD=0.86
M$7905 \$1369 A3|B|Y VGND VGND sky130_fd_pr__nfet_01v8 L=0.15 W=0.65 AS=0.06825
+ AD=0.169 PS=0.86 PD=1.82
M$7906 \$1232 A|Y VGND VGND sky130_fd_pr__nfet_01v8 L=0.15 W=0.65 AS=0.169
+ AD=0.08775 PS=1.82 PD=0.92
M$7907 VGND A|Y \$1237 VGND sky130_fd_pr__nfet_01v8 L=0.15 W=0.65 AS=0.08775
+ AD=0.06825 PS=0.92 PD=0.86
M$7908 \$1237 B|Y \$1208 VGND sky130_fd_pr__nfet_01v8 L=0.15 W=0.65 AS=0.06825
+ AD=0.169 PS=0.86 PD=1.82
M$7913 \$1020 A|B|B1_N|X VGND VGND sky130_fd_pr__nfet_01v8 L=0.15 W=0.42
+ AS=0.1092 AD=0.1092 PS=1.36 PD=1.36
M$7914 VGND A2|B|C|D|X \$1344 VGND sky130_fd_pr__nfet_01v8 L=0.15 W=0.65
+ AS=0.169 AD=0.08775 PS=1.82 PD=0.92
M$7915 \$1344 A|A1|Y B|Y VGND sky130_fd_pr__nfet_01v8 L=0.15 W=0.65 AS=0.08775
+ AD=0.169 PS=0.92 PD=1.82
M$7916 VGND A2|B1|Y A|A1|B|B1|Y VGND sky130_fd_pr__nfet_01v8 L=0.15 W=0.65
+ AS=0.17225 AD=0.091 PS=1.83 PD=0.93
M$7917 A|A1|B|B1|Y A|A1|Y \$1333 VGND sky130_fd_pr__nfet_01v8 L=0.15 W=0.65
+ AS=0.091 AD=0.095875 PS=0.93 PD=0.945
M$7918 \$1333 A2|B|C|D|X VGND VGND sky130_fd_pr__nfet_01v8 L=0.15 W=0.65
+ AS=0.095875 AD=0.17225 PS=0.945 PD=1.83
M$7922 A2|B1|Y B1|B2|D|X \$1287 VGND sky130_fd_pr__nfet_01v8 L=0.15 W=0.42
+ AS=0.1113 AD=0.0588 PS=1.37 PD=0.7
M$7923 \$1287 A2|B|X VGND VGND sky130_fd_pr__nfet_01v8 L=0.15 W=0.42 AS=0.0588
+ AD=0.0588 PS=0.7 PD=0.7
M$7924 VGND A|A1|Y \$1287 VGND sky130_fd_pr__nfet_01v8 L=0.15 W=0.42 AS=0.0588
+ AD=0.1113 PS=0.7 PD=1.37
M$7925 VGND B1|B2|D|X B2|D|SLEEP|Y VGND sky130_fd_pr__nfet_01v8 L=0.15 W=0.65
+ AS=0.169 AD=0.118625 PS=1.82 PD=1.015
M$7926 B2|D|SLEEP|Y A2|B|B1|C|Y VGND VGND sky130_fd_pr__nfet_01v8 L=0.15 W=0.65
+ AS=0.118625 AD=0.089375 PS=1.015 PD=0.925
M$7927 VGND A2|B|X B2|D|SLEEP|Y VGND sky130_fd_pr__nfet_01v8 L=0.15 W=0.65
+ AS=0.089375 AD=0.08775 PS=0.925 PD=0.92
M$7928 B2|D|SLEEP|Y A|A1|Y VGND VGND sky130_fd_pr__nfet_01v8 L=0.15 W=0.65
+ AS=0.08775 AD=0.169 PS=0.92 PD=1.82
M$7929 VGND \$1210 A2|B|C|D|X VGND sky130_fd_pr__nfet_01v8 L=0.15 W=0.65
+ AS=0.208 AD=0.25025 PS=1.94 PD=1.42
M$7930 A2|B|C|D|X A2|B|X \$1235 VGND sky130_fd_pr__nfet_01v8 L=0.15 W=0.65
+ AS=0.25025 AD=0.08775 PS=1.42 PD=0.92
M$7931 \$1235 A|A1|Y VGND VGND sky130_fd_pr__nfet_01v8 L=0.15 W=0.65 AS=0.08775
+ AD=0.08775 PS=0.92 PD=0.92
M$7932 VGND A|A1|Y \$1210 VGND sky130_fd_pr__nfet_01v8 L=0.15 W=0.65 AS=0.08775
+ AD=0.08775 PS=0.92 PD=0.92
M$7933 \$1210 A2|B|X VGND VGND sky130_fd_pr__nfet_01v8 L=0.15 W=0.65 AS=0.08775
+ AD=0.169 PS=0.92 PD=1.82
M$7936 VGND B1|Y A|Y VGND sky130_fd_pr__nfet_01v8 L=0.15 W=2.6 AS=0.5265
+ AD=0.5265 PS=5.52 PD=5.52
M$7937 A|Y A|A1|B1|C_N|X \$1557 VGND sky130_fd_pr__nfet_01v8 L=0.15 W=0.65
+ AS=0.091 AD=0.095875 PS=0.93 PD=0.945
M$7938 \$1557 A2|Y VGND VGND sky130_fd_pr__nfet_01v8 L=0.15 W=0.65 AS=0.095875
+ AD=0.17225 PS=0.945 PD=1.83
M$7939 VGND A|A2|B|X \$1559 VGND sky130_fd_pr__nfet_01v8 L=0.15 W=0.65 AS=0.169
+ AD=0.08775 PS=1.82 PD=0.92
M$7940 \$1559 A|A1|Y A2|Y VGND sky130_fd_pr__nfet_01v8 L=0.15 W=0.65 AS=0.08775
+ AD=0.169 PS=0.92 PD=1.82
M$7941 A3|B|X \$1453 VGND VGND sky130_fd_pr__nfet_01v8 L=0.15 W=0.65 AS=0.169
+ AD=0.10025 PS=1.82 PD=0.985
M$7942 VGND A|A2|SLEEP|X \$1453 VGND sky130_fd_pr__nfet_01v8 L=0.15 W=0.42
+ AS=0.10025 AD=0.0567 PS=0.985 PD=0.69
M$7943 \$1453 A|A3|B|Y VGND VGND sky130_fd_pr__nfet_01v8 L=0.15 W=0.42
+ AS=0.0567 AD=0.1092 PS=0.69 PD=1.36
M$7944 VGND A3|A_N|B|C|X \$1455 VGND sky130_fd_pr__nfet_01v8 L=0.15 W=0.42
+ AS=0.1165 AD=0.1785 PS=1.035 PD=1.69
M$7945 A1|A2|X \$1454 VGND VGND sky130_fd_pr__nfet_01v8 L=0.15 W=0.65 AS=0.169
+ AD=0.1165 PS=1.82 PD=1.035
M$7946 \$1457 A3|A_N|B|C|X \$1454 VGND sky130_fd_pr__nfet_01v8 L=0.15 W=0.64
+ AS=0.1728 AD=0.0928 PS=1.82 PD=0.93
M$7947 \$1454 \$1455 \$1456 VGND sky130_fd_pr__nfet_01v8 L=0.15 W=0.64
+ AS=0.0928 AD=0.224 PS=0.93 PD=1.98
M$7948 VGND A|B|Y \$1458 VGND sky130_fd_pr__nfet_01v8 L=0.15 W=0.65 AS=0.1885
+ AD=0.16515 PS=1.88 PD=1.82
M$7949 \$1459 A|B|Y \$1456 VGND sky130_fd_pr__nfet_01v8 L=0.15 W=0.64
+ AS=0.16275 AD=0.18205 PS=1.8 PD=1.245
M$7950 \$1456 \$1458 \$1460 VGND sky130_fd_pr__nfet_01v8 L=0.15 W=0.42
+ AS=0.18205 AD=0.19265 PS=1.245 PD=1.285
M$7951 \$1460 A|B|Y \$1457 VGND sky130_fd_pr__nfet_01v8 L=0.15 W=0.64
+ AS=0.19265 AD=0.140825 PS=1.285 PD=1.1
M$7952 \$1457 \$1458 \$1459 VGND sky130_fd_pr__nfet_01v8 L=0.15 W=0.6
+ AS=0.140825 AD=0.11 PS=1.1 PD=0.99
M$7953 \$1459 A|Y VGND VGND sky130_fd_pr__nfet_01v8 L=0.15 W=0.64 AS=0.11
+ AD=0.0864 PS=0.99 PD=0.91
M$7954 VGND \$1459 \$1460 VGND sky130_fd_pr__nfet_01v8 L=0.15 W=0.64 AS=0.0864
+ AD=0.1824 PS=0.91 PD=1.85
M$7955 A|Y \$1462 \$1545 VGND sky130_fd_pr__nfet_01v8 L=0.15 W=0.65 AS=0.195
+ AD=0.08775 PS=1.9 PD=0.92
M$7956 \$1545 B|Y VGND VGND sky130_fd_pr__nfet_01v8 L=0.15 W=0.65 AS=0.08775
+ AD=0.169 PS=0.92 PD=1.82
M$7957 \$1545 A|X VGND VGND sky130_fd_pr__nfet_01v8 L=0.15 W=0.65 AS=0.169
+ AD=0.08775 PS=1.82 PD=0.92
M$7958 VGND A|X \$1560 VGND sky130_fd_pr__nfet_01v8 L=0.15 W=0.65 AS=0.08775
+ AD=0.06825 PS=0.92 PD=0.86
M$7959 \$1560 B|Y \$1462 VGND sky130_fd_pr__nfet_01v8 L=0.15 W=0.65 AS=0.06825
+ AD=0.169 PS=0.86 PD=1.82
M$7960 VGND B|C|X \$1464 VGND sky130_fd_pr__nfet_01v8 L=0.15 W=0.42 AS=0.1165
+ AD=0.1785 PS=1.035 PD=1.69
M$7961 A|X \$1463 VGND VGND sky130_fd_pr__nfet_01v8 L=0.15 W=0.65 AS=0.169
+ AD=0.1165 PS=1.82 PD=1.035
M$7962 \$1466 B|C|X \$1463 VGND sky130_fd_pr__nfet_01v8 L=0.15 W=0.64 AS=0.1728
+ AD=0.0928 PS=1.82 PD=0.93
M$7963 \$1463 \$1464 \$1465 VGND sky130_fd_pr__nfet_01v8 L=0.15 W=0.64
+ AS=0.0928 AD=0.224 PS=0.93 PD=1.98
M$7964 VGND B|C|Y \$1467 VGND sky130_fd_pr__nfet_01v8 L=0.15 W=0.65 AS=0.1885
+ AD=0.16515 PS=1.88 PD=1.82
M$7965 \$1468 B|C|Y \$1465 VGND sky130_fd_pr__nfet_01v8 L=0.15 W=0.64
+ AS=0.16275 AD=0.18205 PS=1.8 PD=1.245
M$7966 \$1465 \$1467 \$1469 VGND sky130_fd_pr__nfet_01v8 L=0.15 W=0.42
+ AS=0.18205 AD=0.19265 PS=1.245 PD=1.285
M$7967 \$1469 B|C|Y \$1466 VGND sky130_fd_pr__nfet_01v8 L=0.15 W=0.64
+ AS=0.19265 AD=0.140825 PS=1.285 PD=1.1
M$7968 \$1466 \$1467 \$1468 VGND sky130_fd_pr__nfet_01v8 L=0.15 W=0.6
+ AS=0.140825 AD=0.11 PS=1.1 PD=0.99
M$7969 \$1468 A|X VGND VGND sky130_fd_pr__nfet_01v8 L=0.15 W=0.64 AS=0.11
+ AD=0.0864 PS=0.99 PD=0.91
M$7970 VGND \$1468 \$1469 VGND sky130_fd_pr__nfet_01v8 L=0.15 W=0.64 AS=0.0864
+ AD=0.1824 PS=0.91 PD=1.85
M$7971 VGND \$1512 A|X VGND sky130_fd_pr__nfet_01v8 L=0.15 W=0.65 AS=0.208
+ AD=0.25025 PS=1.94 PD=1.42
M$7972 A|X B|C|Y \$1563 VGND sky130_fd_pr__nfet_01v8 L=0.15 W=0.65 AS=0.25025
+ AD=0.08775 PS=1.42 PD=0.92
M$7973 \$1563 A|X VGND VGND sky130_fd_pr__nfet_01v8 L=0.15 W=0.65 AS=0.08775
+ AD=0.08775 PS=0.92 PD=0.92
M$7974 VGND A|X \$1512 VGND sky130_fd_pr__nfet_01v8 L=0.15 W=0.65 AS=0.08775
+ AD=0.08775 PS=0.92 PD=0.92
M$7975 \$1512 B|C|Y VGND VGND sky130_fd_pr__nfet_01v8 L=0.15 W=0.65 AS=0.08775
+ AD=0.169 PS=0.92 PD=1.82
M$7976 B|SLEEP|X \$1472 VGND VGND sky130_fd_pr__nfet_01v8 L=0.15 W=0.65
+ AS=0.23725 AD=0.1474 PS=2.03 PD=1.215
M$7977 VGND B|C|Y \$1564 VGND sky130_fd_pr__nfet_01v8 L=0.15 W=0.42 AS=0.1474
+ AD=0.0441 PS=1.215 PD=0.63
M$7978 \$1564 B|C|Y \$1472 VGND sky130_fd_pr__nfet_01v8 L=0.15 W=0.42 AS=0.0441
+ AD=0.0567 PS=0.63 PD=0.69
M$7979 \$1472 B|C|Y \$1565 VGND sky130_fd_pr__nfet_01v8 L=0.15 W=0.42 AS=0.0567
+ AD=0.0441 PS=0.69 PD=0.63
M$7980 \$1565 A|Y VGND VGND sky130_fd_pr__nfet_01v8 L=0.15 W=0.42 AS=0.0441
+ AD=0.0567 PS=0.63 PD=0.69
M$7981 VGND A|Y \$1566 VGND sky130_fd_pr__nfet_01v8 L=0.15 W=0.42 AS=0.0567
+ AD=0.0441 PS=0.69 PD=0.63
M$7982 \$1566 B|C|Y \$1472 VGND sky130_fd_pr__nfet_01v8 L=0.15 W=0.42 AS=0.0441
+ AD=0.1092 PS=0.63 PD=1.36
M$7983 \$1256 B|C|Y \$1253 VGND sky130_fd_pr__nfet_01v8 L=0.15 W=0.64 AS=0.1728
+ AD=0.128 PS=1.82 PD=1.04
M$7984 \$1253 \$1255 \$1257 VGND sky130_fd_pr__nfet_01v8 L=0.15 W=0.64 AS=0.128
+ AD=0.3168 PS=1.04 PD=2.27
M$7987 A|Y \$1475 \$1546 VGND sky130_fd_pr__nfet_01v8 L=0.15 W=0.65 AS=0.195
+ AD=0.08775 PS=1.9 PD=0.92
M$7988 \$1546 B|B2|Y VGND VGND sky130_fd_pr__nfet_01v8 L=0.15 W=0.65 AS=0.08775
+ AD=0.169 PS=0.92 PD=1.82
M$7989 \$1546 A|B1|X VGND VGND sky130_fd_pr__nfet_01v8 L=0.15 W=0.65 AS=0.169
+ AD=0.08775 PS=1.82 PD=0.92
M$7990 VGND A|B1|X \$1567 VGND sky130_fd_pr__nfet_01v8 L=0.15 W=0.65 AS=0.08775
+ AD=0.06825 PS=0.92 PD=0.86
M$7991 \$1567 B|B2|Y \$1475 VGND sky130_fd_pr__nfet_01v8 L=0.15 W=0.65
+ AS=0.06825 AD=0.169 PS=0.86 PD=1.82
M$7992 VGND B|B2|Y \$1571 VGND sky130_fd_pr__nfet_01v8 L=0.15 W=0.65 AS=0.169
+ AD=0.07475 PS=1.82 PD=0.88
M$7993 \$1571 A|B1|X B|Y VGND sky130_fd_pr__nfet_01v8 L=0.15 W=0.65 AS=0.07475
+ AD=0.169 PS=0.88 PD=1.82
M$7994 B|Y A|A1|X \$1572 VGND sky130_fd_pr__nfet_01v8 L=0.15 W=0.65 AS=0.169
+ AD=0.06825 PS=1.82 PD=0.86
M$7995 \$1572 A2|B|C|X VGND VGND sky130_fd_pr__nfet_01v8 L=0.15 W=0.65
+ AS=0.06825 AD=0.234 PS=0.86 PD=2.02
M$7996 VGND A2|B|C|X \$1481 VGND sky130_fd_pr__nfet_01v8 L=0.15 W=0.42
+ AS=0.144125 AD=0.1764 PS=1.12 PD=1.68
M$7997 A|B1|X \$1480 VGND VGND sky130_fd_pr__nfet_01v8 L=0.15 W=0.65 AS=0.169
+ AD=0.144125 PS=1.82 PD=1.12
M$7998 \$1483 A2|B|C|X \$1480 VGND sky130_fd_pr__nfet_01v8 L=0.15 W=0.64
+ AS=0.1728 AD=0.128 PS=1.82 PD=1.04
M$7999 \$1480 \$1481 \$1482 VGND sky130_fd_pr__nfet_01v8 L=0.15 W=0.64 AS=0.128
+ AD=0.3168 PS=1.04 PD=2.27
M$8000 VGND A2|B|Y \$1484 VGND sky130_fd_pr__nfet_01v8 L=0.15 W=0.65 AS=0.195
+ AD=0.1653 PS=1.9 PD=1.82
M$8001 \$1485 A2|B|Y \$1483 VGND sky130_fd_pr__nfet_01v8 L=0.15 W=0.64
+ AS=0.1628 AD=0.18365 PS=1.8 PD=1.25
M$8002 \$1483 \$1484 \$1486 VGND sky130_fd_pr__nfet_01v8 L=0.15 W=0.42
+ AS=0.18365 AD=0.19265 PS=1.25 PD=1.285
M$8003 \$1486 A2|B|Y \$1482 VGND sky130_fd_pr__nfet_01v8 L=0.15 W=0.64
+ AS=0.19265 AD=0.140825 PS=1.285 PD=1.1
M$8004 \$1482 \$1484 \$1485 VGND sky130_fd_pr__nfet_01v8 L=0.15 W=0.6
+ AS=0.140825 AD=0.11 PS=1.1 PD=0.99
M$8005 \$1485 A|A1|X VGND VGND sky130_fd_pr__nfet_01v8 L=0.15 W=0.64 AS=0.11
+ AD=0.0864 PS=0.99 PD=0.91
M$8006 VGND \$1485 \$1486 VGND sky130_fd_pr__nfet_01v8 L=0.15 W=0.64 AS=0.0864
+ AD=0.1824 PS=0.91 PD=1.85
M$8007 B|X \$1487 VGND VGND sky130_fd_pr__nfet_01v8 L=0.15 W=0.65 AS=0.234
+ AD=0.12675 PS=2.02 PD=1.04
M$8008 VGND A|A1|X \$1548 VGND sky130_fd_pr__nfet_01v8 L=0.15 W=0.65 AS=0.12675
+ AD=0.08775 PS=1.04 PD=0.92
M$8009 \$1548 A2|B|Y VGND VGND sky130_fd_pr__nfet_01v8 L=0.15 W=0.65 AS=0.08775
+ AD=0.10725 PS=0.92 PD=0.98
M$8010 VGND A|A3|B|Y \$1548 VGND sky130_fd_pr__nfet_01v8 L=0.15 W=0.65
+ AS=0.10725 AD=0.10725 PS=0.98 PD=0.98
M$8011 \$1548 A|B1|Y \$1487 VGND sky130_fd_pr__nfet_01v8 L=0.15 W=0.65
+ AS=0.10725 AD=0.2015 PS=0.98 PD=1.92
M$8012 \$1266 A_N|C|Y \$1264 VGND sky130_fd_pr__nfet_01v8 L=0.15 W=0.64
+ AS=0.1728 AD=0.128 PS=1.82 PD=1.04
M$8013 \$1264 \$1265 \$1267 VGND sky130_fd_pr__nfet_01v8 L=0.15 W=0.64 AS=0.128
+ AD=0.3168 PS=1.04 PD=2.27
M$8014 VGND B|SLEEP|Y \$1575 VGND sky130_fd_pr__nfet_01v8 L=0.15 W=0.65
+ AS=0.169 AD=0.08775 PS=1.82 PD=0.92
M$8015 \$1575 A|Y D|Y VGND sky130_fd_pr__nfet_01v8 L=0.15 W=0.65 AS=0.08775
+ AD=0.169 PS=0.92 PD=1.82
M$8016 B|X \$1490 VGND VGND sky130_fd_pr__nfet_01v8 L=0.15 W=0.65 AS=0.23725
+ AD=0.1474 PS=2.03 PD=1.215
M$8017 VGND A_N|C|Y \$1578 VGND sky130_fd_pr__nfet_01v8 L=0.15 W=0.42 AS=0.1474
+ AD=0.0441 PS=1.215 PD=0.63
M$8018 \$1578 B|SLEEP|Y \$1490 VGND sky130_fd_pr__nfet_01v8 L=0.15 W=0.42
+ AS=0.0441 AD=0.0567 PS=0.63 PD=0.69
M$8019 \$1490 B|SLEEP|Y \$1577 VGND sky130_fd_pr__nfet_01v8 L=0.15 W=0.42
+ AS=0.0567 AD=0.0441 PS=0.69 PD=0.63
M$8020 \$1577 A|Y VGND VGND sky130_fd_pr__nfet_01v8 L=0.15 W=0.42 AS=0.0441
+ AD=0.0567 PS=0.63 PD=0.69
M$8021 VGND A|Y \$1579 VGND sky130_fd_pr__nfet_01v8 L=0.15 W=0.42 AS=0.0567
+ AD=0.0441 PS=0.69 PD=0.63
M$8022 \$1579 A_N|C|Y \$1490 VGND sky130_fd_pr__nfet_01v8 L=0.15 W=0.42
+ AS=0.0441 AD=0.1092 PS=0.63 PD=1.36
M$8023 \$1549 A1|X VGND VGND sky130_fd_pr__nfet_01v8 L=0.15 W=0.65 AS=0.17225
+ AD=0.12675 PS=1.83 PD=1.04
M$8024 VGND A2|X \$1549 VGND sky130_fd_pr__nfet_01v8 L=0.15 W=0.65 AS=0.12675
+ AD=0.12675 PS=1.04 PD=1.04
M$8025 \$1549 A|A1|B1|Y \$1582 VGND sky130_fd_pr__nfet_01v8 L=0.15 W=0.65
+ AS=0.12675 AD=0.06825 PS=1.04 PD=0.86
M$8026 \$1582 A|B|C1|Y A|B|B1|B_N|Y VGND sky130_fd_pr__nfet_01v8 L=0.15 W=0.65
+ AS=0.06825 AD=0.39325 PS=0.86 PD=2.51
M$8027 A2|X \$1499 VGND VGND sky130_fd_pr__nfet_01v8 L=0.15 W=0.65 AS=0.169
+ AD=0.10075 PS=1.82 PD=0.96
M$8028 VGND A2|B|C|X \$1583 VGND sky130_fd_pr__nfet_01v8 L=0.15 W=0.65
+ AS=0.10075 AD=0.11375 PS=0.96 PD=1
M$8029 \$1583 A|A1|Y \$1499 VGND sky130_fd_pr__nfet_01v8 L=0.15 W=0.65
+ AS=0.11375 AD=0.169 PS=1 PD=1.82
M$8030 \$1499 A|B1|C|Y \$1584 VGND sky130_fd_pr__nfet_01v8 L=0.15 W=0.65
+ AS=0.169 AD=0.07475 PS=1.82 PD=0.88
M$8031 \$1584 B2|D|Y VGND VGND sky130_fd_pr__nfet_01v8 L=0.15 W=0.65 AS=0.07475
+ AD=0.169 PS=0.88 PD=1.82
M$8032 A|B|C1|Y A|A1|Y \$1585 VGND sky130_fd_pr__nfet_01v8 L=0.15 W=0.65
+ AS=0.195 AD=0.10725 PS=1.9 PD=0.98
M$8033 \$1585 A2|B|C|X \$1586 VGND sky130_fd_pr__nfet_01v8 L=0.15 W=0.65
+ AS=0.10725 AD=0.08775 PS=0.98 PD=0.92
M$8034 \$1586 A|B1|C|Y \$1587 VGND sky130_fd_pr__nfet_01v8 L=0.15 W=0.65
+ AS=0.08775 AD=0.08775 PS=0.92 PD=0.92
M$8035 \$1587 B2|D|Y VGND VGND sky130_fd_pr__nfet_01v8 L=0.15 W=0.65 AS=0.08775
+ AD=0.169 PS=0.92 PD=1.82
M$8036 VGND A|A1|A_N|B1|X A|Y VGND sky130_fd_pr__nfet_01v8 L=0.15 W=0.65
+ AS=0.1755 AD=0.105625 PS=1.84 PD=0.975
M$8037 A|Y A1|A1_N|C|X \$1588 VGND sky130_fd_pr__nfet_01v8 L=0.15 W=0.65
+ AS=0.105625 AD=0.118625 PS=0.975 PD=1.015
M$8038 \$1588 A2|A2_N|B|D|X \$1589 VGND sky130_fd_pr__nfet_01v8 L=0.15 W=0.65
+ AS=0.118625 AD=0.06825 PS=1.015 PD=0.86
M$8039 \$1589 A3|B|X VGND VGND sky130_fd_pr__nfet_01v8 L=0.15 W=0.65 AS=0.06825
+ AD=0.169 PS=0.86 PD=1.82
M$8040 A|S|X \$1502 VGND VGND sky130_fd_pr__nfet_01v8 L=0.15 W=0.65 AS=0.169
+ AD=0.169 PS=1.82 PD=1.82
M$8041 \$1502 A|A_N|B1|Y \$1550 VGND sky130_fd_pr__nfet_01v8 L=0.15 W=0.65
+ AS=0.169 AD=0.10075 PS=1.82 PD=0.96
M$8042 \$1550 A2|B1|Y VGND VGND sky130_fd_pr__nfet_01v8 L=0.15 W=0.65
+ AS=0.10075 AD=0.08775 PS=0.96 PD=0.92
M$8043 VGND A|A1|B|C1|X \$1550 VGND sky130_fd_pr__nfet_01v8 L=0.15 W=0.65
+ AS=0.08775 AD=0.169 PS=0.92 PD=1.82
M$8044 A|A_N|B1|Y A|A1|B|C1|X \$1580 VGND sky130_fd_pr__nfet_01v8 L=0.15 W=0.65
+ AS=0.39325 AD=0.06825 PS=2.51 PD=0.86
M$8045 \$1580 A2|B1|Y \$1551 VGND sky130_fd_pr__nfet_01v8 L=0.15 W=0.65
+ AS=0.06825 AD=0.12675 PS=0.86 PD=1.04
M$8046 \$1551 A2|B1|SLEEP|Y VGND VGND sky130_fd_pr__nfet_01v8 L=0.15 W=0.65
+ AS=0.12675 AD=0.12675 PS=1.04 PD=1.04
M$8047 VGND A|A1|B|B1|Y \$1551 VGND sky130_fd_pr__nfet_01v8 L=0.15 W=0.65
+ AS=0.12675 AD=0.17225 PS=1.04 PD=1.83
M$8048 A2|B1|SLEEP|Y A|B|B1_N|X \$1574 VGND sky130_fd_pr__nfet_01v8 L=0.15
+ W=0.65 AS=0.195 AD=0.10725 PS=1.9 PD=0.98
M$8049 \$1574 B|Y \$1573 VGND sky130_fd_pr__nfet_01v8 L=0.15 W=0.65 AS=0.10725
+ AD=0.08775 PS=0.98 PD=0.92
M$8050 \$1573 C|Y \$1570 VGND sky130_fd_pr__nfet_01v8 L=0.15 W=0.65 AS=0.08775
+ AD=0.08775 PS=0.92 PD=0.92
M$8051 \$1570 A1|D|X VGND VGND sky130_fd_pr__nfet_01v8 L=0.15 W=0.65 AS=0.08775
+ AD=0.169 PS=0.92 PD=1.82
M$8052 C|Y A|A1|B|X \$1562 VGND sky130_fd_pr__nfet_01v8 L=0.15 W=0.65 AS=0.169
+ AD=0.08775 PS=1.82 PD=0.92
M$8053 \$1562 A2|B|Y VGND VGND sky130_fd_pr__nfet_01v8 L=0.15 W=0.65 AS=0.08775
+ AD=0.169 PS=0.92 PD=1.82
M$8054 A1|D|X \$1522 VGND VGND sky130_fd_pr__nfet_01v8 L=0.15 W=0.65 AS=0.169
+ AD=0.10025 PS=1.82 PD=0.985
M$8055 VGND B2|D|SLEEP|Y \$1522 VGND sky130_fd_pr__nfet_01v8 L=0.15 W=0.42
+ AS=0.10025 AD=0.0567 PS=0.985 PD=0.69
M$8056 \$1522 A|B1|C|X VGND VGND sky130_fd_pr__nfet_01v8 L=0.15 W=0.42
+ AS=0.0567 AD=0.1092 PS=0.69 PD=1.36
M$8057 A|B1|C|X \$1503 VGND VGND sky130_fd_pr__nfet_01v8 L=0.15 W=0.65 AS=0.169
+ AD=0.169 PS=1.82 PD=1.82
M$8058 \$1552 A2|B|B1|C|Y \$1503 VGND sky130_fd_pr__nfet_01v8 L=0.15 W=0.65
+ AS=0.169 AD=0.08775 PS=1.82 PD=0.92
M$8059 \$1503 B1|B2|D|X \$1552 VGND sky130_fd_pr__nfet_01v8 L=0.15 W=0.65
+ AS=0.08775 AD=0.11375 PS=0.92 PD=1
M$8060 \$1552 A2|B|X VGND VGND sky130_fd_pr__nfet_01v8 L=0.15 W=0.65 AS=0.11375
+ AD=0.08775 PS=1 PD=0.92
M$8061 VGND A|A1|Y \$1552 VGND sky130_fd_pr__nfet_01v8 L=0.15 W=0.65 AS=0.08775
+ AD=0.169 PS=0.92 PD=1.82
M$8062 A2|B|Y \$1504 \$1553 VGND sky130_fd_pr__nfet_01v8 L=0.15 W=0.65 AS=0.195
+ AD=0.08775 PS=1.9 PD=0.92
M$8063 \$1553 A2|B|X VGND VGND sky130_fd_pr__nfet_01v8 L=0.15 W=0.65 AS=0.08775
+ AD=0.169 PS=0.92 PD=1.82
M$8064 \$1553 A|A1|Y VGND VGND sky130_fd_pr__nfet_01v8 L=0.15 W=0.65 AS=0.169
+ AD=0.08775 PS=1.82 PD=0.92
M$8065 VGND A|A1|Y \$1556 VGND sky130_fd_pr__nfet_01v8 L=0.15 W=0.65 AS=0.08775
+ AD=0.06825 PS=0.92 PD=0.86
M$8066 \$1556 A2|B|X \$1504 VGND sky130_fd_pr__nfet_01v8 L=0.15 W=0.65
+ AS=0.06825 AD=0.169 PS=0.86 PD=1.82
M$8081 VGND \$1592 B|C|X VGND sky130_fd_pr__nfet_01v8 L=0.15 W=0.65 AS=0.208
+ AD=0.25025 PS=1.94 PD=1.42
M$8082 B|C|X A|A3|B|Y \$1652 VGND sky130_fd_pr__nfet_01v8 L=0.15 W=0.65
+ AS=0.25025 AD=0.08775 PS=1.42 PD=0.92
M$8083 \$1652 A|Y VGND VGND sky130_fd_pr__nfet_01v8 L=0.15 W=0.65 AS=0.08775
+ AD=0.08775 PS=0.92 PD=0.92
M$8084 VGND A|Y \$1592 VGND sky130_fd_pr__nfet_01v8 L=0.15 W=0.65 AS=0.08775
+ AD=0.08775 PS=0.92 PD=0.92
M$8085 \$1592 A|A3|B|Y VGND VGND sky130_fd_pr__nfet_01v8 L=0.15 W=0.65
+ AS=0.08775 AD=0.169 PS=0.92 PD=1.82
M$8086 A1|B|Y \$1593 \$1594 VGND sky130_fd_pr__nfet_01v8 L=0.15 W=0.65 AS=0.195
+ AD=0.08775 PS=1.9 PD=0.92
M$8087 \$1594 A|A2|B|X VGND VGND sky130_fd_pr__nfet_01v8 L=0.15 W=0.65
+ AS=0.08775 AD=0.169 PS=0.92 PD=1.82
M$8088 \$1594 A|A1|Y VGND VGND sky130_fd_pr__nfet_01v8 L=0.15 W=0.65 AS=0.169
+ AD=0.08775 PS=1.82 PD=0.92
M$8089 VGND A|A1|Y \$1660 VGND sky130_fd_pr__nfet_01v8 L=0.15 W=0.65 AS=0.08775
+ AD=0.06825 PS=0.92 PD=0.86
M$8090 \$1660 A|A2|B|X \$1593 VGND sky130_fd_pr__nfet_01v8 L=0.15 W=0.65
+ AS=0.06825 AD=0.169 PS=0.86 PD=1.82
M$8093 VGND A3|B|X B|Y VGND sky130_fd_pr__nfet_01v8 L=0.15 W=0.65 AS=0.169
+ AD=0.08775 PS=1.82 PD=0.92
M$8094 B|Y A|A2|B|X VGND VGND sky130_fd_pr__nfet_01v8 L=0.15 W=0.65 AS=0.08775
+ AD=0.169 PS=0.92 PD=1.82
M$8095 VGND B|Y \$1672 VGND sky130_fd_pr__nfet_01v8 L=0.15 W=0.65 AS=0.169
+ AD=0.08775 PS=1.82 PD=0.92
M$8096 \$1672 A|A0|X B|Y VGND sky130_fd_pr__nfet_01v8 L=0.15 W=0.65 AS=0.08775
+ AD=0.169 PS=0.92 PD=1.82
M$8100 A|X \$1597 VGND VGND sky130_fd_pr__nfet_01v8 L=0.15 W=0.65 AS=0.169
+ AD=0.1165 PS=1.82 PD=1.035
M$8101 VGND A|C|X \$1598 VGND sky130_fd_pr__nfet_01v8 L=0.15 W=0.42 AS=0.1165
+ AD=0.1785 PS=1.035 PD=1.69
M$8103 VGND B|Y \$1601 VGND sky130_fd_pr__nfet_01v8 L=0.15 W=0.65 AS=0.1885
+ AD=0.16515 PS=1.88 PD=1.82
M$8104 \$1600 \$1601 \$1603 VGND sky130_fd_pr__nfet_01v8 L=0.15 W=0.42
+ AS=0.18205 AD=0.19265 PS=1.245 PD=1.285
M$8105 \$1599 \$1601 \$1602 VGND sky130_fd_pr__nfet_01v8 L=0.15 W=0.6
+ AS=0.140825 AD=0.11 PS=1.1 PD=0.99
M$8106 \$1602 A|X VGND VGND sky130_fd_pr__nfet_01v8 L=0.15 W=0.64 AS=0.11
+ AD=0.0864 PS=0.99 PD=0.91
M$8107 VGND \$1602 \$1603 VGND sky130_fd_pr__nfet_01v8 L=0.15 W=0.64 AS=0.0864
+ AD=0.1824 PS=0.91 PD=1.85
M$8108 \$1602 B|Y \$1600 VGND sky130_fd_pr__nfet_01v8 L=0.15 W=0.64 AS=0.16275
+ AD=0.18205 PS=1.8 PD=1.245
M$8109 \$1599 B|Y \$1603 VGND sky130_fd_pr__nfet_01v8 L=0.15 W=0.64 AS=0.140825
+ AD=0.19265 PS=1.1 PD=1.285
M$8111 VGND B|Y A|Y VGND sky130_fd_pr__nfet_01v8 L=0.15 W=4.55 AS=0.77675
+ AD=0.93925 PS=8.24 PD=10.04
M$8119 \$1476 A|B1|X \$1569 VGND sky130_fd_pr__nfet_01v8 L=0.15 W=0.42
+ AS=0.1092 AD=0.0441 PS=1.36 PD=0.63
M$8120 \$1569 B|B2|Y \$1568 VGND sky130_fd_pr__nfet_01v8 L=0.15 W=0.42
+ AS=0.0441 AD=0.0441 PS=0.63 PD=0.63
M$8121 VGND A|C|Y \$1568 VGND sky130_fd_pr__nfet_01v8 L=0.15 W=0.42 AS=0.13165
+ AD=0.0441 PS=1.14 PD=0.63
M$8122 VGND \$1476 A|A1|X VGND sky130_fd_pr__nfet_01v8 L=0.15 W=0.65 AS=0.13165
+ AD=0.169 PS=1.14 PD=1.82
M$8123 A|B|Y \$1605 \$1606 VGND sky130_fd_pr__nfet_01v8 L=0.15 W=0.65 AS=0.195
+ AD=0.08775 PS=1.9 PD=0.92
M$8124 \$1606 B|Y VGND VGND sky130_fd_pr__nfet_01v8 L=0.15 W=0.65 AS=0.08775
+ AD=0.169 PS=0.92 PD=1.82
M$8125 \$1606 A|C|Y VGND VGND sky130_fd_pr__nfet_01v8 L=0.15 W=0.65 AS=0.169
+ AD=0.08775 PS=1.82 PD=0.92
M$8126 VGND A|C|Y \$1715 VGND sky130_fd_pr__nfet_01v8 L=0.15 W=0.65 AS=0.08775
+ AD=0.06825 PS=0.92 PD=0.86
M$8127 \$1715 B|Y \$1605 VGND sky130_fd_pr__nfet_01v8 L=0.15 W=0.65 AS=0.06825
+ AD=0.169 PS=0.86 PD=1.82
M$8129 A|Y A|A1|X \$1721 VGND sky130_fd_pr__nfet_01v8 L=0.15 W=0.65 AS=0.169
+ AD=0.10725 PS=1.82 PD=0.98
M$8130 \$1721 A2|B|C|X \$1723 VGND sky130_fd_pr__nfet_01v8 L=0.15 W=0.65
+ AS=0.10725 AD=0.08775 PS=0.98 PD=0.92
M$8131 \$1723 A|C|Y VGND VGND sky130_fd_pr__nfet_01v8 L=0.15 W=0.65 AS=0.08775
+ AD=0.169 PS=0.92 PD=1.82
M$8133 VGND A|A1|X A|D_N|Y VGND sky130_fd_pr__nfet_01v8 L=0.15 W=0.65 AS=0.169
+ AD=0.08775 PS=1.82 PD=0.92
M$8134 A|D_N|Y A2|B|Y VGND VGND sky130_fd_pr__nfet_01v8 L=0.15 W=0.65
+ AS=0.08775 AD=0.169 PS=0.92 PD=1.82
M$8135 A|C|Y \$1609 \$1610 VGND sky130_fd_pr__nfet_01v8 L=0.15 W=0.65 AS=0.195
+ AD=0.08775 PS=1.9 PD=0.92
M$8136 \$1610 A|A3|B|Y VGND VGND sky130_fd_pr__nfet_01v8 L=0.15 W=0.65
+ AS=0.08775 AD=0.169 PS=0.92 PD=1.82
M$8137 \$1610 A|D_N|Y VGND VGND sky130_fd_pr__nfet_01v8 L=0.15 W=0.65 AS=0.169
+ AD=0.08775 PS=1.82 PD=0.92
M$8138 VGND A|D_N|Y \$1736 VGND sky130_fd_pr__nfet_01v8 L=0.15 W=0.65
+ AS=0.08775 AD=0.06825 PS=0.92 PD=0.86
M$8139 \$1736 A|A3|B|Y \$1609 VGND sky130_fd_pr__nfet_01v8 L=0.15 W=0.65
+ AS=0.06825 AD=0.169 PS=0.86 PD=1.82
M$8142 A|A3|B|Y \$1612 \$1613 VGND sky130_fd_pr__nfet_01v8 L=0.15 W=0.65
+ AS=0.195 AD=0.08775 PS=1.9 PD=0.92
M$8143 \$1613 B|X VGND VGND sky130_fd_pr__nfet_01v8 L=0.15 W=0.65 AS=0.08775
+ AD=0.169 PS=0.92 PD=1.82
M$8144 \$1613 A|B|B1|B_N|Y VGND VGND sky130_fd_pr__nfet_01v8 L=0.15 W=0.65
+ AS=0.169 AD=0.08775 PS=1.82 PD=0.92
M$8145 VGND A|B|B1|B_N|Y \$1742 VGND sky130_fd_pr__nfet_01v8 L=0.15 W=0.65
+ AS=0.08775 AD=0.06825 PS=0.92 PD=0.86
M$8146 \$1742 B|X \$1612 VGND sky130_fd_pr__nfet_01v8 L=0.15 W=0.65 AS=0.06825
+ AD=0.169 PS=0.86 PD=1.82
M$8147 VGND A|B|B1|B_N|Y \$1614 VGND sky130_fd_pr__nfet_01v8 L=0.15 W=0.42
+ AS=0.11975 AD=0.1092 PS=1.045 PD=1.36
M$8148 VGND D|Y \$1745 VGND sky130_fd_pr__nfet_01v8 L=0.15 W=0.65 AS=0.11975
+ AD=0.12675 PS=1.045 PD=1.04
M$8149 \$1745 A|C|C1|X \$1747 VGND sky130_fd_pr__nfet_01v8 L=0.15 W=0.65
+ AS=0.12675 AD=0.11375 PS=1.04 PD=1
M$8150 \$1747 \$1614 \$1748 VGND sky130_fd_pr__nfet_01v8 L=0.15 W=0.65
+ AS=0.11375 AD=0.11375 PS=1 PD=1
M$8151 \$1748 \$1615 A|B1|Y VGND sky130_fd_pr__nfet_01v8 L=0.15 W=0.65
+ AS=0.11375 AD=0.169 PS=1 PD=1.82
M$8152 VGND A_N|C|Y \$1615 VGND sky130_fd_pr__nfet_01v8 L=0.15 W=0.42 AS=0.1092
+ AD=0.1827 PS=1.36 PD=1.71
M$8154 VGND A|Y \$1491 VGND sky130_fd_pr__nfet_01v8 L=0.15 W=0.42 AS=0.1092
+ AD=0.0567 PS=1.36 PD=0.69
M$8155 VGND B|SLEEP|Y \$1491 VGND sky130_fd_pr__nfet_01v8 L=0.15 W=0.42
+ AS=0.10025 AD=0.0567 PS=0.985 PD=0.69
M$8156 VGND \$1491 A|C|C1|X VGND sky130_fd_pr__nfet_01v8 L=0.15 W=0.65
+ AS=0.10025 AD=0.169 PS=0.985 PD=1.82
M$8157 \$1494 A|X \$1581 VGND sky130_fd_pr__nfet_01v8 L=0.15 W=0.42 AS=0.1113
+ AD=0.0441 PS=1.37 PD=0.63
M$8158 \$1581 B|X VGND VGND sky130_fd_pr__nfet_01v8 L=0.15 W=0.42 AS=0.0441
+ AD=0.0966 PS=0.63 PD=0.88
M$8159 VGND \$1494 A1|X VGND sky130_fd_pr__nfet_01v8 L=0.15 W=0.42 AS=0.0966
+ AD=0.1113 PS=0.88 PD=1.37
M$8160 A|A1|B1|Y A|X \$1760 VGND sky130_fd_pr__nfet_01v8 L=0.15 W=0.65 AS=0.195
+ AD=0.10725 PS=1.9 PD=0.98
M$8161 \$1760 B|X \$1761 VGND sky130_fd_pr__nfet_01v8 L=0.15 W=0.65 AS=0.10725
+ AD=0.08775 PS=0.98 PD=0.92
M$8162 \$1761 A|B1|C|Y \$1762 VGND sky130_fd_pr__nfet_01v8 L=0.15 W=0.65
+ AS=0.08775 AD=0.08775 PS=0.92 PD=0.92
M$8163 \$1762 B2|D|Y VGND VGND sky130_fd_pr__nfet_01v8 L=0.15 W=0.65 AS=0.08775
+ AD=0.169 PS=0.92 PD=1.82
M$8172 A|X \$1616 VGND VGND sky130_fd_pr__nfet_01v8 L=0.15 W=0.42 AS=0.1113
+ AD=0.0966 PS=1.37 PD=0.88
M$8173 VGND A1|B|Y \$1728 VGND sky130_fd_pr__nfet_01v8 L=0.15 W=0.42 AS=0.0966
+ AD=0.0441 PS=0.88 PD=0.63
M$8174 \$1728 A|S|X \$1616 VGND sky130_fd_pr__nfet_01v8 L=0.15 W=0.42 AS=0.0441
+ AD=0.1113 PS=0.63 PD=1.37
M$8176 \$1617 A|B|Y \$1719 VGND sky130_fd_pr__nfet_01v8 L=0.15 W=0.65 AS=0.169
+ AD=0.06825 PS=1.82 PD=0.86
M$8177 \$1719 A|A1|C1|Y VGND VGND sky130_fd_pr__nfet_01v8 L=0.15 W=0.65
+ AS=0.06825 AD=0.08775 PS=0.86 PD=0.92
M$8178 VGND A|A1|C1|Y \$1619 VGND sky130_fd_pr__nfet_01v8 L=0.15 W=0.65
+ AS=0.08775 AD=0.169 PS=0.92 PD=1.82
M$8179 VGND A|B|Y \$1619 VGND sky130_fd_pr__nfet_01v8 L=0.15 W=0.65 AS=0.169
+ AD=0.08775 PS=1.82 PD=0.92
M$8180 \$1619 \$1617 A|B|Y VGND sky130_fd_pr__nfet_01v8 L=0.15 W=0.65
+ AS=0.08775 AD=0.195 PS=0.92 PD=1.9
M$8182 A2|B|Y \$1620 \$1621 VGND sky130_fd_pr__nfet_01v8 L=0.15 W=0.65 AS=0.195
+ AD=0.08775 PS=1.9 PD=0.92
M$8183 \$1621 B|Y VGND VGND sky130_fd_pr__nfet_01v8 L=0.15 W=0.65 AS=0.08775
+ AD=0.169 PS=0.92 PD=1.82
M$8184 \$1621 A|A_N|B1|Y VGND VGND sky130_fd_pr__nfet_01v8 L=0.15 W=0.65
+ AS=0.169 AD=0.08775 PS=1.82 PD=0.92
M$8185 VGND A|A_N|B1|Y \$1691 VGND sky130_fd_pr__nfet_01v8 L=0.15 W=0.65
+ AS=0.08775 AD=0.06825 PS=0.92 PD=0.86
M$8186 \$1691 B|Y \$1620 VGND sky130_fd_pr__nfet_01v8 L=0.15 W=0.65 AS=0.06825
+ AD=0.169 PS=0.86 PD=1.82
M$8187 VGND A|A_N|B1|Y \$1622 VGND sky130_fd_pr__nfet_01v8 L=0.15 W=0.42
+ AS=0.10025 AD=0.1092 PS=0.985 PD=1.36
M$8188 VGND B|Y \$1684 VGND sky130_fd_pr__nfet_01v8 L=0.15 W=0.65 AS=0.10025
+ AD=0.08775 PS=0.985 PD=0.92
M$8189 \$1684 \$1622 B1|Y VGND sky130_fd_pr__nfet_01v8 L=0.15 W=0.65 AS=0.08775
+ AD=0.169 PS=0.92 PD=1.82
M$8192 \$1624 A|A1|B|X VGND VGND sky130_fd_pr__nfet_01v8 L=0.15 W=0.65 AS=0.169
+ AD=0.08775 PS=1.82 PD=0.92
M$8193 VGND A2|B|Y \$1624 VGND sky130_fd_pr__nfet_01v8 L=0.15 W=0.65 AS=0.08775
+ AD=0.115375 PS=0.92 PD=1.005
M$8194 \$1624 B2|D|SLEEP|Y A|A1|Y VGND sky130_fd_pr__nfet_01v8 L=0.15 W=0.65
+ AS=0.115375 AD=0.092625 PS=1.005 PD=0.935
M$8195 A|A1|Y A|B1|C|X \$1624 VGND sky130_fd_pr__nfet_01v8 L=0.15 W=0.65
+ AS=0.092625 AD=0.169 PS=0.935 PD=1.82
M$8196 VGND A|A1|B|X \$1625 VGND sky130_fd_pr__nfet_01v8 L=0.15 W=0.42
+ AS=0.101875 AD=0.0567 PS=0.99 PD=0.69
M$8197 \$1625 A2|B|Y VGND VGND sky130_fd_pr__nfet_01v8 L=0.15 W=0.42 AS=0.0567
+ AD=0.0567 PS=0.69 PD=0.69
M$8198 VGND A|B1|C|X \$1625 VGND sky130_fd_pr__nfet_01v8 L=0.15 W=0.42
+ AS=0.0567 AD=0.0693 PS=0.69 PD=0.75
M$8199 \$1625 B2|D|SLEEP|Y VGND VGND sky130_fd_pr__nfet_01v8 L=0.15 W=0.42
+ AS=0.0693 AD=0.1092 PS=0.75 PD=1.36
M$8200 A2|B|X \$1625 VGND VGND sky130_fd_pr__nfet_01v8 L=0.15 W=0.65 AS=0.1755
+ AD=0.101875 PS=1.84 PD=0.99
M$8211 VGND \$1795 A2|B|C|X VGND sky130_fd_pr__nfet_01v8 L=0.15 W=0.65 AS=0.208
+ AD=0.25025 PS=1.94 PD=1.42
M$8212 A2|B|C|X A1|B|Y \$1866 VGND sky130_fd_pr__nfet_01v8 L=0.15 W=0.65
+ AS=0.25025 AD=0.08775 PS=1.42 PD=0.92
M$8213 \$1866 A|A1|B1|C_N|X VGND VGND sky130_fd_pr__nfet_01v8 L=0.15 W=0.65
+ AS=0.08775 AD=0.08775 PS=0.92 PD=0.92
M$8214 VGND A|A1|B1|C_N|X \$1795 VGND sky130_fd_pr__nfet_01v8 L=0.15 W=0.65
+ AS=0.08775 AD=0.08775 PS=0.92 PD=0.92
M$8215 \$1795 A1|B|Y VGND VGND sky130_fd_pr__nfet_01v8 L=0.15 W=0.65 AS=0.08775
+ AD=0.169 PS=0.92 PD=1.82
M$8216 VGND A|A1|B1|C_N|X \$1800 VGND sky130_fd_pr__nfet_01v8 L=0.15 W=0.42
+ AS=0.10025 AD=0.1092 PS=0.985 PD=1.36
M$8217 A|B|Y \$1800 VGND VGND sky130_fd_pr__nfet_01v8 L=0.15 W=0.65 AS=0.221
+ AD=0.08775 PS=1.98 PD=0.92
M$8218 VGND A1|B|Y A|B|Y VGND sky130_fd_pr__nfet_01v8 L=0.15 W=0.65 AS=0.08775
+ AD=0.08775 PS=0.92 PD=0.92
M$8219 A|B|Y A|A3|B|Y VGND VGND sky130_fd_pr__nfet_01v8 L=0.15 W=0.65
+ AS=0.08775 AD=0.10025 PS=0.92 PD=0.985
M$8221 VGND A1|B|Y \$1843 VGND sky130_fd_pr__nfet_01v8 L=0.15 W=0.65 AS=0.169
+ AD=0.08775 PS=1.82 PD=0.92
M$8222 \$1843 A1|A2|X VGND VGND sky130_fd_pr__nfet_01v8 L=0.15 W=0.65
+ AS=0.08775 AD=0.08775 PS=0.92 PD=0.92
M$8223 VGND A3|B|X \$1843 VGND sky130_fd_pr__nfet_01v8 L=0.15 W=0.65 AS=0.08775
+ AD=0.19825 PS=0.92 PD=1.26
M$8224 \$1843 A|A1|B1|C_N|X C|SLEEP|Y VGND sky130_fd_pr__nfet_01v8 L=0.15
+ W=0.65 AS=0.19825 AD=0.221 PS=1.26 PD=1.98
M$8227 VGND B|Y \$1865 VGND sky130_fd_pr__nfet_01v8 L=0.15 W=0.65 AS=0.169
+ AD=0.08775 PS=1.82 PD=0.92
M$8228 \$1865 A|X B|C|Y VGND sky130_fd_pr__nfet_01v8 L=0.15 W=0.65 AS=0.08775
+ AD=0.169 PS=0.92 PD=1.82
M$8231 B|Y A|C|X VGND VGND sky130_fd_pr__nfet_01v8 L=0.15 W=0.42 AS=0.1092
+ AD=0.1197 PS=1.36 PD=1.41
M$8232 \$1599 A|C|X \$1597 VGND sky130_fd_pr__nfet_01v8 L=0.15 W=0.64 AS=0.1728
+ AD=0.0928 PS=1.82 PD=0.93
M$8233 \$1597 \$1598 \$1600 VGND sky130_fd_pr__nfet_01v8 L=0.15 W=0.64
+ AS=0.0928 AD=0.224 PS=0.93 PD=1.98
M$8235 VGND B|Y A|A1|Y VGND sky130_fd_pr__nfet_01v8 L=0.15 W=2.6 AS=0.59475
+ AD=0.351 PS=6.38 PD=3.68
M$8236 A|A1|Y A|Y VGND VGND sky130_fd_pr__nfet_01v8 L=0.15 W=4.74 AS=1.01165
+ AD=0.9179 PS=11.055 PD=10.09
M$8238 A|B1_N|Y A|Y \$1864 VGND sky130_fd_pr__nfet_01v8 L=0.15 W=0.65 AS=0.169
+ AD=0.08775 PS=1.82 PD=0.92
M$8239 \$1864 A|A2|B|Y VGND VGND sky130_fd_pr__nfet_01v8 L=0.15 W=0.65
+ AS=0.08775 AD=0.169 PS=0.92 PD=1.82
M$8240 VGND \$1809 A|A2|B|X VGND sky130_fd_pr__nfet_01v8 L=0.15 W=0.65 AS=0.208
+ AD=0.25025 PS=1.94 PD=1.42
M$8241 A|A2|B|X B|X \$1863 VGND sky130_fd_pr__nfet_01v8 L=0.15 W=0.65
+ AS=0.25025 AD=0.08775 PS=1.42 PD=0.92
M$8242 \$1863 A|A2|B|Y VGND VGND sky130_fd_pr__nfet_01v8 L=0.15 W=0.65
+ AS=0.08775 AD=0.08775 PS=0.92 PD=0.92
M$8243 VGND A|A2|B|Y \$1809 VGND sky130_fd_pr__nfet_01v8 L=0.15 W=0.65
+ AS=0.08775 AD=0.08775 PS=0.92 PD=0.92
M$8244 \$1809 B|X VGND VGND sky130_fd_pr__nfet_01v8 L=0.15 W=0.65 AS=0.08775
+ AD=0.169 PS=0.92 PD=1.82
M$8246 VGND \$1811 B1|X VGND sky130_fd_pr__nfet_01v8 L=0.15 W=0.65 AS=0.169
+ AD=0.08775 PS=1.82 PD=0.92
M$8247 B1|X B|SLEEP|X VGND VGND sky130_fd_pr__nfet_01v8 L=0.15 W=0.65
+ AS=0.08775 AD=0.10025 PS=0.92 PD=0.985
M$8248 VGND A|B|Y \$1811 VGND sky130_fd_pr__nfet_01v8 L=0.15 W=0.42 AS=0.10025
+ AD=0.1092 PS=0.985 PD=1.36
M$8249 A|A2|B|Y \$1813 \$1845 VGND sky130_fd_pr__nfet_01v8 L=0.15 W=0.65
+ AS=0.195 AD=0.08775 PS=1.9 PD=0.92
M$8250 \$1845 B|SLEEP|X VGND VGND sky130_fd_pr__nfet_01v8 L=0.15 W=0.65
+ AS=0.08775 AD=0.169 PS=0.92 PD=1.82
M$8251 \$1845 A|B|Y VGND VGND sky130_fd_pr__nfet_01v8 L=0.15 W=0.65 AS=0.169
+ AD=0.08775 PS=1.82 PD=0.92
M$8252 VGND A|B|Y \$1862 VGND sky130_fd_pr__nfet_01v8 L=0.15 W=0.65 AS=0.08775
+ AD=0.06825 PS=0.92 PD=0.86
M$8253 \$1862 B|SLEEP|X \$1813 VGND sky130_fd_pr__nfet_01v8 L=0.15 W=0.65
+ AS=0.06825 AD=0.169 PS=0.86 PD=1.82
M$8265 VGND A|B1|C|Y A|B1|Y VGND sky130_fd_pr__nfet_01v8 L=0.15 W=0.65 AS=0.169
+ AD=0.08775 PS=1.82 PD=0.92
M$8267 B|C|Y \$1817 \$1846 VGND sky130_fd_pr__nfet_01v8 L=0.15 W=0.65 AS=0.195
+ AD=0.08775 PS=1.9 PD=0.92
M$8268 \$1846 B|Y VGND VGND sky130_fd_pr__nfet_01v8 L=0.15 W=0.65 AS=0.08775
+ AD=0.169 PS=0.92 PD=1.82
M$8269 \$1846 A|Y VGND VGND sky130_fd_pr__nfet_01v8 L=0.15 W=0.65 AS=0.169
+ AD=0.08775 PS=1.82 PD=0.92
M$8270 VGND A|Y \$1861 VGND sky130_fd_pr__nfet_01v8 L=0.15 W=0.65 AS=0.08775
+ AD=0.06825 PS=0.92 PD=0.86
M$8271 \$1861 B|Y \$1817 VGND sky130_fd_pr__nfet_01v8 L=0.15 W=0.65 AS=0.06825
+ AD=0.169 PS=0.86 PD=1.82
M$8273 A1|B1|C_N|Y A|A1|A_N|B1|X \$1860 VGND sky130_fd_pr__nfet_01v8 L=0.15
+ W=0.65 AS=0.169 AD=0.10725 PS=1.82 PD=0.98
M$8274 \$1860 A2|B|Y \$1859 VGND sky130_fd_pr__nfet_01v8 L=0.15 W=0.65
+ AS=0.10725 AD=0.08775 PS=0.98 PD=0.92
M$8275 \$1859 B1|C|X VGND VGND sky130_fd_pr__nfet_01v8 L=0.15 W=0.65 AS=0.08775
+ AD=0.169 PS=0.92 PD=1.82
M$8276 B|Y \$1820 \$1847 VGND sky130_fd_pr__nfet_01v8 L=0.15 W=0.65 AS=0.195
+ AD=0.08775 PS=1.9 PD=0.92
M$8277 \$1847 A2|B|Y VGND VGND sky130_fd_pr__nfet_01v8 L=0.15 W=0.65 AS=0.08775
+ AD=0.169 PS=0.92 PD=1.82
M$8278 \$1847 A|X VGND VGND sky130_fd_pr__nfet_01v8 L=0.15 W=0.65 AS=0.169
+ AD=0.08775 PS=1.82 PD=0.92
M$8279 VGND A|X \$1858 VGND sky130_fd_pr__nfet_01v8 L=0.15 W=0.65 AS=0.08775
+ AD=0.06825 PS=0.92 PD=0.86
M$8280 \$1858 A2|B|Y \$1820 VGND sky130_fd_pr__nfet_01v8 L=0.15 W=0.65
+ AS=0.06825 AD=0.169 PS=0.86 PD=1.82
M$8281 A|A1|Y A|X \$1857 VGND sky130_fd_pr__nfet_01v8 L=0.15 W=0.65 AS=0.169
+ AD=0.08775 PS=1.82 PD=0.92
M$8282 \$1857 A2|B|Y VGND VGND sky130_fd_pr__nfet_01v8 L=0.15 W=0.65 AS=0.08775
+ AD=0.169 PS=0.92 PD=1.82
M$8287 B|Y A|A1|Y \$1856 VGND sky130_fd_pr__nfet_01v8 L=0.15 W=0.65 AS=0.091
+ AD=0.095875 PS=0.93 PD=0.945
M$8288 \$1856 A2|B|X VGND VGND sky130_fd_pr__nfet_01v8 L=0.15 W=0.65
+ AS=0.095875 AD=0.17225 PS=0.945 PD=1.83
M$8289 A|B|Y A|A1|Y \$1855 VGND sky130_fd_pr__nfet_01v8 L=0.15 W=0.65 AS=0.169
+ AD=0.08775 PS=1.82 PD=0.92
M$8290 \$1855 A2|B|X VGND VGND sky130_fd_pr__nfet_01v8 L=0.15 W=0.65 AS=0.08775
+ AD=0.169 PS=0.92 PD=1.82
M$8302 VGND B|C|X \$1930 VGND sky130_fd_pr__nfet_01v8 L=0.15 W=0.65 AS=0.169
+ AD=0.08775 PS=1.82 PD=0.92
M$8303 \$1930 A|B|Y S|Y VGND sky130_fd_pr__nfet_01v8 L=0.15 W=0.65 AS=0.08775
+ AD=0.169 PS=0.92 PD=1.82
M$8304 VGND S|Y \$1868 VGND sky130_fd_pr__nfet_01v8 L=0.15 W=0.65 AS=0.169
+ AD=0.169 PS=1.82 PD=1.82
M$8305 \$1869 S|Y VGND VGND sky130_fd_pr__nfet_01v8 L=0.15 W=0.65 AS=0.169
+ AD=0.08775 PS=1.82 PD=0.92
M$8306 VGND \$1868 \$1870 VGND sky130_fd_pr__nfet_01v8 L=0.15 W=0.65 AS=0.08775
+ AD=0.169 PS=0.92 PD=1.82
M$8307 \$1869 A1|A2|X A|B|Y VGND sky130_fd_pr__nfet_01v8 L=0.15 W=0.65 AS=0.182
+ AD=0.08775 PS=1.86 PD=0.92
M$8308 A|B|Y A|A0|X \$1870 VGND sky130_fd_pr__nfet_01v8 L=0.15 W=0.65
+ AS=0.08775 AD=0.169 PS=0.92 PD=1.82
M$8311 A|B|Y \$2056 \$1871 VGND sky130_fd_pr__nfet_01v8 L=0.15 W=0.65 AS=0.195
+ AD=0.08775 PS=1.9 PD=0.92
M$8312 \$1871 B|C|Y VGND VGND sky130_fd_pr__nfet_01v8 L=0.15 W=0.65 AS=0.08775
+ AD=0.169 PS=0.92 PD=1.82
M$8313 \$1871 A|X VGND VGND sky130_fd_pr__nfet_01v8 L=0.15 W=0.65 AS=0.169
+ AD=0.08775 PS=1.82 PD=0.92
M$8314 VGND A|X \$1944 VGND sky130_fd_pr__nfet_01v8 L=0.15 W=0.65 AS=0.08775
+ AD=0.06825 PS=0.92 PD=0.86
M$8315 \$1944 B|C|Y \$2056 VGND sky130_fd_pr__nfet_01v8 L=0.15 W=0.65
+ AS=0.06825 AD=0.169 PS=0.86 PD=1.82
M$8317 VGND B|C|Y \$1952 VGND sky130_fd_pr__nfet_01v8 L=0.15 W=0.42 AS=0.1474
+ AD=0.0441 PS=1.215 PD=0.63
M$8318 \$1952 B|Y \$1873 VGND sky130_fd_pr__nfet_01v8 L=0.15 W=0.42 AS=0.0441
+ AD=0.0567 PS=0.63 PD=0.69
M$8319 \$1873 B|Y \$1954 VGND sky130_fd_pr__nfet_01v8 L=0.15 W=0.42 AS=0.0567
+ AD=0.0441 PS=0.69 PD=0.63
M$8320 \$1954 A|Y VGND VGND sky130_fd_pr__nfet_01v8 L=0.15 W=0.42 AS=0.0441
+ AD=0.0567 PS=0.63 PD=0.69
M$8321 VGND A|Y \$1956 VGND sky130_fd_pr__nfet_01v8 L=0.15 W=0.42 AS=0.0567
+ AD=0.0441 PS=0.69 PD=0.63
M$8322 \$1956 B|C|Y \$1873 VGND sky130_fd_pr__nfet_01v8 L=0.15 W=0.42 AS=0.0441
+ AD=0.1092 PS=0.63 PD=1.36
M$8323 B|X \$1873 VGND VGND sky130_fd_pr__nfet_01v8 L=0.15 W=0.65 AS=0.23725
+ AD=0.1474 PS=2.03 PD=1.215
M$8325 VGND A|A2|B|X \$1965 VGND sky130_fd_pr__nfet_01v8 L=0.15 W=0.42
+ AS=0.1113 AD=0.0441 PS=1.37 PD=0.63
M$8326 \$1965 A|A1|Y B|Y VGND sky130_fd_pr__nfet_01v8 L=0.15 W=0.42 AS=0.0441
+ AD=0.1113 PS=0.63 PD=0.95
M$8327 B|Y \$1874 VGND VGND sky130_fd_pr__nfet_01v8 L=0.15 W=0.42 AS=0.1113
+ AD=0.1302 PS=0.95 PD=1.04
M$8328 VGND A|B1_N|Y \$1874 VGND sky130_fd_pr__nfet_01v8 L=0.15 W=0.42
+ AS=0.1302 AD=0.1113 PS=1.04 PD=1.37
M$8329 A|Y A|A1|Y \$1968 VGND sky130_fd_pr__nfet_01v8 L=0.15 W=0.65 AS=0.169
+ AD=0.08775 PS=1.82 PD=0.92
M$8330 \$1968 A|A2|B|X VGND VGND sky130_fd_pr__nfet_01v8 L=0.15 W=0.65
+ AS=0.08775 AD=0.169 PS=0.92 PD=1.82
M$8332 VGND \$1877 A|B|X VGND sky130_fd_pr__nfet_01v8 L=0.15 W=0.65 AS=0.208
+ AD=0.25025 PS=1.94 PD=1.42
M$8333 A|B|X B|C|X \$1977 VGND sky130_fd_pr__nfet_01v8 L=0.15 W=0.65 AS=0.25025
+ AD=0.08775 PS=1.42 PD=0.92
M$8334 \$1977 A|Y VGND VGND sky130_fd_pr__nfet_01v8 L=0.15 W=0.65 AS=0.08775
+ AD=0.08775 PS=0.92 PD=0.92
M$8335 VGND A|Y \$1877 VGND sky130_fd_pr__nfet_01v8 L=0.15 W=0.65 AS=0.08775
+ AD=0.08775 PS=0.92 PD=0.92
M$8336 \$1877 B|C|X VGND VGND sky130_fd_pr__nfet_01v8 L=0.15 W=0.65 AS=0.08775
+ AD=0.169 PS=0.92 PD=1.82
M$8337 A|Y A|A1|X \$1982 VGND sky130_fd_pr__nfet_01v8 L=0.15 W=0.65 AS=0.169
+ AD=0.10725 PS=1.82 PD=0.98
M$8338 \$1982 A|A2|B|Y \$1984 VGND sky130_fd_pr__nfet_01v8 L=0.15 W=0.65
+ AS=0.10725 AD=0.08775 PS=0.98 PD=0.92
M$8339 \$1984 B|C|X VGND VGND sky130_fd_pr__nfet_01v8 L=0.15 W=0.65 AS=0.08775
+ AD=0.169 PS=0.92 PD=1.82
M$8340 \$1879 A|Y \$1989 VGND sky130_fd_pr__nfet_01v8 L=0.15 W=0.42 AS=0.1092
+ AD=0.0441 PS=1.36 PD=0.63
M$8341 \$1989 A|B|Y \$1987 VGND sky130_fd_pr__nfet_01v8 L=0.15 W=0.42 AS=0.0441
+ AD=0.0441 PS=0.63 PD=0.63
M$8342 \$1987 B|B_N|C|X VGND VGND sky130_fd_pr__nfet_01v8 L=0.15 W=0.42
+ AS=0.0441 AD=0.13165 PS=0.63 PD=1.14
M$8343 VGND \$1879 A|B|X VGND sky130_fd_pr__nfet_01v8 L=0.15 W=0.65 AS=0.13165
+ AD=0.169 PS=1.14 PD=1.82
M$8345 A|A_N|Y A|Y \$1994 VGND sky130_fd_pr__nfet_01v8 L=0.15 W=0.65 AS=0.169
+ AD=0.10725 PS=1.82 PD=0.98
M$8346 \$1994 A|B|Y \$1995 VGND sky130_fd_pr__nfet_01v8 L=0.15 W=0.65
+ AS=0.10725 AD=0.08775 PS=0.98 PD=0.92
M$8347 \$1995 B|B_N|C|X VGND VGND sky130_fd_pr__nfet_01v8 L=0.15 W=0.65
+ AS=0.08775 AD=0.169 PS=0.92 PD=1.82
M$8349 VGND \$1883 B|C|X VGND sky130_fd_pr__nfet_01v8 L=0.15 W=0.65 AS=0.208
+ AD=0.25025 PS=1.94 PD=1.42
M$8350 B|C|X A2|B|Y \$2001 VGND sky130_fd_pr__nfet_01v8 L=0.15 W=0.65
+ AS=0.25025 AD=0.08775 PS=1.42 PD=0.92
M$8351 \$2001 A|A1|X VGND VGND sky130_fd_pr__nfet_01v8 L=0.15 W=0.65 AS=0.08775
+ AD=0.08775 PS=0.92 PD=0.92
M$8352 VGND A|A1|X \$1883 VGND sky130_fd_pr__nfet_01v8 L=0.15 W=0.65 AS=0.08775
+ AD=0.08775 PS=0.92 PD=0.92
M$8353 \$1883 A2|B|Y VGND VGND sky130_fd_pr__nfet_01v8 L=0.15 W=0.65 AS=0.08775
+ AD=0.169 PS=0.92 PD=1.82
M$8354 A2|B|Y \$2060 \$1884 VGND sky130_fd_pr__nfet_01v8 L=0.15 W=0.65 AS=0.195
+ AD=0.08775 PS=1.9 PD=0.92
M$8355 \$1884 B|B_N|C|X VGND VGND sky130_fd_pr__nfet_01v8 L=0.15 W=0.65
+ AS=0.08775 AD=0.169 PS=0.92 PD=1.82
M$8356 \$1884 A|Y VGND VGND sky130_fd_pr__nfet_01v8 L=0.15 W=0.65 AS=0.169
+ AD=0.08775 PS=1.82 PD=0.92
M$8357 VGND A|Y \$2006 VGND sky130_fd_pr__nfet_01v8 L=0.15 W=0.65 AS=0.08775
+ AD=0.06825 PS=0.92 PD=0.86
M$8358 \$2006 B|B_N|C|X \$2060 VGND sky130_fd_pr__nfet_01v8 L=0.15 W=0.65
+ AS=0.06825 AD=0.169 PS=0.86 PD=1.82
M$8359 \$1885 B|B_N|C|X VGND VGND sky130_fd_pr__nfet_01v8 L=0.15 W=0.42
+ AS=0.1092 AD=0.10025 PS=1.36 PD=0.985
M$8360 VGND A|Y A|C1|Y VGND sky130_fd_pr__nfet_01v8 L=0.15 W=0.65 AS=0.10025
+ AD=0.08775 PS=0.985 PD=0.92
M$8361 A|C1|Y \$1885 VGND VGND sky130_fd_pr__nfet_01v8 L=0.15 W=0.65 AS=0.08775
+ AD=0.169 PS=0.92 PD=1.82
M$8364 A|Y A|B|Y VGND VGND sky130_fd_pr__nfet_01v8 L=0.15 W=4.32 AS=0.72745
+ AD=0.8372 PS=7.83 PD=8.8
M$8365 VGND \$1888 B|B_N|C|X VGND sky130_fd_pr__nfet_01v8 L=0.15 W=0.65
+ AS=0.208 AD=0.25025 PS=1.94 PD=1.42
M$8366 B|B_N|C|X B|X \$2014 VGND sky130_fd_pr__nfet_01v8 L=0.15 W=0.65
+ AS=0.25025 AD=0.08775 PS=1.42 PD=0.92
M$8367 \$2014 A|B|Y VGND VGND sky130_fd_pr__nfet_01v8 L=0.15 W=0.65 AS=0.08775
+ AD=0.08775 PS=0.92 PD=0.92
M$8368 VGND A|B|Y \$1888 VGND sky130_fd_pr__nfet_01v8 L=0.15 W=0.65 AS=0.08775
+ AD=0.08775 PS=0.92 PD=0.92
M$8369 \$1888 B|X VGND VGND sky130_fd_pr__nfet_01v8 L=0.15 W=0.65 AS=0.08775
+ AD=0.169 PS=0.92 PD=1.82
M$8370 VGND A|D_N|Y \$1889 VGND sky130_fd_pr__nfet_01v8 L=0.15 W=0.42
+ AS=0.10025 AD=0.1092 PS=0.985 PD=1.36
M$8371 VGND A|A3|B|Y A|Y VGND sky130_fd_pr__nfet_01v8 L=0.15 W=0.65 AS=0.10025
+ AD=0.08775 PS=0.985 PD=0.92
M$8373 VGND B|C|SLEEP|Y A|Y VGND sky130_fd_pr__nfet_01v8 L=0.15 W=1.3 AS=0.195
+ AD=0.25675 PS=1.9 PD=2.74
M$8374 A|Y \$1889 VGND VGND sky130_fd_pr__nfet_01v8 L=0.15 W=0.65 AS=0.08775
+ AD=0.182 PS=0.92 PD=1.86
M$8377 VGND A|B|B1|B_N|Y A|Y VGND sky130_fd_pr__nfet_01v8 L=0.15 W=0.65
+ AS=0.169 AD=0.08775 PS=1.82 PD=0.92
M$8378 A|Y A|C|C1|X VGND VGND sky130_fd_pr__nfet_01v8 L=0.15 W=0.65 AS=0.08775
+ AD=0.169 PS=0.92 PD=1.82
M$8380 VGND A2|B|Y \$2031 VGND sky130_fd_pr__nfet_01v8 L=0.15 W=0.65 AS=0.2665
+ AD=0.091 PS=2.12 PD=0.93
M$8381 \$2031 A|A1|B1|Y A|B2|Y VGND sky130_fd_pr__nfet_01v8 L=0.15 W=0.65
+ AS=0.091 AD=0.091 PS=0.93 PD=0.93
M$8382 A|B2|Y A|B|B1|B_N|Y VGND VGND sky130_fd_pr__nfet_01v8 L=0.15 W=0.65
+ AS=0.091 AD=0.10075 PS=0.93 PD=0.96
M$8383 VGND A|C|C1|X A|B2|Y VGND sky130_fd_pr__nfet_01v8 L=0.15 W=0.65
+ AS=0.10075 AD=0.17225 PS=0.96 PD=1.83
M$8385 B|B1|Y \$2062 \$1894 VGND sky130_fd_pr__nfet_01v8 L=0.15 W=0.65 AS=0.195
+ AD=0.08775 PS=1.9 PD=0.92
M$8386 \$1894 B|X VGND VGND sky130_fd_pr__nfet_01v8 L=0.15 W=0.65 AS=0.08775
+ AD=0.169 PS=0.92 PD=1.82
M$8387 \$1894 A|A2|Y VGND VGND sky130_fd_pr__nfet_01v8 L=0.15 W=0.65 AS=0.169
+ AD=0.08775 PS=1.82 PD=0.92
M$8388 VGND A|A2|Y \$2038 VGND sky130_fd_pr__nfet_01v8 L=0.15 W=0.65 AS=0.08775
+ AD=0.06825 PS=0.92 PD=0.86
M$8389 \$2038 B|X \$2062 VGND sky130_fd_pr__nfet_01v8 L=0.15 W=0.65 AS=0.06825
+ AD=0.169 PS=0.86 PD=1.82
M$8390 A2|B|Y \$2065 \$1895 VGND sky130_fd_pr__nfet_01v8 L=0.15 W=0.65 AS=0.195
+ AD=0.08775 PS=1.9 PD=0.92
M$8391 \$1895 B|C|Y VGND VGND sky130_fd_pr__nfet_01v8 L=0.15 W=0.65 AS=0.08775
+ AD=0.169 PS=0.92 PD=1.82
M$8392 \$1895 A|B|C1|Y VGND VGND sky130_fd_pr__nfet_01v8 L=0.15 W=0.65 AS=0.169
+ AD=0.08775 PS=1.82 PD=0.92
M$8393 VGND A|B|C1|Y \$2041 VGND sky130_fd_pr__nfet_01v8 L=0.15 W=0.65
+ AS=0.08775 AD=0.06825 PS=0.92 PD=0.86
M$8394 \$2041 B|C|Y \$2065 VGND sky130_fd_pr__nfet_01v8 L=0.15 W=0.65
+ AS=0.06825 AD=0.169 PS=0.86 PD=1.82
M$8397 VGND B1|C|X B|Y VGND sky130_fd_pr__nfet_01v8 L=0.15 W=0.65 AS=0.17225
+ AD=0.091 PS=1.83 PD=0.93
M$8398 B|Y A|A1|A_N|B1|X \$2055 VGND sky130_fd_pr__nfet_01v8 L=0.15 W=0.65
+ AS=0.091 AD=0.095875 PS=0.93 PD=0.945
M$8399 \$2055 A2|B|Y VGND VGND sky130_fd_pr__nfet_01v8 L=0.15 W=0.65
+ AS=0.095875 AD=0.17225 PS=0.945 PD=1.83
M$8400 VGND \$1897 B1|C|X VGND sky130_fd_pr__nfet_01v8 L=0.15 W=0.65 AS=0.208
+ AD=0.25025 PS=1.94 PD=1.42
M$8401 B1|C|X A|A2|B|Y \$2049 VGND sky130_fd_pr__nfet_01v8 L=0.15 W=0.65
+ AS=0.25025 AD=0.08775 PS=1.42 PD=0.92
M$8402 \$2049 A|A1|Y VGND VGND sky130_fd_pr__nfet_01v8 L=0.15 W=0.65 AS=0.08775
+ AD=0.08775 PS=0.92 PD=0.92
M$8403 VGND A|A1|Y \$1897 VGND sky130_fd_pr__nfet_01v8 L=0.15 W=0.65 AS=0.08775
+ AD=0.08775 PS=0.92 PD=0.92
M$8404 \$1897 A|A2|B|Y VGND VGND sky130_fd_pr__nfet_01v8 L=0.15 W=0.65
+ AS=0.08775 AD=0.169 PS=0.92 PD=1.82
M$8406 A|A2|B|Y \$2067 \$1898 VGND sky130_fd_pr__nfet_01v8 L=0.15 W=0.65
+ AS=0.195 AD=0.08775 PS=1.9 PD=0.92
M$8407 \$1898 B|Y VGND VGND sky130_fd_pr__nfet_01v8 L=0.15 W=0.65 AS=0.08775
+ AD=0.169 PS=0.92 PD=1.82
M$8408 \$1898 A|B|Y VGND VGND sky130_fd_pr__nfet_01v8 L=0.15 W=0.65 AS=0.169
+ AD=0.08775 PS=1.82 PD=0.92
M$8409 VGND A|B|Y \$2019 VGND sky130_fd_pr__nfet_01v8 L=0.15 W=0.65 AS=0.08775
+ AD=0.06825 PS=0.92 PD=0.86
M$8410 \$2019 B|Y \$2067 VGND sky130_fd_pr__nfet_01v8 L=0.15 W=0.65 AS=0.06825
+ AD=0.169 PS=0.86 PD=1.82
M$8411 \$1899 A|A1|C1|Y VGND VGND sky130_fd_pr__nfet_01v8 L=0.15 W=0.42
+ AS=0.1113 AD=0.0588 PS=1.37 PD=0.7
M$8412 VGND A2|B|B1|C|Y \$1899 VGND sky130_fd_pr__nfet_01v8 L=0.15 W=0.42
+ AS=0.0588 AD=0.0588 PS=0.7 PD=0.7
M$8413 \$1899 B1|Y B|Y VGND sky130_fd_pr__nfet_01v8 L=0.15 W=0.42 AS=0.0588
+ AD=0.1113 PS=0.7 PD=1.37
M$8416 A3|B|Y A2|B1|SLEEP|Y \$1900 VGND sky130_fd_pr__nfet_01v8 L=0.15 W=0.42
+ AS=0.1113 AD=0.0588 PS=1.37 PD=0.7
M$8417 \$1900 A2|C|Y VGND VGND sky130_fd_pr__nfet_01v8 L=0.15 W=0.42 AS=0.0588
+ AD=0.0588 PS=0.7 PD=0.7
M$8418 VGND A|A1|B|X \$1900 VGND sky130_fd_pr__nfet_01v8 L=0.15 W=0.42
+ AS=0.0588 AD=0.1113 PS=0.7 PD=1.37
M$8420 A2|C|Y A|A1|C1|Y VGND VGND sky130_fd_pr__nfet_01v8 L=0.15 W=0.65
+ AS=0.17225 AD=0.10075 PS=1.83 PD=0.96
M$8421 VGND A|A1|B|B1|Y A2|C|Y VGND sky130_fd_pr__nfet_01v8 L=0.15 W=0.65
+ AS=0.10075 AD=0.091 PS=0.96 PD=0.93
M$8422 A2|C|Y A|A1|Y \$1957 VGND sky130_fd_pr__nfet_01v8 L=0.15 W=0.65 AS=0.091
+ AD=0.091 PS=0.93 PD=0.93
M$8423 \$1957 A2|B|X VGND VGND sky130_fd_pr__nfet_01v8 L=0.15 W=0.65 AS=0.091
+ AD=0.2665 PS=0.93 PD=2.12
M$8426 A2|B|B1|C|Y B1|C|Y VGND VGND sky130_fd_pr__nfet_01v8 L=0.15 W=0.65
+ AS=0.169 AD=0.08775 PS=1.82 PD=0.92
M$8427 VGND A|A1|B|Y A2|B|B1|C|Y VGND sky130_fd_pr__nfet_01v8 L=0.15 W=0.65
+ AS=0.08775 AD=0.08775 PS=0.92 PD=0.92
M$8428 A2|B|B1|C|Y A|Y VGND VGND sky130_fd_pr__nfet_01v8 L=0.15 W=0.65
+ AS=0.08775 AD=0.169 PS=0.92 PD=1.82
M$8429 VGND B|C|X \$1915 VGND sky130_fd_pr__nfet_01v8 L=0.15 W=0.65 AS=0.169
+ AD=0.08775 PS=1.82 PD=0.92
M$8430 \$1915 A|X A|Y VGND sky130_fd_pr__nfet_01v8 L=0.15 W=0.65 AS=0.08775
+ AD=0.169 PS=0.92 PD=1.82
M$8439 \$2117 B|C|X \$2213 VGND sky130_fd_pr__nfet_01v8 L=0.15 W=0.65 AS=0.169
+ AD=0.06825 PS=1.82 PD=0.86
M$8440 \$2213 A|B|Y VGND VGND sky130_fd_pr__nfet_01v8 L=0.15 W=0.65 AS=0.06825
+ AD=0.08775 PS=0.86 PD=0.92
M$8441 VGND A|B|Y \$2200 VGND sky130_fd_pr__nfet_01v8 L=0.15 W=0.65 AS=0.08775
+ AD=0.169 PS=0.92 PD=1.82
M$8442 VGND B|C|X \$2200 VGND sky130_fd_pr__nfet_01v8 L=0.15 W=0.65 AS=0.169
+ AD=0.08775 PS=1.82 PD=0.92
M$8443 \$2200 \$2117 B|Y VGND sky130_fd_pr__nfet_01v8 L=0.15 W=0.65 AS=0.08775
+ AD=0.195 PS=0.92 PD=1.9
M$8446 VGND C|SLEEP|Y \$2121 VGND sky130_fd_pr__nfet_01v8 L=0.15 W=0.42
+ AS=0.1165 AD=0.1785 PS=1.035 PD=1.69
M$8447 B|C|X \$2120 VGND VGND sky130_fd_pr__nfet_01v8 L=0.15 W=0.65 AS=0.169
+ AD=0.1165 PS=1.82 PD=1.035
M$8448 \$2123 C|SLEEP|Y \$2120 VGND sky130_fd_pr__nfet_01v8 L=0.15 W=0.64
+ AS=0.1728 AD=0.0928 PS=1.82 PD=0.93
M$8449 \$2120 \$2121 \$2122 VGND sky130_fd_pr__nfet_01v8 L=0.15 W=0.64
+ AS=0.0928 AD=0.224 PS=0.93 PD=1.98
M$8450 VGND B|C|Y \$2124 VGND sky130_fd_pr__nfet_01v8 L=0.15 W=0.65 AS=0.1885
+ AD=0.16515 PS=1.88 PD=1.82
M$8451 \$2125 B|C|Y \$2122 VGND sky130_fd_pr__nfet_01v8 L=0.15 W=0.64
+ AS=0.16275 AD=0.18205 PS=1.8 PD=1.245
M$8452 \$2122 \$2124 \$2126 VGND sky130_fd_pr__nfet_01v8 L=0.15 W=0.42
+ AS=0.18205 AD=0.19265 PS=1.245 PD=1.285
M$8453 \$2126 B|C|Y \$2123 VGND sky130_fd_pr__nfet_01v8 L=0.15 W=0.64
+ AS=0.19265 AD=0.140825 PS=1.285 PD=1.1
M$8454 \$2123 \$2124 \$2125 VGND sky130_fd_pr__nfet_01v8 L=0.15 W=0.6
+ AS=0.140825 AD=0.11 PS=1.1 PD=0.99
M$8455 \$2125 A|X VGND VGND sky130_fd_pr__nfet_01v8 L=0.15 W=0.64 AS=0.11
+ AD=0.0864 PS=0.99 PD=0.91
M$8456 VGND \$2125 \$2126 VGND sky130_fd_pr__nfet_01v8 L=0.15 W=0.64 AS=0.0864
+ AD=0.1824 PS=0.91 PD=1.85
M$8460 A|B1|Y A|Y \$2218 VGND sky130_fd_pr__nfet_01v8 L=0.15 W=0.65 AS=0.169
+ AD=0.08775 PS=1.82 PD=0.92
M$8461 \$2218 A|A2|B|X VGND VGND sky130_fd_pr__nfet_01v8 L=0.15 W=0.65
+ AS=0.08775 AD=0.169 PS=0.92 PD=1.82
M$8462 VGND \$2190 A|A2|B|X VGND sky130_fd_pr__nfet_01v8 L=0.15 W=0.65 AS=0.208
+ AD=0.25025 PS=1.94 PD=1.42
M$8463 A|A2|B|X B|X \$2220 VGND sky130_fd_pr__nfet_01v8 L=0.15 W=0.65
+ AS=0.25025 AD=0.08775 PS=1.42 PD=0.92
M$8464 \$2220 A|A2|B|X VGND VGND sky130_fd_pr__nfet_01v8 L=0.15 W=0.65
+ AS=0.08775 AD=0.08775 PS=0.92 PD=0.92
M$8465 VGND A|A2|B|X \$2190 VGND sky130_fd_pr__nfet_01v8 L=0.15 W=0.65
+ AS=0.08775 AD=0.08775 PS=0.92 PD=0.92
M$8466 \$2190 B|X VGND VGND sky130_fd_pr__nfet_01v8 L=0.15 W=0.65 AS=0.08775
+ AD=0.169 PS=0.92 PD=1.82
M$8469 VGND \$2191 A|B|B_N|X VGND sky130_fd_pr__nfet_01v8 L=0.15 W=0.65
+ AS=0.208 AD=0.25025 PS=1.94 PD=1.42
M$8470 A|B|B_N|X B|Y \$2221 VGND sky130_fd_pr__nfet_01v8 L=0.15 W=0.65
+ AS=0.25025 AD=0.08775 PS=1.42 PD=0.92
M$8471 \$2221 A|B|X VGND VGND sky130_fd_pr__nfet_01v8 L=0.15 W=0.65 AS=0.08775
+ AD=0.08775 PS=0.92 PD=0.92
M$8472 VGND A|B|X \$2191 VGND sky130_fd_pr__nfet_01v8 L=0.15 W=0.65 AS=0.08775
+ AD=0.08775 PS=0.92 PD=0.92
M$8473 \$2191 B|Y VGND VGND sky130_fd_pr__nfet_01v8 L=0.15 W=0.65 AS=0.08775
+ AD=0.169 PS=0.92 PD=1.82
M$8476 VGND A|B1_N|Y A|B|B2|Y VGND sky130_fd_pr__nfet_01v8 L=0.15 W=0.65
+ AS=0.169 AD=0.08775 PS=1.82 PD=0.92
M$8477 A|B|B2|Y A|B|X VGND VGND sky130_fd_pr__nfet_01v8 L=0.15 W=0.65
+ AS=0.08775 AD=0.169 PS=0.92 PD=1.82
M$8479 VGND B1|X A|Y VGND sky130_fd_pr__nfet_01v8 L=0.15 W=0.65 AS=0.17225
+ AD=0.091 PS=1.83 PD=0.93
M$8480 A|Y A|A1|X \$2224 VGND sky130_fd_pr__nfet_01v8 L=0.15 W=0.65 AS=0.091
+ AD=0.095875 PS=0.93 PD=0.945
M$8481 \$2224 A|A2|B|Y VGND VGND sky130_fd_pr__nfet_01v8 L=0.15 W=0.65
+ AS=0.095875 AD=0.17225 PS=0.945 PD=1.83
M$8485 \$2135 A|A1|X \$2229 VGND sky130_fd_pr__nfet_01v8 L=0.15 W=0.42
+ AS=0.1092 AD=0.0441 PS=1.36 PD=0.63
M$8486 \$2229 A2|B|Y \$2228 VGND sky130_fd_pr__nfet_01v8 L=0.15 W=0.42
+ AS=0.0441 AD=0.0441 PS=0.63 PD=0.63
M$8487 VGND B1|C|Y \$2228 VGND sky130_fd_pr__nfet_01v8 L=0.15 W=0.42 AS=0.13165
+ AD=0.0441 PS=1.14 PD=0.63
M$8488 VGND \$2135 A|B|X VGND sky130_fd_pr__nfet_01v8 L=0.15 W=0.65 AS=0.13165
+ AD=0.169 PS=1.14 PD=1.82
M$8489 VGND A2|B|Y \$2230 VGND sky130_fd_pr__nfet_01v8 L=0.15 W=0.65 AS=0.2665
+ AD=0.091 PS=2.12 PD=0.93
M$8490 \$2230 A|A1|X A|Y VGND sky130_fd_pr__nfet_01v8 L=0.15 W=0.65 AS=0.091
+ AD=0.091 PS=0.93 PD=0.93
M$8491 A|Y B1|C|Y VGND VGND sky130_fd_pr__nfet_01v8 L=0.15 W=0.65 AS=0.091
+ AD=0.10075 PS=0.93 PD=0.96
M$8492 VGND A|C1|Y A|Y VGND sky130_fd_pr__nfet_01v8 L=0.15 W=0.65 AS=0.10075
+ AD=0.17225 PS=0.96 PD=1.83
M$8494 B1|C|Y \$2140 \$2201 VGND sky130_fd_pr__nfet_01v8 L=0.15 W=0.65 AS=0.195
+ AD=0.08775 PS=1.9 PD=0.92
M$8495 \$2201 B|C|SLEEP|Y VGND VGND sky130_fd_pr__nfet_01v8 L=0.15 W=0.65
+ AS=0.08775 AD=0.169 PS=0.92 PD=1.82
M$8496 \$2201 A|Y VGND VGND sky130_fd_pr__nfet_01v8 L=0.15 W=0.65 AS=0.169
+ AD=0.08775 PS=1.82 PD=0.92
M$8497 VGND A|Y \$2233 VGND sky130_fd_pr__nfet_01v8 L=0.15 W=0.65 AS=0.08775
+ AD=0.06825 PS=0.92 PD=0.86
M$8498 \$2233 B|C|SLEEP|Y \$2140 VGND sky130_fd_pr__nfet_01v8 L=0.15 W=0.65
+ AS=0.06825 AD=0.169 PS=0.86 PD=1.82
M$8504 A|B|Y \$2143 \$2202 VGND sky130_fd_pr__nfet_01v8 L=0.15 W=0.65 AS=0.195
+ AD=0.08775 PS=1.9 PD=0.92
M$8505 \$2202 B|X VGND VGND sky130_fd_pr__nfet_01v8 L=0.15 W=0.65 AS=0.08775
+ AD=0.169 PS=0.92 PD=1.82
M$8506 \$2202 A|Y VGND VGND sky130_fd_pr__nfet_01v8 L=0.15 W=0.65 AS=0.169
+ AD=0.08775 PS=1.82 PD=0.92
M$8507 VGND A|Y \$2232 VGND sky130_fd_pr__nfet_01v8 L=0.15 W=0.65 AS=0.08775
+ AD=0.06825 PS=0.92 PD=0.86
M$8508 \$2232 B|X \$2143 VGND sky130_fd_pr__nfet_01v8 L=0.15 W=0.65 AS=0.06825
+ AD=0.169 PS=0.86 PD=1.82
M$8509 VGND \$2192 B|X VGND sky130_fd_pr__nfet_01v8 L=0.15 W=0.65 AS=0.208
+ AD=0.25025 PS=1.94 PD=1.42
M$8510 B|X A2|B|Y \$2231 VGND sky130_fd_pr__nfet_01v8 L=0.15 W=0.65 AS=0.25025
+ AD=0.08775 PS=1.42 PD=0.92
M$8511 \$2231 A|A1|B1|Y VGND VGND sky130_fd_pr__nfet_01v8 L=0.15 W=0.65
+ AS=0.08775 AD=0.08775 PS=0.92 PD=0.92
M$8512 VGND A|A1|B1|Y \$2192 VGND sky130_fd_pr__nfet_01v8 L=0.15 W=0.65
+ AS=0.08775 AD=0.08775 PS=0.92 PD=0.92
M$8513 \$2192 A2|B|Y VGND VGND sky130_fd_pr__nfet_01v8 L=0.15 W=0.65 AS=0.08775
+ AD=0.169 PS=0.92 PD=1.82
M$8515 VGND A|A1|B1|Y A1|Y VGND sky130_fd_pr__nfet_01v8 L=0.15 W=0.65 AS=0.169
+ AD=0.08775 PS=1.82 PD=0.92
M$8516 A1|Y A2|B|Y VGND VGND sky130_fd_pr__nfet_01v8 L=0.15 W=0.65 AS=0.08775
+ AD=0.169 PS=0.92 PD=1.82
M$8518 \$2147 B|C|Y \$2227 VGND sky130_fd_pr__nfet_01v8 L=0.15 W=0.42 AS=0.1092
+ AD=0.0441 PS=1.36 PD=0.63
M$8519 \$2227 A|A1|B1|Y VGND VGND sky130_fd_pr__nfet_01v8 L=0.15 W=0.42
+ AS=0.0441 AD=0.0567 PS=0.63 PD=0.69
M$8520 VGND A|A1|B1|Y \$2226 VGND sky130_fd_pr__nfet_01v8 L=0.15 W=0.42
+ AS=0.0567 AD=0.0441 PS=0.69 PD=0.63
M$8521 \$2226 A|B|C1|Y \$2147 VGND sky130_fd_pr__nfet_01v8 L=0.15 W=0.42
+ AS=0.0441 AD=0.0567 PS=0.63 PD=0.69
M$8522 \$2147 A|B|C1|Y \$2225 VGND sky130_fd_pr__nfet_01v8 L=0.15 W=0.42
+ AS=0.0567 AD=0.0441 PS=0.69 PD=0.63
M$8523 VGND B|C|Y \$2225 VGND sky130_fd_pr__nfet_01v8 L=0.15 W=0.42 AS=0.1474
+ AD=0.0441 PS=1.215 PD=0.63
M$8524 VGND \$2147 B|X VGND sky130_fd_pr__nfet_01v8 L=0.15 W=0.65 AS=0.1474
+ AD=0.23725 PS=1.215 PD=2.03
M$8526 VGND A|B|C1|Y A1|Y VGND sky130_fd_pr__nfet_01v8 L=0.15 W=0.65 AS=0.169
+ AD=0.08775 PS=1.82 PD=0.92
M$8527 A1|Y B|C|Y VGND VGND sky130_fd_pr__nfet_01v8 L=0.15 W=0.65 AS=0.08775
+ AD=0.169 PS=0.92 PD=1.82
M$8528 VGND A|A2|Y \$2222 VGND sky130_fd_pr__nfet_01v8 L=0.15 W=0.65 AS=0.17225
+ AD=0.095875 PS=1.83 PD=0.945
M$8529 \$2222 A1|Y A|Y VGND sky130_fd_pr__nfet_01v8 L=0.15 W=0.65 AS=0.095875
+ AD=0.091 PS=0.945 PD=0.93
M$8531 VGND A1|B1|C_N|Y \$2151 VGND sky130_fd_pr__nfet_01v8 L=0.15 W=0.42
+ AS=0.10025 AD=0.1092 PS=0.985 PD=1.36
M$8532 A|A2|Y \$2151 VGND VGND sky130_fd_pr__nfet_01v8 L=0.15 W=0.65 AS=0.221
+ AD=0.08775 PS=1.98 PD=0.92
M$8533 VGND B|Y A|A2|Y VGND sky130_fd_pr__nfet_01v8 L=0.15 W=0.65 AS=0.08775
+ AD=0.08775 PS=0.92 PD=0.92
M$8534 A|A2|Y A|B1|Y VGND VGND sky130_fd_pr__nfet_01v8 L=0.15 W=0.65 AS=0.08775
+ AD=0.10025 PS=0.92 PD=0.985
M$8536 A|Y A1|B1|C_N|Y \$2203 VGND sky130_fd_pr__nfet_01v8 L=0.15 W=0.42
+ AS=0.1113 AD=0.0588 PS=1.37 PD=0.7
M$8537 \$2203 A|A2|B|Y VGND VGND sky130_fd_pr__nfet_01v8 L=0.15 W=0.42
+ AS=0.0588 AD=0.0588 PS=0.7 PD=0.7
M$8538 VGND A|A1|Y \$2203 VGND sky130_fd_pr__nfet_01v8 L=0.15 W=0.42 AS=0.0588
+ AD=0.1113 PS=0.7 PD=1.37
M$8539 VGND B|B1|X B|Y VGND sky130_fd_pr__nfet_01v8 L=0.15 W=0.65 AS=0.17225
+ AD=0.091 PS=1.83 PD=0.93
M$8540 B|Y A1|B1|C_N|Y \$2219 VGND sky130_fd_pr__nfet_01v8 L=0.15 W=0.65
+ AS=0.091 AD=0.095875 PS=0.93 PD=0.945
M$8541 \$2219 A2|X VGND VGND sky130_fd_pr__nfet_01v8 L=0.15 W=0.65 AS=0.095875
+ AD=0.17225 PS=0.945 PD=1.83
M$8543 VGND A1|B|Y \$2217 VGND sky130_fd_pr__nfet_01v8 L=0.15 W=0.65 AS=0.169
+ AD=0.08775 PS=1.82 PD=0.92
M$8544 \$2217 A|Y SLEEP|Y VGND sky130_fd_pr__nfet_01v8 L=0.15 W=0.65 AS=0.08775
+ AD=0.169 PS=0.92 PD=1.82
M$8545 VGND A|A1|C1|Y C|Y VGND sky130_fd_pr__nfet_01v8 L=0.15 W=0.65 AS=0.169
+ AD=0.08775 PS=1.82 PD=0.92
M$8546 C|Y B|Y VGND VGND sky130_fd_pr__nfet_01v8 L=0.15 W=0.65 AS=0.08775
+ AD=0.169 PS=0.92 PD=1.82
M$8547 B|Y A|A1|B|C1|X \$2216 VGND sky130_fd_pr__nfet_01v8 L=0.15 W=0.65
+ AS=0.169 AD=0.08775 PS=1.82 PD=0.92
M$8548 \$2216 A2|B|B1|C|Y VGND VGND sky130_fd_pr__nfet_01v8 L=0.15 W=0.65
+ AS=0.08775 AD=0.169 PS=0.92 PD=1.82
M$8550 VGND A3|B|Y \$2212 VGND sky130_fd_pr__nfet_01v8 L=0.15 W=0.65 AS=0.169
+ AD=0.06825 PS=1.82 PD=0.86
M$8551 \$2212 A|A2|X \$2211 VGND sky130_fd_pr__nfet_01v8 L=0.15 W=0.65
+ AS=0.06825 AD=0.118625 PS=0.86 PD=1.015
M$8552 \$2211 A|A1|B|C1|X B|Y VGND sky130_fd_pr__nfet_01v8 L=0.15 W=0.65
+ AS=0.118625 AD=0.105625 PS=1.015 PD=0.975
M$8555 \$2157 A|A1|C1|Y \$2210 VGND sky130_fd_pr__nfet_01v8 L=0.15 W=0.42
+ AS=0.1113 AD=0.0441 PS=1.37 PD=0.63
M$8556 \$2210 A|A1|B|B1|Y VGND VGND sky130_fd_pr__nfet_01v8 L=0.15 W=0.42
+ AS=0.0441 AD=0.0966 PS=0.63 PD=0.88
M$8557 VGND \$2157 A|A1|B|X VGND sky130_fd_pr__nfet_01v8 L=0.15 W=0.42
+ AS=0.0966 AD=0.1113 PS=0.88 PD=1.37
M$8560 B1|B2|D|X \$2158 VGND VGND sky130_fd_pr__nfet_01v8 L=0.15 W=0.65
+ AS=0.169 AD=0.169 PS=1.82 PD=1.82
M$8561 \$2158 B1|C|Y \$2205 VGND sky130_fd_pr__nfet_01v8 L=0.15 W=0.65 AS=0.169
+ AD=0.10075 PS=1.82 PD=0.96
M$8562 \$2205 A2|B|X VGND VGND sky130_fd_pr__nfet_01v8 L=0.15 W=0.65 AS=0.10075
+ AD=0.08775 PS=0.96 PD=0.92
M$8563 VGND A|A1|B|Y \$2205 VGND sky130_fd_pr__nfet_01v8 L=0.15 W=0.65
+ AS=0.08775 AD=0.169 PS=0.92 PD=1.82
M$8564 \$2159 A2|B|X \$2209 VGND sky130_fd_pr__nfet_01v8 L=0.15 W=0.65 AS=0.169
+ AD=0.06825 PS=1.82 PD=0.86
M$8565 \$2209 A|A1|B|Y VGND VGND sky130_fd_pr__nfet_01v8 L=0.15 W=0.65
+ AS=0.06825 AD=0.08775 PS=0.86 PD=0.92
M$8566 VGND A|A1|B|Y \$2206 VGND sky130_fd_pr__nfet_01v8 L=0.15 W=0.65
+ AS=0.08775 AD=0.169 PS=0.92 PD=1.82
M$8567 VGND A2|B|X \$2206 VGND sky130_fd_pr__nfet_01v8 L=0.15 W=0.65 AS=0.169
+ AD=0.08775 PS=1.82 PD=0.92
M$8568 \$2206 \$2159 A|A1|Y VGND sky130_fd_pr__nfet_01v8 L=0.15 W=0.65
+ AS=0.08775 AD=0.195 PS=0.92 PD=1.9
M$8569 B|Y A|X VGND VGND sky130_fd_pr__nfet_01v8 L=0.15 W=2.37 AS=0.4537
+ AD=0.54545 PS=5.02 PD=5.97
M$8577 B|X \$2235 VGND VGND sky130_fd_pr__nfet_01v8 L=0.15 W=0.65 AS=0.169
+ AD=0.1165 PS=1.82 PD=1.035
M$8578 VGND B|C|X \$2236 VGND sky130_fd_pr__nfet_01v8 L=0.15 W=0.42 AS=0.1165
+ AD=0.1785 PS=1.035 PD=1.69
M$8579 \$2237 B|C|X \$2235 VGND sky130_fd_pr__nfet_01v8 L=0.15 W=0.64 AS=0.1728
+ AD=0.0928 PS=1.82 PD=0.93
M$8580 \$2235 \$2236 \$2238 VGND sky130_fd_pr__nfet_01v8 L=0.15 W=0.64
+ AS=0.0928 AD=0.224 PS=0.93 PD=1.98
M$8581 VGND A|B|Y \$2239 VGND sky130_fd_pr__nfet_01v8 L=0.15 W=0.65 AS=0.1885
+ AD=0.16515 PS=1.88 PD=1.82
M$8582 \$2238 \$2239 \$2241 VGND sky130_fd_pr__nfet_01v8 L=0.15 W=0.42
+ AS=0.18205 AD=0.19265 PS=1.245 PD=1.285
M$8583 \$2237 \$2239 \$2240 VGND sky130_fd_pr__nfet_01v8 L=0.15 W=0.6
+ AS=0.140825 AD=0.11 PS=1.1 PD=0.99
M$8584 \$2240 A|B|X VGND VGND sky130_fd_pr__nfet_01v8 L=0.15 W=0.64 AS=0.11
+ AD=0.0864 PS=0.99 PD=0.91
M$8585 VGND \$2240 \$2241 VGND sky130_fd_pr__nfet_01v8 L=0.15 W=0.64 AS=0.0864
+ AD=0.1824 PS=0.91 PD=1.85
M$8586 \$2240 A|B|Y \$2238 VGND sky130_fd_pr__nfet_01v8 L=0.15 W=0.64
+ AS=0.16275 AD=0.18205 PS=1.8 PD=1.245
M$8587 \$2237 A|B|Y \$2241 VGND sky130_fd_pr__nfet_01v8 L=0.15 W=0.64
+ AS=0.140825 AD=0.19265 PS=1.1 PD=1.285
M$8588 A|Y A|B|X \$2532 VGND sky130_fd_pr__nfet_01v8 L=0.15 W=0.65 AS=0.169
+ AD=0.08775 PS=1.82 PD=0.92
M$8589 \$2532 B|Y VGND VGND sky130_fd_pr__nfet_01v8 L=0.15 W=0.65 AS=0.08775
+ AD=0.169 PS=0.92 PD=1.82
M$8595 VGND A|B|B_N|X \$2462 VGND sky130_fd_pr__nfet_01v8 L=0.15 W=0.42
+ AS=0.10025 AD=0.1092 PS=0.985 PD=1.36
M$8596 VGND A|B1|Y B|Y VGND sky130_fd_pr__nfet_01v8 L=0.15 W=2.6 AS=0.45125
+ AD=0.45125 PS=4.665 PD=4.665
M$8597 B|Y \$2462 VGND VGND sky130_fd_pr__nfet_01v8 L=0.15 W=0.65 AS=0.08775
+ AD=0.169 PS=0.92 PD=1.82
M$8599 VGND B|B1|C|X \$2243 VGND sky130_fd_pr__nfet_01v8 L=0.15 W=0.65 AS=0.169
+ AD=0.08775 PS=1.82 PD=0.92
M$8600 \$2243 A|B|B2|Y VGND VGND sky130_fd_pr__nfet_01v8 L=0.15 W=0.65
+ AS=0.08775 AD=0.08775 PS=0.92 PD=0.92
M$8601 VGND A|B|B2|Y \$2330 VGND sky130_fd_pr__nfet_01v8 L=0.15 W=0.65
+ AS=0.08775 AD=0.08775 PS=0.92 PD=0.92
M$8602 \$2330 B|B1|C|X C|X VGND sky130_fd_pr__nfet_01v8 L=0.15 W=0.65
+ AS=0.08775 AD=0.25025 PS=0.92 PD=1.42
M$8603 C|X \$2243 VGND VGND sky130_fd_pr__nfet_01v8 L=0.15 W=0.65 AS=0.25025
+ AD=0.208 PS=1.42 PD=1.94
M$8605 VGND B|C|SLEEP|Y \$2467 VGND sky130_fd_pr__nfet_01v8 L=0.15 W=0.42
+ AS=0.1165 AD=0.1785 PS=1.035 PD=1.69
M$8606 B|B1|C|X \$2466 VGND VGND sky130_fd_pr__nfet_01v8 L=0.15 W=0.65 AS=0.169
+ AD=0.1165 PS=1.82 PD=1.035
M$8607 VGND A|Y A1|Y VGND sky130_fd_pr__nfet_01v8 L=0.15 W=3.67 AS=0.72095
+ AD=0.7917 PS=7.81 PD=8.66
M$8608 \$2469 B|C|SLEEP|Y \$2466 VGND sky130_fd_pr__nfet_01v8 L=0.15 W=0.64
+ AS=0.1728 AD=0.0928 PS=1.82 PD=0.93
M$8609 \$2466 \$2467 \$2468 VGND sky130_fd_pr__nfet_01v8 L=0.15 W=0.64
+ AS=0.0928 AD=0.224 PS=0.93 PD=1.98
M$8610 VGND B|C|SLEEP|Y \$2247 VGND sky130_fd_pr__nfet_01v8 L=0.15 W=0.42
+ AS=0.10025 AD=0.0567 PS=0.985 PD=0.69
M$8611 \$2247 A|B|X VGND VGND sky130_fd_pr__nfet_01v8 L=0.15 W=0.42 AS=0.0567
+ AD=0.1092 PS=0.69 PD=1.36
M$8612 A3|X \$2247 VGND VGND sky130_fd_pr__nfet_01v8 L=0.15 W=0.65 AS=0.169
+ AD=0.10025 PS=1.82 PD=0.985
M$8613 VGND A|B|X \$2470 VGND sky130_fd_pr__nfet_01v8 L=0.15 W=0.65 AS=0.1885
+ AD=0.16515 PS=1.88 PD=1.82
M$8614 \$2471 A|B|X \$2468 VGND sky130_fd_pr__nfet_01v8 L=0.15 W=0.64
+ AS=0.16275 AD=0.18205 PS=1.8 PD=1.245
M$8615 \$2468 \$2470 \$2472 VGND sky130_fd_pr__nfet_01v8 L=0.15 W=0.42
+ AS=0.18205 AD=0.19265 PS=1.245 PD=1.285
M$8616 \$2472 A|B|X \$2469 VGND sky130_fd_pr__nfet_01v8 L=0.15 W=0.64
+ AS=0.19265 AD=0.140825 PS=1.285 PD=1.1
M$8617 \$2469 \$2470 \$2471 VGND sky130_fd_pr__nfet_01v8 L=0.15 W=0.6
+ AS=0.140825 AD=0.11 PS=1.1 PD=0.99
M$8618 \$2471 A|Y VGND VGND sky130_fd_pr__nfet_01v8 L=0.15 W=0.64 AS=0.11
+ AD=0.0864 PS=0.99 PD=0.91
M$8619 VGND \$2471 \$2472 VGND sky130_fd_pr__nfet_01v8 L=0.15 W=0.64 AS=0.0864
+ AD=0.1824 PS=0.91 PD=1.85
M$8620 A|A2|Y A|B|X \$2343 VGND sky130_fd_pr__nfet_01v8 L=0.15 W=0.65 AS=0.169
+ AD=0.08775 PS=1.82 PD=0.92
M$8621 \$2343 B|C|SLEEP|Y VGND VGND sky130_fd_pr__nfet_01v8 L=0.15 W=0.65
+ AS=0.08775 AD=0.169 PS=0.92 PD=1.82
M$8623 B|C|SLEEP|Y \$2250 \$2251 VGND sky130_fd_pr__nfet_01v8 L=0.15 W=0.65
+ AS=0.195 AD=0.08775 PS=1.9 PD=0.92
M$8624 \$2251 B|Y VGND VGND sky130_fd_pr__nfet_01v8 L=0.15 W=0.65 AS=0.08775
+ AD=0.169 PS=0.92 PD=1.82
M$8625 \$2251 A|A_N|Y VGND VGND sky130_fd_pr__nfet_01v8 L=0.15 W=0.65 AS=0.169
+ AD=0.08775 PS=1.82 PD=0.92
M$8626 VGND A|A_N|Y \$2352 VGND sky130_fd_pr__nfet_01v8 L=0.15 W=0.65
+ AS=0.08775 AD=0.06825 PS=0.92 PD=0.86
M$8627 \$2352 B|Y \$2250 VGND sky130_fd_pr__nfet_01v8 L=0.15 W=0.65 AS=0.06825
+ AD=0.169 PS=0.86 PD=1.82
M$8628 \$2473 A|A_N|Y VGND VGND sky130_fd_pr__nfet_01v8 L=0.15 W=0.42 AS=0.1092
+ AD=0.10025 PS=1.36 PD=0.985
M$8629 VGND B|Y \$2534 VGND sky130_fd_pr__nfet_01v8 L=0.15 W=0.65 AS=0.10025
+ AD=0.08775 PS=0.985 PD=0.92
M$8630 \$2534 \$2473 A|Y VGND sky130_fd_pr__nfet_01v8 L=0.15 W=0.65 AS=0.08775
+ AD=0.169 PS=0.92 PD=1.82
M$8632 B|Y A|B|C|X VGND VGND sky130_fd_pr__nfet_01v8 L=0.15 W=0.65 AS=0.169
+ AD=0.08775 PS=1.82 PD=0.92
M$8635 B|Y \$2476 \$2519 VGND sky130_fd_pr__nfet_01v8 L=0.15 W=0.65 AS=0.195
+ AD=0.08775 PS=1.9 PD=0.92
M$8636 \$2519 B|X VGND VGND sky130_fd_pr__nfet_01v8 L=0.15 W=0.65 AS=0.08775
+ AD=0.169 PS=0.92 PD=1.82
M$8638 \$2519 A|B|X VGND VGND sky130_fd_pr__nfet_01v8 L=0.15 W=0.65 AS=0.169
+ AD=0.08775 PS=1.82 PD=0.92
M$8639 VGND A|B|X \$2531 VGND sky130_fd_pr__nfet_01v8 L=0.15 W=0.65 AS=0.08775
+ AD=0.06825 PS=0.92 PD=0.86
M$8640 \$2531 B|X \$2476 VGND sky130_fd_pr__nfet_01v8 L=0.15 W=0.65 AS=0.06825
+ AD=0.169 PS=0.86 PD=1.82
M$8641 \$2254 A|C1|Y VGND VGND sky130_fd_pr__nfet_01v8 L=0.15 W=0.42 AS=0.1092
+ AD=0.10025 PS=1.36 PD=0.985
M$8642 VGND B|C|SLEEP|Y A|B|C|X VGND sky130_fd_pr__nfet_01v8 L=0.15 W=0.65
+ AS=0.10025 AD=0.08775 PS=0.985 PD=0.92
M$8643 A|B|C|X \$2254 VGND VGND sky130_fd_pr__nfet_01v8 L=0.15 W=0.65
+ AS=0.08775 AD=0.169 PS=0.92 PD=1.82
M$8646 VGND \$2480 B|C|X VGND sky130_fd_pr__nfet_01v8 L=0.15 W=0.65 AS=0.208
+ AD=0.25025 PS=1.94 PD=1.42
M$8647 B|C|X B|X \$2530 VGND sky130_fd_pr__nfet_01v8 L=0.15 W=0.65 AS=0.25025
+ AD=0.08775 PS=1.42 PD=0.92
M$8648 \$2530 A|Y VGND VGND sky130_fd_pr__nfet_01v8 L=0.15 W=0.65 AS=0.08775
+ AD=0.08775 PS=0.92 PD=0.92
M$8649 VGND A|Y \$2480 VGND sky130_fd_pr__nfet_01v8 L=0.15 W=0.65 AS=0.08775
+ AD=0.08775 PS=0.92 PD=0.92
M$8650 \$2480 B|X VGND VGND sky130_fd_pr__nfet_01v8 L=0.15 W=0.65 AS=0.08775
+ AD=0.169 PS=0.92 PD=1.82
M$8651 C1|Y A|Y \$2529 VGND sky130_fd_pr__nfet_01v8 L=0.15 W=0.65 AS=0.169
+ AD=0.08775 PS=1.82 PD=0.92
M$8652 \$2529 B|X VGND VGND sky130_fd_pr__nfet_01v8 L=0.15 W=0.65 AS=0.08775
+ AD=0.169 PS=0.92 PD=1.82
M$8653 VGND \$2256 B|X VGND sky130_fd_pr__nfet_01v8 L=0.15 W=0.65 AS=0.208
+ AD=0.25025 PS=1.94 PD=1.42
M$8654 B|X B|X \$2378 VGND sky130_fd_pr__nfet_01v8 L=0.15 W=0.65 AS=0.25025
+ AD=0.08775 PS=1.42 PD=0.92
M$8655 \$2378 A|Y VGND VGND sky130_fd_pr__nfet_01v8 L=0.15 W=0.65 AS=0.08775
+ AD=0.08775 PS=0.92 PD=0.92
M$8656 VGND A|Y \$2256 VGND sky130_fd_pr__nfet_01v8 L=0.15 W=0.65 AS=0.08775
+ AD=0.08775 PS=0.92 PD=0.92
M$8657 \$2256 B|X VGND VGND sky130_fd_pr__nfet_01v8 L=0.15 W=0.65 AS=0.08775
+ AD=0.169 PS=0.92 PD=1.82
M$8658 VGND B|X \$2528 VGND sky130_fd_pr__nfet_01v8 L=0.15 W=0.65 AS=0.169
+ AD=0.08775 PS=1.82 PD=0.92
M$8659 \$2528 A|Y B1|Y VGND sky130_fd_pr__nfet_01v8 L=0.15 W=0.65 AS=0.08775
+ AD=0.169 PS=0.92 PD=1.82
M$8660 VGND \$2483 B|X VGND sky130_fd_pr__nfet_01v8 L=0.15 W=0.65 AS=0.208
+ AD=0.25025 PS=1.94 PD=1.42
M$8661 B|X A2|B|Y \$2527 VGND sky130_fd_pr__nfet_01v8 L=0.15 W=0.65 AS=0.25025
+ AD=0.08775 PS=1.42 PD=0.92
M$8662 \$2527 A|A1|Y VGND VGND sky130_fd_pr__nfet_01v8 L=0.15 W=0.65 AS=0.08775
+ AD=0.08775 PS=0.92 PD=0.92
M$8663 VGND A|A1|Y \$2483 VGND sky130_fd_pr__nfet_01v8 L=0.15 W=0.65 AS=0.08775
+ AD=0.08775 PS=0.92 PD=0.92
M$8664 \$2483 A2|B|Y VGND VGND sky130_fd_pr__nfet_01v8 L=0.15 W=0.65 AS=0.08775
+ AD=0.169 PS=0.92 PD=1.82
M$8665 C|Y D1|Y \$2383 VGND sky130_fd_pr__nfet_01v8 L=0.15 W=0.65 AS=0.17225
+ AD=0.06825 PS=1.83 PD=0.86
M$8666 \$2383 C1|Y \$2384 VGND sky130_fd_pr__nfet_01v8 L=0.15 W=0.65 AS=0.06825
+ AD=0.12675 PS=0.86 PD=1.04
M$8667 \$2384 B1|Y \$2261 VGND sky130_fd_pr__nfet_01v8 L=0.15 W=0.65 AS=0.12675
+ AD=0.131625 PS=1.04 PD=1.055
M$8668 \$2261 A2|B|Y VGND VGND sky130_fd_pr__nfet_01v8 L=0.15 W=0.65
+ AS=0.131625 AD=0.12675 PS=1.055 PD=1.04
M$8669 VGND A|A1|Y \$2261 VGND sky130_fd_pr__nfet_01v8 L=0.15 W=0.65 AS=0.12675
+ AD=0.17225 PS=1.04 PD=1.83
M$8672 B|C|SLEEP|Y \$2263 \$2264 VGND sky130_fd_pr__nfet_01v8 L=0.15 W=0.65
+ AS=0.195 AD=0.08775 PS=1.9 PD=0.92
M$8673 \$2264 B|B1|Y VGND VGND sky130_fd_pr__nfet_01v8 L=0.15 W=0.65 AS=0.08775
+ AD=0.169 PS=0.92 PD=1.82
M$8674 \$2264 A|B2|Y VGND VGND sky130_fd_pr__nfet_01v8 L=0.15 W=0.65 AS=0.169
+ AD=0.08775 PS=1.82 PD=0.92
M$8675 VGND A|B2|Y \$2396 VGND sky130_fd_pr__nfet_01v8 L=0.15 W=0.65 AS=0.08775
+ AD=0.06825 PS=0.92 PD=0.86
M$8676 \$2396 B|B1|Y \$2263 VGND sky130_fd_pr__nfet_01v8 L=0.15 W=0.65
+ AS=0.06825 AD=0.169 PS=0.86 PD=1.82
M$8677 VGND A|B2|Y \$2401 VGND sky130_fd_pr__nfet_01v8 L=0.15 W=0.65 AS=0.169
+ AD=0.07475 PS=1.82 PD=0.88
M$8678 \$2401 B|B1|Y A2|B|Y VGND sky130_fd_pr__nfet_01v8 L=0.15 W=0.65
+ AS=0.07475 AD=0.169 PS=0.88 PD=1.82
M$8679 A2|B|Y A1|Y \$2404 VGND sky130_fd_pr__nfet_01v8 L=0.15 W=0.65 AS=0.169
+ AD=0.06825 PS=1.82 PD=0.86
M$8680 \$2404 A|A2|Y VGND VGND sky130_fd_pr__nfet_01v8 L=0.15 W=0.65 AS=0.06825
+ AD=0.234 PS=0.86 PD=2.02
M$8683 A|A1|Y \$2484 \$2520 VGND sky130_fd_pr__nfet_01v8 L=0.15 W=0.65 AS=0.195
+ AD=0.08775 PS=1.9 PD=0.92
M$8684 \$2520 B|X VGND VGND sky130_fd_pr__nfet_01v8 L=0.15 W=0.65 AS=0.08775
+ AD=0.169 PS=0.92 PD=1.82
M$8686 \$2520 A|Y VGND VGND sky130_fd_pr__nfet_01v8 L=0.15 W=0.65 AS=0.169
+ AD=0.08775 PS=1.82 PD=0.92
M$8687 VGND A|Y \$2525 VGND sky130_fd_pr__nfet_01v8 L=0.15 W=0.65 AS=0.08775
+ AD=0.06825 PS=0.92 PD=0.86
M$8688 \$2525 B|X \$2484 VGND sky130_fd_pr__nfet_01v8 L=0.15 W=0.65 AS=0.06825
+ AD=0.169 PS=0.86 PD=1.82
M$8692 VGND A|Y D1|Y VGND sky130_fd_pr__nfet_01v8 L=0.15 W=0.65 AS=0.169
+ AD=0.08775 PS=1.82 PD=0.92
M$8693 D1|Y B|Y VGND VGND sky130_fd_pr__nfet_01v8 L=0.15 W=0.65 AS=0.08775
+ AD=0.08775 PS=0.92 PD=0.92
M$8694 VGND C|Y D1|Y VGND sky130_fd_pr__nfet_01v8 L=0.15 W=0.65 AS=0.08775
+ AD=0.169 PS=0.92 PD=1.82
M$8696 VGND \$2266 B|X VGND sky130_fd_pr__nfet_01v8 L=0.15 W=0.65 AS=0.208
+ AD=0.25025 PS=1.94 PD=1.42
M$8697 B|X B|B1|X \$2394 VGND sky130_fd_pr__nfet_01v8 L=0.15 W=0.65 AS=0.25025
+ AD=0.08775 PS=1.42 PD=0.92
M$8698 \$2394 A|Y VGND VGND sky130_fd_pr__nfet_01v8 L=0.15 W=0.65 AS=0.08775
+ AD=0.08775 PS=0.92 PD=0.92
M$8699 VGND A|Y \$2266 VGND sky130_fd_pr__nfet_01v8 L=0.15 W=0.65 AS=0.08775
+ AD=0.08775 PS=0.92 PD=0.92
M$8700 \$2266 B|B1|X VGND VGND sky130_fd_pr__nfet_01v8 L=0.15 W=0.65 AS=0.08775
+ AD=0.169 PS=0.92 PD=1.82
M$8702 VGND SLEEP|Y \$2267 VGND sky130_fd_pr__nfet_01v8 L=0.15 W=0.42
+ AS=0.10025 AD=0.0567 PS=0.985 PD=0.69
M$8703 \$2267 A|A2|B|Y VGND VGND sky130_fd_pr__nfet_01v8 L=0.15 W=0.42
+ AS=0.0567 AD=0.1092 PS=0.69 PD=1.36
M$8704 A2|X \$2267 VGND VGND sky130_fd_pr__nfet_01v8 L=0.15 W=0.65 AS=0.169
+ AD=0.10025 PS=1.82 PD=0.985
M$8706 A|Y A|A2|X \$2351 VGND sky130_fd_pr__nfet_01v8 L=0.15 W=0.65 AS=0.169
+ AD=0.08775 PS=1.82 PD=0.92
M$8707 \$2351 A3|B|Y VGND VGND sky130_fd_pr__nfet_01v8 L=0.15 W=0.65 AS=0.08775
+ AD=0.169 PS=0.92 PD=1.82
M$8709 VGND A2|B1|SLEEP|Y \$2268 VGND sky130_fd_pr__nfet_01v8 L=0.15 W=0.42
+ AS=0.10025 AD=0.0567 PS=0.985 PD=0.69
M$8710 \$2268 A|A1|B|B1|Y VGND VGND sky130_fd_pr__nfet_01v8 L=0.15 W=0.42
+ AS=0.0567 AD=0.1092 PS=0.69 PD=1.36
M$8711 A|A2|X \$2268 VGND VGND sky130_fd_pr__nfet_01v8 L=0.15 W=0.65 AS=0.169
+ AD=0.10025 PS=1.82 PD=0.985
M$8712 VGND \$2269 B|B1|X VGND sky130_fd_pr__nfet_01v8 L=0.15 W=0.65 AS=0.208
+ AD=0.25025 PS=1.94 PD=1.42
M$8713 B|B1|X B|Y \$2323 VGND sky130_fd_pr__nfet_01v8 L=0.15 W=0.65 AS=0.25025
+ AD=0.08775 PS=1.42 PD=0.92
M$8714 \$2323 A|A1|B|X VGND VGND sky130_fd_pr__nfet_01v8 L=0.15 W=0.65
+ AS=0.08775 AD=0.08775 PS=0.92 PD=0.92
M$8715 VGND A|A1|B|X \$2269 VGND sky130_fd_pr__nfet_01v8 L=0.15 W=0.65
+ AS=0.08775 AD=0.08775 PS=0.92 PD=0.92
M$8716 \$2269 B|Y VGND VGND sky130_fd_pr__nfet_01v8 L=0.15 W=0.65 AS=0.08775
+ AD=0.169 PS=0.92 PD=1.82
M$8717 B1|Y A2|C|Y VGND VGND sky130_fd_pr__nfet_01v8 L=0.15 W=0.65 AS=0.169
+ AD=0.08775 PS=1.82 PD=0.92
M$8718 VGND A|A1|B|X B1|Y VGND sky130_fd_pr__nfet_01v8 L=0.15 W=0.65 AS=0.08775
+ AD=0.08775 PS=0.92 PD=0.92
M$8719 B1|Y A|A1|B|C1|X VGND VGND sky130_fd_pr__nfet_01v8 L=0.15 W=0.65
+ AS=0.08775 AD=0.169 PS=0.92 PD=1.82
M$8721 VGND B|C|X \$2486 VGND sky130_fd_pr__nfet_01v8 L=0.15 W=0.42 AS=0.1165
+ AD=0.1785 PS=1.035 PD=1.69
M$8722 B|C|X \$2485 VGND VGND sky130_fd_pr__nfet_01v8 L=0.15 W=0.65 AS=0.169
+ AD=0.1165 PS=1.82 PD=1.035
M$8724 \$2489 B|C|X \$2485 VGND sky130_fd_pr__nfet_01v8 L=0.15 W=0.64 AS=0.1728
+ AD=0.0928 PS=1.82 PD=0.93
M$8725 \$2485 \$2486 \$2487 VGND sky130_fd_pr__nfet_01v8 L=0.15 W=0.64
+ AS=0.0928 AD=0.224 PS=0.93 PD=1.98
M$8726 VGND A|B|X \$2490 VGND sky130_fd_pr__nfet_01v8 L=0.15 W=0.65 AS=0.1885
+ AD=0.16515 PS=1.88 PD=1.82
M$8727 \$2491 A|B|X \$2487 VGND sky130_fd_pr__nfet_01v8 L=0.15 W=0.64
+ AS=0.16275 AD=0.18205 PS=1.8 PD=1.245
M$8728 \$2487 \$2490 \$2492 VGND sky130_fd_pr__nfet_01v8 L=0.15 W=0.42
+ AS=0.18205 AD=0.19265 PS=1.245 PD=1.285
M$8729 \$2492 A|B|X \$2489 VGND sky130_fd_pr__nfet_01v8 L=0.15 W=0.64
+ AS=0.19265 AD=0.140825 PS=1.285 PD=1.1
M$8730 \$2489 \$2490 \$2491 VGND sky130_fd_pr__nfet_01v8 L=0.15 W=0.6
+ AS=0.140825 AD=0.11 PS=1.1 PD=0.99
M$8731 \$2491 A|B|X VGND VGND sky130_fd_pr__nfet_01v8 L=0.15 W=0.64 AS=0.11
+ AD=0.0864 PS=0.99 PD=0.91
M$8732 VGND \$2491 \$2492 VGND sky130_fd_pr__nfet_01v8 L=0.15 W=0.64 AS=0.0864
+ AD=0.1824 PS=0.91 PD=1.85
M$8733 VGND C|X \$2293 VGND sky130_fd_pr__nfet_01v8 L=0.15 W=0.42 AS=0.1474
+ AD=0.0441 PS=1.215 PD=0.63
M$8734 \$2293 B|Y \$2270 VGND sky130_fd_pr__nfet_01v8 L=0.15 W=0.42 AS=0.0441
+ AD=0.0567 PS=0.63 PD=0.69
M$8735 \$2270 B|Y \$2291 VGND sky130_fd_pr__nfet_01v8 L=0.15 W=0.42 AS=0.0567
+ AD=0.0441 PS=0.69 PD=0.63
M$8736 \$2291 A|Y VGND VGND sky130_fd_pr__nfet_01v8 L=0.15 W=0.42 AS=0.0441
+ AD=0.0567 PS=0.63 PD=0.69
M$8737 VGND A|Y \$2289 VGND sky130_fd_pr__nfet_01v8 L=0.15 W=0.42 AS=0.0567
+ AD=0.0441 PS=0.69 PD=0.63
M$8738 \$2289 C|X \$2270 VGND sky130_fd_pr__nfet_01v8 L=0.15 W=0.42 AS=0.0441
+ AD=0.1092 PS=0.63 PD=1.36
M$8739 A2|B|X \$2270 VGND VGND sky130_fd_pr__nfet_01v8 L=0.15 W=0.65 AS=0.23725
+ AD=0.1474 PS=2.03 PD=1.215
M$8750 \$2457 C|SLEEP|Y \$2535 VGND sky130_fd_pr__nfet_01v8 L=0.15 W=0.42
+ AS=0.1092 AD=0.0441 PS=1.36 PD=0.63
M$8751 \$2535 A|Y VGND VGND sky130_fd_pr__nfet_01v8 L=0.15 W=0.42 AS=0.0441
+ AD=0.0567 PS=0.63 PD=0.69
M$8752 VGND A|Y \$2536 VGND sky130_fd_pr__nfet_01v8 L=0.15 W=0.42 AS=0.0567
+ AD=0.0441 PS=0.69 PD=0.63
M$8753 \$2536 A|B|Y \$2457 VGND sky130_fd_pr__nfet_01v8 L=0.15 W=0.42 AS=0.0441
+ AD=0.0567 PS=0.63 PD=0.69
M$8754 \$2457 A|B|Y \$2537 VGND sky130_fd_pr__nfet_01v8 L=0.15 W=0.42 AS=0.0567
+ AD=0.0441 PS=0.69 PD=0.63
M$8755 VGND C|SLEEP|Y \$2537 VGND sky130_fd_pr__nfet_01v8 L=0.15 W=0.42
+ AS=0.1474 AD=0.0441 PS=1.215 PD=0.63
M$8756 VGND \$2457 B|X VGND sky130_fd_pr__nfet_01v8 L=0.15 W=0.65 AS=0.1474
+ AD=0.23725 PS=1.215 PD=2.03
M$8757 VGND A|B|Y \$2459 VGND sky130_fd_pr__nfet_01v8 L=0.15 W=0.42 AS=0.1092
+ AD=0.0567 PS=1.36 PD=0.69
M$8758 VGND C|SLEEP|Y \$2459 VGND sky130_fd_pr__nfet_01v8 L=0.15 W=0.42
+ AS=0.10025 AD=0.0567 PS=0.985 PD=0.69
M$8759 VGND \$2459 A|A1|X VGND sky130_fd_pr__nfet_01v8 L=0.15 W=0.65 AS=0.10025
+ AD=0.169 PS=0.985 PD=1.82
M$8761 \$2521 A|A1|X VGND VGND sky130_fd_pr__nfet_01v8 L=0.15 W=0.42 AS=0.1113
+ AD=0.0588 PS=1.37 PD=0.7
M$8762 VGND A|A2|B|X \$2521 VGND sky130_fd_pr__nfet_01v8 L=0.15 W=0.42
+ AS=0.0588 AD=0.0588 PS=0.7 PD=0.7
M$8763 \$2521 A|B1|Y B|Y VGND sky130_fd_pr__nfet_01v8 L=0.15 W=0.42 AS=0.0588
+ AD=0.1113 PS=0.7 PD=1.37
M$8766 \$2464 C|X \$2541 VGND sky130_fd_pr__nfet_01v8 L=0.15 W=0.42 AS=0.1092
+ AD=0.0441 PS=1.36 PD=0.63
M$8767 \$2541 A|Y VGND VGND sky130_fd_pr__nfet_01v8 L=0.15 W=0.42 AS=0.0441
+ AD=0.0567 PS=0.63 PD=0.69
M$8768 VGND A|Y \$2540 VGND sky130_fd_pr__nfet_01v8 L=0.15 W=0.42 AS=0.0567
+ AD=0.0441 PS=0.69 PD=0.63
M$8769 \$2540 B|Y \$2464 VGND sky130_fd_pr__nfet_01v8 L=0.15 W=0.42 AS=0.0441
+ AD=0.0567 PS=0.63 PD=0.69
M$8770 \$2464 B|Y \$2539 VGND sky130_fd_pr__nfet_01v8 L=0.15 W=0.42 AS=0.0567
+ AD=0.0441 PS=0.69 PD=0.63
M$8771 VGND C|X \$2539 VGND sky130_fd_pr__nfet_01v8 L=0.15 W=0.42 AS=0.1474
+ AD=0.0441 PS=1.215 PD=0.63
M$8772 VGND \$2464 A2|B|X VGND sky130_fd_pr__nfet_01v8 L=0.15 W=0.65 AS=0.1474
+ AD=0.23725 PS=1.215 PD=2.03
M$8792 \$2542 A|FINE_MUX[2] VGND VGND sky130_fd_pr__nfet_01v8 L=0.15 W=0.42
+ AS=0.1134 AD=0.10435 PS=1.38 PD=1.01
M$8793 VGND \$2542 \$2543 VGND sky130_fd_pr__nfet_01v8 L=0.5 W=0.65 AS=0.10435
+ AD=0.169 PS=1.01 PD=1.82
M$8794 VGND A|FINE_MUX[0] \$2754 VGND sky130_fd_pr__nfet_01v8 L=0.15 W=0.42
+ AS=0.10435 AD=0.1134 PS=1.01 PD=1.38
M$8795 VGND \$2754 \$2755 VGND sky130_fd_pr__nfet_01v8 L=0.5 W=0.65 AS=0.10435
+ AD=0.169 PS=1.01 PD=1.82
M$8796 VGND \$2544 A|C|X VGND sky130_fd_pr__nfet_01v8 L=0.15 W=0.42 AS=0.097
+ AD=0.1491 PS=0.975 PD=1.55
M$8797 \$2544 \$2543 VGND VGND sky130_fd_pr__nfet_01v8 L=0.5 W=0.65 AS=0.17225
+ AD=0.097 PS=1.83 PD=0.975
M$8798 \$2756 \$2755 VGND VGND sky130_fd_pr__nfet_01v8 L=0.5 W=0.65 AS=0.17225
+ AD=0.097 PS=1.83 PD=0.975
M$8799 VGND \$2756 A|B|X VGND sky130_fd_pr__nfet_01v8 L=0.15 W=0.42 AS=0.097
+ AD=0.1491 PS=0.975 PD=1.55
M$8804 A1|Y A|B|Y \$2821 VGND sky130_fd_pr__nfet_01v8 L=0.15 W=0.65 AS=0.169
+ AD=0.08775 PS=1.82 PD=0.92
M$8805 \$2821 B|X VGND VGND sky130_fd_pr__nfet_01v8 L=0.15 W=0.65 AS=0.08775
+ AD=0.169 PS=0.92 PD=1.82
M$8806 VGND B|C|X \$2823 VGND sky130_fd_pr__nfet_01v8 L=0.15 W=0.65 AS=0.169
+ AD=0.08775 PS=1.82 PD=0.92
M$8807 \$2823 A|Y B|Y VGND sky130_fd_pr__nfet_01v8 L=0.15 W=0.65 AS=0.08775
+ AD=0.169 PS=0.92 PD=1.82
M$8808 VGND A2|B|C|X A|Y VGND sky130_fd_pr__nfet_01v8 L=0.15 W=0.65 AS=0.169
+ AD=0.08775 PS=1.82 PD=0.92
M$8810 VGND B|Y \$2825 VGND sky130_fd_pr__nfet_01v8 L=0.15 W=0.65 AS=0.169
+ AD=0.08775 PS=1.82 PD=0.92
M$8811 \$2825 A|C|X B|SLEEP|Y VGND sky130_fd_pr__nfet_01v8 L=0.15 W=0.65
+ AS=0.08775 AD=0.169 PS=0.92 PD=1.82
M$8812 A|Y A|X \$2609 VGND sky130_fd_pr__nfet_01v8 L=0.15 W=0.65 AS=0.169
+ AD=0.08775 PS=1.82 PD=0.92
M$8813 \$2609 A|B|X VGND VGND sky130_fd_pr__nfet_01v8 L=0.15 W=0.65 AS=0.08775
+ AD=0.169 PS=0.92 PD=1.82
M$8815 VGND \$2764 A|X VGND sky130_fd_pr__nfet_01v8 L=0.15 W=0.65 AS=0.208
+ AD=0.25025 PS=1.94 PD=1.42
M$8816 A|X B|X \$2826 VGND sky130_fd_pr__nfet_01v8 L=0.15 W=0.65 AS=0.25025
+ AD=0.08775 PS=1.42 PD=0.92
M$8817 \$2826 A|X VGND VGND sky130_fd_pr__nfet_01v8 L=0.15 W=0.65 AS=0.08775
+ AD=0.08775 PS=0.92 PD=0.92
M$8818 VGND A|X \$2764 VGND sky130_fd_pr__nfet_01v8 L=0.15 W=0.65 AS=0.08775
+ AD=0.08775 PS=0.92 PD=0.92
M$8819 \$2764 B|X VGND VGND sky130_fd_pr__nfet_01v8 L=0.15 W=0.65 AS=0.08775
+ AD=0.169 PS=0.92 PD=1.82
M$8820 A|B|Y A|X \$2612 VGND sky130_fd_pr__nfet_01v8 L=0.15 W=0.65 AS=0.169
+ AD=0.08775 PS=1.82 PD=0.92
M$8821 \$2612 B|X VGND VGND sky130_fd_pr__nfet_01v8 L=0.15 W=0.65 AS=0.08775
+ AD=0.169 PS=0.92 PD=1.82
M$8823 VGND \$2767 A|A0|B|SLEEP|X VGND sky130_fd_pr__nfet_01v8 L=0.15 W=0.65
+ AS=0.208 AD=0.25025 PS=1.94 PD=1.42
M$8824 A|A0|B|SLEEP|X B|Y \$2828 VGND sky130_fd_pr__nfet_01v8 L=0.15 W=0.65
+ AS=0.25025 AD=0.08775 PS=1.42 PD=0.92
M$8825 \$2828 A|B|Y VGND VGND sky130_fd_pr__nfet_01v8 L=0.15 W=0.65 AS=0.08775
+ AD=0.08775 PS=0.92 PD=0.92
M$8826 VGND A|B|Y \$2767 VGND sky130_fd_pr__nfet_01v8 L=0.15 W=0.65 AS=0.08775
+ AD=0.08775 PS=0.92 PD=0.92
M$8827 \$2767 B|Y VGND VGND sky130_fd_pr__nfet_01v8 L=0.15 W=0.65 AS=0.08775
+ AD=0.169 PS=0.92 PD=1.82
M$8828 VGND A|B|Y \$2622 VGND sky130_fd_pr__nfet_01v8 L=0.15 W=0.65 AS=0.169
+ AD=0.08775 PS=1.82 PD=0.92
M$8829 \$2622 A|Y B|Y VGND sky130_fd_pr__nfet_01v8 L=0.15 W=0.65 AS=0.08775
+ AD=0.169 PS=0.92 PD=1.82
M$8830 VGND A|B|Y A|A1_N|Y VGND sky130_fd_pr__nfet_01v8 L=0.15 W=1.3 AS=0.25675
+ AD=0.25675 PS=2.74 PD=2.74
M$8832 VGND A|Y A|B|Y VGND sky130_fd_pr__nfet_01v8 L=0.15 W=1.95 AS=0.43825
+ AD=0.26325 PS=4.625 PD=2.76
M$8833 A|B|Y A|B|Y VGND VGND sky130_fd_pr__nfet_01v8 L=0.15 W=1.95 AS=0.3445
+ AD=0.42575 PS=3.66 PD=4.56
M$8835 \$2815 A|B|Y VGND VGND sky130_fd_pr__nfet_01v8 L=0.15 W=0.65 AS=0.16515
+ AD=0.1885 PS=1.82 PD=1.88
M$8836 A2_N|B|Y \$2552 \$2553 VGND sky130_fd_pr__nfet_01v8 L=0.15 W=0.65
+ AS=0.195 AD=0.08775 PS=1.9 PD=0.92
M$8837 \$2553 B|C|X VGND VGND sky130_fd_pr__nfet_01v8 L=0.15 W=0.65 AS=0.08775
+ AD=0.169 PS=0.92 PD=1.82
M$8838 \$2770 \$2773 \$2772 VGND sky130_fd_pr__nfet_01v8 L=0.15 W=0.64 AS=0.224
+ AD=0.0928 PS=1.98 PD=0.93
M$8839 \$2772 B|C|X \$2771 VGND sky130_fd_pr__nfet_01v8 L=0.15 W=0.64 AS=0.0928
+ AD=0.1728 PS=0.93 PD=1.82
M$8840 \$2553 A|Y VGND VGND sky130_fd_pr__nfet_01v8 L=0.15 W=0.65 AS=0.169
+ AD=0.08775 PS=1.82 PD=0.92
M$8841 VGND A|Y \$2635 VGND sky130_fd_pr__nfet_01v8 L=0.15 W=0.65 AS=0.08775
+ AD=0.06825 PS=0.92 PD=0.86
M$8842 \$2635 B|C|X \$2552 VGND sky130_fd_pr__nfet_01v8 L=0.15 W=0.65
+ AS=0.06825 AD=0.169 PS=0.86 PD=1.82
M$8843 \$2773 B|C|X VGND VGND sky130_fd_pr__nfet_01v8 L=0.15 W=0.42 AS=0.1785
+ AD=0.1165 PS=1.69 PD=1.035
M$8844 VGND \$2772 A|B|B1|X VGND sky130_fd_pr__nfet_01v8 L=0.15 W=0.65
+ AS=0.1165 AD=0.169 PS=1.035 PD=1.82
M$8845 VGND B|C|X \$2641 VGND sky130_fd_pr__nfet_01v8 L=0.15 W=0.65 AS=0.169
+ AD=0.08775 PS=1.82 PD=0.92
M$8846 \$2641 A|B|Y A|Y VGND sky130_fd_pr__nfet_01v8 L=0.15 W=0.65 AS=0.08775
+ AD=0.169 PS=0.92 PD=1.82
M$8848 A|B|C|Y \$2556 \$2557 VGND sky130_fd_pr__nfet_01v8 L=0.15 W=0.65
+ AS=0.195 AD=0.08775 PS=1.9 PD=0.92
M$8849 \$2557 B|X VGND VGND sky130_fd_pr__nfet_01v8 L=0.15 W=0.65 AS=0.08775
+ AD=0.169 PS=0.92 PD=1.82
M$8850 \$2557 A|A2|B|X VGND VGND sky130_fd_pr__nfet_01v8 L=0.15 W=0.65 AS=0.169
+ AD=0.08775 PS=1.82 PD=0.92
M$8851 VGND A|A2|B|X \$2646 VGND sky130_fd_pr__nfet_01v8 L=0.15 W=0.65
+ AS=0.08775 AD=0.06825 PS=0.92 PD=0.86
M$8852 \$2646 B|X \$2556 VGND sky130_fd_pr__nfet_01v8 L=0.15 W=0.65 AS=0.06825
+ AD=0.169 PS=0.86 PD=1.82
M$8854 A|B1|Y A|A2|B|X VGND VGND sky130_fd_pr__nfet_01v8 L=0.15 W=0.65
+ AS=0.08775 AD=0.169 PS=0.92 PD=1.82
M$8857 A|Y A|A2|B|X VGND VGND sky130_fd_pr__nfet_01v8 L=0.15 W=1.3 AS=0.25675
+ AD=0.25675 PS=2.74 PD=2.74
M$8858 VGND \$2777 A2|B|X VGND sky130_fd_pr__nfet_01v8 L=0.15 W=0.65 AS=0.208
+ AD=0.25025 PS=1.94 PD=1.42
M$8859 A2|B|X B|Y \$2831 VGND sky130_fd_pr__nfet_01v8 L=0.15 W=0.65 AS=0.25025
+ AD=0.08775 PS=1.42 PD=0.92
M$8860 \$2831 A|B|B_N|X VGND VGND sky130_fd_pr__nfet_01v8 L=0.15 W=0.65
+ AS=0.08775 AD=0.08775 PS=0.92 PD=0.92
M$8861 VGND A|B|B_N|X \$2777 VGND sky130_fd_pr__nfet_01v8 L=0.15 W=0.65
+ AS=0.08775 AD=0.08775 PS=0.92 PD=0.92
M$8862 \$2777 B|Y VGND VGND sky130_fd_pr__nfet_01v8 L=0.15 W=0.65 AS=0.08775
+ AD=0.169 PS=0.92 PD=1.82
M$8863 VGND B|Y \$2659 VGND sky130_fd_pr__nfet_01v8 L=0.15 W=0.65 AS=0.169
+ AD=0.08775 PS=1.82 PD=0.92
M$8864 \$2659 A|B|B_N|X A|Y VGND sky130_fd_pr__nfet_01v8 L=0.15 W=0.65
+ AS=0.08775 AD=0.169 PS=0.92 PD=1.82
M$8866 VGND A|B|X \$2778 VGND sky130_fd_pr__nfet_01v8 L=0.15 W=0.65 AS=0.169
+ AD=0.08775 PS=1.82 PD=0.92
M$8867 \$2778 A|Y VGND VGND sky130_fd_pr__nfet_01v8 L=0.15 W=0.65 AS=0.08775
+ AD=0.08775 PS=0.92 PD=0.92
M$8868 VGND A|Y \$2833 VGND sky130_fd_pr__nfet_01v8 L=0.15 W=0.65 AS=0.08775
+ AD=0.08775 PS=0.92 PD=0.92
M$8869 \$2833 A|B|X A2|B|X VGND sky130_fd_pr__nfet_01v8 L=0.15 W=0.65
+ AS=0.08775 AD=0.25025 PS=0.92 PD=1.42
M$8870 A2|B|X \$2778 VGND VGND sky130_fd_pr__nfet_01v8 L=0.15 W=0.65 AS=0.25025
+ AD=0.208 PS=1.42 PD=1.94
M$8871 B|C|Y A|B|X VGND VGND sky130_fd_pr__nfet_01v8 L=0.15 W=0.42 AS=0.1092
+ AD=0.1197 PS=1.36 PD=1.41
M$8872 A|B|X \$2564 VGND VGND sky130_fd_pr__nfet_01v8 L=0.15 W=0.65 AS=0.169
+ AD=0.1165 PS=1.82 PD=1.035
M$8873 VGND B|B1|C|X \$2565 VGND sky130_fd_pr__nfet_01v8 L=0.15 W=0.42
+ AS=0.1165 AD=0.1785 PS=1.035 PD=1.69
M$8874 \$2566 B|B1|C|X \$2564 VGND sky130_fd_pr__nfet_01v8 L=0.15 W=0.64
+ AS=0.1728 AD=0.0928 PS=1.82 PD=0.93
M$8875 \$2564 \$2565 \$2567 VGND sky130_fd_pr__nfet_01v8 L=0.15 W=0.64
+ AS=0.0928 AD=0.224 PS=0.93 PD=1.98
M$8876 VGND A|B|B2|Y \$2568 VGND sky130_fd_pr__nfet_01v8 L=0.15 W=0.65
+ AS=0.1885 AD=0.16515 PS=1.88 PD=1.82
M$8877 \$2567 \$2568 \$2570 VGND sky130_fd_pr__nfet_01v8 L=0.15 W=0.42
+ AS=0.18205 AD=0.19265 PS=1.245 PD=1.285
M$8878 \$2566 \$2568 \$2569 VGND sky130_fd_pr__nfet_01v8 L=0.15 W=0.6
+ AS=0.140825 AD=0.11 PS=1.1 PD=0.99
M$8879 \$2569 A|Y VGND VGND sky130_fd_pr__nfet_01v8 L=0.15 W=0.64 AS=0.11
+ AD=0.0864 PS=0.99 PD=0.91
M$8880 VGND \$2569 \$2570 VGND sky130_fd_pr__nfet_01v8 L=0.15 W=0.64 AS=0.0864
+ AD=0.1824 PS=0.91 PD=1.85
M$8881 \$2569 A|B|B2|Y \$2567 VGND sky130_fd_pr__nfet_01v8 L=0.15 W=0.64
+ AS=0.16275 AD=0.18205 PS=1.8 PD=1.245
M$8882 \$2566 A|B|B2|Y \$2570 VGND sky130_fd_pr__nfet_01v8 L=0.15 W=0.64
+ AS=0.140825 AD=0.19265 PS=1.1 PD=1.285
M$8884 VGND A2|B|X \$2837 VGND sky130_fd_pr__nfet_01v8 L=0.15 W=0.65 AS=0.2665
+ AD=0.091 PS=2.12 PD=0.93
M$8885 \$2837 A|A1|Y B|Y VGND sky130_fd_pr__nfet_01v8 L=0.15 W=0.65 AS=0.091
+ AD=0.091 PS=0.93 PD=0.93
M$8886 B|Y B1|X VGND VGND sky130_fd_pr__nfet_01v8 L=0.15 W=0.65 AS=0.091
+ AD=0.10075 PS=0.93 PD=0.96
M$8887 VGND C1|X B|Y VGND sky130_fd_pr__nfet_01v8 L=0.15 W=0.65 AS=0.10075
+ AD=0.17225 PS=0.96 PD=1.83
M$8888 VGND A|B|B2|Y \$2678 VGND sky130_fd_pr__nfet_01v8 L=0.15 W=0.65
+ AS=0.17225 AD=0.06825 PS=1.83 PD=0.86
M$8889 \$2678 B|B1|C|X \$2571 VGND sky130_fd_pr__nfet_01v8 L=0.15 W=0.65
+ AS=0.06825 AD=0.143 PS=0.86 PD=1.09
M$8890 \$2571 A1|Y \$2682 VGND sky130_fd_pr__nfet_01v8 L=0.15 W=0.65 AS=0.143
+ AD=0.14625 PS=1.09 PD=1.1
M$8891 \$2682 A|A2|Y \$2683 VGND sky130_fd_pr__nfet_01v8 L=0.15 W=0.65
+ AS=0.14625 AD=0.0975 PS=1.1 PD=0.95
M$8892 \$2683 A3|X VGND VGND sky130_fd_pr__nfet_01v8 L=0.15 W=0.65 AS=0.0975
+ AD=0.167375 PS=0.95 PD=1.165
M$8893 VGND \$2571 A|B|X VGND sky130_fd_pr__nfet_01v8 L=0.15 W=0.65 AS=0.167375
+ AD=0.2145 PS=1.165 PD=1.96
M$8895 A|SLEEP|Y \$2786 \$2817 VGND sky130_fd_pr__nfet_01v8 L=0.15 W=0.65
+ AS=0.195 AD=0.08775 PS=1.9 PD=0.92
M$8896 \$2817 B|Y VGND VGND sky130_fd_pr__nfet_01v8 L=0.15 W=0.65 AS=0.08775
+ AD=0.169 PS=0.92 PD=1.82
M$8897 \$2817 A|A2|Y VGND VGND sky130_fd_pr__nfet_01v8 L=0.15 W=0.65 AS=0.169
+ AD=0.08775 PS=1.82 PD=0.92
M$8898 VGND A|A2|Y \$2836 VGND sky130_fd_pr__nfet_01v8 L=0.15 W=0.65 AS=0.08775
+ AD=0.06825 PS=0.92 PD=0.86
M$8899 \$2836 B|Y \$2786 VGND sky130_fd_pr__nfet_01v8 L=0.15 W=0.65 AS=0.06825
+ AD=0.169 PS=0.86 PD=1.82
M$8900 VGND A|A2|Y B|Y VGND sky130_fd_pr__nfet_01v8 L=0.15 W=0.65 AS=0.169
+ AD=0.08775 PS=1.82 PD=0.92
M$8901 B|Y B|Y VGND VGND sky130_fd_pr__nfet_01v8 L=0.15 W=3.25 AS=0.76375
+ AD=0.52 PS=8.2 PD=5.5
M$8902 B|Y \$2575 \$2576 VGND sky130_fd_pr__nfet_01v8 L=0.15 W=0.65 AS=0.195
+ AD=0.08775 PS=1.9 PD=0.92
M$8903 \$2576 B|Y VGND VGND sky130_fd_pr__nfet_01v8 L=0.15 W=0.65 AS=0.08775
+ AD=0.169 PS=0.92 PD=1.82
M$8904 \$2576 A|Y VGND VGND sky130_fd_pr__nfet_01v8 L=0.15 W=0.65 AS=0.169
+ AD=0.08775 PS=1.82 PD=0.92
M$8905 VGND A|Y \$2698 VGND sky130_fd_pr__nfet_01v8 L=0.15 W=0.65 AS=0.08775
+ AD=0.06825 PS=0.92 PD=0.86
M$8906 \$2698 B|Y \$2575 VGND sky130_fd_pr__nfet_01v8 L=0.15 W=0.65 AS=0.06825
+ AD=0.169 PS=0.86 PD=1.82
M$8909 VGND A|Y \$2577 VGND sky130_fd_pr__nfet_01v8 L=0.15 W=0.42 AS=0.101875
+ AD=0.0567 PS=0.99 PD=0.69
M$8910 \$2577 B|Y VGND VGND sky130_fd_pr__nfet_01v8 L=0.15 W=0.42 AS=0.0567
+ AD=0.0567 PS=0.69 PD=0.69
M$8911 VGND C|Y \$2577 VGND sky130_fd_pr__nfet_01v8 L=0.15 W=0.42 AS=0.0567
+ AD=0.0693 PS=0.69 PD=0.75
M$8912 \$2577 D|X VGND VGND sky130_fd_pr__nfet_01v8 L=0.15 W=0.42 AS=0.0693
+ AD=0.1092 PS=0.75 PD=1.36
M$8913 B1|X \$2577 VGND VGND sky130_fd_pr__nfet_01v8 L=0.15 W=0.65 AS=0.1755
+ AD=0.101875 PS=1.84 PD=0.99
M$8915 \$2579 B|C|X \$2707 VGND sky130_fd_pr__nfet_01v8 L=0.15 W=0.42 AS=0.1092
+ AD=0.0441 PS=1.36 PD=0.63
M$8916 \$2707 A|B|X VGND VGND sky130_fd_pr__nfet_01v8 L=0.15 W=0.42 AS=0.0441
+ AD=0.0567 PS=0.63 PD=0.69
M$8917 VGND A|B|X \$2708 VGND sky130_fd_pr__nfet_01v8 L=0.15 W=0.42 AS=0.0567
+ AD=0.0441 PS=0.69 PD=0.63
M$8918 \$2708 A|B|C|X \$2579 VGND sky130_fd_pr__nfet_01v8 L=0.15 W=0.42
+ AS=0.0441 AD=0.0567 PS=0.63 PD=0.69
M$8919 \$2579 A|B|C|X \$2709 VGND sky130_fd_pr__nfet_01v8 L=0.15 W=0.42
+ AS=0.0567 AD=0.0441 PS=0.69 PD=0.63
M$8920 \$2709 B|C|X VGND VGND sky130_fd_pr__nfet_01v8 L=0.15 W=0.42 AS=0.0441
+ AD=0.1474 PS=0.63 PD=1.215
M$8921 VGND \$2579 D|X VGND sky130_fd_pr__nfet_01v8 L=0.15 W=0.65 AS=0.1474
+ AD=0.23725 PS=1.215 PD=2.03
M$8922 VGND \$2789 B|X VGND sky130_fd_pr__nfet_01v8 L=0.15 W=0.65 AS=0.208
+ AD=0.25025 PS=1.94 PD=1.42
M$8923 B|X B|C|X \$2832 VGND sky130_fd_pr__nfet_01v8 L=0.15 W=0.65 AS=0.25025
+ AD=0.08775 PS=1.42 PD=0.92
M$8924 \$2832 A|B|C|X VGND VGND sky130_fd_pr__nfet_01v8 L=0.15 W=0.65
+ AS=0.08775 AD=0.08775 PS=0.92 PD=0.92
M$8925 VGND A|B|C|X \$2789 VGND sky130_fd_pr__nfet_01v8 L=0.15 W=0.65
+ AS=0.08775 AD=0.08775 PS=0.92 PD=0.92
M$8926 \$2789 B|C|X VGND VGND sky130_fd_pr__nfet_01v8 L=0.15 W=0.65 AS=0.08775
+ AD=0.169 PS=0.92 PD=1.82
M$8941 VGND B|C|X \$2580 VGND sky130_fd_pr__nfet_01v8 L=0.15 W=0.65 AS=0.169
+ AD=0.08775 PS=1.82 PD=0.92
M$8942 \$2580 A|B|X VGND VGND sky130_fd_pr__nfet_01v8 L=0.15 W=0.65 AS=0.08775
+ AD=0.08775 PS=0.92 PD=0.92
M$8943 VGND A|B|X \$2613 VGND sky130_fd_pr__nfet_01v8 L=0.15 W=0.65 AS=0.08775
+ AD=0.08775 PS=0.92 PD=0.92
M$8944 \$2613 B|C|X C|X VGND sky130_fd_pr__nfet_01v8 L=0.15 W=0.65 AS=0.08775
+ AD=0.25025 PS=0.92 PD=1.42
M$8945 C|X \$2580 VGND VGND sky130_fd_pr__nfet_01v8 L=0.15 W=0.65 AS=0.25025
+ AD=0.208 PS=1.42 PD=1.94
M$8946 \$2795 A2|B|X \$2822 VGND sky130_fd_pr__nfet_01v8 L=0.15 W=0.65 AS=0.169
+ AD=0.06825 PS=1.82 PD=0.86
M$8947 \$2822 A|A1|X VGND VGND sky130_fd_pr__nfet_01v8 L=0.15 W=0.65 AS=0.06825
+ AD=0.08775 PS=0.86 PD=0.92
M$8948 VGND A|A1|X \$2818 VGND sky130_fd_pr__nfet_01v8 L=0.15 W=0.65 AS=0.08775
+ AD=0.169 PS=0.92 PD=1.82
M$8950 VGND A2|B|X \$2818 VGND sky130_fd_pr__nfet_01v8 L=0.15 W=0.65 AS=0.169
+ AD=0.08775 PS=1.82 PD=0.92
M$8951 \$2818 \$2795 A|A1|B|Y VGND sky130_fd_pr__nfet_01v8 L=0.15 W=0.65
+ AS=0.08775 AD=0.195 PS=0.92 PD=1.9
M$8952 A|B|X \$2582 VGND VGND sky130_fd_pr__nfet_01v8 L=0.15 W=0.42 AS=0.1491
+ AD=0.097 PS=1.55 PD=0.975
M$8953 VGND \$2583 \$2582 VGND sky130_fd_pr__nfet_01v8 L=0.5 W=0.65 AS=0.097
+ AD=0.17225 PS=0.975 PD=1.83
M$8954 VGND \$2796 A|B|X VGND sky130_fd_pr__nfet_01v8 L=0.15 W=0.42 AS=0.097
+ AD=0.1491 PS=0.975 PD=1.55
M$8955 VGND \$2797 \$2796 VGND sky130_fd_pr__nfet_01v8 L=0.5 W=0.65 AS=0.097
+ AD=0.17225 PS=0.975 PD=1.83
M$8956 VGND A|COARSE_MUX[6] \$2584 VGND sky130_fd_pr__nfet_01v8 L=0.15 W=0.42
+ AS=0.10435 AD=0.1134 PS=1.01 PD=1.38
M$8957 \$2583 \$2584 VGND VGND sky130_fd_pr__nfet_01v8 L=0.5 W=0.65 AS=0.169
+ AD=0.10435 PS=1.82 PD=1.01
M$8958 \$2797 \$2798 VGND VGND sky130_fd_pr__nfet_01v8 L=0.5 W=0.65 AS=0.169
+ AD=0.10435 PS=1.82 PD=1.01
M$8959 VGND A|COARSE_MUX[5] \$2798 VGND sky130_fd_pr__nfet_01v8 L=0.15 W=0.42
+ AS=0.10435 AD=0.1134 PS=1.01 PD=1.38
M$8960 A_N|B|C|X \$2840 VGND VGND sky130_fd_pr__nfet_01v8 L=0.15 W=0.65
+ AS=0.169 AD=0.144125 PS=1.82 PD=1.12
M$8961 VGND A|C|X \$2841 VGND sky130_fd_pr__nfet_01v8 L=0.15 W=0.42 AS=0.144125
+ AD=0.1764 PS=1.12 PD=1.68
M$8963 VGND A|B|X \$2844 VGND sky130_fd_pr__nfet_01v8 L=0.15 W=0.65 AS=0.195
+ AD=0.1653 PS=1.9 PD=1.82
M$8964 \$2842 \$2844 \$2846 VGND sky130_fd_pr__nfet_01v8 L=0.15 W=0.42
+ AS=0.18365 AD=0.19265 PS=1.25 PD=1.285
M$8965 \$2843 \$2844 \$2845 VGND sky130_fd_pr__nfet_01v8 L=0.15 W=0.6
+ AS=0.140825 AD=0.11 PS=1.1 PD=0.99
M$8966 \$2845 A|X VGND VGND sky130_fd_pr__nfet_01v8 L=0.15 W=0.64 AS=0.11
+ AD=0.0864 PS=0.99 PD=0.91
M$8967 VGND \$2845 \$2846 VGND sky130_fd_pr__nfet_01v8 L=0.15 W=0.64 AS=0.0864
+ AD=0.1824 PS=0.91 PD=1.85
M$8968 \$2845 A|B|X \$2842 VGND sky130_fd_pr__nfet_01v8 L=0.15 W=0.64 AS=0.1628
+ AD=0.18365 PS=1.8 PD=1.25
M$8969 \$2843 A|B|X \$2846 VGND sky130_fd_pr__nfet_01v8 L=0.15 W=0.64
+ AS=0.140825 AD=0.19265 PS=1.1 PD=1.285
M$8970 VGND A|X \$2848 VGND sky130_fd_pr__nfet_01v8 L=0.15 W=0.42 AS=0.101875
+ AD=0.0567 PS=0.99 PD=0.69
M$8971 \$2848 A|B|X VGND VGND sky130_fd_pr__nfet_01v8 L=0.15 W=0.42 AS=0.0567
+ AD=0.0567 PS=0.69 PD=0.69
M$8972 VGND A|C|X \$2848 VGND sky130_fd_pr__nfet_01v8 L=0.15 W=0.42 AS=0.0567
+ AD=0.1092 PS=0.69 PD=1.36
M$8973 A|X \$2848 VGND VGND sky130_fd_pr__nfet_01v8 L=0.15 W=0.65 AS=0.182
+ AD=0.101875 PS=1.86 PD=0.99
M$8978 VGND A|C|X \$2886 VGND sky130_fd_pr__nfet_01v8 L=0.15 W=0.65 AS=0.169
+ AD=0.08775 PS=1.82 PD=0.92
M$8979 \$2886 A|B|X \$2889 VGND sky130_fd_pr__nfet_01v8 L=0.15 W=0.65
+ AS=0.08775 AD=0.10725 PS=0.92 PD=0.98
M$8980 \$2889 A|X A|B|Y VGND sky130_fd_pr__nfet_01v8 L=0.15 W=0.65 AS=0.10725
+ AD=0.169 PS=0.98 PD=1.82
M$8982 \$2849 A|C|X \$2897 VGND sky130_fd_pr__nfet_01v8 L=0.15 W=0.42 AS=0.1092
+ AD=0.0441 PS=1.36 PD=0.63
M$8983 \$2897 A|X VGND VGND sky130_fd_pr__nfet_01v8 L=0.15 W=0.42 AS=0.0441
+ AD=0.0567 PS=0.63 PD=0.69
M$8984 VGND A|X \$2899 VGND sky130_fd_pr__nfet_01v8 L=0.15 W=0.42 AS=0.0567
+ AD=0.0441 PS=0.69 PD=0.63
M$8985 \$2899 A|B|X \$2849 VGND sky130_fd_pr__nfet_01v8 L=0.15 W=0.42 AS=0.0441
+ AD=0.0567 PS=0.63 PD=0.69
M$8986 \$2849 A|B|X \$2900 VGND sky130_fd_pr__nfet_01v8 L=0.15 W=0.42 AS=0.0567
+ AD=0.0441 PS=0.69 PD=0.63
M$8987 \$2900 A|C|X VGND VGND sky130_fd_pr__nfet_01v8 L=0.15 W=0.42 AS=0.0441
+ AD=0.1474 PS=0.63 PD=1.215
M$8988 VGND \$2849 B|X VGND sky130_fd_pr__nfet_01v8 L=0.15 W=0.65 AS=0.1474
+ AD=0.23725 PS=1.215 PD=2.03
M$8992 A|B1|Y \$2850 \$2851 VGND sky130_fd_pr__nfet_01v8 L=0.15 W=0.65 AS=0.195
+ AD=0.08775 PS=1.9 PD=0.92
M$8993 \$2851 B|SLEEP|Y VGND VGND sky130_fd_pr__nfet_01v8 L=0.15 W=0.65
+ AS=0.08775 AD=0.169 PS=0.92 PD=1.82
M$8994 \$2851 A|X VGND VGND sky130_fd_pr__nfet_01v8 L=0.15 W=0.65 AS=0.169
+ AD=0.08775 PS=1.82 PD=0.92
M$8995 VGND A|X \$2913 VGND sky130_fd_pr__nfet_01v8 L=0.15 W=0.65 AS=0.08775
+ AD=0.06825 PS=0.92 PD=0.86
M$8996 \$2913 B|SLEEP|Y \$2850 VGND sky130_fd_pr__nfet_01v8 L=0.15 W=0.65
+ AS=0.06825 AD=0.169 PS=0.86 PD=1.82
M$8997 \$2852 A|X VGND VGND sky130_fd_pr__nfet_01v8 L=0.15 W=0.42 AS=0.1092
+ AD=0.10025 PS=1.36 PD=0.985
M$8998 VGND B|SLEEP|Y A|A1|X VGND sky130_fd_pr__nfet_01v8 L=0.15 W=1.3
+ AS=0.2005 AD=0.1755 PS=1.97 PD=1.84
M$8999 A|A1|X \$2852 VGND VGND sky130_fd_pr__nfet_01v8 L=0.15 W=0.65 AS=0.08775
+ AD=0.169 PS=0.92 PD=1.82
M$9003 \$2771 A|B|Y \$2768 VGND sky130_fd_pr__nfet_01v8 L=0.15 W=0.64
+ AS=0.140825 AD=0.19265 PS=1.1 PD=1.285
M$9004 \$2768 \$2815 \$2770 VGND sky130_fd_pr__nfet_01v8 L=0.15 W=0.42
+ AS=0.19265 AD=0.18205 PS=1.285 PD=1.245
M$9005 \$2770 A|B|Y \$2769 VGND sky130_fd_pr__nfet_01v8 L=0.15 W=0.64
+ AS=0.18205 AD=0.16275 PS=1.245 PD=1.8
M$9006 \$2768 \$2769 VGND VGND sky130_fd_pr__nfet_01v8 L=0.15 W=0.64 AS=0.1824
+ AD=0.0864 PS=1.85 PD=0.91
M$9007 VGND A|A1_N|Y \$2769 VGND sky130_fd_pr__nfet_01v8 L=0.15 W=0.64
+ AS=0.0864 AD=0.11 PS=0.91 PD=0.99
M$9008 \$2771 \$2815 \$2769 VGND sky130_fd_pr__nfet_01v8 L=0.15 W=0.6
+ AS=0.140825 AD=0.11 PS=1.1 PD=0.99
M$9010 A|Y A|A1_N|Y \$2929 VGND sky130_fd_pr__nfet_01v8 L=0.15 W=0.65 AS=0.169
+ AD=0.08775 PS=1.82 PD=0.92
M$9011 \$2929 A2_N|B|Y VGND VGND sky130_fd_pr__nfet_01v8 L=0.15 W=0.65
+ AS=0.08775 AD=0.169 PS=0.92 PD=1.82
M$9018 A|B|Y A|B1|Y \$2947 VGND sky130_fd_pr__nfet_01v8 L=0.15 W=0.65 AS=0.169
+ AD=0.08775 PS=1.82 PD=0.92
M$9019 \$2947 B|C|Y VGND VGND sky130_fd_pr__nfet_01v8 L=0.15 W=0.65 AS=0.08775
+ AD=0.169 PS=0.92 PD=1.82
M$9021 \$2781 A|Y \$2834 VGND sky130_fd_pr__nfet_01v8 L=0.15 W=0.42 AS=0.1092
+ AD=0.0441 PS=1.36 PD=0.63
M$9022 \$2834 A|B|B_N|X \$2835 VGND sky130_fd_pr__nfet_01v8 L=0.15 W=0.42
+ AS=0.0441 AD=0.0441 PS=0.63 PD=0.63
M$9023 VGND B|C|Y \$2835 VGND sky130_fd_pr__nfet_01v8 L=0.15 W=0.42 AS=0.13165
+ AD=0.0441 PS=1.14 PD=0.63
M$9024 VGND \$2781 A|X VGND sky130_fd_pr__nfet_01v8 L=0.15 W=0.65 AS=0.13165
+ AD=0.169 PS=1.14 PD=1.82
M$9026 A|Y A|X \$2955 VGND sky130_fd_pr__nfet_01v8 L=0.15 W=0.65 AS=0.169
+ AD=0.08775 PS=1.82 PD=0.92
M$9027 \$2955 B|X VGND VGND sky130_fd_pr__nfet_01v8 L=0.15 W=0.65 AS=0.08775
+ AD=0.169 PS=0.92 PD=1.82
M$9029 VGND \$2858 B|X VGND sky130_fd_pr__nfet_01v8 L=0.15 W=0.65 AS=0.208
+ AD=0.25025 PS=1.94 PD=1.42
M$9030 B|X A2|B|X \$2959 VGND sky130_fd_pr__nfet_01v8 L=0.15 W=0.65 AS=0.25025
+ AD=0.08775 PS=1.42 PD=0.92
M$9031 \$2959 A|A1|Y VGND VGND sky130_fd_pr__nfet_01v8 L=0.15 W=0.65 AS=0.08775
+ AD=0.08775 PS=0.92 PD=0.92
M$9032 VGND A|A1|Y \$2858 VGND sky130_fd_pr__nfet_01v8 L=0.15 W=0.65 AS=0.08775
+ AD=0.08775 PS=0.92 PD=0.92
M$9033 \$2858 A2|B|X VGND VGND sky130_fd_pr__nfet_01v8 L=0.15 W=0.65 AS=0.08775
+ AD=0.169 PS=0.92 PD=1.82
M$9034 A|A1|Y \$2859 \$2860 VGND sky130_fd_pr__nfet_01v8 L=0.15 W=0.65 AS=0.195
+ AD=0.08775 PS=1.9 PD=0.92
M$9035 \$2860 A|B|X VGND VGND sky130_fd_pr__nfet_01v8 L=0.15 W=0.65 AS=0.08775
+ AD=0.169 PS=0.92 PD=1.82
M$9036 \$2860 A|SLEEP|Y VGND VGND sky130_fd_pr__nfet_01v8 L=0.15 W=0.65
+ AS=0.169 AD=0.08775 PS=1.82 PD=0.92
M$9037 VGND A|SLEEP|Y \$2968 VGND sky130_fd_pr__nfet_01v8 L=0.15 W=0.65
+ AS=0.08775 AD=0.06825 PS=0.92 PD=0.86
M$9038 \$2968 A|B|X \$2859 VGND sky130_fd_pr__nfet_01v8 L=0.15 W=0.65
+ AS=0.06825 AD=0.169 PS=0.86 PD=1.82
M$9040 VGND A|B|X \$2862 VGND sky130_fd_pr__nfet_01v8 L=0.15 W=0.42 AS=0.10025
+ AD=0.1092 PS=0.985 PD=1.36
M$9041 VGND \$2862 C1|X VGND sky130_fd_pr__nfet_01v8 L=0.15 W=0.65 AS=0.169
+ AD=0.08775 PS=1.82 PD=0.92
M$9042 C1|X A|SLEEP|Y VGND VGND sky130_fd_pr__nfet_01v8 L=0.15 W=0.65
+ AS=0.08775 AD=0.10025 PS=0.92 PD=0.985
M$9078 \$2790 A|B1_N|Y VGND VGND sky130_fd_pr__nfet_01v8 L=0.15 W=0.42
+ AS=0.1113 AD=0.1302 PS=1.37 PD=1.04
M$9079 VGND \$2790 B1|C|Y VGND sky130_fd_pr__nfet_01v8 L=0.15 W=0.42 AS=0.1302
+ AD=0.1113 PS=1.04 PD=0.95
M$9080 B1|C|Y A|A1|X \$2824 VGND sky130_fd_pr__nfet_01v8 L=0.15 W=0.42
+ AS=0.1113 AD=0.0441 PS=0.95 PD=0.63
M$9081 \$2824 A2|B|X VGND VGND sky130_fd_pr__nfet_01v8 L=0.15 W=0.42 AS=0.0441
+ AD=0.1113 PS=0.63 PD=1.37
M$9082 VGND A2|B|C|X \$2864 VGND sky130_fd_pr__nfet_01v8 L=0.15 W=0.65 AS=0.169
+ AD=0.08775 PS=1.82 PD=0.92
M$9083 \$2864 A|A1|D|X VGND VGND sky130_fd_pr__nfet_01v8 L=0.15 W=0.65
+ AS=0.08775 AD=0.08775 PS=0.92 PD=0.92
M$9084 VGND A|A1|D|X \$2890 VGND sky130_fd_pr__nfet_01v8 L=0.15 W=0.65
+ AS=0.08775 AD=0.08775 PS=0.92 PD=0.92
M$9085 \$2890 A2|B|C|X C|X VGND sky130_fd_pr__nfet_01v8 L=0.15 W=0.65
+ AS=0.08775 AD=0.25025 PS=0.92 PD=1.42
M$9086 C|X \$2864 VGND VGND sky130_fd_pr__nfet_01v8 L=0.15 W=0.65 AS=0.25025
+ AD=0.208 PS=1.42 PD=1.94
M$9087 VGND C|X \$2879 VGND sky130_fd_pr__nfet_01v8 L=0.15 W=0.42 AS=0.1474
+ AD=0.0441 PS=1.215 PD=0.63
M$9088 \$2879 A|B|X \$2867 VGND sky130_fd_pr__nfet_01v8 L=0.15 W=0.42 AS=0.0441
+ AD=0.0567 PS=0.63 PD=0.69
M$9089 \$2867 A|B|X \$2878 VGND sky130_fd_pr__nfet_01v8 L=0.15 W=0.42 AS=0.0567
+ AD=0.0441 PS=0.69 PD=0.63
M$9090 \$2878 A|B|X VGND VGND sky130_fd_pr__nfet_01v8 L=0.15 W=0.42 AS=0.0441
+ AD=0.0567 PS=0.63 PD=0.69
M$9091 VGND A|B|X \$2876 VGND sky130_fd_pr__nfet_01v8 L=0.15 W=0.42 AS=0.0567
+ AD=0.0441 PS=0.69 PD=0.63
M$9092 \$2876 C|X \$2867 VGND sky130_fd_pr__nfet_01v8 L=0.15 W=0.42 AS=0.0441
+ AD=0.1092 PS=0.63 PD=1.36
M$9093 A2|B|X \$2867 VGND VGND sky130_fd_pr__nfet_01v8 L=0.15 W=0.65 AS=0.23725
+ AD=0.1474 PS=2.03 PD=1.215
M$9095 VGND A|FINE_MUX[1] \$3024 VGND sky130_fd_pr__nfet_01v8 L=0.15 W=0.42
+ AS=0.10435 AD=0.1134 PS=1.01 PD=1.38
M$9096 VGND \$3024 \$3025 VGND sky130_fd_pr__nfet_01v8 L=0.5 W=0.65 AS=0.10435
+ AD=0.169 PS=1.01 PD=1.82
M$9097 \$3026 \$3025 VGND VGND sky130_fd_pr__nfet_01v8 L=0.5 W=0.65 AS=0.17225
+ AD=0.097 PS=1.83 PD=0.975
M$9098 VGND \$3026 A|X VGND sky130_fd_pr__nfet_01v8 L=0.15 W=0.42 AS=0.097
+ AD=0.1491 PS=0.975 PD=1.55
M$9099 \$2842 A|C|X \$2840 VGND sky130_fd_pr__nfet_01v8 L=0.15 W=0.64 AS=0.1728
+ AD=0.128 PS=1.82 PD=1.04
M$9100 \$2840 \$2841 \$2843 VGND sky130_fd_pr__nfet_01v8 L=0.15 W=0.64 AS=0.128
+ AD=0.3168 PS=1.04 PD=2.27
M$9102 VGND A|B|Y \$3084 VGND sky130_fd_pr__nfet_01v8 L=0.15 W=0.65 AS=0.169
+ AD=0.08775 PS=1.82 PD=0.92
M$9103 \$3084 A|X B|Y VGND sky130_fd_pr__nfet_01v8 L=0.15 W=0.65 AS=0.08775
+ AD=0.169 PS=0.92 PD=1.82
M$9104 VGND \$3031 A2|C|X VGND sky130_fd_pr__nfet_01v8 L=0.15 W=0.65 AS=0.208
+ AD=0.25025 PS=1.94 PD=1.42
M$9105 A2|C|X A2|B|C|X \$3087 VGND sky130_fd_pr__nfet_01v8 L=0.15 W=0.65
+ AS=0.25025 AD=0.08775 PS=1.42 PD=0.92
M$9106 \$3087 A|B|Y VGND VGND sky130_fd_pr__nfet_01v8 L=0.15 W=0.65 AS=0.08775
+ AD=0.08775 PS=0.92 PD=0.92
M$9107 VGND A|B|Y \$3031 VGND sky130_fd_pr__nfet_01v8 L=0.15 W=0.65 AS=0.08775
+ AD=0.08775 PS=0.92 PD=0.92
M$9108 \$3031 A2|B|C|X VGND VGND sky130_fd_pr__nfet_01v8 L=0.15 W=0.65
+ AS=0.08775 AD=0.169 PS=0.92 PD=1.82
M$9111 A|B|Y A2|B|C|X VGND VGND sky130_fd_pr__nfet_01v8 L=0.15 W=0.65
+ AS=0.08775 AD=0.169 PS=0.92 PD=1.82
M$9113 VGND A1|Y \$3078 VGND sky130_fd_pr__nfet_01v8 L=0.15 W=0.65 AS=0.169
+ AD=0.08775 PS=1.82 PD=0.92
M$9114 \$3078 A2|B|C|X VGND VGND sky130_fd_pr__nfet_01v8 L=0.15 W=0.65
+ AS=0.08775 AD=0.08775 PS=0.92 PD=0.92
M$9115 VGND A3|Y \$3078 VGND sky130_fd_pr__nfet_01v8 L=0.15 W=0.65 AS=0.08775
+ AD=0.19825 PS=0.92 PD=1.26
M$9116 \$3078 A|B|B1|C1|X B|B_N|Y VGND sky130_fd_pr__nfet_01v8 L=0.15 W=0.65
+ AS=0.19825 AD=0.221 PS=1.26 PD=1.98
M$9123 A|A1|Y A|B|C|Y VGND VGND sky130_fd_pr__nfet_01v8 L=0.15 W=1.3 AS=0.1755
+ AD=0.25675 PS=1.84 PD=2.74
M$9126 VGND B|C|Y A|A1|Y VGND sky130_fd_pr__nfet_01v8 L=0.15 W=0.65 AS=0.08775
+ AD=0.169 PS=0.92 PD=1.82
M$9127 B|C|Y \$3043 \$3079 VGND sky130_fd_pr__nfet_01v8 L=0.15 W=0.65 AS=0.195
+ AD=0.08775 PS=1.9 PD=0.92
M$9128 \$3079 A2|B|X VGND VGND sky130_fd_pr__nfet_01v8 L=0.15 W=0.65 AS=0.08775
+ AD=0.169 PS=0.92 PD=1.82
M$9129 \$3079 A|B1|Y VGND VGND sky130_fd_pr__nfet_01v8 L=0.15 W=0.65 AS=0.169
+ AD=0.08775 PS=1.82 PD=0.92
M$9130 VGND A|B1|Y \$3094 VGND sky130_fd_pr__nfet_01v8 L=0.15 W=0.65 AS=0.08775
+ AD=0.06825 PS=0.92 PD=0.86
M$9131 \$3094 A2|B|X \$3043 VGND sky130_fd_pr__nfet_01v8 L=0.15 W=0.65
+ AS=0.06825 AD=0.169 PS=0.86 PD=1.82
M$9132 VGND A2|B|X \$3093 VGND sky130_fd_pr__nfet_01v8 L=0.15 W=0.65 AS=0.17225
+ AD=0.095875 PS=1.83 PD=0.945
M$9133 \$3093 A|A1|Y A|Y VGND sky130_fd_pr__nfet_01v8 L=0.15 W=0.65 AS=0.095875
+ AD=0.091 PS=0.945 PD=0.93
M$9136 A3|Y A|B|Y \$3092 VGND sky130_fd_pr__nfet_01v8 L=0.15 W=0.65 AS=0.169
+ AD=0.08775 PS=1.82 PD=0.92
M$9137 \$3092 B|C|Y VGND VGND sky130_fd_pr__nfet_01v8 L=0.15 W=0.65 AS=0.08775
+ AD=0.169 PS=0.92 PD=1.82
M$9139 B|C|Y \$3048 \$3080 VGND sky130_fd_pr__nfet_01v8 L=0.15 W=0.65 AS=0.195
+ AD=0.08775 PS=1.9 PD=0.92
M$9140 \$3080 B|X VGND VGND sky130_fd_pr__nfet_01v8 L=0.15 W=0.65 AS=0.08775
+ AD=0.169 PS=0.92 PD=1.82
M$9141 \$3080 A|X VGND VGND sky130_fd_pr__nfet_01v8 L=0.15 W=0.65 AS=0.169
+ AD=0.08775 PS=1.82 PD=0.92
M$9142 VGND A|X \$3091 VGND sky130_fd_pr__nfet_01v8 L=0.15 W=0.65 AS=0.08775
+ AD=0.06825 PS=0.92 PD=0.86
M$9143 \$3091 B|X \$3048 VGND sky130_fd_pr__nfet_01v8 L=0.15 W=0.65 AS=0.06825
+ AD=0.169 PS=0.86 PD=1.82
M$9144 C1|Y A|Y \$3090 VGND sky130_fd_pr__nfet_01v8 L=0.15 W=0.65 AS=0.169
+ AD=0.08775 PS=1.82 PD=0.92
M$9145 \$3090 B|Y VGND VGND sky130_fd_pr__nfet_01v8 L=0.15 W=0.65 AS=0.08775
+ AD=0.169 PS=0.92 PD=1.82
M$9164 VGND A2|B|C|X \$3051 VGND sky130_fd_pr__nfet_01v8 L=0.15 W=0.42
+ AS=0.1165 AD=0.1785 PS=1.035 PD=1.69
M$9165 B|C|X \$3050 VGND VGND sky130_fd_pr__nfet_01v8 L=0.15 W=0.65 AS=0.169
+ AD=0.1165 PS=1.82 PD=1.035
M$9166 \$3053 A2|B|C|X \$3050 VGND sky130_fd_pr__nfet_01v8 L=0.15 W=0.64
+ AS=0.1728 AD=0.0928 PS=1.82 PD=0.93
M$9167 \$3050 \$3051 \$3052 VGND sky130_fd_pr__nfet_01v8 L=0.15 W=0.64
+ AS=0.0928 AD=0.224 PS=0.93 PD=1.98
M$9168 VGND A|B|X \$3054 VGND sky130_fd_pr__nfet_01v8 L=0.15 W=0.65 AS=0.1885
+ AD=0.16515 PS=1.88 PD=1.82
M$9169 \$3055 A|B|X \$3052 VGND sky130_fd_pr__nfet_01v8 L=0.15 W=0.64
+ AS=0.16275 AD=0.18205 PS=1.8 PD=1.245
M$9170 \$3052 \$3054 \$3057 VGND sky130_fd_pr__nfet_01v8 L=0.15 W=0.42
+ AS=0.18205 AD=0.19265 PS=1.245 PD=1.285
M$9171 \$3057 A|B|X \$3053 VGND sky130_fd_pr__nfet_01v8 L=0.15 W=0.64
+ AS=0.19265 AD=0.140825 PS=1.285 PD=1.1
M$9172 \$3053 \$3054 \$3055 VGND sky130_fd_pr__nfet_01v8 L=0.15 W=0.6
+ AS=0.140825 AD=0.11 PS=1.1 PD=0.99
M$9173 \$3055 A|A1|D|X VGND VGND sky130_fd_pr__nfet_01v8 L=0.15 W=0.64 AS=0.11
+ AD=0.0864 PS=0.99 PD=0.91
M$9174 VGND \$3055 \$3057 VGND sky130_fd_pr__nfet_01v8 L=0.15 W=0.64 AS=0.0864
+ AD=0.1824 PS=0.91 PD=1.85
M$9175 VGND \$3058 A|A1|D|X VGND sky130_fd_pr__nfet_01v8 L=0.15 W=0.42 AS=0.097
+ AD=0.1491 PS=0.975 PD=1.55
M$9176 VGND \$3059 \$3058 VGND sky130_fd_pr__nfet_01v8 L=0.5 W=0.65 AS=0.097
+ AD=0.17225 PS=0.975 PD=1.83
M$9177 \$3059 \$3060 VGND VGND sky130_fd_pr__nfet_01v8 L=0.5 W=0.65 AS=0.169
+ AD=0.10435 PS=1.82 PD=1.01
M$9178 VGND A|COARSE_MUX[3] \$3060 VGND sky130_fd_pr__nfet_01v8 L=0.15 W=0.42
+ AS=0.10435 AD=0.1134 PS=1.01 PD=1.38
M$9180 VGND A_N|B|C|X \$3097 VGND sky130_fd_pr__nfet_01v8 L=0.15 W=0.42
+ AS=0.10025 AD=0.1092 PS=0.985 PD=1.36
M$9181 VGND A|B|B1|C1|X \$3132 VGND sky130_fd_pr__nfet_01v8 L=0.15 W=0.65
+ AS=0.10025 AD=0.08775 PS=0.985 PD=0.92
M$9182 \$3132 \$3097 A|Y VGND sky130_fd_pr__nfet_01v8 L=0.15 W=0.65 AS=0.08775
+ AD=0.169 PS=0.92 PD=1.82
M$9185 \$3028 A|X \$3086 VGND sky130_fd_pr__nfet_01v8 L=0.15 W=0.42 AS=0.1113
+ AD=0.0441 PS=1.37 PD=0.63
M$9186 \$3086 A|B|Y VGND VGND sky130_fd_pr__nfet_01v8 L=0.15 W=0.42 AS=0.0441
+ AD=0.0966 PS=0.63 PD=0.88
M$9187 VGND \$3028 B|X VGND sky130_fd_pr__nfet_01v8 L=0.15 W=0.42 AS=0.0966
+ AD=0.1113 PS=0.88 PD=1.37
M$9189 A1|Y B|Y VGND VGND sky130_fd_pr__nfet_01v8 L=0.15 W=1.3 AS=0.1755
+ AD=0.338 PS=1.84 PD=3.64
M$9190 VGND A|Y A|B1_N|Y VGND sky130_fd_pr__nfet_01v8 L=0.15 W=0.65 AS=0.169
+ AD=0.08775 PS=1.82 PD=0.92
M$9191 A|B1_N|Y B|Y VGND VGND sky130_fd_pr__nfet_01v8 L=0.15 W=0.65 AS=0.08775
+ AD=0.08775 PS=0.92 PD=0.92
M$9192 VGND A2|B|C|X A|B1_N|Y VGND sky130_fd_pr__nfet_01v8 L=0.15 W=0.65
+ AS=0.08775 AD=0.169 PS=0.92 PD=1.82
M$9195 \$3101 B|C|X \$3156 VGND sky130_fd_pr__nfet_01v8 L=0.15 W=0.65 AS=0.169
+ AD=0.06825 PS=1.82 PD=0.86
M$9196 \$3156 A|B|Y VGND VGND sky130_fd_pr__nfet_01v8 L=0.15 W=0.65 AS=0.06825
+ AD=0.08775 PS=0.86 PD=0.92
M$9197 VGND A|B|Y \$3102 VGND sky130_fd_pr__nfet_01v8 L=0.15 W=0.65 AS=0.08775
+ AD=0.169 PS=0.92 PD=1.82
M$9198 VGND B|C|X \$3102 VGND sky130_fd_pr__nfet_01v8 L=0.15 W=0.65 AS=0.169
+ AD=0.08775 PS=1.82 PD=0.92
M$9199 \$3102 \$3101 A3|Y VGND sky130_fd_pr__nfet_01v8 L=0.15 W=0.65 AS=0.08775
+ AD=0.195 PS=0.92 PD=1.9
M$9200 VGND A1|Y \$3103 VGND sky130_fd_pr__nfet_01v8 L=0.15 W=0.42 AS=0.1176
+ AD=0.0567 PS=1.4 PD=0.69
M$9201 \$3103 A2|B|C|X VGND VGND sky130_fd_pr__nfet_01v8 L=0.15 W=0.42
+ AS=0.0567 AD=0.0567 PS=0.69 PD=0.69
M$9202 VGND A3|Y \$3103 VGND sky130_fd_pr__nfet_01v8 L=0.15 W=0.42 AS=0.0567
+ AD=0.1281 PS=0.69 PD=1.03
M$9203 \$3103 A|B1|Y \$3160 VGND sky130_fd_pr__nfet_01v8 L=0.15 W=0.42
+ AS=0.1281 AD=0.0441 PS=1.03 PD=0.63
M$9204 \$3160 A|B|B1|C1|X A|C_N|S|Y VGND sky130_fd_pr__nfet_01v8 L=0.15 W=0.42
+ AS=0.0441 AD=0.1176 PS=0.63 PD=1.4
M$9206 VGND A|C_N|S|Y \$3105 VGND sky130_fd_pr__nfet_01v8 L=0.15 W=0.42
+ AS=0.1092 AD=0.0567 PS=1.36 PD=0.69
M$9207 \$3105 A|A0|B|SLEEP|X VGND VGND sky130_fd_pr__nfet_01v8 L=0.15 W=0.42
+ AS=0.0567 AD=0.10025 PS=0.69 PD=0.985
M$9208 VGND \$3105 A|B1_N|X VGND sky130_fd_pr__nfet_01v8 L=0.15 W=0.65
+ AS=0.10025 AD=0.169 PS=0.985 PD=1.82
M$9209 \$3107 A|B1_N|X VGND VGND sky130_fd_pr__nfet_01v8 L=0.15 W=0.42
+ AS=0.1113 AD=0.1302 PS=1.37 PD=1.04
M$9210 VGND \$3107 B|Y VGND sky130_fd_pr__nfet_01v8 L=0.15 W=0.42 AS=0.1302
+ AD=0.1113 PS=1.04 PD=0.95
M$9211 B|Y A|A1|X \$3172 VGND sky130_fd_pr__nfet_01v8 L=0.15 W=0.42 AS=0.1113
+ AD=0.0441 PS=0.95 PD=0.63
M$9212 \$3172 A2|B|Y VGND VGND sky130_fd_pr__nfet_01v8 L=0.15 W=0.42 AS=0.0441
+ AD=0.1113 PS=0.63 PD=1.37
M$9213 A2|B|Y A|A0|B|SLEEP|X VGND VGND sky130_fd_pr__nfet_01v8 L=0.15 W=0.42
+ AS=0.1092 AD=0.1197 PS=1.36 PD=1.41
M$9214 VGND A2|B|Y \$3174 VGND sky130_fd_pr__nfet_01v8 L=0.15 W=0.65 AS=0.169
+ AD=0.08775 PS=1.82 PD=0.92
M$9215 \$3174 A|A1|X A|B2|Y VGND sky130_fd_pr__nfet_01v8 L=0.15 W=0.65
+ AS=0.08775 AD=0.169 PS=0.92 PD=1.82
M$9217 \$3081 A|B|B1|X VGND VGND sky130_fd_pr__nfet_01v8 L=0.15 W=0.42
+ AS=0.1092 AD=0.0567 PS=1.36 PD=0.69
M$9218 VGND A|B2|Y \$3081 VGND sky130_fd_pr__nfet_01v8 L=0.15 W=0.42 AS=0.0567
+ AD=0.0567 PS=0.69 PD=0.69
M$9219 \$3081 \$3038 \$3037 VGND sky130_fd_pr__nfet_01v8 L=0.15 W=0.42
+ AS=0.0567 AD=0.1092 PS=0.69 PD=1.36
M$9220 VGND \$3111 B|X VGND sky130_fd_pr__nfet_01v8 L=0.15 W=0.65 AS=0.208
+ AD=0.25025 PS=1.94 PD=1.42
M$9221 B|X B|X \$3179 VGND sky130_fd_pr__nfet_01v8 L=0.15 W=0.65 AS=0.25025
+ AD=0.08775 PS=1.42 PD=0.92
M$9222 \$3179 A|B|C|Y VGND VGND sky130_fd_pr__nfet_01v8 L=0.15 W=0.65
+ AS=0.08775 AD=0.08775 PS=0.92 PD=0.92
M$9223 VGND A|B|C|Y \$3111 VGND sky130_fd_pr__nfet_01v8 L=0.15 W=0.65
+ AS=0.08775 AD=0.08775 PS=0.92 PD=0.92
M$9224 \$3111 B|X VGND VGND sky130_fd_pr__nfet_01v8 L=0.15 W=0.65 AS=0.08775
+ AD=0.169 PS=0.92 PD=1.82
M$9225 \$3038 A2_N|B|Y \$3096 VGND sky130_fd_pr__nfet_01v8 L=0.15 W=0.42
+ AS=0.1092 AD=0.06615 PS=1.36 PD=0.735
M$9226 VGND A|A1_N|Y \$3096 VGND sky130_fd_pr__nfet_01v8 L=0.15 W=0.42
+ AS=0.098625 AD=0.06615 PS=0.98 PD=0.735
M$9227 VGND \$3037 B|X VGND sky130_fd_pr__nfet_01v8 L=0.15 W=0.65 AS=0.098625
+ AD=0.169 PS=0.98 PD=1.82
M$9230 VGND \$3115 B|C|X VGND sky130_fd_pr__nfet_01v8 L=0.15 W=0.65 AS=0.208
+ AD=0.25025 PS=1.94 PD=1.42
M$9231 B|C|X B|C|Y \$3193 VGND sky130_fd_pr__nfet_01v8 L=0.15 W=0.65 AS=0.25025
+ AD=0.08775 PS=1.42 PD=0.92
M$9232 \$3193 A|A1|Y VGND VGND sky130_fd_pr__nfet_01v8 L=0.15 W=0.65 AS=0.08775
+ AD=0.08775 PS=0.92 PD=0.92
M$9233 VGND A|A1|Y \$3115 VGND sky130_fd_pr__nfet_01v8 L=0.15 W=0.65 AS=0.08775
+ AD=0.08775 PS=0.92 PD=0.92
M$9234 \$3115 B|C|Y VGND VGND sky130_fd_pr__nfet_01v8 L=0.15 W=0.65 AS=0.08775
+ AD=0.169 PS=0.92 PD=1.82
M$9237 A|Y A|A1|Y \$3204 VGND sky130_fd_pr__nfet_01v8 L=0.15 W=0.65 AS=0.169
+ AD=0.08775 PS=1.82 PD=0.92
M$9238 \$3204 A2|B|X VGND VGND sky130_fd_pr__nfet_01v8 L=0.15 W=0.65 AS=0.08775
+ AD=0.169 PS=0.92 PD=1.82
M$9239 VGND A3|Y \$3208 VGND sky130_fd_pr__nfet_01v8 L=0.15 W=0.65 AS=0.169
+ AD=0.089375 PS=1.82 PD=0.925
M$9240 \$3208 A2|B|X \$3209 VGND sky130_fd_pr__nfet_01v8 L=0.15 W=0.65
+ AS=0.089375 AD=0.091 PS=0.925 PD=0.93
M$9241 \$3209 A|A1|Y C1|Y VGND sky130_fd_pr__nfet_01v8 L=0.15 W=0.65 AS=0.091
+ AD=0.115375 PS=0.93 PD=1.005
M$9242 C1|Y B1|Y VGND VGND sky130_fd_pr__nfet_01v8 L=0.15 W=0.65 AS=0.115375
+ AD=0.112125 PS=1.005 PD=0.995
M$9243 VGND C1|Y C1|Y VGND sky130_fd_pr__nfet_01v8 L=0.15 W=0.65 AS=0.112125
+ AD=0.169 PS=0.995 PD=1.82
M$9244 VGND A|B|Y B1|Y VGND sky130_fd_pr__nfet_01v8 L=0.15 W=1.3 AS=0.338
+ AD=0.1755 PS=3.64 PD=1.84
M$9245 B1|Y B|C|Y VGND VGND sky130_fd_pr__nfet_01v8 L=0.15 W=0.65 AS=0.08775
+ AD=0.169 PS=0.92 PD=1.82
M$9266 \$3119 A|B1_N|Y VGND VGND sky130_fd_pr__nfet_01v8 L=0.15 W=0.42
+ AS=0.1092 AD=0.10025 PS=1.36 PD=0.985
M$9267 VGND SLEEP|Y A|A1|X VGND sky130_fd_pr__nfet_01v8 L=0.15 W=0.65
+ AS=0.10025 AD=0.08775 PS=0.985 PD=0.92
M$9268 A|A1|X \$3119 VGND VGND sky130_fd_pr__nfet_01v8 L=0.15 W=0.65 AS=0.08775
+ AD=0.169 PS=0.92 PD=1.82
M$9269 VGND A2|B|C|X \$3144 VGND sky130_fd_pr__nfet_01v8 L=0.15 W=0.65
+ AS=0.17225 AD=0.095875 PS=1.83 PD=0.945
M$9270 \$3144 A|A1|D|X SLEEP|Y VGND sky130_fd_pr__nfet_01v8 L=0.15 W=0.65
+ AS=0.095875 AD=0.091 PS=0.945 PD=0.93
M$9271 SLEEP|Y B1|X VGND VGND sky130_fd_pr__nfet_01v8 L=0.15 W=0.65 AS=0.091
+ AD=0.17225 PS=0.93 PD=1.83
M$9272 A|X \$3122 VGND VGND sky130_fd_pr__nfet_01v8 L=0.15 W=0.42 AS=0.1491
+ AD=0.097 PS=1.55 PD=0.975
M$9273 VGND \$3123 \$3122 VGND sky130_fd_pr__nfet_01v8 L=0.5 W=0.65 AS=0.097
+ AD=0.17225 PS=0.975 PD=1.83
M$9274 VGND A|COARSE_MUX[1] \$3124 VGND sky130_fd_pr__nfet_01v8 L=0.15 W=0.42
+ AS=0.10435 AD=0.1134 PS=1.01 PD=1.38
M$9275 \$3123 \$3124 VGND VGND sky130_fd_pr__nfet_01v8 L=0.5 W=0.65 AS=0.169
+ AD=0.10435 PS=1.82 PD=1.01
M$9278 \$3277 B|X \$3343 VGND sky130_fd_pr__nfet_01v8 L=0.15 W=0.65 AS=0.169
+ AD=0.06825 PS=1.82 PD=0.86
M$9279 \$3343 A|Y VGND VGND sky130_fd_pr__nfet_01v8 L=0.15 W=0.65 AS=0.06825
+ AD=0.08775 PS=0.86 PD=0.92
M$9280 VGND A|Y \$3332 VGND sky130_fd_pr__nfet_01v8 L=0.15 W=0.65 AS=0.08775
+ AD=0.169 PS=0.92 PD=1.82
M$9281 VGND B|X \$3332 VGND sky130_fd_pr__nfet_01v8 L=0.15 W=0.65 AS=0.169
+ AD=0.08775 PS=1.82 PD=0.92
M$9282 \$3332 \$3277 A2|B|C|Y VGND sky130_fd_pr__nfet_01v8 L=0.15 W=0.65
+ AS=0.08775 AD=0.195 PS=0.92 PD=1.9
M$9284 \$3333 A1|Y VGND VGND sky130_fd_pr__nfet_01v8 L=0.15 W=0.65 AS=0.169
+ AD=0.08775 PS=1.82 PD=0.92
M$9285 VGND A2|C|X \$3333 VGND sky130_fd_pr__nfet_01v8 L=0.15 W=0.65 AS=0.08775
+ AD=0.10075 PS=0.92 PD=0.96
M$9286 \$3333 \$3280 B|Y VGND sky130_fd_pr__nfet_01v8 L=0.15 W=0.65 AS=0.10075
+ AD=0.169 PS=0.96 PD=1.82
M$9287 \$3280 A|B1_N|Y VGND VGND sky130_fd_pr__nfet_01v8 L=0.15 W=0.42
+ AS=0.1092 AD=0.1092 PS=1.36 PD=1.36
M$9289 VGND B|C|X \$3283 VGND sky130_fd_pr__nfet_01v8 L=0.15 W=0.42 AS=0.1165
+ AD=0.1785 PS=1.035 PD=1.69
M$9290 A0|A1|X \$3282 VGND VGND sky130_fd_pr__nfet_01v8 L=0.15 W=0.65 AS=0.169
+ AD=0.1165 PS=1.82 PD=1.035
M$9291 \$3285 B|C|X \$3282 VGND sky130_fd_pr__nfet_01v8 L=0.15 W=0.64 AS=0.1728
+ AD=0.0928 PS=1.82 PD=0.93
M$9292 \$3282 \$3283 \$3284 VGND sky130_fd_pr__nfet_01v8 L=0.15 W=0.64
+ AS=0.0928 AD=0.224 PS=0.93 PD=1.98
M$9293 VGND A|B|Y \$3286 VGND sky130_fd_pr__nfet_01v8 L=0.15 W=0.65 AS=0.1885
+ AD=0.16515 PS=1.88 PD=1.82
M$9294 \$3287 A|B|Y \$3284 VGND sky130_fd_pr__nfet_01v8 L=0.15 W=0.64
+ AS=0.16275 AD=0.18205 PS=1.8 PD=1.245
M$9295 \$3284 \$3286 \$3288 VGND sky130_fd_pr__nfet_01v8 L=0.15 W=0.42
+ AS=0.18205 AD=0.19265 PS=1.245 PD=1.285
M$9296 \$3288 A|B|Y \$3285 VGND sky130_fd_pr__nfet_01v8 L=0.15 W=0.64
+ AS=0.19265 AD=0.140825 PS=1.285 PD=1.1
M$9297 \$3285 \$3286 \$3287 VGND sky130_fd_pr__nfet_01v8 L=0.15 W=0.6
+ AS=0.140825 AD=0.11 PS=1.1 PD=0.99
M$9298 \$3287 A|B1_N|Y VGND VGND sky130_fd_pr__nfet_01v8 L=0.15 W=0.64 AS=0.11
+ AD=0.0864 PS=0.99 PD=0.91
M$9299 VGND \$3287 \$3288 VGND sky130_fd_pr__nfet_01v8 L=0.15 W=0.64 AS=0.0864
+ AD=0.1824 PS=0.91 PD=1.85
M$9302 A1|B|Y \$3290 \$3334 VGND sky130_fd_pr__nfet_01v8 L=0.15 W=0.65 AS=0.195
+ AD=0.08775 PS=1.9 PD=0.92
M$9303 \$3334 A|A0|B|SLEEP|X VGND VGND sky130_fd_pr__nfet_01v8 L=0.15 W=0.65
+ AS=0.08775 AD=0.169 PS=0.92 PD=1.82
M$9304 \$3334 A|A1|X VGND VGND sky130_fd_pr__nfet_01v8 L=0.15 W=0.65 AS=0.169
+ AD=0.08775 PS=1.82 PD=0.92
M$9305 VGND A|A1|X \$3349 VGND sky130_fd_pr__nfet_01v8 L=0.15 W=0.65 AS=0.08775
+ AD=0.06825 PS=0.92 PD=0.86
M$9306 \$3349 A|A0|B|SLEEP|X \$3290 VGND sky130_fd_pr__nfet_01v8 L=0.15 W=0.65
+ AS=0.06825 AD=0.169 PS=0.86 PD=1.82
M$9307 B|Y \$3292 \$3335 VGND sky130_fd_pr__nfet_01v8 L=0.15 W=0.65 AS=0.195
+ AD=0.08775 PS=1.9 PD=0.92
M$9308 \$3335 B|Y VGND VGND sky130_fd_pr__nfet_01v8 L=0.15 W=0.65 AS=0.08775
+ AD=0.169 PS=0.92 PD=1.82
M$9309 \$3335 A|B|B1|X VGND VGND sky130_fd_pr__nfet_01v8 L=0.15 W=0.65 AS=0.169
+ AD=0.08775 PS=1.82 PD=0.92
M$9310 VGND A|B|B1|X \$3348 VGND sky130_fd_pr__nfet_01v8 L=0.15 W=0.65
+ AS=0.08775 AD=0.06825 PS=0.92 PD=0.86
M$9311 \$3348 B|Y \$3292 VGND sky130_fd_pr__nfet_01v8 L=0.15 W=0.65 AS=0.06825
+ AD=0.169 PS=0.86 PD=1.82
M$9312 VGND A|B1_N|X A|Y VGND sky130_fd_pr__nfet_01v8 L=0.15 W=0.65 AS=0.169
+ AD=0.08775 PS=1.82 PD=0.92
M$9313 A|Y A|B|B1|X VGND VGND sky130_fd_pr__nfet_01v8 L=0.15 W=1.95 AS=0.3445
+ AD=0.3445 PS=3.66 PD=3.66
M$9315 \$3112 A|B|C|Y VGND VGND sky130_fd_pr__nfet_01v8 L=0.15 W=0.42 AS=0.1092
+ AD=0.0567 PS=1.36 PD=0.69
M$9316 VGND A|B|B1|X \$3112 VGND sky130_fd_pr__nfet_01v8 L=0.15 W=0.42
+ AS=0.0567 AD=0.0567 PS=0.69 PD=0.69
M$9317 VGND A|B2|Y \$3112 VGND sky130_fd_pr__nfet_01v8 L=0.15 W=0.42
+ AS=0.101875 AD=0.0567 PS=0.99 PD=0.69
M$9318 VGND \$3112 A|X VGND sky130_fd_pr__nfet_01v8 L=0.15 W=0.65 AS=0.101875
+ AD=0.182 PS=0.99 PD=1.86
M$9321 VGND \$3297 B|X VGND sky130_fd_pr__nfet_01v8 L=0.15 W=0.65 AS=0.208
+ AD=0.25025 PS=1.94 PD=1.42
M$9322 B|X A2|B|X \$3344 VGND sky130_fd_pr__nfet_01v8 L=0.15 W=0.65 AS=0.25025
+ AD=0.08775 PS=1.42 PD=0.92
M$9323 \$3344 A|Y VGND VGND sky130_fd_pr__nfet_01v8 L=0.15 W=0.65 AS=0.08775
+ AD=0.08775 PS=0.92 PD=0.92
M$9324 VGND A|Y \$3297 VGND sky130_fd_pr__nfet_01v8 L=0.15 W=0.65 AS=0.08775
+ AD=0.08775 PS=0.92 PD=0.92
M$9325 \$3297 A2|B|X VGND VGND sky130_fd_pr__nfet_01v8 L=0.15 W=0.65 AS=0.08775
+ AD=0.169 PS=0.92 PD=1.82
M$9327 \$3302 A|B|Y \$3299 VGND sky130_fd_pr__nfet_01v8 L=0.15 W=0.64
+ AS=0.140825 AD=0.19265 PS=1.1 PD=1.285
M$9328 \$3299 \$3336 \$3301 VGND sky130_fd_pr__nfet_01v8 L=0.15 W=0.42
+ AS=0.19265 AD=0.18205 PS=1.285 PD=1.245
M$9329 \$3301 A|B|Y \$3300 VGND sky130_fd_pr__nfet_01v8 L=0.15 W=0.64
+ AS=0.18205 AD=0.16275 PS=1.245 PD=1.8
M$9330 \$3299 \$3300 VGND VGND sky130_fd_pr__nfet_01v8 L=0.15 W=0.64 AS=0.1824
+ AD=0.0864 PS=1.85 PD=0.91
M$9331 VGND A|Y \$3300 VGND sky130_fd_pr__nfet_01v8 L=0.15 W=0.64 AS=0.0864
+ AD=0.11 PS=0.91 PD=0.99
M$9332 \$3302 \$3336 \$3300 VGND sky130_fd_pr__nfet_01v8 L=0.15 W=0.6
+ AS=0.140825 AD=0.11 PS=1.1 PD=0.99
M$9333 \$3336 A|B|Y VGND VGND sky130_fd_pr__nfet_01v8 L=0.15 W=0.65 AS=0.16515
+ AD=0.1885 PS=1.82 PD=1.88
M$9334 \$3301 \$3303 \$3304 VGND sky130_fd_pr__nfet_01v8 L=0.15 W=0.64 AS=0.224
+ AD=0.0928 PS=1.98 PD=0.93
M$9335 \$3304 B|C|Y \$3302 VGND sky130_fd_pr__nfet_01v8 L=0.15 W=0.64 AS=0.0928
+ AD=0.1728 PS=0.93 PD=1.82
M$9336 \$3303 B|C|Y VGND VGND sky130_fd_pr__nfet_01v8 L=0.15 W=0.42 AS=0.1785
+ AD=0.1165 PS=1.69 PD=1.035
M$9337 VGND \$3304 A|B|SLEEP|X VGND sky130_fd_pr__nfet_01v8 L=0.15 W=0.65
+ AS=0.1165 AD=0.169 PS=1.035 PD=1.82
M$9357 VGND A|COARSE_MUX[4] \$3306 VGND sky130_fd_pr__nfet_01v8 L=0.15 W=0.42
+ AS=0.10435 AD=0.1134 PS=1.01 PD=1.38
M$9358 VGND \$3306 \$3307 VGND sky130_fd_pr__nfet_01v8 L=0.5 W=0.65 AS=0.10435
+ AD=0.169 PS=1.01 PD=1.82
M$9359 \$3308 \$3307 VGND VGND sky130_fd_pr__nfet_01v8 L=0.5 W=0.65 AS=0.17225
+ AD=0.097 PS=1.83 PD=0.975
M$9360 VGND \$3308 A|B|X VGND sky130_fd_pr__nfet_01v8 L=0.15 W=0.42 AS=0.097
+ AD=0.1491 PS=0.975 PD=1.55
M$9361 VGND C|X \$3311 VGND sky130_fd_pr__nfet_01v8 L=0.15 W=0.42 AS=0.144125
+ AD=0.1764 PS=1.12 PD=1.68
M$9362 A2|B|C|X \$3310 VGND VGND sky130_fd_pr__nfet_01v8 L=0.15 W=0.65 AS=0.169
+ AD=0.144125 PS=1.82 PD=1.12
M$9363 \$3313 C|X \$3310 VGND sky130_fd_pr__nfet_01v8 L=0.15 W=0.64 AS=0.1728
+ AD=0.128 PS=1.82 PD=1.04
M$9364 \$3310 \$3311 \$3312 VGND sky130_fd_pr__nfet_01v8 L=0.15 W=0.64 AS=0.128
+ AD=0.3168 PS=1.04 PD=2.27
M$9365 VGND B|X \$3314 VGND sky130_fd_pr__nfet_01v8 L=0.15 W=0.65 AS=0.195
+ AD=0.1653 PS=1.9 PD=1.82
M$9366 \$3315 B|X \$3313 VGND sky130_fd_pr__nfet_01v8 L=0.15 W=0.64 AS=0.1628
+ AD=0.18365 PS=1.8 PD=1.25
M$9367 \$3313 \$3314 \$3316 VGND sky130_fd_pr__nfet_01v8 L=0.15 W=0.42
+ AS=0.18365 AD=0.19265 PS=1.25 PD=1.285
M$9368 \$3316 B|X \$3312 VGND sky130_fd_pr__nfet_01v8 L=0.15 W=0.64 AS=0.19265
+ AD=0.140825 PS=1.285 PD=1.1
M$9369 \$3312 \$3314 \$3315 VGND sky130_fd_pr__nfet_01v8 L=0.15 W=0.6
+ AS=0.140825 AD=0.11 PS=1.1 PD=0.99
M$9370 \$3315 A|X VGND VGND sky130_fd_pr__nfet_01v8 L=0.15 W=0.64 AS=0.11
+ AD=0.0864 PS=0.99 PD=0.91
M$9371 VGND \$3315 \$3316 VGND sky130_fd_pr__nfet_01v8 L=0.15 W=0.64 AS=0.0864
+ AD=0.1824 PS=0.91 PD=1.85
M$9372 VGND A_N|B|C|X \$3512 VGND sky130_fd_pr__nfet_01v8 L=0.15 W=0.42
+ AS=0.1165 AD=0.1785 PS=1.035 PD=1.69
M$9373 A|B|X \$3511 VGND VGND sky130_fd_pr__nfet_01v8 L=0.15 W=0.65 AS=0.169
+ AD=0.1165 PS=1.82 PD=1.035
M$9375 \$3514 A_N|B|C|X \$3511 VGND sky130_fd_pr__nfet_01v8 L=0.15 W=0.64
+ AS=0.1728 AD=0.0928 PS=1.82 PD=0.93
M$9376 \$3511 \$3512 \$3513 VGND sky130_fd_pr__nfet_01v8 L=0.15 W=0.64
+ AS=0.0928 AD=0.224 PS=0.93 PD=1.98
M$9377 \$3350 A_N|B|C|X \$3377 VGND sky130_fd_pr__nfet_01v8 L=0.15 W=0.65
+ AS=0.169 AD=0.06825 PS=1.82 PD=0.86
M$9378 \$3377 A|B|B1|C1|X VGND VGND sky130_fd_pr__nfet_01v8 L=0.15 W=0.65
+ AS=0.06825 AD=0.08775 PS=0.86 PD=0.92
M$9379 VGND A|B|B1|C1|X \$3351 VGND sky130_fd_pr__nfet_01v8 L=0.15 W=0.65
+ AS=0.08775 AD=0.169 PS=0.92 PD=1.82
M$9380 VGND A|B|B1|X \$3515 VGND sky130_fd_pr__nfet_01v8 L=0.15 W=0.65
+ AS=0.1885 AD=0.16515 PS=1.88 PD=1.82
M$9381 VGND A_N|B|C|X \$3351 VGND sky130_fd_pr__nfet_01v8 L=0.15 W=0.65
+ AS=0.169 AD=0.08775 PS=1.82 PD=0.92
M$9382 \$3351 \$3350 A|B|Y VGND sky130_fd_pr__nfet_01v8 L=0.15 W=0.65
+ AS=0.08775 AD=0.195 PS=0.92 PD=1.9
M$9383 \$3353 A|B|B1|X \$3382 VGND sky130_fd_pr__nfet_01v8 L=0.15 W=0.42
+ AS=0.1113 AD=0.0441 PS=1.37 PD=0.63
M$9384 \$3382 A|B|Y VGND VGND sky130_fd_pr__nfet_01v8 L=0.15 W=0.42 AS=0.0441
+ AD=0.0966 PS=0.63 PD=0.88
M$9385 VGND \$3353 A|A1|X VGND sky130_fd_pr__nfet_01v8 L=0.15 W=0.42 AS=0.0966
+ AD=0.1113 PS=0.88 PD=1.37
M$9386 \$3516 A|B|B1|X \$3513 VGND sky130_fd_pr__nfet_01v8 L=0.15 W=0.64
+ AS=0.16275 AD=0.18205 PS=1.8 PD=1.245
M$9387 \$3513 \$3515 \$3517 VGND sky130_fd_pr__nfet_01v8 L=0.15 W=0.42
+ AS=0.18205 AD=0.19265 PS=1.245 PD=1.285
M$9388 \$3517 A|B|B1|X \$3514 VGND sky130_fd_pr__nfet_01v8 L=0.15 W=0.64
+ AS=0.19265 AD=0.140825 PS=1.285 PD=1.1
M$9389 \$3514 \$3515 \$3516 VGND sky130_fd_pr__nfet_01v8 L=0.15 W=0.6
+ AS=0.140825 AD=0.11 PS=1.1 PD=0.99
M$9390 \$3516 A|B|B1|C1|X VGND VGND sky130_fd_pr__nfet_01v8 L=0.15 W=0.64
+ AS=0.11 AD=0.0864 PS=0.99 PD=0.91
M$9391 VGND \$3516 \$3517 VGND sky130_fd_pr__nfet_01v8 L=0.15 W=0.64 AS=0.0864
+ AD=0.1824 PS=0.91 PD=1.85
M$9393 A|B1|Y A|A1|X \$3552 VGND sky130_fd_pr__nfet_01v8 L=0.15 W=0.65 AS=0.169
+ AD=0.08775 PS=1.82 PD=0.92
M$9394 \$3552 B|X VGND VGND sky130_fd_pr__nfet_01v8 L=0.15 W=0.65 AS=0.08775
+ AD=0.169 PS=0.92 PD=1.82
M$9395 A2|Y A|B|Y \$3390 VGND sky130_fd_pr__nfet_01v8 L=0.15 W=0.65 AS=0.169
+ AD=0.10725 PS=1.82 PD=0.98
M$9396 \$3390 B|X \$3392 VGND sky130_fd_pr__nfet_01v8 L=0.15 W=0.65 AS=0.10725
+ AD=0.08775 PS=0.98 PD=0.92
M$9397 \$3392 A2|C|X VGND VGND sky130_fd_pr__nfet_01v8 L=0.15 W=0.65 AS=0.08775
+ AD=0.169 PS=0.92 PD=1.82
M$9399 VGND \$3356 A1|X VGND sky130_fd_pr__nfet_01v8 L=0.15 W=0.65 AS=0.208
+ AD=0.25025 PS=1.94 PD=1.42
M$9400 A1|X B|C|X \$3400 VGND sky130_fd_pr__nfet_01v8 L=0.15 W=0.65 AS=0.25025
+ AD=0.08775 PS=1.42 PD=0.92
M$9401 \$3400 A|B|Y VGND VGND sky130_fd_pr__nfet_01v8 L=0.15 W=0.65 AS=0.08775
+ AD=0.08775 PS=0.92 PD=0.92
M$9402 VGND A|B|Y \$3356 VGND sky130_fd_pr__nfet_01v8 L=0.15 W=0.65 AS=0.08775
+ AD=0.08775 PS=0.92 PD=0.92
M$9403 \$3356 B|C|X VGND VGND sky130_fd_pr__nfet_01v8 L=0.15 W=0.65 AS=0.08775
+ AD=0.169 PS=0.92 PD=1.82
M$9405 VGND \$3521 B|Y VGND sky130_fd_pr__nfet_01v8 L=0.15 W=0.65 AS=0.169
+ AD=0.08775 PS=1.82 PD=0.92
M$9407 VGND B|B_N|Y \$3521 VGND sky130_fd_pr__nfet_01v8 L=0.15 W=0.42
+ AS=0.10025 AD=0.1092 PS=0.985 PD=1.36
M$9409 \$3522 A|C_N|S|Y VGND VGND sky130_fd_pr__nfet_01v8 L=0.15 W=0.42
+ AS=0.1092 AD=0.10025 PS=1.36 PD=0.985
M$9410 VGND A|C|Y A|A1|Y VGND sky130_fd_pr__nfet_01v8 L=0.15 W=0.65 AS=0.10025
+ AD=0.08775 PS=0.985 PD=0.92
M$9412 VGND \$3522 A|A1|Y VGND sky130_fd_pr__nfet_01v8 L=0.15 W=0.65 AS=0.08775
+ AD=0.221 PS=0.92 PD=1.98
M$9413 VGND A|C_N|S|Y \$3416 VGND sky130_fd_pr__nfet_01v8 L=0.15 W=0.42
+ AS=0.11285 AD=0.0693 PS=1.045 PD=0.75
M$9414 \$3416 A1|B|Y \$3357 VGND sky130_fd_pr__nfet_01v8 L=0.15 W=0.42
+ AS=0.0693 AD=0.09975 PS=0.75 PD=0.895
M$9415 \$3357 A|A0|B|SLEEP|X \$3417 VGND sky130_fd_pr__nfet_01v8 L=0.15 W=0.42
+ AS=0.09975 AD=0.0693 PS=0.895 PD=0.75
M$9416 \$3417 \$3358 VGND VGND sky130_fd_pr__nfet_01v8 L=0.15 W=0.42 AS=0.0693
+ AD=0.1449 PS=0.75 PD=1.11
M$9417 VGND A|C_N|S|Y \$3358 VGND sky130_fd_pr__nfet_01v8 L=0.15 W=0.42
+ AS=0.1449 AD=0.1092 PS=1.11 PD=1.36
M$9418 A2|X \$3357 VGND VGND sky130_fd_pr__nfet_01v8 L=0.15 W=0.65 AS=0.169
+ AD=0.11285 PS=1.82 PD=1.045
M$9420 VGND \$3359 B|C|X VGND sky130_fd_pr__nfet_01v8 L=0.15 W=0.65 AS=0.208
+ AD=0.25025 PS=1.94 PD=1.42
M$9421 B|C|X B|X \$3427 VGND sky130_fd_pr__nfet_01v8 L=0.15 W=0.65 AS=0.25025
+ AD=0.08775 PS=1.42 PD=0.92
M$9422 \$3427 A|Y VGND VGND sky130_fd_pr__nfet_01v8 L=0.15 W=0.65 AS=0.08775
+ AD=0.08775 PS=0.92 PD=0.92
M$9423 VGND A|Y \$3359 VGND sky130_fd_pr__nfet_01v8 L=0.15 W=0.65 AS=0.08775
+ AD=0.08775 PS=0.92 PD=0.92
M$9424 \$3359 B|X VGND VGND sky130_fd_pr__nfet_01v8 L=0.15 W=0.65 AS=0.08775
+ AD=0.169 PS=0.92 PD=1.82
M$9425 VGND B|X \$3432 VGND sky130_fd_pr__nfet_01v8 L=0.15 W=0.65 AS=0.169
+ AD=0.08775 PS=1.82 PD=0.92
M$9426 \$3432 A|Y B|Y VGND sky130_fd_pr__nfet_01v8 L=0.15 W=0.65 AS=0.08775
+ AD=0.169 PS=0.92 PD=1.82
M$9427 B|X \$3362 VGND VGND sky130_fd_pr__nfet_01v8 L=0.15 W=0.65 AS=0.169
+ AD=0.1165 PS=1.82 PD=1.035
M$9428 VGND B|C|X \$3363 VGND sky130_fd_pr__nfet_01v8 L=0.15 W=0.42 AS=0.1165
+ AD=0.1785 PS=1.035 PD=1.69
M$9429 \$3364 B|C|X \$3362 VGND sky130_fd_pr__nfet_01v8 L=0.15 W=0.64 AS=0.1728
+ AD=0.0928 PS=1.82 PD=0.93
M$9430 \$3362 \$3363 \$3365 VGND sky130_fd_pr__nfet_01v8 L=0.15 W=0.64
+ AS=0.0928 AD=0.224 PS=0.93 PD=1.98
M$9431 VGND \$3525 A|B|X VGND sky130_fd_pr__nfet_01v8 L=0.15 W=0.65 AS=0.208
+ AD=0.25025 PS=1.94 PD=1.42
M$9432 A|B|X B|C|X \$3558 VGND sky130_fd_pr__nfet_01v8 L=0.15 W=0.65 AS=0.25025
+ AD=0.08775 PS=1.42 PD=0.92
M$9433 \$3558 A|X VGND VGND sky130_fd_pr__nfet_01v8 L=0.15 W=0.65 AS=0.08775
+ AD=0.08775 PS=0.92 PD=0.92
M$9434 VGND A|X \$3525 VGND sky130_fd_pr__nfet_01v8 L=0.15 W=0.65 AS=0.08775
+ AD=0.08775 PS=0.92 PD=0.92
M$9435 \$3525 B|C|X VGND VGND sky130_fd_pr__nfet_01v8 L=0.15 W=0.65 AS=0.08775
+ AD=0.169 PS=0.92 PD=1.82
M$9436 VGND B|Y \$3366 VGND sky130_fd_pr__nfet_01v8 L=0.15 W=0.65 AS=0.1885
+ AD=0.16515 PS=1.88 PD=1.82
M$9437 \$3365 \$3366 \$3368 VGND sky130_fd_pr__nfet_01v8 L=0.15 W=0.42
+ AS=0.18205 AD=0.19265 PS=1.245 PD=1.285
M$9438 \$3364 \$3366 \$3367 VGND sky130_fd_pr__nfet_01v8 L=0.15 W=0.6
+ AS=0.140825 AD=0.11 PS=1.1 PD=0.99
M$9439 \$3367 A|X VGND VGND sky130_fd_pr__nfet_01v8 L=0.15 W=0.64 AS=0.11
+ AD=0.0864 PS=0.99 PD=0.91
M$9440 VGND \$3367 \$3368 VGND sky130_fd_pr__nfet_01v8 L=0.15 W=0.64 AS=0.0864
+ AD=0.1824 PS=0.91 PD=1.85
M$9441 \$3367 B|Y \$3365 VGND sky130_fd_pr__nfet_01v8 L=0.15 W=0.64 AS=0.16275
+ AD=0.18205 PS=1.8 PD=1.245
M$9442 \$3364 B|Y \$3368 VGND sky130_fd_pr__nfet_01v8 L=0.15 W=0.64 AS=0.140825
+ AD=0.19265 PS=1.1 PD=1.285
M$9443 \$3294 B|C|X \$3347 VGND sky130_fd_pr__nfet_01v8 L=0.15 W=0.42 AS=0.1092
+ AD=0.0441 PS=1.36 PD=0.63
M$9444 \$3347 A|X VGND VGND sky130_fd_pr__nfet_01v8 L=0.15 W=0.42 AS=0.0441
+ AD=0.0567 PS=0.63 PD=0.69
M$9445 VGND A|X \$3346 VGND sky130_fd_pr__nfet_01v8 L=0.15 W=0.42 AS=0.0567
+ AD=0.0441 PS=0.69 PD=0.63
M$9446 \$3346 B|Y \$3294 VGND sky130_fd_pr__nfet_01v8 L=0.15 W=0.42 AS=0.0441
+ AD=0.0567 PS=0.63 PD=0.69
M$9447 \$3294 B|Y \$3345 VGND sky130_fd_pr__nfet_01v8 L=0.15 W=0.42 AS=0.0567
+ AD=0.0441 PS=0.69 PD=0.63
M$9448 VGND B|C|X \$3345 VGND sky130_fd_pr__nfet_01v8 L=0.15 W=0.42 AS=0.1474
+ AD=0.0441 PS=1.215 PD=0.63
M$9449 VGND \$3294 A|X VGND sky130_fd_pr__nfet_01v8 L=0.15 W=0.65 AS=0.1474
+ AD=0.23725 PS=1.215 PD=2.03
M$9451 VGND A|X B1|Y VGND sky130_fd_pr__nfet_01v8 L=0.15 W=1.49 AS=0.4084
+ AD=0.30615 PS=4.64 PD=3.64
M$9452 B1|Y B|X VGND VGND sky130_fd_pr__nfet_01v8 L=0.15 W=1.3 AS=0.1755
+ AD=0.338 PS=1.84 PD=3.64
M$9453 VGND \$3529 B|X VGND sky130_fd_pr__nfet_01v8 L=0.15 W=0.65 AS=0.208
+ AD=0.25025 PS=1.94 PD=1.42
M$9454 B|X B|X \$3559 VGND sky130_fd_pr__nfet_01v8 L=0.15 W=0.65 AS=0.25025
+ AD=0.08775 PS=1.42 PD=0.92
M$9455 \$3559 A|X VGND VGND sky130_fd_pr__nfet_01v8 L=0.15 W=0.65 AS=0.08775
+ AD=0.08775 PS=0.92 PD=0.92
M$9456 VGND A|X \$3529 VGND sky130_fd_pr__nfet_01v8 L=0.15 W=0.65 AS=0.08775
+ AD=0.08775 PS=0.92 PD=0.92
M$9457 \$3529 B|X VGND VGND sky130_fd_pr__nfet_01v8 L=0.15 W=0.65 AS=0.08775
+ AD=0.169 PS=0.92 PD=1.82
M$9459 A2|Y A|X \$3557 VGND sky130_fd_pr__nfet_01v8 L=0.15 W=0.65 AS=0.169
+ AD=0.08775 PS=1.82 PD=0.92
M$9460 \$3557 B|X VGND VGND sky130_fd_pr__nfet_01v8 L=0.15 W=0.65 AS=0.08775
+ AD=0.169 PS=0.92 PD=1.82
M$9481 VGND A|A1|D|X \$3410 VGND sky130_fd_pr__nfet_01v8 L=0.15 W=0.65 AS=0.169
+ AD=0.08775 PS=1.82 PD=0.92
M$9482 \$3410 C|X \$3408 VGND sky130_fd_pr__nfet_01v8 L=0.15 W=0.65 AS=0.08775
+ AD=0.08775 PS=0.92 PD=0.92
M$9483 \$3408 B|X \$3406 VGND sky130_fd_pr__nfet_01v8 L=0.15 W=0.65 AS=0.08775
+ AD=0.10725 PS=0.92 PD=0.98
M$9484 \$3406 A|X A|B1_N|Y VGND sky130_fd_pr__nfet_01v8 L=0.15 W=0.65
+ AS=0.10725 AD=0.195 PS=0.98 PD=1.9
M$9485 VGND C|X \$3393 VGND sky130_fd_pr__nfet_01v8 L=0.15 W=0.42 AS=0.1474
+ AD=0.0441 PS=1.215 PD=0.63
M$9486 \$3393 B|X \$3371 VGND sky130_fd_pr__nfet_01v8 L=0.15 W=0.42 AS=0.0441
+ AD=0.0567 PS=0.63 PD=0.69
M$9487 \$3371 B|X \$3391 VGND sky130_fd_pr__nfet_01v8 L=0.15 W=0.42 AS=0.0567
+ AD=0.0441 PS=0.69 PD=0.63
M$9488 \$3391 A|X VGND VGND sky130_fd_pr__nfet_01v8 L=0.15 W=0.42 AS=0.0441
+ AD=0.0567 PS=0.63 PD=0.69
M$9489 VGND A|X \$3386 VGND sky130_fd_pr__nfet_01v8 L=0.15 W=0.42 AS=0.0567
+ AD=0.0441 PS=0.69 PD=0.63
M$9490 \$3386 C|X \$3371 VGND sky130_fd_pr__nfet_01v8 L=0.15 W=0.42 AS=0.0441
+ AD=0.1092 PS=0.63 PD=1.36
M$9491 B1|X \$3371 VGND VGND sky130_fd_pr__nfet_01v8 L=0.15 W=0.65 AS=0.23725
+ AD=0.1474 PS=2.03 PD=1.215
M$9492 VGND \$3531 B|X VGND sky130_fd_pr__nfet_01v8 L=0.15 W=0.42 AS=0.097
+ AD=0.1491 PS=0.975 PD=1.55
M$9493 VGND \$3532 \$3531 VGND sky130_fd_pr__nfet_01v8 L=0.5 W=0.65 AS=0.097
+ AD=0.17225 PS=0.975 PD=1.83
M$9495 \$3532 \$3533 VGND VGND sky130_fd_pr__nfet_01v8 L=0.5 W=0.65 AS=0.169
+ AD=0.10435 PS=1.82 PD=1.01
M$9496 VGND A|COARSE_MUX[0] \$3533 VGND sky130_fd_pr__nfet_01v8 L=0.15 W=0.42
+ AS=0.10435 AD=0.1134 PS=1.01 PD=1.38
M$9526 \$3561 A|FINE_MUX[3] VGND VGND sky130_fd_pr__nfet_01v8 L=0.15 W=0.42
+ AS=0.1134 AD=0.10435 PS=1.38 PD=1.01
M$9527 VGND \$3561 \$3562 VGND sky130_fd_pr__nfet_01v8 L=0.5 W=0.65 AS=0.10435
+ AD=0.169 PS=1.01 PD=1.82
M$9528 VGND \$3563 A|B|B1|C1|X VGND sky130_fd_pr__nfet_01v8 L=0.15 W=0.42
+ AS=0.097 AD=0.1491 PS=0.975 PD=1.55
M$9529 \$3563 \$3562 VGND VGND sky130_fd_pr__nfet_01v8 L=0.5 W=0.65 AS=0.17225
+ AD=0.097 PS=1.83 PD=0.975
M$9531 B1|SLEEP|Y A|B1|Y \$3565 VGND sky130_fd_pr__nfet_01v8 L=0.15 W=0.42
+ AS=0.1113 AD=0.0588 PS=1.37 PD=0.7
M$9532 \$3565 A2|B|C|Y VGND VGND sky130_fd_pr__nfet_01v8 L=0.15 W=0.42
+ AS=0.0588 AD=0.0588 PS=0.7 PD=0.7
M$9533 VGND A|A1|X \$3565 VGND sky130_fd_pr__nfet_01v8 L=0.15 W=0.42 AS=0.0588
+ AD=0.1113 PS=0.7 PD=1.37
M$9535 A|C|Y A|B|B1|X \$3548 VGND sky130_fd_pr__nfet_01v8 L=0.15 W=0.42
+ AS=0.1113 AD=0.0588 PS=1.37 PD=0.7
M$9536 \$3548 A2|Y VGND VGND sky130_fd_pr__nfet_01v8 L=0.15 W=0.42 AS=0.0588
+ AD=0.0588 PS=0.7 PD=0.7
M$9537 VGND A0|A1|X \$3548 VGND sky130_fd_pr__nfet_01v8 L=0.15 W=0.42 AS=0.0588
+ AD=0.1113 PS=0.7 PD=1.37
M$9538 VGND A|B1|Y S|Y VGND sky130_fd_pr__nfet_01v8 L=0.15 W=0.65 AS=0.169
+ AD=0.08775 PS=1.82 PD=0.92
M$9539 S|Y B|Y VGND VGND sky130_fd_pr__nfet_01v8 L=0.15 W=0.65 AS=0.08775
+ AD=0.169 PS=0.92 PD=1.82
M$9540 \$3567 A0|A1|X A|B|SLEEP|Y VGND sky130_fd_pr__nfet_01v8 L=0.15 W=0.65
+ AS=0.169 AD=0.08775 PS=1.82 PD=0.92
M$9541 A|B|SLEEP|Y A1|X \$3569 VGND sky130_fd_pr__nfet_01v8 L=0.15 W=0.65
+ AS=0.08775 AD=0.182 PS=0.92 PD=1.86
M$9542 \$3567 \$3570 VGND VGND sky130_fd_pr__nfet_01v8 L=0.15 W=0.65 AS=0.169
+ AD=0.08775 PS=1.82 PD=0.92
M$9543 VGND S|Y \$3569 VGND sky130_fd_pr__nfet_01v8 L=0.15 W=0.65 AS=0.08775
+ AD=0.169 PS=0.92 PD=1.82
M$9544 \$3570 S|Y VGND VGND sky130_fd_pr__nfet_01v8 L=0.15 W=0.65 AS=0.169
+ AD=0.169 PS=1.82 PD=1.82
M$9546 A|X \$3571 VGND VGND sky130_fd_pr__nfet_01v8 L=0.15 W=0.65 AS=0.169
+ AD=0.1165 PS=1.82 PD=1.035
M$9547 VGND A|C|Y \$3572 VGND sky130_fd_pr__nfet_01v8 L=0.15 W=0.42 AS=0.1165
+ AD=0.1785 PS=1.035 PD=1.69
M$9548 VGND B|B_N|Y \$3575 VGND sky130_fd_pr__nfet_01v8 L=0.15 W=0.65 AS=0.1885
+ AD=0.16515 PS=1.88 PD=1.82
M$9549 \$3574 \$3575 \$3577 VGND sky130_fd_pr__nfet_01v8 L=0.15 W=0.42
+ AS=0.18205 AD=0.19265 PS=1.245 PD=1.285
M$9550 \$3573 \$3575 \$3576 VGND sky130_fd_pr__nfet_01v8 L=0.15 W=0.6
+ AS=0.140825 AD=0.11 PS=1.1 PD=0.99
M$9551 \$3576 A|B1|Y VGND VGND sky130_fd_pr__nfet_01v8 L=0.15 W=0.64 AS=0.11
+ AD=0.0864 PS=0.99 PD=0.91
M$9552 VGND \$3576 \$3577 VGND sky130_fd_pr__nfet_01v8 L=0.15 W=0.64 AS=0.0864
+ AD=0.1824 PS=0.91 PD=1.85
M$9553 \$3576 B|B_N|Y \$3574 VGND sky130_fd_pr__nfet_01v8 L=0.15 W=0.64
+ AS=0.16275 AD=0.18205 PS=1.8 PD=1.245
M$9554 \$3573 B|B_N|Y \$3577 VGND sky130_fd_pr__nfet_01v8 L=0.15 W=0.64
+ AS=0.140825 AD=0.19265 PS=1.1 PD=1.285
M$9556 A|B1|Y A|A1|Y \$3620 VGND sky130_fd_pr__nfet_01v8 L=0.15 W=0.65 AS=0.169
+ AD=0.08775 PS=1.82 PD=0.92
M$9557 \$3620 A1|B|Y VGND VGND sky130_fd_pr__nfet_01v8 L=0.15 W=0.65 AS=0.08775
+ AD=0.169 PS=0.92 PD=1.82
M$9563 VGND B1|Y A|A_N|B|Y VGND sky130_fd_pr__nfet_01v8 L=0.15 W=0.65
+ AS=0.17225 AD=0.091 PS=1.83 PD=0.93
M$9564 A|A_N|B|Y A|A1|A2|B|C|X \$3640 VGND sky130_fd_pr__nfet_01v8 L=0.15
+ W=0.65 AS=0.091 AD=0.095875 PS=0.93 PD=0.945
M$9565 \$3640 A2|Y VGND VGND sky130_fd_pr__nfet_01v8 L=0.15 W=0.65 AS=0.095875
+ AD=0.17225 PS=0.945 PD=1.83
M$9588 C|X \$3580 VGND VGND sky130_fd_pr__nfet_01v8 L=0.15 W=0.42 AS=0.1491
+ AD=0.097 PS=1.55 PD=0.975
M$9589 VGND \$3581 \$3580 VGND sky130_fd_pr__nfet_01v8 L=0.5 W=0.65 AS=0.097
+ AD=0.17225 PS=0.975 PD=1.83
M$9590 VGND A|COARSE_MUX[2] \$3582 VGND sky130_fd_pr__nfet_01v8 L=0.15 W=0.42
+ AS=0.10435 AD=0.1134 PS=1.01 PD=1.38
M$9591 \$3581 \$3582 VGND VGND sky130_fd_pr__nfet_01v8 L=0.5 W=0.65 AS=0.169
+ AD=0.10435 PS=1.82 PD=1.01
M$9592 VGND A|FINE_MUX[4] \$3697 VGND sky130_fd_pr__nfet_01v8 L=0.15 W=0.42
+ AS=0.10435 AD=0.1134 PS=1.01 PD=1.38
M$9593 VGND \$3697 \$3698 VGND sky130_fd_pr__nfet_01v8 L=0.5 W=0.65 AS=0.10435
+ AD=0.169 PS=1.01 PD=1.82
M$9594 \$3699 \$3698 VGND VGND sky130_fd_pr__nfet_01v8 L=0.5 W=0.65 AS=0.17225
+ AD=0.097 PS=1.83 PD=0.975
M$9595 VGND \$3699 A|B|B1|X VGND sky130_fd_pr__nfet_01v8 L=0.15 W=0.42 AS=0.097
+ AD=0.1491 PS=0.975 PD=1.55
M$9597 B|Y A|B|X \$3742 VGND sky130_fd_pr__nfet_01v8 L=0.15 W=0.65 AS=0.169
+ AD=0.08775 PS=1.82 PD=0.92
M$9598 \$3742 A2|B|C|Y VGND VGND sky130_fd_pr__nfet_01v8 L=0.15 W=0.65
+ AS=0.08775 AD=0.169 PS=0.92 PD=1.82
M$9601 \$3701 B|Y \$3744 VGND sky130_fd_pr__nfet_01v8 L=0.15 W=0.65 AS=0.169
+ AD=0.06825 PS=1.82 PD=0.86
M$9602 \$3744 A|B1|Y VGND VGND sky130_fd_pr__nfet_01v8 L=0.15 W=0.65 AS=0.06825
+ AD=0.08775 PS=0.86 PD=0.92
M$9603 VGND A|B1|Y \$3733 VGND sky130_fd_pr__nfet_01v8 L=0.15 W=0.65 AS=0.08775
+ AD=0.169 PS=0.92 PD=1.82
M$9604 VGND B|Y \$3733 VGND sky130_fd_pr__nfet_01v8 L=0.15 W=0.65 AS=0.169
+ AD=0.08775 PS=1.82 PD=0.92
M$9605 \$3733 \$3701 A|A2|B|Y VGND sky130_fd_pr__nfet_01v8 L=0.15 W=0.65
+ AS=0.08775 AD=0.195 PS=0.92 PD=1.9
M$9608 \$3573 A|C|Y \$3571 VGND sky130_fd_pr__nfet_01v8 L=0.15 W=0.64 AS=0.1728
+ AD=0.0928 PS=1.82 PD=0.93
M$9609 \$3571 \$3572 \$3574 VGND sky130_fd_pr__nfet_01v8 L=0.15 W=0.64
+ AS=0.0928 AD=0.224 PS=0.93 PD=1.98
M$9610 \$3736 A|A1|Y VGND VGND sky130_fd_pr__nfet_01v8 L=0.15 W=0.65 AS=0.17225
+ AD=0.12675 PS=1.83 PD=1.04
M$9611 VGND A2|X \$3736 VGND sky130_fd_pr__nfet_01v8 L=0.15 W=0.65 AS=0.12675
+ AD=0.12675 PS=1.04 PD=1.04
M$9612 \$3736 A|B1|Y \$3746 VGND sky130_fd_pr__nfet_01v8 L=0.15 W=0.65
+ AS=0.12675 AD=0.06825 PS=1.04 PD=0.86
M$9613 \$3746 B|C1|Y A|Y VGND sky130_fd_pr__nfet_01v8 L=0.15 W=0.65 AS=0.06825
+ AD=0.39325 PS=0.86 PD=2.51
M$9615 VGND \$3707 B|X VGND sky130_fd_pr__nfet_01v8 L=0.15 W=0.65 AS=0.208
+ AD=0.25025 PS=1.94 PD=1.42
M$9616 B|X B|Y \$3747 VGND sky130_fd_pr__nfet_01v8 L=0.15 W=0.65 AS=0.25025
+ AD=0.08775 PS=1.42 PD=0.92
M$9617 \$3747 A|B1|Y VGND VGND sky130_fd_pr__nfet_01v8 L=0.15 W=0.65 AS=0.08775
+ AD=0.08775 PS=0.92 PD=0.92
M$9618 VGND A|B1|Y \$3707 VGND sky130_fd_pr__nfet_01v8 L=0.15 W=0.65 AS=0.08775
+ AD=0.08775 PS=0.92 PD=0.92
M$9619 \$3707 B|Y VGND VGND sky130_fd_pr__nfet_01v8 L=0.15 W=0.65 AS=0.08775
+ AD=0.169 PS=0.92 PD=1.82
M$9624 A|A1|B|Y B|C|X VGND VGND sky130_fd_pr__nfet_01v8 L=0.15 W=0.65 AS=0.169
+ AD=0.08775 PS=1.82 PD=0.92
M$9625 VGND B|X A|A1|B|Y VGND sky130_fd_pr__nfet_01v8 L=0.15 W=0.65 AS=0.08775
+ AD=0.08775 PS=0.92 PD=0.92
M$9626 A|A1|B|Y A|X VGND VGND sky130_fd_pr__nfet_01v8 L=0.15 W=0.65 AS=0.08775
+ AD=0.169 PS=0.92 PD=1.82
M$9628 \$3714 B|X \$3753 VGND sky130_fd_pr__nfet_01v8 L=0.15 W=0.65 AS=0.169
+ AD=0.06825 PS=1.82 PD=0.86
M$9629 \$3753 A|A1|A2|B|C|X VGND VGND sky130_fd_pr__nfet_01v8 L=0.15 W=0.65
+ AS=0.06825 AD=0.08775 PS=0.86 PD=0.92
M$9630 VGND A|A1|A2|B|C|X \$3738 VGND sky130_fd_pr__nfet_01v8 L=0.15 W=0.65
+ AS=0.08775 AD=0.169 PS=0.92 PD=1.82
M$9631 VGND B|X \$3738 VGND sky130_fd_pr__nfet_01v8 L=0.15 W=0.65 AS=0.169
+ AD=0.08775 PS=1.82 PD=0.92
M$9632 \$3738 \$3714 B|C|Y VGND sky130_fd_pr__nfet_01v8 L=0.15 W=0.65
+ AS=0.08775 AD=0.195 PS=0.92 PD=1.9
M$9634 \$3716 A|A_N|B|Y \$3751 VGND sky130_fd_pr__nfet_01v8 L=0.15 W=0.65
+ AS=0.169 AD=0.06825 PS=1.82 PD=0.86
M$9635 \$3751 A|B|SLEEP|X VGND VGND sky130_fd_pr__nfet_01v8 L=0.15 W=0.65
+ AS=0.06825 AD=0.08775 PS=0.86 PD=0.92
M$9636 VGND A|B|SLEEP|X \$3739 VGND sky130_fd_pr__nfet_01v8 L=0.15 W=0.65
+ AS=0.08775 AD=0.169 PS=0.92 PD=1.82
M$9637 VGND A|A_N|B|Y \$3739 VGND sky130_fd_pr__nfet_01v8 L=0.15 W=0.65
+ AS=0.169 AD=0.08775 PS=1.82 PD=0.92
M$9638 \$3739 \$3716 A|Y VGND sky130_fd_pr__nfet_01v8 L=0.15 W=0.65 AS=0.08775
+ AD=0.195 PS=0.92 PD=1.9
M$9662 VGND A|B|X \$3785 VGND sky130_fd_pr__nfet_01v8 L=0.15 W=0.65 AS=0.169
+ AD=0.08775 PS=1.82 PD=0.92
M$9663 \$3785 A|X C1|Y VGND sky130_fd_pr__nfet_01v8 L=0.15 W=0.65 AS=0.08775
+ AD=0.169 PS=0.92 PD=1.82
M$9664 A|C|Y A|X \$3788 VGND sky130_fd_pr__nfet_01v8 L=0.15 W=0.65 AS=0.169
+ AD=0.10725 PS=1.82 PD=0.98
M$9665 \$3788 A|B|X \$3787 VGND sky130_fd_pr__nfet_01v8 L=0.15 W=0.65
+ AS=0.10725 AD=0.08775 PS=0.98 PD=0.92
M$9666 \$3787 A2|B|C|Y VGND VGND sky130_fd_pr__nfet_01v8 L=0.15 W=0.65
+ AS=0.08775 AD=0.169 PS=0.92 PD=1.82
M$9670 VGND A|C|Y A|Y VGND sky130_fd_pr__nfet_01v8 L=0.15 W=1.3 AS=0.338
+ AD=0.1755 PS=3.64 PD=1.84
M$9672 VGND B|Y \$3805 VGND sky130_fd_pr__nfet_01v8 L=0.15 W=0.65 AS=0.169
+ AD=0.08775 PS=1.82 PD=0.92
M$9673 \$3805 A|B|SLEEP|Y B|Y VGND sky130_fd_pr__nfet_01v8 L=0.15 W=0.65
+ AS=0.08775 AD=0.169 PS=0.92 PD=1.82
M$9674 VGND B|Y \$3809 VGND sky130_fd_pr__nfet_01v8 L=0.15 W=0.65 AS=0.169
+ AD=0.08775 PS=1.82 PD=0.92
M$9675 \$3809 A|X B|Y VGND sky130_fd_pr__nfet_01v8 L=0.15 W=0.65 AS=0.08775
+ AD=0.169 PS=0.92 PD=1.82
M$9678 \$3735 A|A1|Y VGND VGND sky130_fd_pr__nfet_01v8 L=0.15 W=0.42 AS=0.1113
+ AD=0.0588 PS=1.37 PD=0.7
M$9679 VGND A2|X \$3735 VGND sky130_fd_pr__nfet_01v8 L=0.15 W=0.42 AS=0.0588
+ AD=0.0588 PS=0.7 PD=0.7
M$9680 \$3735 A|B1|Y A|C|Y VGND sky130_fd_pr__nfet_01v8 L=0.15 W=0.42 AS=0.0588
+ AD=0.1113 PS=0.7 PD=1.37
M$9684 \$3764 B|X \$3826 VGND sky130_fd_pr__nfet_01v8 L=0.15 W=0.65 AS=0.169
+ AD=0.06825 PS=1.82 PD=0.86
M$9685 \$3826 A|X VGND VGND sky130_fd_pr__nfet_01v8 L=0.15 W=0.65 AS=0.06825
+ AD=0.08775 PS=0.86 PD=0.92
M$9686 VGND A|X \$3765 VGND sky130_fd_pr__nfet_01v8 L=0.15 W=0.65 AS=0.08775
+ AD=0.169 PS=0.92 PD=1.82
M$9687 VGND B|X \$3765 VGND sky130_fd_pr__nfet_01v8 L=0.15 W=0.65 AS=0.169
+ AD=0.08775 PS=1.82 PD=0.92
M$9688 \$3765 \$3764 A2|B|C|Y VGND sky130_fd_pr__nfet_01v8 L=0.15 W=0.65
+ AS=0.08775 AD=0.195 PS=0.92 PD=1.9
M$9689 VGND \$3767 A|X VGND sky130_fd_pr__nfet_01v8 L=0.15 W=0.65 AS=0.208
+ AD=0.25025 PS=1.94 PD=1.42
M$9690 A|X B|C|X \$3834 VGND sky130_fd_pr__nfet_01v8 L=0.15 W=0.65 AS=0.25025
+ AD=0.08775 PS=1.42 PD=0.92
M$9691 \$3834 A|Y VGND VGND sky130_fd_pr__nfet_01v8 L=0.15 W=0.65 AS=0.08775
+ AD=0.08775 PS=0.92 PD=0.92
M$9692 VGND A|Y \$3767 VGND sky130_fd_pr__nfet_01v8 L=0.15 W=0.65 AS=0.08775
+ AD=0.08775 PS=0.92 PD=0.92
M$9693 \$3767 B|C|X VGND VGND sky130_fd_pr__nfet_01v8 L=0.15 W=0.65 AS=0.08775
+ AD=0.169 PS=0.92 PD=1.82
M$9694 \$3710 A|Y \$3750 VGND sky130_fd_pr__nfet_01v8 L=0.15 W=0.42 AS=0.1113
+ AD=0.0441 PS=1.37 PD=0.63
M$9695 \$3750 B|C|X VGND VGND sky130_fd_pr__nfet_01v8 L=0.15 W=0.42 AS=0.0441
+ AD=0.0966 PS=0.63 PD=0.88
M$9696 VGND \$3710 A|X VGND sky130_fd_pr__nfet_01v8 L=0.15 W=0.42 AS=0.0966
+ AD=0.1113 PS=0.88 PD=1.37
M$9697 \$3768 A|B1|Y \$3840 VGND sky130_fd_pr__nfet_01v8 L=0.15 W=0.42
+ AS=0.1113 AD=0.0441 PS=1.37 PD=0.63
M$9698 \$3840 B|C|X VGND VGND sky130_fd_pr__nfet_01v8 L=0.15 W=0.42 AS=0.0441
+ AD=0.0966 PS=0.63 PD=0.88
M$9699 VGND \$3768 B|C|X VGND sky130_fd_pr__nfet_01v8 L=0.15 W=0.42 AS=0.0966
+ AD=0.1113 PS=0.88 PD=1.37
M$9701 \$3769 A|B|X \$3845 VGND sky130_fd_pr__nfet_01v8 L=0.15 W=0.42 AS=0.1113
+ AD=0.0441 PS=1.37 PD=0.63
M$9702 \$3845 B|C|X VGND VGND sky130_fd_pr__nfet_01v8 L=0.15 W=0.42 AS=0.0441
+ AD=0.0966 PS=0.63 PD=0.88
M$9703 VGND \$3769 A|A3|C|D|X VGND sky130_fd_pr__nfet_01v8 L=0.15 W=0.42
+ AS=0.0966 AD=0.1113 PS=0.88 PD=1.37
M$9704 \$3713 A|X \$3752 VGND sky130_fd_pr__nfet_01v8 L=0.15 W=0.42 AS=0.1113
+ AD=0.0441 PS=1.37 PD=0.63
M$9705 \$3752 A|B|X VGND VGND sky130_fd_pr__nfet_01v8 L=0.15 W=0.42 AS=0.0441
+ AD=0.0966 PS=0.63 PD=0.88
M$9706 VGND \$3713 A|A1|A2|B|C|X VGND sky130_fd_pr__nfet_01v8 L=0.15 W=0.42
+ AS=0.0966 AD=0.1113 PS=0.88 PD=1.37
M$9709 VGND A|A_N|B|Y \$3771 VGND sky130_fd_pr__nfet_01v8 L=0.15 W=0.42
+ AS=0.10025 AD=0.1092 PS=0.985 PD=1.36
M$9710 VGND A|B|SLEEP|X \$3859 VGND sky130_fd_pr__nfet_01v8 L=0.15 W=0.65
+ AS=0.10025 AD=0.08775 PS=0.985 PD=0.92
M$9711 \$3859 \$3771 D1|Y VGND sky130_fd_pr__nfet_01v8 L=0.15 W=0.65 AS=0.08775
+ AD=0.169 PS=0.92 PD=1.82
M$9712 D|Y D1|Y \$3863 VGND sky130_fd_pr__nfet_01v8 L=0.15 W=0.65 AS=0.17225
+ AD=0.06825 PS=1.83 PD=0.86
M$9713 \$3863 C1|Y \$3864 VGND sky130_fd_pr__nfet_01v8 L=0.15 W=0.65 AS=0.06825
+ AD=0.12675 PS=0.86 PD=1.04
M$9714 \$3864 B1|Y \$3775 VGND sky130_fd_pr__nfet_01v8 L=0.15 W=0.65 AS=0.12675
+ AD=0.131625 PS=1.04 PD=1.055
M$9715 \$3775 A2|B|X VGND VGND sky130_fd_pr__nfet_01v8 L=0.15 W=0.65
+ AS=0.131625 AD=0.12675 PS=1.055 PD=1.04
M$9716 VGND A1|X \$3775 VGND sky130_fd_pr__nfet_01v8 L=0.15 W=0.65 AS=0.12675
+ AD=0.17225 PS=1.04 PD=1.83
M$9717 \$3777 A|A_N|B|Y VGND VGND sky130_fd_pr__nfet_01v8 L=0.15 W=0.42
+ AS=0.1092 AD=0.10025 PS=1.36 PD=0.985
M$9718 VGND A|B|SLEEP|X A1|X VGND sky130_fd_pr__nfet_01v8 L=0.15 W=0.65
+ AS=0.10025 AD=0.08775 PS=0.985 PD=0.92
M$9719 A1|X \$3777 VGND VGND sky130_fd_pr__nfet_01v8 L=0.15 W=0.65 AS=0.08775
+ AD=0.169 PS=0.92 PD=1.82
M$9741 VGND A|FINE_MUX[5] \$3918 VGND sky130_fd_pr__nfet_01v8 L=0.15 W=0.42
+ AS=0.10435 AD=0.1134 PS=1.01 PD=1.38
M$9742 VGND \$3918 \$3919 VGND sky130_fd_pr__nfet_01v8 L=0.5 W=0.65 AS=0.10435
+ AD=0.169 PS=1.01 PD=1.82
M$9743 \$3920 \$3919 VGND VGND sky130_fd_pr__nfet_01v8 L=0.5 W=0.65 AS=0.17225
+ AD=0.097 PS=1.83 PD=0.975
M$9744 VGND \$3920 A|X VGND sky130_fd_pr__nfet_01v8 L=0.15 W=0.42 AS=0.097
+ AD=0.1491 PS=0.975 PD=1.55
M$9745 A|A2|B|Y \$3922 \$3953 VGND sky130_fd_pr__nfet_01v8 L=0.15 W=0.65
+ AS=0.195 AD=0.08775 PS=1.9 PD=0.92
M$9746 \$3953 A|B|X VGND VGND sky130_fd_pr__nfet_01v8 L=0.15 W=0.65 AS=0.08775
+ AD=0.169 PS=0.92 PD=1.82
M$9747 \$3953 A|X VGND VGND sky130_fd_pr__nfet_01v8 L=0.15 W=0.65 AS=0.169
+ AD=0.08775 PS=1.82 PD=0.92
M$9748 VGND A|X \$3959 VGND sky130_fd_pr__nfet_01v8 L=0.15 W=0.65 AS=0.08775
+ AD=0.06825 PS=0.92 PD=0.86
M$9749 \$3959 A|B|X \$3922 VGND sky130_fd_pr__nfet_01v8 L=0.15 W=0.65
+ AS=0.06825 AD=0.169 PS=0.86 PD=1.82
M$9752 \$3923 A|B|SLEEP|Y \$3961 VGND sky130_fd_pr__nfet_01v8 L=0.15 W=0.65
+ AS=0.169 AD=0.06825 PS=1.82 PD=0.86
M$9753 \$3961 A|Y VGND VGND sky130_fd_pr__nfet_01v8 L=0.15 W=0.65 AS=0.06825
+ AD=0.08775 PS=0.86 PD=0.92
M$9754 VGND A|Y \$3954 VGND sky130_fd_pr__nfet_01v8 L=0.15 W=0.65 AS=0.08775
+ AD=0.169 PS=0.92 PD=1.82
M$9755 VGND A|B|SLEEP|Y \$3954 VGND sky130_fd_pr__nfet_01v8 L=0.15 W=0.65
+ AS=0.169 AD=0.08775 PS=1.82 PD=0.92
M$9756 \$3954 \$3923 A2|A3|Y VGND sky130_fd_pr__nfet_01v8 L=0.15 W=0.65
+ AS=0.08775 AD=0.195 PS=0.92 PD=1.9
M$9758 \$3924 A|X \$3963 VGND sky130_fd_pr__nfet_01v8 L=0.15 W=0.42 AS=0.1113
+ AD=0.0441 PS=1.37 PD=0.63
M$9759 \$3963 B|Y VGND VGND sky130_fd_pr__nfet_01v8 L=0.15 W=0.42 AS=0.0441
+ AD=0.0966 PS=0.63 PD=0.88
M$9760 VGND \$3924 B|X VGND sky130_fd_pr__nfet_01v8 L=0.15 W=0.42 AS=0.0966
+ AD=0.1113 PS=0.88 PD=1.37
M$9764 \$3761 A|C|Y VGND VGND sky130_fd_pr__nfet_01v8 L=0.15 W=0.42 AS=0.1092
+ AD=0.0567 PS=1.36 PD=0.69
M$9765 VGND B|Y \$3761 VGND sky130_fd_pr__nfet_01v8 L=0.15 W=0.42 AS=0.0567
+ AD=0.0567 PS=0.69 PD=0.69
M$9766 VGND A|X \$3761 VGND sky130_fd_pr__nfet_01v8 L=0.15 W=0.42 AS=0.101875
+ AD=0.0567 PS=0.99 PD=0.69
M$9767 VGND \$3761 A|X VGND sky130_fd_pr__nfet_01v8 L=0.15 W=0.65 AS=0.101875
+ AD=0.182 PS=0.99 PD=1.86
M$9770 VGND A2|B|C|Y \$3966 VGND sky130_fd_pr__nfet_01v8 L=0.15 W=0.65
+ AS=0.17225 AD=0.095875 PS=1.83 PD=0.945
M$9771 \$3966 A|A1|Y B|Y VGND sky130_fd_pr__nfet_01v8 L=0.15 W=0.65 AS=0.095875
+ AD=0.091 PS=0.945 PD=0.93
M$9773 A|B|B1|Y A|A1|Y \$3968 VGND sky130_fd_pr__nfet_01v8 L=0.15 W=0.65
+ AS=0.169 AD=0.10725 PS=1.82 PD=0.98
M$9774 \$3968 A2|B|C|Y \$3967 VGND sky130_fd_pr__nfet_01v8 L=0.15 W=0.65
+ AS=0.10725 AD=0.08775 PS=0.98 PD=0.92
M$9775 \$3967 B|C|X VGND VGND sky130_fd_pr__nfet_01v8 L=0.15 W=0.65 AS=0.08775
+ AD=0.169 PS=0.92 PD=1.82
M$9778 VGND A|A3|C|D|X \$3930 VGND sky130_fd_pr__nfet_01v8 L=0.15 W=0.42
+ AS=0.1092 AD=0.0693 PS=1.36 PD=0.75
M$9779 \$3930 A|A1|A2|B|C|X VGND VGND sky130_fd_pr__nfet_01v8 L=0.15 W=0.42
+ AS=0.0693 AD=0.0567 PS=0.75 PD=0.69
M$9780 VGND A|A1|B|Y \$3930 VGND sky130_fd_pr__nfet_01v8 L=0.15 W=0.42
+ AS=0.0567 AD=0.0567 PS=0.69 PD=0.69
M$9781 VGND A|B|B1|Y \$3930 VGND sky130_fd_pr__nfet_01v8 L=0.15 W=0.42
+ AS=0.101875 AD=0.0567 PS=0.99 PD=0.69
M$9782 VGND \$3930 B|B1|D_N|X VGND sky130_fd_pr__nfet_01v8 L=0.15 W=0.65
+ AS=0.101875 AD=0.1755 PS=0.99 PD=1.84
M$9783 A|Y A|A3|C|D|X VGND VGND sky130_fd_pr__nfet_01v8 L=0.15 W=0.42 AS=0.1092
+ AD=0.1197 PS=1.36 PD=1.41
M$9785 \$3933 B|C|Y \$3972 VGND sky130_fd_pr__nfet_01v8 L=0.15 W=0.42 AS=0.1092
+ AD=0.0441 PS=1.36 PD=0.63
M$9786 \$3972 A|Y VGND VGND sky130_fd_pr__nfet_01v8 L=0.15 W=0.42 AS=0.0441
+ AD=0.0567 PS=0.63 PD=0.69
M$9787 VGND A|Y \$3971 VGND sky130_fd_pr__nfet_01v8 L=0.15 W=0.42 AS=0.0567
+ AD=0.0441 PS=0.69 PD=0.63
M$9788 \$3971 B|B1|D_N|X \$3933 VGND sky130_fd_pr__nfet_01v8 L=0.15 W=0.42
+ AS=0.0441 AD=0.0567 PS=0.63 PD=0.69
M$9789 \$3933 B|B1|D_N|X \$3970 VGND sky130_fd_pr__nfet_01v8 L=0.15 W=0.42
+ AS=0.0567 AD=0.0441 PS=0.69 PD=0.63
M$9790 VGND B|C|Y \$3970 VGND sky130_fd_pr__nfet_01v8 L=0.15 W=0.42 AS=0.1474
+ AD=0.0441 PS=1.215 PD=0.63
M$9791 VGND \$3933 A2|B|X VGND sky130_fd_pr__nfet_01v8 L=0.15 W=0.65 AS=0.1474
+ AD=0.23725 PS=1.215 PD=2.03
M$9793 B|Y \$3936 \$3956 VGND sky130_fd_pr__nfet_01v8 L=0.15 W=0.65 AS=0.195
+ AD=0.08775 PS=1.9 PD=0.92
M$9794 \$3956 A2|B|X VGND VGND sky130_fd_pr__nfet_01v8 L=0.15 W=0.65 AS=0.08775
+ AD=0.169 PS=0.92 PD=1.82
M$9795 \$3956 A|Y VGND VGND sky130_fd_pr__nfet_01v8 L=0.15 W=0.65 AS=0.169
+ AD=0.08775 PS=1.82 PD=0.92
M$9796 VGND A|Y \$3969 VGND sky130_fd_pr__nfet_01v8 L=0.15 W=0.65 AS=0.08775
+ AD=0.06825 PS=0.92 PD=0.86
M$9797 \$3969 A2|B|X \$3936 VGND sky130_fd_pr__nfet_01v8 L=0.15 W=0.65
+ AS=0.06825 AD=0.169 PS=0.86 PD=1.82
M$9821 VGND A|B1|X A1|Y VGND sky130_fd_pr__nfet_01v8 L=0.15 W=0.42 AS=0.1197
+ AD=0.1092 PS=1.41 PD=1.36
M$9822 \$3975 A1|Y VGND VGND sky130_fd_pr__nfet_01v8 L=0.15 W=0.65 AS=0.17225
+ AD=0.12675 PS=1.83 PD=1.04
M$9823 VGND A|A2|B|Y \$3975 VGND sky130_fd_pr__nfet_01v8 L=0.15 W=0.65
+ AS=0.12675 AD=0.12675 PS=1.04 PD=1.04
M$9824 \$3975 B1|SLEEP|Y \$4008 VGND sky130_fd_pr__nfet_01v8 L=0.15 W=0.65
+ AS=0.12675 AD=0.06825 PS=1.04 PD=0.86
M$9825 \$4008 C1|Y B|Y VGND sky130_fd_pr__nfet_01v8 L=0.15 W=0.65 AS=0.06825
+ AD=0.39325 PS=0.86 PD=2.51
M$9826 VGND A|A2|B|Y \$3977 VGND sky130_fd_pr__nfet_01v8 L=0.15 W=0.42
+ AS=0.1092 AD=0.0567 PS=1.36 PD=0.69
M$9827 \$3977 B1|SLEEP|Y VGND VGND sky130_fd_pr__nfet_01v8 L=0.15 W=0.42
+ AS=0.0567 AD=0.10025 PS=0.69 PD=0.985
M$9828 VGND \$3977 A|A1|X VGND sky130_fd_pr__nfet_01v8 L=0.15 W=0.65 AS=0.10025
+ AD=0.169 PS=0.985 PD=1.82
M$9830 B|Y A|A1|X VGND VGND sky130_fd_pr__nfet_01v8 L=0.15 W=1.07 AS=0.2782
+ AD=0.20745 PS=3.18 PD=2.33
M$9831 VGND \$3980 B|B_N|C|X VGND sky130_fd_pr__nfet_01v8 L=0.15 W=0.65
+ AS=0.208 AD=0.25025 PS=1.94 PD=1.42
M$9832 B|B_N|C|X A|A2|B|Y \$4019 VGND sky130_fd_pr__nfet_01v8 L=0.15 W=0.65
+ AS=0.25025 AD=0.08775 PS=1.42 PD=0.92
M$9833 \$4019 A|C|Y VGND VGND sky130_fd_pr__nfet_01v8 L=0.15 W=0.65 AS=0.08775
+ AD=0.08775 PS=0.92 PD=0.92
M$9834 VGND A|C|Y \$3980 VGND sky130_fd_pr__nfet_01v8 L=0.15 W=0.65 AS=0.08775
+ AD=0.08775 PS=0.92 PD=0.92
M$9835 \$3980 A|A2|B|Y VGND VGND sky130_fd_pr__nfet_01v8 L=0.15 W=0.65
+ AS=0.08775 AD=0.169 PS=0.92 PD=1.82
M$9836 VGND A|A1|X \$3981 VGND sky130_fd_pr__nfet_01v8 L=0.15 W=0.65 AS=0.169
+ AD=0.08775 PS=1.82 PD=0.92
M$9837 \$3981 A|A2|B|Y VGND VGND sky130_fd_pr__nfet_01v8 L=0.15 W=0.65
+ AS=0.08775 AD=0.08775 PS=0.92 PD=0.92
M$9838 VGND A2|A3|Y \$3981 VGND sky130_fd_pr__nfet_01v8 L=0.15 W=0.65
+ AS=0.08775 AD=0.19825 PS=0.92 PD=1.26
M$9839 \$3981 A|B1|X C|Y VGND sky130_fd_pr__nfet_01v8 L=0.15 W=0.65 AS=0.19825
+ AD=0.221 PS=1.26 PD=1.98
M$9841 B|C|X \$3983 VGND VGND sky130_fd_pr__nfet_01v8 L=0.15 W=0.65 AS=0.169
+ AD=0.1165 PS=1.82 PD=1.035
M$9842 VGND C|Y \$3984 VGND sky130_fd_pr__nfet_01v8 L=0.15 W=0.42 AS=0.1165
+ AD=0.1785 PS=1.035 PD=1.69
M$9843 VGND B|Y \$3986 VGND sky130_fd_pr__nfet_01v8 L=0.15 W=0.65 AS=0.1885
+ AD=0.16515 PS=1.88 PD=1.82
M$9844 \$4114 \$3986 \$3988 VGND sky130_fd_pr__nfet_01v8 L=0.15 W=0.42
+ AS=0.18205 AD=0.19265 PS=1.245 PD=1.285
M$9845 \$3985 \$3986 \$3987 VGND sky130_fd_pr__nfet_01v8 L=0.15 W=0.6
+ AS=0.140825 AD=0.11 PS=1.1 PD=0.99
M$9846 \$3987 A|X VGND VGND sky130_fd_pr__nfet_01v8 L=0.15 W=0.64 AS=0.11
+ AD=0.0864 PS=0.99 PD=0.91
M$9847 VGND \$3987 \$3988 VGND sky130_fd_pr__nfet_01v8 L=0.15 W=0.64 AS=0.0864
+ AD=0.1824 PS=0.91 PD=1.85
M$9848 \$3987 B|Y \$4114 VGND sky130_fd_pr__nfet_01v8 L=0.15 W=0.64 AS=0.16275
+ AD=0.18205 PS=1.8 PD=1.245
M$9849 \$3985 B|Y \$3988 VGND sky130_fd_pr__nfet_01v8 L=0.15 W=0.64 AS=0.140825
+ AD=0.19265 PS=1.1 PD=1.285
M$9851 B|Y B|C1|Y VGND VGND sky130_fd_pr__nfet_01v8 L=0.15 W=0.65 AS=0.08775
+ AD=0.169 PS=0.92 PD=1.82
M$9854 \$3991 B|Y \$4050 VGND sky130_fd_pr__nfet_01v8 L=0.15 W=0.65 AS=0.169
+ AD=0.06825 PS=1.82 PD=0.86
M$9855 \$4050 A|X VGND VGND sky130_fd_pr__nfet_01v8 L=0.15 W=0.65 AS=0.06825
+ AD=0.08775 PS=0.86 PD=0.92
M$9856 VGND A|X \$3992 VGND sky130_fd_pr__nfet_01v8 L=0.15 W=0.65 AS=0.08775
+ AD=0.169 PS=0.92 PD=1.82
M$9857 VGND B|Y \$3992 VGND sky130_fd_pr__nfet_01v8 L=0.15 W=0.65 AS=0.169
+ AD=0.08775 PS=1.82 PD=0.92
M$9858 \$3992 \$3991 B|C|Y VGND sky130_fd_pr__nfet_01v8 L=0.15 W=0.65
+ AS=0.08775 AD=0.195 PS=0.92 PD=1.9
M$9861 VGND A|A1|B|Y C|Y VGND sky130_fd_pr__nfet_01v8 L=0.15 W=0.65 AS=0.169
+ AD=0.08775 PS=1.82 PD=0.92
M$9862 C|Y A|A1|A2|B|C|X VGND VGND sky130_fd_pr__nfet_01v8 L=0.15 W=0.65
+ AS=0.08775 AD=0.08775 PS=0.92 PD=0.92
M$9863 VGND A|A3|C|D|X C|Y VGND sky130_fd_pr__nfet_01v8 L=0.15 W=0.65
+ AS=0.08775 AD=0.169 PS=0.92 PD=1.82
M$9864 \$3994 A|B|B1|Y \$3995 VGND sky130_fd_pr__nfet_01v8 L=0.15 W=0.65
+ AS=0.2015 AD=0.10725 PS=1.92 PD=0.98
M$9865 \$3995 A|A3|C|D|X VGND VGND sky130_fd_pr__nfet_01v8 L=0.15 W=0.65
+ AS=0.10725 AD=0.10725 PS=0.98 PD=0.98
M$9866 VGND A|A1|A2|B|C|X \$3995 VGND sky130_fd_pr__nfet_01v8 L=0.15 W=0.65
+ AS=0.10725 AD=0.08775 PS=0.98 PD=0.92
M$9867 \$3995 A|A1|B|Y VGND VGND sky130_fd_pr__nfet_01v8 L=0.15 W=0.65
+ AS=0.08775 AD=0.12675 PS=0.92 PD=1.04
M$9868 VGND \$3994 A2|C|X VGND sky130_fd_pr__nfet_01v8 L=0.15 W=0.65 AS=0.12675
+ AD=0.234 PS=1.04 PD=2.02
M$9870 A|B|Y \$3998 \$3999 VGND sky130_fd_pr__nfet_01v8 L=0.15 W=0.65 AS=0.195
+ AD=0.08775 PS=1.9 PD=0.92
M$9871 \$3999 B|C|Y VGND VGND sky130_fd_pr__nfet_01v8 L=0.15 W=0.65 AS=0.08775
+ AD=0.169 PS=0.92 PD=1.82
M$9872 \$3999 A|Y VGND VGND sky130_fd_pr__nfet_01v8 L=0.15 W=0.65 AS=0.169
+ AD=0.08775 PS=1.82 PD=0.92
M$9873 VGND A|Y \$4076 VGND sky130_fd_pr__nfet_01v8 L=0.15 W=0.65 AS=0.08775
+ AD=0.06825 PS=0.92 PD=0.86
M$9874 \$4076 B|C|Y \$3998 VGND sky130_fd_pr__nfet_01v8 L=0.15 W=0.65
+ AS=0.06825 AD=0.169 PS=0.86 PD=1.82
M$9876 B1|Y A|Y \$4083 VGND sky130_fd_pr__nfet_01v8 L=0.15 W=0.65 AS=0.169
+ AD=0.08775 PS=1.82 PD=0.92
M$9877 \$4083 B|Y VGND VGND sky130_fd_pr__nfet_01v8 L=0.15 W=0.65 AS=0.08775
+ AD=0.169 PS=0.92 PD=1.82
M$9900 \$4178 A|FINE_MUX[6] VGND VGND sky130_fd_pr__nfet_01v8 L=0.15 W=0.42
+ AS=0.1134 AD=0.10435 PS=1.38 PD=1.01
M$9901 VGND \$4178 \$4179 VGND sky130_fd_pr__nfet_01v8 L=0.5 W=0.65 AS=0.10435
+ AD=0.169 PS=1.01 PD=1.82
M$9902 VGND \$4180 A|B1|X VGND sky130_fd_pr__nfet_01v8 L=0.15 W=0.42 AS=0.097
+ AD=0.1491 PS=0.975 PD=1.55
M$9903 \$4180 \$4179 VGND VGND sky130_fd_pr__nfet_01v8 L=0.5 W=0.65 AS=0.17225
+ AD=0.097 PS=1.83 PD=0.975
M$9904 A|B|C|Y \$4182 \$4183 VGND sky130_fd_pr__nfet_01v8 L=0.15 W=0.65
+ AS=0.195 AD=0.08775 PS=1.9 PD=0.92
M$9905 \$4183 A|A2|B|Y VGND VGND sky130_fd_pr__nfet_01v8 L=0.15 W=0.65
+ AS=0.08775 AD=0.169 PS=0.92 PD=1.82
M$9906 \$4183 A|B1|X VGND VGND sky130_fd_pr__nfet_01v8 L=0.15 W=0.65 AS=0.169
+ AD=0.08775 PS=1.82 PD=0.92
M$9907 VGND A|B1|X \$4220 VGND sky130_fd_pr__nfet_01v8 L=0.15 W=0.65 AS=0.08775
+ AD=0.06825 PS=0.92 PD=0.86
M$9908 \$4220 A|A2|B|Y \$4182 VGND sky130_fd_pr__nfet_01v8 L=0.15 W=0.65
+ AS=0.06825 AD=0.169 PS=0.86 PD=1.82
M$9909 VGND A|C|Y \$4165 VGND sky130_fd_pr__nfet_01v8 L=0.15 W=0.65 AS=0.169
+ AD=0.08775 PS=1.82 PD=0.92
M$9910 \$4165 B|Y \$4166 VGND sky130_fd_pr__nfet_01v8 L=0.15 W=0.65 AS=0.08775
+ AD=0.10725 PS=0.92 PD=0.98
M$9911 \$4166 A|Y A|Y VGND sky130_fd_pr__nfet_01v8 L=0.15 W=0.65 AS=0.10725
+ AD=0.169 PS=0.98 PD=1.82
M$9913 A|B|C|D|Y \$4185 \$4186 VGND sky130_fd_pr__nfet_01v8 L=0.15 W=0.65
+ AS=0.195 AD=0.08775 PS=1.9 PD=0.92
M$9914 \$4186 B|B_N|C|X VGND VGND sky130_fd_pr__nfet_01v8 L=0.15 W=0.65
+ AS=0.08775 AD=0.169 PS=0.92 PD=1.82
M$9915 \$4186 A|Y VGND VGND sky130_fd_pr__nfet_01v8 L=0.15 W=0.65 AS=0.169
+ AD=0.08775 PS=1.82 PD=0.92
M$9916 VGND A|Y \$4227 VGND sky130_fd_pr__nfet_01v8 L=0.15 W=0.65 AS=0.08775
+ AD=0.06825 PS=0.92 PD=0.86
M$9917 \$4227 B|B_N|C|X \$4185 VGND sky130_fd_pr__nfet_01v8 L=0.15 W=0.65
+ AS=0.06825 AD=0.169 PS=0.86 PD=1.82
M$9919 A|Y A|B1|X \$4168 VGND sky130_fd_pr__nfet_01v8 L=0.15 W=0.65 AS=0.169
+ AD=0.08775 PS=1.82 PD=0.92
M$9920 \$4168 B|Y VGND VGND sky130_fd_pr__nfet_01v8 L=0.15 W=0.65 AS=0.08775
+ AD=0.169 PS=0.92 PD=1.82
M$9921 \$4187 B|B_N|C|X VGND VGND sky130_fd_pr__nfet_01v8 L=0.15 W=0.42
+ AS=0.1092 AD=0.10025 PS=1.36 PD=0.985
M$9923 A|A1|Y \$4187 VGND VGND sky130_fd_pr__nfet_01v8 L=0.15 W=0.65 AS=0.08775
+ AD=0.169 PS=0.92 PD=1.82
M$9924 VGND B|B_N|C|X \$4169 VGND sky130_fd_pr__nfet_01v8 L=0.15 W=0.65
+ AS=0.169 AD=0.08775 PS=1.82 PD=0.92
M$9925 \$4169 B|Y \$4170 VGND sky130_fd_pr__nfet_01v8 L=0.15 W=0.65 AS=0.08775
+ AD=0.10725 PS=0.92 PD=0.98
M$9926 \$4170 A|B1|X A|A1|Y VGND sky130_fd_pr__nfet_01v8 L=0.15 W=0.65
+ AS=0.10725 AD=0.169 PS=0.98 PD=1.82
M$9929 VGND A|A1|Y \$4189 VGND sky130_fd_pr__nfet_01v8 L=0.15 W=0.42 AS=0.1092
+ AD=0.0567 PS=1.36 PD=0.69
M$9930 \$4189 A|B|SLEEP|Y VGND VGND sky130_fd_pr__nfet_01v8 L=0.15 W=0.42
+ AS=0.0567 AD=0.10025 PS=0.69 PD=0.985
M$9931 VGND \$4189 B1|X VGND sky130_fd_pr__nfet_01v8 L=0.15 W=0.65 AS=0.10025
+ AD=0.169 PS=0.985 PD=1.82
M$9934 \$3985 C|Y \$3983 VGND sky130_fd_pr__nfet_01v8 L=0.15 W=0.64 AS=0.1728
+ AD=0.0928 PS=1.82 PD=0.93
M$9935 \$3983 \$3984 \$4114 VGND sky130_fd_pr__nfet_01v8 L=0.15 W=0.64
+ AS=0.0928 AD=0.224 PS=0.93 PD=1.98
M$9937 B|C1|Y C|Y VGND VGND sky130_fd_pr__nfet_01v8 L=0.15 W=0.65 AS=0.169
+ AD=0.08775 PS=1.82 PD=0.92
M$9938 VGND B|X B|C1|Y VGND sky130_fd_pr__nfet_01v8 L=0.15 W=0.65 AS=0.08775
+ AD=0.08775 PS=0.92 PD=0.92
M$9939 B|C1|Y A|Y VGND VGND sky130_fd_pr__nfet_01v8 L=0.15 W=0.65 AS=0.08775
+ AD=0.169 PS=0.92 PD=1.82
M$9940 \$4138 B|Y \$4172 VGND sky130_fd_pr__nfet_01v8 L=0.15 W=0.65 AS=0.169
+ AD=0.06825 PS=1.82 PD=0.86
M$9941 \$4172 A|C|Y VGND VGND sky130_fd_pr__nfet_01v8 L=0.15 W=0.65 AS=0.06825
+ AD=0.08775 PS=0.86 PD=0.92
M$9942 VGND A|C|Y \$4161 VGND sky130_fd_pr__nfet_01v8 L=0.15 W=0.65 AS=0.08775
+ AD=0.169 PS=0.92 PD=1.82
M$9943 VGND B|Y \$4161 VGND sky130_fd_pr__nfet_01v8 L=0.15 W=0.65 AS=0.169
+ AD=0.08775 PS=1.82 PD=0.92
M$9944 \$4161 \$4138 B|Y VGND sky130_fd_pr__nfet_01v8 L=0.15 W=0.65 AS=0.08775
+ AD=0.195 PS=0.92 PD=1.9
M$9947 B|C|X \$4192 VGND VGND sky130_fd_pr__nfet_01v8 L=0.15 W=0.65 AS=0.169
+ AD=0.1165 PS=1.82 PD=1.035
M$9948 VGND A2|B|C|Y \$4193 VGND sky130_fd_pr__nfet_01v8 L=0.15 W=0.42
+ AS=0.1165 AD=0.1785 PS=1.035 PD=1.69
M$9949 VGND A|B|Y \$4196 VGND sky130_fd_pr__nfet_01v8 L=0.15 W=0.65 AS=0.1885
+ AD=0.16515 PS=1.88 PD=1.82
M$9951 \$4140 A2|B|C|Y \$4175 VGND sky130_fd_pr__nfet_01v8 L=0.15 W=0.65
+ AS=0.169 AD=0.06825 PS=1.82 PD=0.86
M$9952 \$4175 A|Y VGND VGND sky130_fd_pr__nfet_01v8 L=0.15 W=0.65 AS=0.06825
+ AD=0.08775 PS=0.86 PD=0.92
M$9953 VGND A|Y \$4162 VGND sky130_fd_pr__nfet_01v8 L=0.15 W=0.65 AS=0.08775
+ AD=0.169 PS=0.92 PD=1.82
M$9954 \$4195 \$4196 \$4198 VGND sky130_fd_pr__nfet_01v8 L=0.15 W=0.42
+ AS=0.18205 AD=0.19265 PS=1.245 PD=1.285
M$9955 \$4194 \$4196 \$4197 VGND sky130_fd_pr__nfet_01v8 L=0.15 W=0.6
+ AS=0.140825 AD=0.11 PS=1.1 PD=0.99
M$9956 \$4197 A|Y VGND VGND sky130_fd_pr__nfet_01v8 L=0.15 W=0.64 AS=0.11
+ AD=0.0864 PS=0.99 PD=0.91
M$9957 VGND \$4197 \$4198 VGND sky130_fd_pr__nfet_01v8 L=0.15 W=0.64 AS=0.0864
+ AD=0.1824 PS=0.91 PD=1.85
M$9958 \$4197 A|B|Y \$4195 VGND sky130_fd_pr__nfet_01v8 L=0.15 W=0.64
+ AS=0.16275 AD=0.18205 PS=1.8 PD=1.245
M$9959 \$4194 A|B|Y \$4198 VGND sky130_fd_pr__nfet_01v8 L=0.15 W=0.64
+ AS=0.140825 AD=0.19265 PS=1.1 PD=1.285
M$9960 VGND A2|B|C|Y \$4162 VGND sky130_fd_pr__nfet_01v8 L=0.15 W=0.65 AS=0.169
+ AD=0.08775 PS=1.82 PD=0.92
M$9961 \$4162 \$4140 B|Y VGND sky130_fd_pr__nfet_01v8 L=0.15 W=0.65 AS=0.08775
+ AD=0.195 PS=0.92 PD=1.9
M$9962 VGND B|C|Y \$4258 VGND sky130_fd_pr__nfet_01v8 L=0.15 W=0.65 AS=0.169
+ AD=0.08775 PS=1.82 PD=0.92
M$9963 \$4258 B|Y \$4260 VGND sky130_fd_pr__nfet_01v8 L=0.15 W=0.65 AS=0.08775
+ AD=0.10725 PS=0.92 PD=0.98
M$9964 \$4260 A|B|Y A|A1|Y VGND sky130_fd_pr__nfet_01v8 L=0.15 W=0.65
+ AS=0.10725 AD=0.169 PS=0.98 PD=1.82
M$9966 A|Y A|B|Y \$4263 VGND sky130_fd_pr__nfet_01v8 L=0.15 W=0.65 AS=0.169
+ AD=0.08775 PS=1.82 PD=0.92
M$9967 \$4263 B|Y VGND VGND sky130_fd_pr__nfet_01v8 L=0.15 W=0.65 AS=0.08775
+ AD=0.169 PS=0.92 PD=1.82
M$9969 A|B|C|X \$4202 VGND VGND sky130_fd_pr__nfet_01v8 L=0.15 W=0.65 AS=0.169
+ AD=0.144125 PS=1.82 PD=1.12
M$9970 VGND C|Y \$4203 VGND sky130_fd_pr__nfet_01v8 L=0.15 W=0.42 AS=0.144125
+ AD=0.1764 PS=1.12 PD=1.68
M$9972 VGND A|B|B1|Y \$4206 VGND sky130_fd_pr__nfet_01v8 L=0.15 W=0.65 AS=0.195
+ AD=0.1653 PS=1.9 PD=1.82
M$9973 \$4204 \$4206 \$4208 VGND sky130_fd_pr__nfet_01v8 L=0.15 W=0.42
+ AS=0.18365 AD=0.19265 PS=1.25 PD=1.285
M$9974 \$4205 \$4206 \$4207 VGND sky130_fd_pr__nfet_01v8 L=0.15 W=0.6
+ AS=0.140825 AD=0.11 PS=1.1 PD=0.99
M$9975 \$4207 A|A1|Y VGND VGND sky130_fd_pr__nfet_01v8 L=0.15 W=0.64 AS=0.11
+ AD=0.0864 PS=0.99 PD=0.91
M$9976 VGND \$4207 \$4208 VGND sky130_fd_pr__nfet_01v8 L=0.15 W=0.64 AS=0.0864
+ AD=0.1824 PS=0.91 PD=1.85
M$9977 \$4207 A|B|B1|Y \$4204 VGND sky130_fd_pr__nfet_01v8 L=0.15 W=0.64
+ AS=0.1628 AD=0.18365 PS=1.8 PD=1.25
M$9978 \$4205 A|B|B1|Y \$4208 VGND sky130_fd_pr__nfet_01v8 L=0.15 W=0.64
+ AS=0.140825 AD=0.19265 PS=1.1 PD=1.285
M$9979 \$4142 B|B1|D_N|X VGND VGND sky130_fd_pr__nfet_01v8 L=0.15 W=0.42
+ AS=0.1092 AD=0.10025 PS=1.36 PD=0.985
M$9980 VGND A|A1|Y A|Y VGND sky130_fd_pr__nfet_01v8 L=0.15 W=1.95 AS=0.357
+ AD=0.3445 PS=3.725 PD=3.66
M$9982 VGND A2|C|X A|Y VGND sky130_fd_pr__nfet_01v8 L=0.15 W=0.65 AS=0.10725
+ AD=0.08775 PS=0.98 PD=0.92
M$9983 A|Y \$4142 VGND VGND sky130_fd_pr__nfet_01v8 L=0.15 W=0.65 AS=0.08775
+ AD=0.182 PS=0.92 PD=1.86
M$9984 \$4210 A|A1|Y VGND VGND sky130_fd_pr__nfet_01v8 L=0.15 W=0.42 AS=0.1113
+ AD=0.0588 PS=1.37 PD=0.7
M$9985 VGND A2|C|X \$4210 VGND sky130_fd_pr__nfet_01v8 L=0.15 W=0.42 AS=0.0588
+ AD=0.0588 PS=0.7 PD=0.7
M$9986 \$4210 B|B1|D_N|X B|Y VGND sky130_fd_pr__nfet_01v8 L=0.15 W=0.42
+ AS=0.0588 AD=0.1113 PS=0.7 PD=1.37
M$9990 VGND \$4145 A|X VGND sky130_fd_pr__nfet_01v8 L=0.15 W=0.65 AS=0.208
+ AD=0.25025 PS=1.94 PD=1.42
M$9991 A|X B|Y \$4176 VGND sky130_fd_pr__nfet_01v8 L=0.15 W=0.65 AS=0.25025
+ AD=0.08775 PS=1.42 PD=0.92
M$9992 \$4176 A|Y VGND VGND sky130_fd_pr__nfet_01v8 L=0.15 W=0.65 AS=0.08775
+ AD=0.08775 PS=0.92 PD=0.92
M$9993 VGND A|Y \$4145 VGND sky130_fd_pr__nfet_01v8 L=0.15 W=0.65 AS=0.08775
+ AD=0.08775 PS=0.92 PD=0.92
M$9994 \$4145 B|Y VGND VGND sky130_fd_pr__nfet_01v8 L=0.15 W=0.65 AS=0.08775
+ AD=0.169 PS=0.92 PD=1.82
M$10039 C1|Y A|B|C|Y \$4358 VGND sky130_fd_pr__nfet_01v8 L=0.15 W=0.65 AS=0.169
+ AD=0.10725 PS=1.82 PD=0.98
M$10040 \$4358 A|B|C|Y \$4359 VGND sky130_fd_pr__nfet_01v8 L=0.15 W=0.65
+ AS=0.10725 AD=0.08775 PS=0.98 PD=0.92
M$10041 \$4359 A|B|C|D|Y VGND VGND sky130_fd_pr__nfet_01v8 L=0.15 W=0.65
+ AS=0.08775 AD=0.169 PS=0.92 PD=1.82
M$10043 \$4330 C1|Y VGND VGND sky130_fd_pr__nfet_01v8 L=0.15 W=0.65 AS=0.17225
+ AD=0.10075 PS=1.83 PD=0.96
M$10044 VGND B1|X \$4330 VGND sky130_fd_pr__nfet_01v8 L=0.15 W=0.65 AS=0.10075
+ AD=0.091 PS=0.96 PD=0.93
M$10045 \$4330 A|A1|Y \$4361 VGND sky130_fd_pr__nfet_01v8 L=0.15 W=0.65
+ AS=0.091 AD=0.091 PS=0.93 PD=0.93
M$10046 \$4361 A2|A3|Y VGND VGND sky130_fd_pr__nfet_01v8 L=0.15 W=0.65 AS=0.091
+ AD=0.26 PS=0.93 PD=1.45
M$10047 VGND \$4330 B|X VGND sky130_fd_pr__nfet_01v8 L=0.15 W=0.65 AS=0.26
+ AD=0.17225 PS=1.45 PD=1.83
M$10048 \$4353 A|A1|Y VGND VGND sky130_fd_pr__nfet_01v8 L=0.15 W=0.65
+ AS=0.17225 AD=0.12675 PS=1.83 PD=1.04
M$10049 VGND A2|A3|Y \$4353 VGND sky130_fd_pr__nfet_01v8 L=0.15 W=0.65
+ AS=0.12675 AD=0.12675 PS=1.04 PD=1.04
M$10050 \$4353 B1|X \$4362 VGND sky130_fd_pr__nfet_01v8 L=0.15 W=0.65
+ AS=0.12675 AD=0.06825 PS=1.04 PD=0.86
M$10051 \$4362 C1|Y A|A1|Y VGND sky130_fd_pr__nfet_01v8 L=0.15 W=0.65
+ AS=0.06825 AD=0.39325 PS=0.86 PD=2.51
M$10053 \$4335 A|A_N|Y VGND VGND sky130_fd_pr__nfet_01v8 L=0.15 W=0.42
+ AS=0.1092 AD=0.10025 PS=1.36 PD=0.985
M$10054 VGND B|C|X \$4364 VGND sky130_fd_pr__nfet_01v8 L=0.15 W=0.65 AS=0.10025
+ AD=0.08775 PS=0.985 PD=0.92
M$10055 \$4364 \$4335 A|Y VGND sky130_fd_pr__nfet_01v8 L=0.15 W=0.65 AS=0.08775
+ AD=0.169 PS=0.92 PD=1.82
M$10058 A|B|Y B|Y VGND VGND sky130_fd_pr__nfet_01v8 L=0.15 W=0.65 AS=0.08775
+ AD=0.169 PS=0.92 PD=1.82
M$10060 \$4194 A2|B|C|Y \$4192 VGND sky130_fd_pr__nfet_01v8 L=0.15 W=0.64
+ AS=0.1728 AD=0.0928 PS=1.82 PD=0.93
M$10061 \$4192 \$4193 \$4195 VGND sky130_fd_pr__nfet_01v8 L=0.15 W=0.64
+ AS=0.0928 AD=0.224 PS=0.93 PD=1.98
M$10063 \$4337 B|C|Y \$4367 VGND sky130_fd_pr__nfet_01v8 L=0.15 W=0.65 AS=0.169
+ AD=0.06825 PS=1.82 PD=0.86
M$10064 \$4367 A|Y VGND VGND sky130_fd_pr__nfet_01v8 L=0.15 W=0.65 AS=0.06825
+ AD=0.08775 PS=0.86 PD=0.92
M$10065 VGND A|Y \$4354 VGND sky130_fd_pr__nfet_01v8 L=0.15 W=0.65 AS=0.08775
+ AD=0.169 PS=0.92 PD=1.82
M$10066 VGND B|C|Y \$4354 VGND sky130_fd_pr__nfet_01v8 L=0.15 W=0.65 AS=0.169
+ AD=0.08775 PS=1.82 PD=0.92
M$10067 \$4354 \$4337 B|Y VGND sky130_fd_pr__nfet_01v8 L=0.15 W=0.65 AS=0.08775
+ AD=0.195 PS=0.92 PD=1.9
M$10069 \$4204 C|Y \$4202 VGND sky130_fd_pr__nfet_01v8 L=0.15 W=0.64 AS=0.1728
+ AD=0.128 PS=1.82 PD=1.04
M$10070 \$4202 \$4203 \$4205 VGND sky130_fd_pr__nfet_01v8 L=0.15 W=0.64
+ AS=0.128 AD=0.3168 PS=1.04 PD=2.27
M$10072 VGND B|Y \$4339 VGND sky130_fd_pr__nfet_01v8 L=0.15 W=0.65 AS=0.169
+ AD=0.08775 PS=1.82 PD=0.92
M$10073 \$4339 A|B|Y VGND VGND sky130_fd_pr__nfet_01v8 L=0.15 W=0.65 AS=0.08775
+ AD=0.08775 PS=0.92 PD=0.92
M$10074 VGND A|B|Y \$4368 VGND sky130_fd_pr__nfet_01v8 L=0.15 W=0.65 AS=0.08775
+ AD=0.08775 PS=0.92 PD=0.92
M$10075 \$4368 B|Y C|X VGND sky130_fd_pr__nfet_01v8 L=0.15 W=0.65 AS=0.08775
+ AD=0.25025 PS=0.92 PD=1.42
M$10076 C|X \$4339 VGND VGND sky130_fd_pr__nfet_01v8 L=0.15 W=0.65 AS=0.25025
+ AD=0.208 PS=1.42 PD=1.94
M$10101 VGND A|B|C|Y \$4370 VGND sky130_fd_pr__nfet_01v8 L=0.15 W=0.65 AS=0.169
+ AD=0.08775 PS=1.82 PD=0.92
M$10102 \$4370 A|X VGND VGND sky130_fd_pr__nfet_01v8 L=0.15 W=0.65 AS=0.08775
+ AD=0.08775 PS=0.92 PD=0.92
M$10103 VGND A|X \$4395 VGND sky130_fd_pr__nfet_01v8 L=0.15 W=0.65 AS=0.08775
+ AD=0.08775 PS=0.92 PD=0.92
M$10104 \$4395 A|B|C|Y A|B|X VGND sky130_fd_pr__nfet_01v8 L=0.15 W=0.65
+ AS=0.08775 AD=0.25025 PS=0.92 PD=1.42
M$10105 A|B|X \$4370 VGND VGND sky130_fd_pr__nfet_01v8 L=0.15 W=0.65 AS=0.25025
+ AD=0.208 PS=1.42 PD=1.94
M$10106 VGND A|Y A|B|C|Y VGND sky130_fd_pr__nfet_01v8 L=0.15 W=0.42 AS=0.1197
+ AD=0.1092 PS=1.41 PD=1.36
M$10107 VGND A|B|C|D|Y \$4400 VGND sky130_fd_pr__nfet_01v8 L=0.15 W=0.65
+ AS=0.169 AD=0.08775 PS=1.82 PD=0.92
M$10108 \$4400 A|B|C|Y \$4402 VGND sky130_fd_pr__nfet_01v8 L=0.15 W=0.65
+ AS=0.08775 AD=0.08775 PS=0.92 PD=0.92
M$10109 \$4402 A|B|C|Y \$4405 VGND sky130_fd_pr__nfet_01v8 L=0.15 W=0.65
+ AS=0.08775 AD=0.10725 PS=0.92 PD=0.98
M$10110 \$4405 A|X C1|Y VGND sky130_fd_pr__nfet_01v8 L=0.15 W=0.65 AS=0.10725
+ AD=0.195 PS=0.98 PD=1.9
M$10112 \$4329 A|A1|Y \$4360 VGND sky130_fd_pr__nfet_01v8 L=0.15 W=0.42
+ AS=0.1113 AD=0.0441 PS=1.37 PD=0.63
M$10113 \$4360 A|B|SLEEP|Y VGND VGND sky130_fd_pr__nfet_01v8 L=0.15 W=0.42
+ AS=0.0441 AD=0.0966 PS=0.63 PD=0.88
M$10114 VGND \$4329 B1|X VGND sky130_fd_pr__nfet_01v8 L=0.15 W=0.42 AS=0.0966
+ AD=0.1113 PS=0.88 PD=1.37
M$10115 A|A_N|Y A|X \$4410 VGND sky130_fd_pr__nfet_01v8 L=0.15 W=0.65 AS=0.169
+ AD=0.08775 PS=1.82 PD=0.92
M$10116 \$4410 B|X VGND VGND sky130_fd_pr__nfet_01v8 L=0.15 W=0.65 AS=0.08775
+ AD=0.169 PS=0.92 PD=1.82
M$10117 A2|B|X \$4372 VGND VGND sky130_fd_pr__nfet_01v8 L=0.15 W=0.65
+ AS=0.17225 AD=0.26 PS=1.83 PD=1.45
M$10118 VGND A2|A3|Y \$4415 VGND sky130_fd_pr__nfet_01v8 L=0.15 W=0.65 AS=0.26
+ AD=0.091 PS=1.45 PD=0.93
M$10119 \$4415 A|A1|Y \$4372 VGND sky130_fd_pr__nfet_01v8 L=0.15 W=0.65
+ AS=0.091 AD=0.091 PS=0.93 PD=0.93
M$10120 \$4372 B1|X VGND VGND sky130_fd_pr__nfet_01v8 L=0.15 W=0.65 AS=0.091
+ AD=0.10075 PS=0.93 PD=0.96
M$10121 VGND C1|Y \$4372 VGND sky130_fd_pr__nfet_01v8 L=0.15 W=0.65 AS=0.10075
+ AD=0.17225 PS=0.96 PD=1.83
M$10124 \$4374 B|C|X \$4425 VGND sky130_fd_pr__nfet_01v8 L=0.15 W=0.65 AS=0.169
+ AD=0.06825 PS=1.82 PD=0.86
M$10125 \$4425 A|A_N|Y VGND VGND sky130_fd_pr__nfet_01v8 L=0.15 W=0.65
+ AS=0.06825 AD=0.08775 PS=0.86 PD=0.92
M$10126 VGND A|A_N|Y \$4376 VGND sky130_fd_pr__nfet_01v8 L=0.15 W=0.65
+ AS=0.08775 AD=0.169 PS=0.92 PD=1.82
M$10127 VGND B|C|X \$4376 VGND sky130_fd_pr__nfet_01v8 L=0.15 W=0.65 AS=0.169
+ AD=0.08775 PS=1.82 PD=0.92
M$10128 \$4376 \$4374 B|Y VGND sky130_fd_pr__nfet_01v8 L=0.15 W=0.65 AS=0.08775
+ AD=0.195 PS=0.92 PD=1.9
M$10129 VGND B|Y \$4378 VGND sky130_fd_pr__nfet_01v8 L=0.15 W=0.65 AS=0.169
+ AD=0.08775 PS=1.82 PD=0.92
M$10130 \$4378 A|Y VGND VGND sky130_fd_pr__nfet_01v8 L=0.15 W=0.65 AS=0.08775
+ AD=0.08775 PS=0.92 PD=0.92
M$10131 VGND A|Y \$4434 VGND sky130_fd_pr__nfet_01v8 L=0.15 W=0.65 AS=0.08775
+ AD=0.08775 PS=0.92 PD=0.92
M$10132 \$4434 B|Y A|B|X VGND sky130_fd_pr__nfet_01v8 L=0.15 W=0.65 AS=0.08775
+ AD=0.25025 PS=0.92 PD=1.42
M$10133 A|B|X \$4378 VGND VGND sky130_fd_pr__nfet_01v8 L=0.15 W=0.65 AS=0.25025
+ AD=0.208 PS=1.42 PD=1.94
M$10136 VGND A|A_N|Y \$4381 VGND sky130_fd_pr__nfet_01v8 L=0.15 W=0.42
+ AS=0.10025 AD=0.1092 PS=0.985 PD=1.36
M$10137 VGND B|Y \$4445 VGND sky130_fd_pr__nfet_01v8 L=0.15 W=0.65 AS=0.10025
+ AD=0.08775 PS=0.985 PD=0.92
M$10138 \$4445 \$4381 A_N|B1_N|Y VGND sky130_fd_pr__nfet_01v8 L=0.15 W=0.65
+ AS=0.08775 AD=0.169 PS=0.92 PD=1.82
M$10140 A|Y A|A1|X \$4450 VGND sky130_fd_pr__nfet_01v8 L=0.15 W=0.65 AS=0.169
+ AD=0.10725 PS=1.82 PD=0.98
M$10141 \$4450 A2|B|Y \$4451 VGND sky130_fd_pr__nfet_01v8 L=0.15 W=0.65
+ AS=0.10725 AD=0.08775 PS=0.98 PD=0.92
M$10142 \$4451 A|B|C|X VGND VGND sky130_fd_pr__nfet_01v8 L=0.15 W=0.65
+ AS=0.08775 AD=0.169 PS=0.92 PD=1.82
M$10145 \$4386 C|X \$4459 VGND sky130_fd_pr__nfet_01v8 L=0.15 W=0.42 AS=0.1092
+ AD=0.0441 PS=1.36 PD=0.63
M$10146 \$4459 A|Y VGND VGND sky130_fd_pr__nfet_01v8 L=0.15 W=0.42 AS=0.0441
+ AD=0.0567 PS=0.63 PD=0.69
M$10147 VGND A|Y \$4460 VGND sky130_fd_pr__nfet_01v8 L=0.15 W=0.42 AS=0.0567
+ AD=0.0441 PS=0.69 PD=0.63
M$10148 \$4460 B|Y \$4386 VGND sky130_fd_pr__nfet_01v8 L=0.15 W=0.42 AS=0.0441
+ AD=0.0567 PS=0.63 PD=0.69
M$10149 \$4386 B|Y \$4461 VGND sky130_fd_pr__nfet_01v8 L=0.15 W=0.42 AS=0.0567
+ AD=0.0441 PS=0.69 PD=0.63
M$10150 \$4461 C|X VGND VGND sky130_fd_pr__nfet_01v8 L=0.15 W=0.42 AS=0.0441
+ AD=0.1474 PS=0.63 PD=1.215
M$10151 VGND \$4386 B|SLEEP|X VGND sky130_fd_pr__nfet_01v8 L=0.15 W=0.65
+ AS=0.1474 AD=0.23725 PS=1.215 PD=2.03
M$10175 \$4519 A|B|C|Y \$4558 VGND sky130_fd_pr__nfet_01v8 L=0.15 W=0.42
+ AS=0.1092 AD=0.0441 PS=1.36 PD=0.63
M$10176 \$4558 A|X VGND VGND sky130_fd_pr__nfet_01v8 L=0.15 W=0.42 AS=0.0441
+ AD=0.0567 PS=0.63 PD=0.69
M$10177 VGND A|X \$4559 VGND sky130_fd_pr__nfet_01v8 L=0.15 W=0.42 AS=0.0567
+ AD=0.0441 PS=0.69 PD=0.63
M$10178 \$4559 A|B|X \$4519 VGND sky130_fd_pr__nfet_01v8 L=0.15 W=0.42
+ AS=0.0441 AD=0.0567 PS=0.63 PD=0.69
M$10179 \$4519 A|B|X \$4560 VGND sky130_fd_pr__nfet_01v8 L=0.15 W=0.42
+ AS=0.0567 AD=0.0441 PS=0.69 PD=0.63
M$10180 VGND A|B|C|Y \$4560 VGND sky130_fd_pr__nfet_01v8 L=0.15 W=0.42
+ AS=0.1474 AD=0.0441 PS=1.215 PD=0.63
M$10181 VGND \$4519 B|X VGND sky130_fd_pr__nfet_01v8 L=0.15 W=0.65 AS=0.1474
+ AD=0.23725 PS=1.215 PD=2.03
M$10182 \$4521 A|B|X \$4561 VGND sky130_fd_pr__nfet_01v8 L=0.15 W=0.42
+ AS=0.1092 AD=0.0441 PS=1.36 PD=0.63
M$10183 \$4561 A|B|C|Y \$4562 VGND sky130_fd_pr__nfet_01v8 L=0.15 W=0.42
+ AS=0.0441 AD=0.0441 PS=0.63 PD=0.63
M$10184 VGND A|B|C|D|Y \$4562 VGND sky130_fd_pr__nfet_01v8 L=0.15 W=0.42
+ AS=0.13165 AD=0.0441 PS=1.14 PD=0.63
M$10185 VGND \$4521 A3|B|X VGND sky130_fd_pr__nfet_01v8 L=0.15 W=0.65
+ AS=0.13165 AD=0.169 PS=1.14 PD=1.82
M$10189 VGND B|C|X \$4525 VGND sky130_fd_pr__nfet_01v8 L=0.15 W=0.42 AS=0.1165
+ AD=0.1785 PS=1.035 PD=1.69
M$10190 A|X \$4524 VGND VGND sky130_fd_pr__nfet_01v8 L=0.15 W=0.65 AS=0.169
+ AD=0.1165 PS=1.82 PD=1.035
M$10191 \$4527 B|C|X \$4524 VGND sky130_fd_pr__nfet_01v8 L=0.15 W=0.64
+ AS=0.1728 AD=0.0928 PS=1.82 PD=0.93
M$10192 \$4524 \$4525 \$4526 VGND sky130_fd_pr__nfet_01v8 L=0.15 W=0.64
+ AS=0.0928 AD=0.224 PS=0.93 PD=1.98
M$10193 VGND A|B|Y \$4528 VGND sky130_fd_pr__nfet_01v8 L=0.15 W=0.65 AS=0.1885
+ AD=0.16515 PS=1.88 PD=1.82
M$10194 \$4529 A|B|Y \$4526 VGND sky130_fd_pr__nfet_01v8 L=0.15 W=0.64
+ AS=0.16275 AD=0.18205 PS=1.8 PD=1.245
M$10195 \$4526 \$4528 \$4530 VGND sky130_fd_pr__nfet_01v8 L=0.15 W=0.42
+ AS=0.18205 AD=0.19265 PS=1.245 PD=1.285
M$10196 \$4530 A|B|Y \$4527 VGND sky130_fd_pr__nfet_01v8 L=0.15 W=0.64
+ AS=0.19265 AD=0.140825 PS=1.285 PD=1.1
M$10197 \$4527 \$4528 \$4529 VGND sky130_fd_pr__nfet_01v8 L=0.15 W=0.6
+ AS=0.140825 AD=0.11 PS=1.1 PD=0.99
M$10198 \$4529 A|A_N|Y VGND VGND sky130_fd_pr__nfet_01v8 L=0.15 W=0.64 AS=0.11
+ AD=0.0864 PS=0.99 PD=0.91
M$10199 VGND \$4529 \$4530 VGND sky130_fd_pr__nfet_01v8 L=0.15 W=0.64 AS=0.0864
+ AD=0.1824 PS=0.91 PD=1.85
M$10201 A|A_N|Y A|X \$4565 VGND sky130_fd_pr__nfet_01v8 L=0.15 W=0.65 AS=0.169
+ AD=0.10725 PS=1.82 PD=0.98
M$10202 \$4565 A|B|X \$4564 VGND sky130_fd_pr__nfet_01v8 L=0.15 W=0.65
+ AS=0.10725 AD=0.08775 PS=0.98 PD=0.92
M$10203 \$4564 B|C|X VGND VGND sky130_fd_pr__nfet_01v8 L=0.15 W=0.65 AS=0.08775
+ AD=0.169 PS=0.92 PD=1.82
M$10206 \$4531 B|Y \$4567 VGND sky130_fd_pr__nfet_01v8 L=0.15 W=0.65 AS=0.169
+ AD=0.06825 PS=1.82 PD=0.86
M$10207 \$4567 A|A_N|Y VGND VGND sky130_fd_pr__nfet_01v8 L=0.15 W=0.65
+ AS=0.06825 AD=0.08775 PS=0.86 PD=0.92
M$10208 VGND A|A_N|Y \$4554 VGND sky130_fd_pr__nfet_01v8 L=0.15 W=0.65
+ AS=0.08775 AD=0.169 PS=0.92 PD=1.82
M$10209 VGND B|Y \$4554 VGND sky130_fd_pr__nfet_01v8 L=0.15 W=0.65 AS=0.169
+ AD=0.08775 PS=1.82 PD=0.92
M$10210 \$4554 \$4531 A2|B|Y VGND sky130_fd_pr__nfet_01v8 L=0.15 W=0.65
+ AS=0.08775 AD=0.195 PS=0.92 PD=1.9
M$10212 VGND A2|B|Y \$4568 VGND sky130_fd_pr__nfet_01v8 L=0.15 W=0.42 AS=0.1113
+ AD=0.0441 PS=1.37 PD=0.63
M$10213 \$4568 A|A1|X B|Y VGND sky130_fd_pr__nfet_01v8 L=0.15 W=0.42 AS=0.0441
+ AD=0.1113 PS=0.63 PD=0.95
M$10214 B|Y \$4555 VGND VGND sky130_fd_pr__nfet_01v8 L=0.15 W=0.42 AS=0.1113
+ AD=0.1302 PS=0.95 PD=1.04
M$10215 VGND A_N|B1_N|Y \$4555 VGND sky130_fd_pr__nfet_01v8 L=0.15 W=0.42
+ AS=0.1302 AD=0.1113 PS=1.04 PD=1.37
M$10216 \$4534 A_N|B1_N|Y VGND VGND sky130_fd_pr__nfet_01v8 L=0.15 W=0.42
+ AS=0.1092 AD=0.10025 PS=1.36 PD=0.985
M$10217 VGND A|B|C|X \$4569 VGND sky130_fd_pr__nfet_01v8 L=0.15 W=0.65
+ AS=0.10025 AD=0.08775 PS=0.985 PD=0.92
M$10218 \$4569 \$4534 B|Y VGND sky130_fd_pr__nfet_01v8 L=0.15 W=0.65 AS=0.08775
+ AD=0.169 PS=0.92 PD=1.82
M$10220 \$4540 B|Y \$4536 VGND sky130_fd_pr__nfet_01v8 L=0.15 W=0.64
+ AS=0.140825 AD=0.19265 PS=1.1 PD=1.285
M$10221 \$4536 \$4538 \$4539 VGND sky130_fd_pr__nfet_01v8 L=0.15 W=0.42
+ AS=0.19265 AD=0.18365 PS=1.285 PD=1.25
M$10222 \$4539 B|Y \$4537 VGND sky130_fd_pr__nfet_01v8 L=0.15 W=0.64 AS=0.18365
+ AD=0.1628 PS=1.25 PD=1.8
M$10223 \$4536 \$4537 VGND VGND sky130_fd_pr__nfet_01v8 L=0.15 W=0.64 AS=0.1824
+ AD=0.0864 PS=1.85 PD=0.91
M$10224 VGND A|Y \$4537 VGND sky130_fd_pr__nfet_01v8 L=0.15 W=0.64 AS=0.0864
+ AD=0.11 PS=0.91 PD=0.99
M$10225 \$4540 \$4538 \$4537 VGND sky130_fd_pr__nfet_01v8 L=0.15 W=0.6
+ AS=0.140825 AD=0.11 PS=1.1 PD=0.99
M$10226 \$4538 B|Y VGND VGND sky130_fd_pr__nfet_01v8 L=0.15 W=0.65 AS=0.1653
+ AD=0.195 PS=1.82 PD=1.9
M$10227 \$4540 \$4541 \$4542 VGND sky130_fd_pr__nfet_01v8 L=0.15 W=0.64
+ AS=0.3168 AD=0.128 PS=2.27 PD=1.04
M$10228 \$4542 C|X \$4539 VGND sky130_fd_pr__nfet_01v8 L=0.15 W=0.64 AS=0.128
+ AD=0.1728 PS=1.04 PD=1.82
M$10229 \$4541 C|X VGND VGND sky130_fd_pr__nfet_01v8 L=0.15 W=0.42 AS=0.1764
+ AD=0.144125 PS=1.68 PD=1.12
M$10230 VGND \$4542 A|A_N|X VGND sky130_fd_pr__nfet_01v8 L=0.15 W=0.65
+ AS=0.144125 AD=0.169 PS=1.12 PD=1.82
M$10253 \$4573 A|FINE_MUX[7] VGND VGND sky130_fd_pr__nfet_01v8 L=0.15 W=0.42
+ AS=0.1134 AD=0.10435 PS=1.38 PD=1.01
M$10254 VGND \$4573 \$4574 VGND sky130_fd_pr__nfet_01v8 L=0.5 W=0.65 AS=0.10435
+ AD=0.169 PS=1.01 PD=1.82
M$10255 VGND \$4575 A|X VGND sky130_fd_pr__nfet_01v8 L=0.15 W=0.42 AS=0.097
+ AD=0.1491 PS=0.975 PD=1.55
M$10256 \$4575 \$4574 VGND VGND sky130_fd_pr__nfet_01v8 L=0.5 W=0.65 AS=0.17225
+ AD=0.097 PS=1.83 PD=0.975
M$10258 VGND B|X \$4576 VGND sky130_fd_pr__nfet_01v8 L=0.15 W=0.65 AS=0.169
+ AD=0.08775 PS=1.82 PD=0.92
M$10259 \$4576 A|Y VGND VGND sky130_fd_pr__nfet_01v8 L=0.15 W=0.65 AS=0.08775
+ AD=0.08775 PS=0.92 PD=0.92
M$10260 VGND A|Y \$4608 VGND sky130_fd_pr__nfet_01v8 L=0.15 W=0.65 AS=0.08775
+ AD=0.08775 PS=0.92 PD=0.92
M$10261 \$4608 B|X A|A_N|X VGND sky130_fd_pr__nfet_01v8 L=0.15 W=0.65
+ AS=0.08775 AD=0.25025 PS=0.92 PD=1.42
M$10262 A|A_N|X \$4576 VGND VGND sky130_fd_pr__nfet_01v8 L=0.15 W=0.65
+ AS=0.25025 AD=0.208 PS=1.42 PD=1.94
M$10263 VGND A|A_N|X \$4578 VGND sky130_fd_pr__nfet_01v8 L=0.15 W=0.42
+ AS=0.10025 AD=0.1092 PS=0.985 PD=1.36
M$10264 VGND A|B|C|D|Y \$4613 VGND sky130_fd_pr__nfet_01v8 L=0.15 W=0.65
+ AS=0.10025 AD=0.08775 PS=0.985 PD=0.92
M$10265 \$4613 \$4578 A2|B|SLEEP|Y VGND sky130_fd_pr__nfet_01v8 L=0.15 W=0.65
+ AS=0.08775 AD=0.169 PS=0.92 PD=1.82
M$10268 VGND A2|B|X \$4620 VGND sky130_fd_pr__nfet_01v8 L=0.15 W=0.65 AS=0.169
+ AD=0.08775 PS=1.82 PD=0.92
M$10269 \$4620 A|A1|Y A|B|Y VGND sky130_fd_pr__nfet_01v8 L=0.15 W=0.65
+ AS=0.08775 AD=0.169 PS=0.92 PD=1.82
M$10270 VGND A3|B|X \$4624 VGND sky130_fd_pr__nfet_01v8 L=0.15 W=0.65 AS=0.169
+ AD=0.06825 PS=1.82 PD=0.86
M$10271 \$4624 A2|B|X \$4625 VGND sky130_fd_pr__nfet_01v8 L=0.15 W=0.65
+ AS=0.06825 AD=0.118625 PS=0.86 PD=1.015
M$10272 \$4625 A|A1|Y A|B|Y VGND sky130_fd_pr__nfet_01v8 L=0.15 W=0.65
+ AS=0.118625 AD=0.105625 PS=1.015 PD=0.975
M$10273 A|B|Y B1|Y VGND VGND sky130_fd_pr__nfet_01v8 L=0.15 W=0.65 AS=0.105625
+ AD=0.1755 PS=0.975 PD=1.84
M$10274 B1|Y A|B|X VGND VGND sky130_fd_pr__nfet_01v8 L=0.15 W=0.42 AS=0.1092
+ AD=0.1197 PS=1.36 PD=1.41
M$10277 \$4584 A|B|Y \$4636 VGND sky130_fd_pr__nfet_01v8 L=0.15 W=0.42
+ AS=0.1113 AD=0.0441 PS=1.37 PD=0.63
M$10278 \$4636 B|Y VGND VGND sky130_fd_pr__nfet_01v8 L=0.15 W=0.42 AS=0.0441
+ AD=0.0966 PS=0.63 PD=0.88
M$10279 VGND \$4584 A|X VGND sky130_fd_pr__nfet_01v8 L=0.15 W=0.42 AS=0.0966
+ AD=0.1113 PS=0.88 PD=1.37
M$10281 \$4586 A|B|X \$4641 VGND sky130_fd_pr__nfet_01v8 L=0.15 W=0.42
+ AS=0.1092 AD=0.0441 PS=1.36 PD=0.63
M$10282 \$4641 A|B|X \$4642 VGND sky130_fd_pr__nfet_01v8 L=0.15 W=0.42
+ AS=0.0441 AD=0.0441 PS=0.63 PD=0.63
M$10283 \$4642 B|C|X VGND VGND sky130_fd_pr__nfet_01v8 L=0.15 W=0.42 AS=0.0441
+ AD=0.13165 PS=0.63 PD=1.14
M$10284 VGND \$4586 A|A1|X VGND sky130_fd_pr__nfet_01v8 L=0.15 W=0.65
+ AS=0.13165 AD=0.169 PS=1.14 PD=1.82
M$10287 \$4587 A2|B|Y \$4654 VGND sky130_fd_pr__nfet_01v8 L=0.15 W=0.65
+ AS=0.169 AD=0.06825 PS=1.82 PD=0.86
M$10288 \$4654 A|A1|X VGND VGND sky130_fd_pr__nfet_01v8 L=0.15 W=0.65
+ AS=0.06825 AD=0.08775 PS=0.86 PD=0.92
M$10289 VGND A|A1|X \$4588 VGND sky130_fd_pr__nfet_01v8 L=0.15 W=0.65
+ AS=0.08775 AD=0.169 PS=0.92 PD=1.82
M$10290 VGND A2|B|Y \$4588 VGND sky130_fd_pr__nfet_01v8 L=0.15 W=0.65 AS=0.169
+ AD=0.08775 PS=1.82 PD=0.92
M$10291 \$4588 \$4587 A|Y VGND sky130_fd_pr__nfet_01v8 L=0.15 W=0.65 AS=0.08775
+ AD=0.195 PS=0.92 PD=1.9
M$10292 \$4589 B|Y \$4660 VGND sky130_fd_pr__nfet_01v8 L=0.15 W=0.65 AS=0.169
+ AD=0.06825 PS=1.82 PD=0.86
M$10293 \$4660 A|B|C|X VGND VGND sky130_fd_pr__nfet_01v8 L=0.15 W=0.65
+ AS=0.06825 AD=0.08775 PS=0.86 PD=0.92
M$10294 VGND A|B|C|X \$4590 VGND sky130_fd_pr__nfet_01v8 L=0.15 W=0.65
+ AS=0.08775 AD=0.169 PS=0.92 PD=1.82
M$10295 VGND B|Y \$4590 VGND sky130_fd_pr__nfet_01v8 L=0.15 W=0.65 AS=0.169
+ AD=0.08775 PS=1.82 PD=0.92
M$10296 \$4590 \$4589 B|C|Y VGND sky130_fd_pr__nfet_01v8 L=0.15 W=0.65
+ AS=0.08775 AD=0.195 PS=0.92 PD=1.9
M$10300 B|B_N|Y \$4593 \$4594 VGND sky130_fd_pr__nfet_01v8 L=0.15 W=0.65
+ AS=0.195 AD=0.08775 PS=1.9 PD=0.92
M$10301 \$4594 B|SLEEP|X VGND VGND sky130_fd_pr__nfet_01v8 L=0.15 W=0.65
+ AS=0.08775 AD=0.169 PS=0.92 PD=1.82
M$10302 \$4594 A|X VGND VGND sky130_fd_pr__nfet_01v8 L=0.15 W=0.65 AS=0.169
+ AD=0.08775 PS=1.82 PD=0.92
M$10303 VGND A|X \$4672 VGND sky130_fd_pr__nfet_01v8 L=0.15 W=0.65 AS=0.08775
+ AD=0.06825 PS=0.92 PD=0.86
M$10304 \$4672 B|SLEEP|X \$4593 VGND sky130_fd_pr__nfet_01v8 L=0.15 W=0.65
+ AS=0.06825 AD=0.169 PS=0.86 PD=1.82
M$10327 VGND A|REF \$4595 VGND sky130_fd_pr__nfet_01v8 L=0.15 W=0.42 AS=0.097
+ AD=0.1092 PS=0.975 PD=1.36
M$10328 VGND \$4595 A|X VGND sky130_fd_pr__nfet_01v8 L=0.15 W=1.3 AS=0.26
+ AD=0.18475 PS=2.75 PD=1.895
M$10331 \$4775 A|FINE_MUX[9] VGND VGND sky130_fd_pr__nfet_01v8 L=0.15 W=0.42
+ AS=0.1134 AD=0.10435 PS=1.38 PD=1.01
M$10332 VGND \$4775 \$4776 VGND sky130_fd_pr__nfet_01v8 L=0.5 W=0.65 AS=0.10435
+ AD=0.169 PS=1.01 PD=1.82
M$10333 VGND A|FINE_MUX[8] \$4724 VGND sky130_fd_pr__nfet_01v8 L=0.15 W=0.42
+ AS=0.10435 AD=0.1134 PS=1.01 PD=1.38
M$10334 VGND \$4724 \$4725 VGND sky130_fd_pr__nfet_01v8 L=0.5 W=0.65 AS=0.10435
+ AD=0.169 PS=1.01 PD=1.82
M$10335 \$4726 \$4725 VGND VGND sky130_fd_pr__nfet_01v8 L=0.5 W=0.65 AS=0.17225
+ AD=0.097 PS=1.83 PD=0.975
M$10336 VGND \$4726 A|B|X VGND sky130_fd_pr__nfet_01v8 L=0.15 W=0.42 AS=0.097
+ AD=0.1491 PS=0.975 PD=1.55
M$10337 VGND \$4777 A|B1|X VGND sky130_fd_pr__nfet_01v8 L=0.15 W=0.42 AS=0.097
+ AD=0.1491 PS=0.975 PD=1.55
M$10338 \$4777 \$4776 VGND VGND sky130_fd_pr__nfet_01v8 L=0.5 W=0.65 AS=0.17225
+ AD=0.097 PS=1.83 PD=0.975
M$10340 A|A1|B|Y \$4779 \$4780 VGND sky130_fd_pr__nfet_01v8 L=0.15 W=0.65
+ AS=0.195 AD=0.08775 PS=1.9 PD=0.92
M$10341 \$4780 A|B|X VGND VGND sky130_fd_pr__nfet_01v8 L=0.15 W=1.3 AS=0.25675
+ AD=0.25675 PS=2.74 PD=2.74
M$10343 VGND A|B|X \$4818 VGND sky130_fd_pr__nfet_01v8 L=0.15 W=0.65 AS=0.08775
+ AD=0.06825 PS=0.92 PD=0.86
M$10344 \$4818 A|B|X \$4779 VGND sky130_fd_pr__nfet_01v8 L=0.15 W=0.65
+ AS=0.06825 AD=0.169 PS=0.86 PD=1.82
M$10345 \$4728 B|C|Y \$4766 VGND sky130_fd_pr__nfet_01v8 L=0.15 W=0.42
+ AS=0.1092 AD=0.0441 PS=1.36 PD=0.63
M$10346 \$4766 A|B|C|Y VGND VGND sky130_fd_pr__nfet_01v8 L=0.15 W=0.42
+ AS=0.0441 AD=0.0567 PS=0.63 PD=0.69
M$10347 VGND A|B|C|Y \$4767 VGND sky130_fd_pr__nfet_01v8 L=0.15 W=0.42
+ AS=0.0567 AD=0.0441 PS=0.69 PD=0.63
M$10348 \$4767 B|X \$4728 VGND sky130_fd_pr__nfet_01v8 L=0.15 W=0.42 AS=0.0441
+ AD=0.0567 PS=0.63 PD=0.69
M$10349 \$4728 B|X \$4765 VGND sky130_fd_pr__nfet_01v8 L=0.15 W=0.42 AS=0.0567
+ AD=0.0441 PS=0.69 PD=0.63
M$10350 VGND B|C|Y \$4765 VGND sky130_fd_pr__nfet_01v8 L=0.15 W=0.42 AS=0.1474
+ AD=0.0441 PS=1.215 PD=0.63
M$10351 VGND \$4728 B|X VGND sky130_fd_pr__nfet_01v8 L=0.15 W=0.65 AS=0.1474
+ AD=0.23725 PS=1.215 PD=2.03
M$10352 \$4781 B|C|Y \$4820 VGND sky130_fd_pr__nfet_01v8 L=0.15 W=0.65 AS=0.169
+ AD=0.06825 PS=1.82 PD=0.86
M$10353 \$4820 A|A_N|X VGND VGND sky130_fd_pr__nfet_01v8 L=0.15 W=0.65
+ AS=0.06825 AD=0.08775 PS=0.86 PD=0.92
M$10354 VGND A|A_N|X \$4782 VGND sky130_fd_pr__nfet_01v8 L=0.15 W=0.65
+ AS=0.08775 AD=0.169 PS=0.92 PD=1.82
M$10355 VGND B|C|Y \$4782 VGND sky130_fd_pr__nfet_01v8 L=0.15 W=0.65 AS=0.169
+ AD=0.08775 PS=1.82 PD=0.92
M$10356 \$4782 \$4781 A|A1|C|Y VGND sky130_fd_pr__nfet_01v8 L=0.15 W=0.65
+ AS=0.08775 AD=0.195 PS=0.92 PD=1.9
M$10357 VGND B|X \$4730 VGND sky130_fd_pr__nfet_01v8 L=0.15 W=0.65 AS=0.169
+ AD=0.08775 PS=1.82 PD=0.92
M$10358 \$4730 A|B|C|D|Y VGND VGND sky130_fd_pr__nfet_01v8 L=0.15 W=0.65
+ AS=0.08775 AD=0.08775 PS=0.92 PD=0.92
M$10359 VGND A|B|C|D|Y \$4768 VGND sky130_fd_pr__nfet_01v8 L=0.15 W=0.65
+ AS=0.08775 AD=0.08775 PS=0.92 PD=0.92
M$10360 \$4768 B|X B|D|X VGND sky130_fd_pr__nfet_01v8 L=0.15 W=0.65 AS=0.08775
+ AD=0.25025 PS=0.92 PD=1.42
M$10361 B|D|X \$4730 VGND VGND sky130_fd_pr__nfet_01v8 L=0.15 W=0.65 AS=0.25025
+ AD=0.208 PS=1.42 PD=1.94
M$10364 VGND A3|B|X \$4769 VGND sky130_fd_pr__nfet_01v8 L=0.15 W=0.65 AS=0.169
+ AD=0.08775 PS=1.82 PD=0.92
M$10365 \$4769 A|B|X B|Y VGND sky130_fd_pr__nfet_01v8 L=0.15 W=0.65 AS=0.08775
+ AD=0.169 PS=0.92 PD=1.82
M$10366 A2|A3|Y \$4785 \$4786 VGND sky130_fd_pr__nfet_01v8 L=0.15 W=0.65
+ AS=0.195 AD=0.08775 PS=1.9 PD=0.92
M$10367 \$4786 B|Y VGND VGND sky130_fd_pr__nfet_01v8 L=0.15 W=0.65 AS=0.08775
+ AD=0.169 PS=0.92 PD=1.82
M$10369 \$4786 A|B|Y VGND VGND sky130_fd_pr__nfet_01v8 L=0.15 W=0.65 AS=0.169
+ AD=0.08775 PS=1.82 PD=0.92
M$10370 VGND A|B|Y \$4833 VGND sky130_fd_pr__nfet_01v8 L=0.15 W=0.65 AS=0.08775
+ AD=0.06825 PS=0.92 PD=0.86
M$10371 \$4833 B|Y \$4785 VGND sky130_fd_pr__nfet_01v8 L=0.15 W=0.65 AS=0.06825
+ AD=0.169 PS=0.86 PD=1.82
M$10374 \$4787 A|X \$4841 VGND sky130_fd_pr__nfet_01v8 L=0.15 W=0.42 AS=0.1113
+ AD=0.0441 PS=1.37 PD=0.63
M$10375 \$4841 B|X VGND VGND sky130_fd_pr__nfet_01v8 L=0.15 W=0.42 AS=0.0441
+ AD=0.0966 PS=0.63 PD=0.88
M$10376 VGND \$4787 A|B|X VGND sky130_fd_pr__nfet_01v8 L=0.15 W=0.42 AS=0.0966
+ AD=0.1113 PS=0.88 PD=1.37
M$10379 VGND A|B|X \$4788 VGND sky130_fd_pr__nfet_01v8 L=0.15 W=0.42 AS=0.10025
+ AD=0.1092 PS=0.985 PD=1.36
M$10380 VGND \$4788 A|X VGND sky130_fd_pr__nfet_01v8 L=0.15 W=0.65 AS=0.169
+ AD=0.08775 PS=1.82 PD=0.92
M$10381 A|X B|C|SLEEP|Y VGND VGND sky130_fd_pr__nfet_01v8 L=0.15 W=0.65
+ AS=0.08775 AD=0.10025 PS=0.92 PD=0.985
M$10382 VGND A|X B|C|SLEEP|Y VGND sky130_fd_pr__nfet_01v8 L=0.15 W=0.65
+ AS=0.169 AD=0.08775 PS=1.82 PD=0.92
M$10383 B|C|SLEEP|Y A|B|X VGND VGND sky130_fd_pr__nfet_01v8 L=0.15 W=0.65
+ AS=0.08775 AD=0.169 PS=0.92 PD=1.82
M$10385 \$4789 B|C|X \$4850 VGND sky130_fd_pr__nfet_01v8 L=0.15 W=0.65 AS=0.169
+ AD=0.06825 PS=1.82 PD=0.86
M$10386 \$4850 A|X VGND VGND sky130_fd_pr__nfet_01v8 L=0.15 W=0.65 AS=0.06825
+ AD=0.08775 PS=0.86 PD=0.92
M$10387 VGND A|X \$4791 VGND sky130_fd_pr__nfet_01v8 L=0.15 W=0.65 AS=0.08775
+ AD=0.169 PS=0.92 PD=1.82
M$10388 VGND B|C|X \$4791 VGND sky130_fd_pr__nfet_01v8 L=0.15 W=0.65 AS=0.169
+ AD=0.08775 PS=1.82 PD=0.92
M$10389 \$4791 \$4789 B|Y VGND sky130_fd_pr__nfet_01v8 L=0.15 W=0.65 AS=0.08775
+ AD=0.195 PS=0.92 PD=1.9
M$10391 VGND B|C|Y \$4737 VGND sky130_fd_pr__nfet_01v8 L=0.15 W=0.42 AS=0.1165
+ AD=0.1785 PS=1.035 PD=1.69
M$10392 A|B|X \$4736 VGND VGND sky130_fd_pr__nfet_01v8 L=0.15 W=0.65 AS=0.169
+ AD=0.1165 PS=1.82 PD=1.035
M$10393 \$4739 B|C|Y \$4736 VGND sky130_fd_pr__nfet_01v8 L=0.15 W=0.64
+ AS=0.1728 AD=0.0928 PS=1.82 PD=0.93
M$10394 \$4736 \$4737 \$4738 VGND sky130_fd_pr__nfet_01v8 L=0.15 W=0.64
+ AS=0.0928 AD=0.224 PS=0.93 PD=1.98
M$10396 VGND A2|B|Y \$4740 VGND sky130_fd_pr__nfet_01v8 L=0.15 W=0.65 AS=0.1885
+ AD=0.16515 PS=1.88 PD=1.82
M$10397 \$4741 A2|B|Y \$4738 VGND sky130_fd_pr__nfet_01v8 L=0.15 W=0.64
+ AS=0.16275 AD=0.18205 PS=1.8 PD=1.245
M$10398 \$4738 \$4740 \$4742 VGND sky130_fd_pr__nfet_01v8 L=0.15 W=0.42
+ AS=0.18205 AD=0.19265 PS=1.245 PD=1.285
M$10399 \$4742 A2|B|Y \$4739 VGND sky130_fd_pr__nfet_01v8 L=0.15 W=0.64
+ AS=0.19265 AD=0.140825 PS=1.285 PD=1.1
M$10400 \$4739 \$4740 \$4741 VGND sky130_fd_pr__nfet_01v8 L=0.15 W=0.6
+ AS=0.140825 AD=0.11 PS=1.1 PD=0.99
M$10401 \$4741 A|A1|X VGND VGND sky130_fd_pr__nfet_01v8 L=0.15 W=0.64 AS=0.11
+ AD=0.0864 PS=0.99 PD=0.91
M$10402 VGND \$4741 \$4742 VGND sky130_fd_pr__nfet_01v8 L=0.15 W=0.64 AS=0.0864
+ AD=0.1824 PS=0.91 PD=1.85
M$10409 VGND A|A_N|X \$4793 VGND sky130_fd_pr__nfet_01v8 L=0.15 W=0.42
+ AS=0.10025 AD=0.1092 PS=0.985 PD=1.36
M$10410 VGND B|X \$4866 VGND sky130_fd_pr__nfet_01v8 L=0.15 W=0.65 AS=0.10025
+ AD=0.08775 PS=0.985 PD=0.92
M$10411 \$4866 \$4793 A|Y VGND sky130_fd_pr__nfet_01v8 L=0.15 W=0.65 AS=0.08775
+ AD=0.169 PS=0.92 PD=1.82
M$10414 \$4795 B|B_N|Y VGND VGND sky130_fd_pr__nfet_01v8 L=0.15 W=0.42
+ AS=0.1092 AD=0.10025 PS=1.36 PD=0.985
M$10416 B|Y \$4795 VGND VGND sky130_fd_pr__nfet_01v8 L=0.15 W=0.65 AS=0.08775
+ AD=0.169 PS=0.92 PD=1.82
M$10417 VGND A|X \$4743 VGND sky130_fd_pr__nfet_01v8 L=0.15 W=0.42 AS=0.10025
+ AD=0.1092 PS=0.985 PD=1.36
M$10418 VGND B|SLEEP|X A|X VGND sky130_fd_pr__nfet_01v8 L=0.15 W=0.65
+ AS=0.10025 AD=0.08775 PS=0.985 PD=0.92
M$10419 A|X \$4743 VGND VGND sky130_fd_pr__nfet_01v8 L=0.15 W=0.65 AS=0.08775
+ AD=0.169 PS=0.92 PD=1.82
M$10420 VGND D|Y C1|Y VGND sky130_fd_pr__nfet_01v8 L=0.15 W=0.65 AS=0.169
+ AD=0.118625 PS=1.82 PD=1.015
M$10421 C1|Y C|X VGND VGND sky130_fd_pr__nfet_01v8 L=0.15 W=0.65 AS=0.118625
+ AD=0.089375 PS=1.015 PD=0.925
M$10422 VGND B|Y C1|Y VGND sky130_fd_pr__nfet_01v8 L=0.15 W=0.65 AS=0.089375
+ AD=0.08775 PS=0.925 PD=0.92
M$10423 C1|Y A|X VGND VGND sky130_fd_pr__nfet_01v8 L=0.15 W=0.65 AS=0.08775
+ AD=0.169 PS=0.92 PD=1.82
M$10466 VGND A|X \$4800 VGND sky130_fd_pr__nfet_01v8 L=0.15 W=0.42 AS=0.097
+ AD=0.1092 PS=0.975 PD=1.36
M$10467 VGND \$4800 A|X VGND sky130_fd_pr__nfet_01v8 L=0.15 W=1.3 AS=0.26
+ AD=0.18475 PS=2.75 PD=1.895
M$10469 \$4802 A|B|Y VGND VGND sky130_fd_pr__nfet_01v8 L=0.15 W=1.3 AS=0.25675
+ AD=0.1755 PS=2.74 PD=1.84
M$10471 \$4802 A|Q A|B|Y VGND sky130_fd_pr__nfet_01v8 L=0.15 W=1.3 AS=0.1755
+ AD=0.25675 PS=1.84 PD=2.74
M$10473 VGND \$4746 A|X VGND sky130_fd_pr__nfet_01v8 L=0.15 W=1.3 AS=0.26
+ AD=0.18475 PS=2.75 PD=1.895
M$10475 VGND A|B|Y \$4746 VGND sky130_fd_pr__nfet_01v8 L=0.15 W=0.42 AS=0.097
+ AD=0.1092 PS=0.975 PD=1.36
M$10476 VGND A|X \$4748 VGND sky130_fd_pr__nfet_01v8 L=0.15 W=0.42 AS=0.097
+ AD=0.1092 PS=0.975 PD=1.36
M$10477 VGND \$4748 A|X VGND sky130_fd_pr__nfet_01v8 L=0.15 W=1.3 AS=0.18475
+ AD=0.26 PS=1.895 PD=2.75
M$10479 \$4806 A|X VGND VGND sky130_fd_pr__nfet_01v8 L=0.15 W=0.42 AS=0.1134
+ AD=0.10435 PS=1.38 PD=1.01
M$10480 VGND \$4806 \$4807 VGND sky130_fd_pr__nfet_01v8 L=0.5 W=0.65 AS=0.10435
+ AD=0.169 PS=1.01 PD=1.82
M$10481 VGND \$4808 OUT|X VGND sky130_fd_pr__nfet_01v8 L=0.15 W=0.42 AS=0.097
+ AD=0.1491 PS=0.975 PD=1.55
M$10482 \$4808 \$4807 VGND VGND sky130_fd_pr__nfet_01v8 L=0.5 W=0.65 AS=0.17225
+ AD=0.097 PS=1.83 PD=0.975
M$10486 VGND B|Y \$4989 VGND sky130_fd_pr__nfet_01v8 L=0.15 W=0.65 AS=0.169
+ AD=0.08775 PS=1.82 PD=0.92
M$10487 \$4989 A|B1|X A|Y VGND sky130_fd_pr__nfet_01v8 L=0.15 W=0.65 AS=0.08775
+ AD=0.169 PS=0.92 PD=1.82
M$10489 \$4939 A|B1|X \$4984 VGND sky130_fd_pr__nfet_01v8 L=0.15 W=0.65
+ AS=0.2015 AD=0.10725 PS=1.92 PD=0.98
M$10490 \$4984 A2|A3|Y VGND VGND sky130_fd_pr__nfet_01v8 L=0.15 W=0.65
+ AS=0.10725 AD=0.10725 PS=0.98 PD=0.98
M$10491 VGND A2|B|SLEEP|Y \$4984 VGND sky130_fd_pr__nfet_01v8 L=0.15 W=0.65
+ AS=0.10725 AD=0.08775 PS=0.98 PD=0.92
M$10492 \$4984 A|A1|B|Y VGND VGND sky130_fd_pr__nfet_01v8 L=0.15 W=0.65
+ AS=0.08775 AD=0.12675 PS=0.92 PD=1.04
M$10493 VGND \$4939 B|X VGND sky130_fd_pr__nfet_01v8 L=0.15 W=0.65 AS=0.12675
+ AD=0.234 PS=1.04 PD=2.02
M$10497 B|Y B|X VGND VGND sky130_fd_pr__nfet_01v8 L=0.15 W=0.65 AS=0.08775
+ AD=0.169 PS=0.92 PD=1.82
M$10498 \$4942 C|C_N|X VGND VGND sky130_fd_pr__nfet_01v8 L=0.15 W=0.42
+ AS=0.1092 AD=0.10025 PS=1.36 PD=0.985
M$10501 VGND \$4942 A|Y VGND sky130_fd_pr__nfet_01v8 L=0.15 W=0.65 AS=0.08775
+ AD=0.221 PS=0.92 PD=1.98
M$10503 VGND B|C|SLEEP|Y \$4947 VGND sky130_fd_pr__nfet_01v8 L=0.15 W=0.42
+ AS=0.1165 AD=0.1785 PS=1.035 PD=1.69
M$10504 B|X \$4946 VGND VGND sky130_fd_pr__nfet_01v8 L=0.15 W=0.65 AS=0.169
+ AD=0.1165 PS=1.82 PD=1.035
M$10505 \$4949 B|C|SLEEP|Y \$4946 VGND sky130_fd_pr__nfet_01v8 L=0.15 W=0.64
+ AS=0.1728 AD=0.0928 PS=1.82 PD=0.93
M$10506 \$4946 \$4947 \$4948 VGND sky130_fd_pr__nfet_01v8 L=0.15 W=0.64
+ AS=0.0928 AD=0.224 PS=0.93 PD=1.98
M$10507 VGND A|B|X \$4950 VGND sky130_fd_pr__nfet_01v8 L=0.15 W=0.65 AS=0.1885
+ AD=0.16515 PS=1.88 PD=1.82
M$10508 \$4951 A|B|X \$4948 VGND sky130_fd_pr__nfet_01v8 L=0.15 W=0.64
+ AS=0.16275 AD=0.18205 PS=1.8 PD=1.245
M$10509 \$4948 \$4950 \$4952 VGND sky130_fd_pr__nfet_01v8 L=0.15 W=0.42
+ AS=0.18205 AD=0.19265 PS=1.245 PD=1.285
M$10510 \$4952 A|B|X \$4949 VGND sky130_fd_pr__nfet_01v8 L=0.15 W=0.64
+ AS=0.19265 AD=0.140825 PS=1.285 PD=1.1
M$10511 \$4949 \$4950 \$4951 VGND sky130_fd_pr__nfet_01v8 L=0.15 W=0.6
+ AS=0.140825 AD=0.11 PS=1.1 PD=0.99
M$10512 \$4951 A|Y VGND VGND sky130_fd_pr__nfet_01v8 L=0.15 W=0.64 AS=0.11
+ AD=0.0864 PS=0.99 PD=0.91
M$10513 VGND \$4951 \$4952 VGND sky130_fd_pr__nfet_01v8 L=0.15 W=0.64 AS=0.0864
+ AD=0.1824 PS=0.91 PD=1.85
M$10516 \$4953 B|C|Y \$4994 VGND sky130_fd_pr__nfet_01v8 L=0.15 W=0.42
+ AS=0.1092 AD=0.0441 PS=1.36 PD=0.63
M$10517 \$4994 A|Y VGND VGND sky130_fd_pr__nfet_01v8 L=0.15 W=0.42 AS=0.0441
+ AD=0.0567 PS=0.63 PD=0.69
M$10518 VGND A|Y \$4995 VGND sky130_fd_pr__nfet_01v8 L=0.15 W=0.42 AS=0.0567
+ AD=0.0441 PS=0.69 PD=0.63
M$10519 \$4995 A|B|X \$4953 VGND sky130_fd_pr__nfet_01v8 L=0.15 W=0.42
+ AS=0.0441 AD=0.0567 PS=0.63 PD=0.69
M$10520 \$4953 A|B|X \$4996 VGND sky130_fd_pr__nfet_01v8 L=0.15 W=0.42
+ AS=0.0567 AD=0.0441 PS=0.69 PD=0.63
M$10521 VGND B|C|Y \$4996 VGND sky130_fd_pr__nfet_01v8 L=0.15 W=0.42 AS=0.1474
+ AD=0.0441 PS=1.215 PD=0.63
M$10522 VGND \$4953 B|X VGND sky130_fd_pr__nfet_01v8 L=0.15 W=0.65 AS=0.1474
+ AD=0.23725 PS=1.215 PD=2.03
M$10524 VGND \$4956 B|X VGND sky130_fd_pr__nfet_01v8 L=0.15 W=0.65 AS=0.208
+ AD=0.25025 PS=1.94 PD=1.42
M$10525 B|X B|X \$4997 VGND sky130_fd_pr__nfet_01v8 L=0.15 W=0.65 AS=0.25025
+ AD=0.08775 PS=1.42 PD=0.92
M$10526 \$4997 A|A_N|X VGND VGND sky130_fd_pr__nfet_01v8 L=0.15 W=0.65
+ AS=0.08775 AD=0.08775 PS=0.92 PD=0.92
M$10527 VGND A|A_N|X \$4956 VGND sky130_fd_pr__nfet_01v8 L=0.15 W=0.65
+ AS=0.08775 AD=0.08775 PS=0.92 PD=0.92
M$10528 \$4956 B|X VGND VGND sky130_fd_pr__nfet_01v8 L=0.15 W=0.65 AS=0.08775
+ AD=0.169 PS=0.92 PD=1.82
M$10530 \$4958 B|B_N|Y \$4998 VGND sky130_fd_pr__nfet_01v8 L=0.15 W=0.65
+ AS=0.169 AD=0.06825 PS=1.82 PD=0.86
M$10531 \$4998 A|Y VGND VGND sky130_fd_pr__nfet_01v8 L=0.15 W=0.65 AS=0.06825
+ AD=0.08775 PS=0.86 PD=0.92
M$10532 VGND A|Y \$4985 VGND sky130_fd_pr__nfet_01v8 L=0.15 W=0.65 AS=0.08775
+ AD=0.169 PS=0.92 PD=1.82
M$10533 VGND B|B_N|Y \$4985 VGND sky130_fd_pr__nfet_01v8 L=0.15 W=0.65 AS=0.169
+ AD=0.08775 PS=1.82 PD=0.92
M$10534 \$4985 \$4958 A|Y VGND sky130_fd_pr__nfet_01v8 L=0.15 W=0.65 AS=0.08775
+ AD=0.195 PS=0.92 PD=1.9
M$10555 VGND \$4960 A|X VGND sky130_fd_pr__nfet_01v8 L=0.15 W=1.3 AS=0.26
+ AD=0.18475 PS=2.75 PD=1.895
M$10557 VGND A|B|Y \$4960 VGND sky130_fd_pr__nfet_01v8 L=0.15 W=0.42 AS=0.097
+ AD=0.1092 PS=0.975 PD=1.36
M$10558 VGND A|X \$4961 VGND sky130_fd_pr__nfet_01v8 L=0.15 W=0.42 AS=0.10435
+ AD=0.1134 PS=1.01 PD=1.38
M$10559 VGND \$4961 \$4962 VGND sky130_fd_pr__nfet_01v8 L=0.5 W=0.65 AS=0.10435
+ AD=0.169 PS=1.01 PD=1.82
M$10560 \$4963 \$4962 VGND VGND sky130_fd_pr__nfet_01v8 L=0.5 W=0.65 AS=0.17225
+ AD=0.097 PS=1.83 PD=0.975
M$10561 VGND \$4963 INJ_EDGE|X VGND sky130_fd_pr__nfet_01v8 L=0.15 W=0.42
+ AS=0.097 AD=0.1491 PS=0.975 PD=1.55
M$10562 VGND A|X \$4964 VGND sky130_fd_pr__nfet_01v8 L=0.15 W=0.42 AS=0.10435
+ AD=0.1134 PS=1.01 PD=1.38
M$10563 VGND \$4964 \$4965 VGND sky130_fd_pr__nfet_01v8 L=0.5 W=0.65 AS=0.10435
+ AD=0.169 PS=1.01 PD=1.82
M$10564 \$4966 \$4965 VGND VGND sky130_fd_pr__nfet_01v8 L=0.5 W=0.65 AS=0.17225
+ AD=0.097 PS=1.83 PD=0.975
M$10565 VGND \$4966 SS_BBPD[1]|X VGND sky130_fd_pr__nfet_01v8 L=0.15 W=0.42
+ AS=0.097 AD=0.1491 PS=0.975 PD=1.55
M$10567 VGND \$4999 A|A1|B|X VGND sky130_fd_pr__nfet_01v8 L=0.15 W=0.65
+ AS=0.208 AD=0.25025 PS=1.94 PD=1.42
M$10568 A|A1|B|X A|A1|B|Y \$5041 VGND sky130_fd_pr__nfet_01v8 L=0.15 W=0.65
+ AS=0.25025 AD=0.08775 PS=1.42 PD=0.92
M$10569 \$5041 A|B1|X VGND VGND sky130_fd_pr__nfet_01v8 L=0.15 W=0.65
+ AS=0.08775 AD=0.08775 PS=0.92 PD=0.92
M$10570 VGND A|B1|X \$4999 VGND sky130_fd_pr__nfet_01v8 L=0.15 W=0.65
+ AS=0.08775 AD=0.08775 PS=0.92 PD=0.92
M$10571 \$4999 A|A1|B|Y VGND VGND sky130_fd_pr__nfet_01v8 L=0.15 W=0.65
+ AS=0.08775 AD=0.169 PS=0.92 PD=1.82
M$10572 VGND A|B|Y \$5047 VGND sky130_fd_pr__nfet_01v8 L=0.15 W=0.65 AS=0.169
+ AD=0.08775 PS=1.82 PD=0.92
M$10573 \$5047 A|Y B|C|Y VGND sky130_fd_pr__nfet_01v8 L=0.15 W=0.65 AS=0.08775
+ AD=0.169 PS=0.92 PD=1.82
M$10576 A|A1|Y A2|B|SLEEP|Y VGND VGND sky130_fd_pr__nfet_01v8 L=0.15 W=0.65
+ AS=0.08775 AD=0.169 PS=0.92 PD=1.82
M$10578 VGND A2|A3|Y \$5057 VGND sky130_fd_pr__nfet_01v8 L=0.15 W=0.65
+ AS=0.2665 AD=0.091 PS=2.12 PD=0.93
M$10579 \$5057 A|A1|Y A2|B|SLEEP|Y VGND sky130_fd_pr__nfet_01v8 L=0.15 W=0.65
+ AS=0.091 AD=0.091 PS=0.93 PD=0.93
M$10580 A2|B|SLEEP|Y B1|C1|X VGND VGND sky130_fd_pr__nfet_01v8 L=0.15 W=0.65
+ AS=0.091 AD=0.10075 PS=0.93 PD=0.96
M$10581 VGND B1|C1|Y A2|B|SLEEP|Y VGND sky130_fd_pr__nfet_01v8 L=0.15 W=0.65
+ AS=0.10075 AD=0.17225 PS=0.96 PD=1.83
M$10582 \$5006 \$5008 \$5010 VGND sky130_fd_pr__nfet_01v8 L=0.15 W=0.42
+ AS=0.19265 AD=0.18365 PS=1.285 PD=1.25
M$10583 \$5007 \$5008 \$5009 VGND sky130_fd_pr__nfet_01v8 L=0.15 W=0.6 AS=0.11
+ AD=0.140825 PS=0.99 PD=1.1
M$10584 \$5006 \$5007 VGND VGND sky130_fd_pr__nfet_01v8 L=0.15 W=0.64 AS=0.1824
+ AD=0.0864 PS=1.85 PD=0.91
M$10585 VGND A|X \$5007 VGND sky130_fd_pr__nfet_01v8 L=0.15 W=0.64 AS=0.0864
+ AD=0.11 PS=0.91 PD=0.99
M$10586 \$5009 B|X \$5006 VGND sky130_fd_pr__nfet_01v8 L=0.15 W=0.64
+ AS=0.140825 AD=0.19265 PS=1.1 PD=1.285
M$10587 \$5010 B|X \$5007 VGND sky130_fd_pr__nfet_01v8 L=0.15 W=0.64 AS=0.18365
+ AD=0.1628 PS=1.25 PD=1.8
M$10588 \$5008 B|X VGND VGND sky130_fd_pr__nfet_01v8 L=0.15 W=0.65 AS=0.1653
+ AD=0.195 PS=1.82 PD=1.9
M$10589 \$5009 \$5011 \$5012 VGND sky130_fd_pr__nfet_01v8 L=0.15 W=0.64
+ AS=0.3168 AD=0.128 PS=2.27 PD=1.04
M$10590 \$5012 C|C_N|X \$5010 VGND sky130_fd_pr__nfet_01v8 L=0.15 W=0.64
+ AS=0.128 AD=0.1728 PS=1.04 PD=1.82
M$10591 VGND C|C_N|X \$5011 VGND sky130_fd_pr__nfet_01v8 L=0.15 W=0.42
+ AS=0.144125 AD=0.1764 PS=1.12 PD=1.68
M$10592 VGND \$5012 B|B_N|X VGND sky130_fd_pr__nfet_01v8 L=0.15 W=0.65
+ AS=0.144125 AD=0.169 PS=1.12 PD=1.82
M$10594 \$5014 B|C|SLEEP|Y \$5075 VGND sky130_fd_pr__nfet_01v8 L=0.15 W=0.65
+ AS=0.169 AD=0.06825 PS=1.82 PD=0.86
M$10595 \$5075 A|B|X VGND VGND sky130_fd_pr__nfet_01v8 L=0.15 W=0.65 AS=0.06825
+ AD=0.08775 PS=0.86 PD=0.92
M$10596 VGND A|B|X \$5015 VGND sky130_fd_pr__nfet_01v8 L=0.15 W=0.65 AS=0.08775
+ AD=0.169 PS=0.92 PD=1.82
M$10597 VGND B|C|SLEEP|Y \$5015 VGND sky130_fd_pr__nfet_01v8 L=0.15 W=0.65
+ AS=0.169 AD=0.08775 PS=1.82 PD=0.92
M$10598 \$5015 \$5014 B|C|Y VGND sky130_fd_pr__nfet_01v8 L=0.15 W=0.65
+ AS=0.08775 AD=0.195 PS=0.92 PD=1.9
M$10599 VGND B|C|X \$5079 VGND sky130_fd_pr__nfet_01v8 L=0.15 W=0.65 AS=0.169
+ AD=0.08775 PS=1.82 PD=0.92
M$10600 \$5079 B|C|Y \$5080 VGND sky130_fd_pr__nfet_01v8 L=0.15 W=0.65
+ AS=0.08775 AD=0.10725 PS=0.92 PD=0.98
M$10601 \$5080 A|Y B|C|Y VGND sky130_fd_pr__nfet_01v8 L=0.15 W=0.65 AS=0.10725
+ AD=0.169 PS=0.98 PD=1.82
M$10603 B|C|D_N|X \$5018 VGND VGND sky130_fd_pr__nfet_01v8 L=0.15 W=0.65
+ AS=0.169 AD=0.144125 PS=1.82 PD=1.12
M$10604 VGND C|X \$5020 VGND sky130_fd_pr__nfet_01v8 L=0.15 W=0.42 AS=0.144125
+ AD=0.1764 PS=1.12 PD=1.68
M$10605 \$5021 C|X \$5018 VGND sky130_fd_pr__nfet_01v8 L=0.15 W=0.64 AS=0.1728
+ AD=0.128 PS=1.82 PD=1.04
M$10606 \$5018 \$5020 \$5022 VGND sky130_fd_pr__nfet_01v8 L=0.15 W=0.64
+ AS=0.128 AD=0.3168 PS=1.04 PD=2.27
M$10607 VGND B|C|Y \$5023 VGND sky130_fd_pr__nfet_01v8 L=0.15 W=0.65 AS=0.195
+ AD=0.1653 PS=1.9 PD=1.82
M$10608 \$5021 \$5023 \$5025 VGND sky130_fd_pr__nfet_01v8 L=0.15 W=0.42
+ AS=0.18365 AD=0.19265 PS=1.25 PD=1.285
M$10609 \$5022 \$5023 \$5024 VGND sky130_fd_pr__nfet_01v8 L=0.15 W=0.6
+ AS=0.140825 AD=0.11 PS=1.1 PD=0.99
M$10610 \$5024 A|Y VGND VGND sky130_fd_pr__nfet_01v8 L=0.15 W=0.64 AS=0.11
+ AD=0.0864 PS=0.99 PD=0.91
M$10611 VGND \$5024 \$5025 VGND sky130_fd_pr__nfet_01v8 L=0.15 W=0.64 AS=0.0864
+ AD=0.1824 PS=0.91 PD=1.85
M$10612 \$5024 B|C|Y \$5021 VGND sky130_fd_pr__nfet_01v8 L=0.15 W=0.64
+ AS=0.1628 AD=0.18365 PS=1.8 PD=1.25
M$10613 \$5022 B|C|Y \$5025 VGND sky130_fd_pr__nfet_01v8 L=0.15 W=0.64
+ AS=0.140825 AD=0.19265 PS=1.1 PD=1.285
M$10615 \$5026 C|Y \$5100 VGND sky130_fd_pr__nfet_01v8 L=0.15 W=0.42 AS=0.1092
+ AD=0.0441 PS=1.36 PD=0.63
M$10616 \$5100 A|Y VGND VGND sky130_fd_pr__nfet_01v8 L=0.15 W=0.42 AS=0.0441
+ AD=0.0567 PS=0.63 PD=0.69
M$10617 VGND A|Y \$5101 VGND sky130_fd_pr__nfet_01v8 L=0.15 W=0.42 AS=0.0567
+ AD=0.0441 PS=0.69 PD=0.63
M$10618 \$5101 B|X \$5026 VGND sky130_fd_pr__nfet_01v8 L=0.15 W=0.42 AS=0.0441
+ AD=0.0567 PS=0.63 PD=0.69
M$10619 \$5026 B|X \$5102 VGND sky130_fd_pr__nfet_01v8 L=0.15 W=0.42 AS=0.0567
+ AD=0.0441 PS=0.69 PD=0.63
M$10620 \$5102 C|Y VGND VGND sky130_fd_pr__nfet_01v8 L=0.15 W=0.42 AS=0.0441
+ AD=0.1474 PS=0.63 PD=1.215
M$10621 VGND \$5026 B|SLEEP|X VGND sky130_fd_pr__nfet_01v8 L=0.15 W=0.65
+ AS=0.1474 AD=0.23725 PS=1.215 PD=2.03
M$10623 VGND A|Y \$5029 VGND sky130_fd_pr__nfet_01v8 L=0.15 W=0.42 AS=0.10025
+ AD=0.1092 PS=0.985 PD=1.36
M$10624 VGND \$5029 C|X VGND sky130_fd_pr__nfet_01v8 L=0.15 W=0.65 AS=0.169
+ AD=0.08775 PS=1.82 PD=0.92
M$10625 C|X B|SLEEP|X VGND VGND sky130_fd_pr__nfet_01v8 L=0.15 W=0.65
+ AS=0.08775 AD=0.10025 PS=0.92 PD=0.985
M$10647 \$5030 A|Q VGND VGND sky130_fd_pr__nfet_01v8 L=0.15 W=0.42 AS=0.1092
+ AD=0.097 PS=1.36 PD=0.975
M$10648 VGND \$5030 A|X VGND sky130_fd_pr__nfet_01v8 L=0.15 W=1.3 AS=0.18475
+ AD=0.26 PS=1.895 PD=2.75
M$10650 \$5031 A|REF A|B|Y VGND sky130_fd_pr__nfet_01v8 L=0.15 W=1.3 AS=0.25675
+ AD=0.1755 PS=2.74 PD=1.84
M$10652 \$5031 A|B|Y VGND VGND sky130_fd_pr__nfet_01v8 L=0.15 W=1.3 AS=0.1755
+ AD=0.25675 PS=1.84 PD=2.74
M$10654 \$5032 A|X VGND VGND sky130_fd_pr__nfet_01v8 L=0.15 W=0.42 AS=0.1134
+ AD=0.10435 PS=1.38 PD=1.01
M$10655 VGND \$5032 \$5033 VGND sky130_fd_pr__nfet_01v8 L=0.5 W=0.65 AS=0.10435
+ AD=0.169 PS=1.01 PD=1.82
M$10656 VGND \$5034 SS_BBPD[0]|X VGND sky130_fd_pr__nfet_01v8 L=0.15 W=0.42
+ AS=0.097 AD=0.1491 PS=0.975 PD=1.55
M$10657 \$5034 \$5033 VGND VGND sky130_fd_pr__nfet_01v8 L=0.5 W=0.65 AS=0.17225
+ AD=0.097 PS=1.83 PD=0.975
M$10659 B|Y A|A1|B|X VGND VGND sky130_fd_pr__nfet_01v8 L=0.15 W=2.52 AS=0.6552
+ AD=0.7182 PS=8.16 PD=8.46
M$10660 B|Y A|A1|B|Y VGND VGND sky130_fd_pr__nfet_01v8 L=0.15 W=1.68 AS=0.4368
+ AD=0.4788 PS=5.44 PD=5.64
M$10661 VGND B|Y \$5241 VGND sky130_fd_pr__nfet_01v8 L=0.15 W=0.65 AS=0.169
+ AD=0.08775 PS=1.82 PD=0.92
M$10662 \$5241 A|B1|X A|B|Y VGND sky130_fd_pr__nfet_01v8 L=0.15 W=0.65
+ AS=0.08775 AD=0.169 PS=0.92 PD=1.82
M$10663 \$5167 A|B1|X \$5227 VGND sky130_fd_pr__nfet_01v8 L=0.15 W=0.65
+ AS=0.2015 AD=0.10725 PS=1.92 PD=0.98
M$10664 \$5227 A3|X VGND VGND sky130_fd_pr__nfet_01v8 L=0.15 W=0.65 AS=0.10725
+ AD=0.10725 PS=0.98 PD=0.98
M$10665 VGND A2|B|SLEEP|Y \$5227 VGND sky130_fd_pr__nfet_01v8 L=0.15 W=0.65
+ AS=0.10725 AD=0.08775 PS=0.98 PD=0.92
M$10666 \$5227 A|A1|B|X VGND VGND sky130_fd_pr__nfet_01v8 L=0.15 W=0.65
+ AS=0.08775 AD=0.12675 PS=0.92 PD=1.04
M$10667 VGND \$5167 C|C_N|X VGND sky130_fd_pr__nfet_01v8 L=0.15 W=0.65
+ AS=0.12675 AD=0.234 PS=1.04 PD=2.02
M$10668 VGND A|B|Y \$5169 VGND sky130_fd_pr__nfet_01v8 L=0.15 W=0.42 AS=0.1092
+ AD=0.0567 PS=1.36 PD=0.69
M$10669 VGND A2|B|SLEEP|Y \$5169 VGND sky130_fd_pr__nfet_01v8 L=0.15 W=0.42
+ AS=0.10025 AD=0.0567 PS=0.985 PD=0.69
M$10670 VGND \$5169 B1|C1|X VGND sky130_fd_pr__nfet_01v8 L=0.15 W=0.65
+ AS=0.10025 AD=0.169 PS=0.985 PD=1.82
M$10671 A3|X \$5170 VGND VGND sky130_fd_pr__nfet_01v8 L=0.15 W=0.65 AS=0.169
+ AD=0.25675 PS=1.82 PD=1.44
M$10672 VGND B1|C1|Y \$5170 VGND sky130_fd_pr__nfet_01v8 L=0.15 W=0.65
+ AS=0.25675 AD=0.089375 PS=1.44 PD=0.925
M$10673 \$5170 A|A1|Y \$5245 VGND sky130_fd_pr__nfet_01v8 L=0.15 W=0.65
+ AS=0.089375 AD=0.091 PS=0.925 PD=0.93
M$10674 \$5245 A2|A3|Y VGND VGND sky130_fd_pr__nfet_01v8 L=0.15 W=0.65 AS=0.091
+ AD=0.17225 PS=0.93 PD=1.83
M$10675 \$5172 B1|C1|X \$5247 VGND sky130_fd_pr__nfet_01v8 L=0.15 W=0.65
+ AS=0.195 AD=0.11375 PS=1.9 PD=1
M$10676 \$5247 B1|Y \$5228 VGND sky130_fd_pr__nfet_01v8 L=0.15 W=0.65
+ AS=0.11375 AD=0.143 PS=1 PD=1.09
M$10677 \$5228 A2|A3|Y VGND VGND sky130_fd_pr__nfet_01v8 L=0.15 W=0.65 AS=0.143
+ AD=0.105625 PS=1.09 PD=0.975
M$10678 VGND A|A1|Y \$5228 VGND sky130_fd_pr__nfet_01v8 L=0.15 W=0.65
+ AS=0.105625 AD=0.169 PS=0.975 PD=1.82
M$10679 VGND \$5172 A|A1|X VGND sky130_fd_pr__nfet_01v8 L=0.15 W=0.65 AS=0.169
+ AD=0.169 PS=1.82 PD=1.82
M$10680 VGND A|B|Y B1|C1|Y VGND sky130_fd_pr__nfet_01v8 L=0.15 W=0.65 AS=0.169
+ AD=0.08775 PS=1.82 PD=0.92
M$10681 B1|C1|Y A|A1|Y VGND VGND sky130_fd_pr__nfet_01v8 L=0.15 W=0.65
+ AS=0.08775 AD=0.169 PS=0.92 PD=1.82
M$10684 \$5174 B|C|Y \$5254 VGND sky130_fd_pr__nfet_01v8 L=0.15 W=0.42
+ AS=0.1092 AD=0.0441 PS=1.36 PD=0.63
M$10685 \$5254 A|Y VGND VGND sky130_fd_pr__nfet_01v8 L=0.15 W=0.42 AS=0.0441
+ AD=0.0567 PS=0.63 PD=0.69
M$10686 VGND A|Y \$5253 VGND sky130_fd_pr__nfet_01v8 L=0.15 W=0.42 AS=0.0567
+ AD=0.0441 PS=0.69 PD=0.63
M$10687 \$5253 A|B|Y \$5174 VGND sky130_fd_pr__nfet_01v8 L=0.15 W=0.42
+ AS=0.0441 AD=0.0567 PS=0.63 PD=0.69
M$10688 \$5174 A|B|Y \$5252 VGND sky130_fd_pr__nfet_01v8 L=0.15 W=0.42
+ AS=0.0567 AD=0.0441 PS=0.69 PD=0.63
M$10689 VGND B|C|Y \$5252 VGND sky130_fd_pr__nfet_01v8 L=0.15 W=0.42 AS=0.1474
+ AD=0.0441 PS=1.215 PD=0.63
M$10690 VGND \$5174 A|X VGND sky130_fd_pr__nfet_01v8 L=0.15 W=0.65 AS=0.1474
+ AD=0.23725 PS=1.215 PD=2.03
M$10693 \$5177 B|C|Y \$5251 VGND sky130_fd_pr__nfet_01v8 L=0.15 W=0.42
+ AS=0.1092 AD=0.0441 PS=1.36 PD=0.63
M$10694 \$5251 A|Y VGND VGND sky130_fd_pr__nfet_01v8 L=0.15 W=0.42 AS=0.0441
+ AD=0.0567 PS=0.63 PD=0.69
M$10695 VGND A|Y \$5250 VGND sky130_fd_pr__nfet_01v8 L=0.15 W=0.42 AS=0.0567
+ AD=0.0441 PS=0.69 PD=0.63
M$10696 \$5250 A|B|X \$5177 VGND sky130_fd_pr__nfet_01v8 L=0.15 W=0.42
+ AS=0.0441 AD=0.0567 PS=0.63 PD=0.69
M$10697 \$5177 A|B|X \$5249 VGND sky130_fd_pr__nfet_01v8 L=0.15 W=0.42
+ AS=0.0567 AD=0.0441 PS=0.69 PD=0.63
M$10698 VGND B|C|Y \$5249 VGND sky130_fd_pr__nfet_01v8 L=0.15 W=0.42 AS=0.1474
+ AD=0.0441 PS=1.215 PD=0.63
M$10699 VGND \$5177 C|X VGND sky130_fd_pr__nfet_01v8 L=0.15 W=0.65 AS=0.1474
+ AD=0.23725 PS=1.215 PD=2.03
M$10700 \$5178 A|B|X \$5248 VGND sky130_fd_pr__nfet_01v8 L=0.15 W=0.42
+ AS=0.1113 AD=0.0441 PS=1.37 PD=0.63
M$10701 \$5248 B|C|Y VGND VGND sky130_fd_pr__nfet_01v8 L=0.15 W=0.42 AS=0.0441
+ AD=0.0966 PS=0.63 PD=0.88
M$10702 VGND \$5178 A|B|X VGND sky130_fd_pr__nfet_01v8 L=0.15 W=0.42 AS=0.0966
+ AD=0.1113 PS=0.88 PD=1.37
M$10705 VGND B|C|Y \$5182 VGND sky130_fd_pr__nfet_01v8 L=0.15 W=0.65 AS=0.169
+ AD=0.08775 PS=1.82 PD=0.92
M$10706 \$5182 A|Y VGND VGND sky130_fd_pr__nfet_01v8 L=0.15 W=0.65 AS=0.08775
+ AD=0.08775 PS=0.92 PD=0.92
M$10707 VGND A|Y \$5246 VGND sky130_fd_pr__nfet_01v8 L=0.15 W=0.65 AS=0.08775
+ AD=0.08775 PS=0.92 PD=0.92
M$10708 \$5246 B|C|Y C|X VGND sky130_fd_pr__nfet_01v8 L=0.15 W=0.65 AS=0.08775
+ AD=0.25025 PS=0.92 PD=1.42
M$10709 C|X \$5182 VGND VGND sky130_fd_pr__nfet_01v8 L=0.15 W=0.65 AS=0.25025
+ AD=0.208 PS=1.42 PD=1.94
M$10710 VGND C|X \$5244 VGND sky130_fd_pr__nfet_01v8 L=0.15 W=0.65 AS=0.169
+ AD=0.08775 PS=1.82 PD=0.92
M$10711 \$5244 B|Y \$5243 VGND sky130_fd_pr__nfet_01v8 L=0.15 W=0.65 AS=0.08775
+ AD=0.10725 PS=0.92 PD=0.98
M$10712 \$5243 A|Y A|Y VGND sky130_fd_pr__nfet_01v8 L=0.15 W=0.65 AS=0.10725
+ AD=0.169 PS=0.98 PD=1.82
M$10713 \$5189 B|X \$5186 VGND sky130_fd_pr__nfet_01v8 L=0.15 W=0.64
+ AS=0.140825 AD=0.19265 PS=1.1 PD=1.285
M$10714 \$5186 \$5226 \$5188 VGND sky130_fd_pr__nfet_01v8 L=0.15 W=0.42
+ AS=0.19265 AD=0.18205 PS=1.285 PD=1.245
M$10715 \$5188 B|X \$5187 VGND sky130_fd_pr__nfet_01v8 L=0.15 W=0.64 AS=0.18205
+ AD=0.16275 PS=1.245 PD=1.8
M$10716 \$5186 \$5187 VGND VGND sky130_fd_pr__nfet_01v8 L=0.15 W=0.64 AS=0.1824
+ AD=0.0864 PS=1.85 PD=0.91
M$10717 VGND A|Y \$5187 VGND sky130_fd_pr__nfet_01v8 L=0.15 W=0.64 AS=0.0864
+ AD=0.11 PS=0.91 PD=0.99
M$10718 \$5189 \$5226 \$5187 VGND sky130_fd_pr__nfet_01v8 L=0.15 W=0.6
+ AS=0.140825 AD=0.11 PS=1.1 PD=0.99
M$10719 \$5226 B|X VGND VGND sky130_fd_pr__nfet_01v8 L=0.15 W=0.65 AS=0.16515
+ AD=0.1885 PS=1.82 PD=1.88
M$10720 \$5188 \$5191 \$5190 VGND sky130_fd_pr__nfet_01v8 L=0.15 W=0.64
+ AS=0.224 AD=0.0928 PS=1.98 PD=0.93
M$10721 \$5190 C|Y \$5189 VGND sky130_fd_pr__nfet_01v8 L=0.15 W=0.64 AS=0.0928
+ AD=0.1728 PS=0.93 PD=1.82
M$10722 \$5191 C|Y VGND VGND sky130_fd_pr__nfet_01v8 L=0.15 W=0.42 AS=0.1785
+ AD=0.1165 PS=1.69 PD=1.035
M$10723 VGND \$5190 A|B|X VGND sky130_fd_pr__nfet_01v8 L=0.15 W=0.65 AS=0.1165
+ AD=0.169 PS=1.035 PD=1.82
M$10724 \$5192 B|SLEEP|X \$5242 VGND sky130_fd_pr__nfet_01v8 L=0.15 W=0.65
+ AS=0.169 AD=0.06825 PS=1.82 PD=0.86
M$10725 \$5242 A|Y VGND VGND sky130_fd_pr__nfet_01v8 L=0.15 W=0.65 AS=0.06825
+ AD=0.08775 PS=0.86 PD=0.92
M$10726 VGND A|Y \$5230 VGND sky130_fd_pr__nfet_01v8 L=0.15 W=0.65 AS=0.08775
+ AD=0.169 PS=0.92 PD=1.82
M$10727 VGND B|SLEEP|X \$5230 VGND sky130_fd_pr__nfet_01v8 L=0.15 W=0.65
+ AS=0.169 AD=0.08775 PS=1.82 PD=0.92
M$10728 \$5230 \$5192 A1|B|C|Y VGND sky130_fd_pr__nfet_01v8 L=0.15 W=0.65
+ AS=0.08775 AD=0.195 PS=0.92 PD=1.9
M$10749 \$5193 CLK|TICK VGND VGND sky130_fd_pr__nfet_01v8 L=0.15 W=0.42
+ AS=0.1092 AD=0.0567 PS=1.36 PD=0.69
M$10750 VGND \$5193 \$5194 VGND sky130_fd_pr__nfet_01v8 L=0.15 W=0.42 AS=0.0567
+ AD=0.1092 PS=0.69 PD=1.36
M$10751 VGND D|X \$5196 VGND sky130_fd_pr__nfet_01v8 L=0.15 W=0.42 AS=0.2205
+ AD=0.066 PS=1.89 PD=0.745
M$10752 \$5196 \$5193 \$5197 VGND sky130_fd_pr__nfet_01v8 L=0.15 W=0.36
+ AS=0.066 AD=0.0594 PS=0.745 PD=0.69
M$10753 \$5240 \$5194 \$5197 VGND sky130_fd_pr__nfet_01v8 L=0.15 W=0.36
+ AS=0.1401 AD=0.0594 PS=1.1 PD=0.69
M$10754 \$5240 \$5199 \$5239 VGND sky130_fd_pr__nfet_01v8 L=0.15 W=0.42
+ AS=0.1401 AD=0.0441 PS=1.1 PD=0.63
M$10755 VGND RESET_B|X \$5239 VGND sky130_fd_pr__nfet_01v8 L=0.15 W=0.42
+ AS=0.1346 AD=0.0441 PS=1.15 PD=0.63
M$10756 VGND \$5197 \$5199 VGND sky130_fd_pr__nfet_01v8 L=0.15 W=0.64 AS=0.1346
+ AD=0.0999 PS=1.15 PD=0.985
M$10757 \$5199 \$5194 \$5200 VGND sky130_fd_pr__nfet_01v8 L=0.15 W=0.36
+ AS=0.0999 AD=0.0711 PS=0.985 PD=0.755
M$10758 \$5238 \$5193 \$5200 VGND sky130_fd_pr__nfet_01v8 L=0.15 W=0.36
+ AS=0.0669 AD=0.0711 PS=0.75 PD=0.755
M$10759 \$5238 \$5201 VGND VGND sky130_fd_pr__nfet_01v8 L=0.15 W=0.42 AS=0.0669
+ AD=0.12495 PS=0.75 PD=1.015
M$10760 VGND RESET_B|X \$5237 VGND sky130_fd_pr__nfet_01v8 L=0.15 W=0.42
+ AS=0.12495 AD=0.06405 PS=1.015 PD=0.725
M$10761 \$5237 \$5200 \$5201 VGND sky130_fd_pr__nfet_01v8 L=0.15 W=0.42
+ AS=0.06405 AD=0.1092 PS=0.725 PD=1.36
M$10762 VGND \$5201 A|Q VGND sky130_fd_pr__nfet_01v8 L=0.15 W=0.65 AS=0.2087
+ AD=0.169 PS=2.02 PD=1.82
M$10763 \$5255 A|FINE_MUX[10] VGND VGND sky130_fd_pr__nfet_01v8 L=0.15 W=0.42
+ AS=0.1134 AD=0.10435 PS=1.38 PD=1.01
M$10764 VGND \$5255 \$5256 VGND sky130_fd_pr__nfet_01v8 L=0.5 W=0.65 AS=0.10435
+ AD=0.169 PS=1.01 PD=1.82
M$10765 VGND \$5257 A|B1|X VGND sky130_fd_pr__nfet_01v8 L=0.15 W=0.42 AS=0.097
+ AD=0.1491 PS=0.975 PD=1.55
M$10766 \$5257 \$5256 VGND VGND sky130_fd_pr__nfet_01v8 L=0.5 W=0.65 AS=0.17225
+ AD=0.097 PS=1.83 PD=0.975
M$10767 VGND A|A1|B|X \$5258 VGND sky130_fd_pr__nfet_01v8 L=0.15 W=0.65
+ AS=0.169 AD=0.08775 PS=1.82 PD=0.92
M$10768 \$5258 A|B1|X VGND VGND sky130_fd_pr__nfet_01v8 L=0.15 W=0.65
+ AS=0.08775 AD=0.08775 PS=0.92 PD=0.92
M$10769 VGND A|B1|X \$5300 VGND sky130_fd_pr__nfet_01v8 L=0.15 W=0.65
+ AS=0.08775 AD=0.08775 PS=0.92 PD=0.92
M$10770 \$5300 A|A1|B|X A|A1|B|X VGND sky130_fd_pr__nfet_01v8 L=0.15 W=0.65
+ AS=0.08775 AD=0.25025 PS=0.92 PD=1.42
M$10771 A|A1|B|X \$5258 VGND VGND sky130_fd_pr__nfet_01v8 L=0.15 W=0.65
+ AS=0.25025 AD=0.208 PS=1.42 PD=1.94
M$10774 VGND A|A1|Y A|A1|Y VGND sky130_fd_pr__nfet_01v8 L=0.15 W=0.42 AS=0.1197
+ AD=0.1092 PS=1.41 PD=1.36
M$10775 B1|Y A|A1|Y \$5312 VGND sky130_fd_pr__nfet_01v8 L=0.15 W=0.65 AS=0.169
+ AD=0.08775 PS=1.82 PD=0.92
M$10776 \$5312 A|B|Y VGND VGND sky130_fd_pr__nfet_01v8 L=0.15 W=0.65 AS=0.08775
+ AD=0.169 PS=0.92 PD=1.82
M$10779 VGND B|B_N|X \$5436 VGND sky130_fd_pr__nfet_01v8 L=0.15 W=0.42
+ AS=0.10025 AD=0.1092 PS=0.985 PD=1.36
M$10781 A|B|Y \$5436 VGND VGND sky130_fd_pr__nfet_01v8 L=0.15 W=0.65 AS=0.08775
+ AD=0.169 PS=0.92 PD=1.82
M$10782 \$5438 B|X \$5512 VGND sky130_fd_pr__nfet_01v8 L=0.15 W=0.65 AS=0.169
+ AD=0.06825 PS=1.82 PD=0.86
M$10783 \$5512 A|B|Y VGND VGND sky130_fd_pr__nfet_01v8 L=0.15 W=0.65 AS=0.06825
+ AD=0.08775 PS=0.86 PD=0.92
M$10784 VGND A|B|Y \$5494 VGND sky130_fd_pr__nfet_01v8 L=0.15 W=0.65 AS=0.08775
+ AD=0.169 PS=0.92 PD=1.82
M$10785 VGND B|X \$5494 VGND sky130_fd_pr__nfet_01v8 L=0.15 W=0.65 AS=0.169
+ AD=0.08775 PS=1.82 PD=0.92
M$10786 \$5494 \$5438 A|C|Y VGND sky130_fd_pr__nfet_01v8 L=0.15 W=0.65
+ AS=0.08775 AD=0.195 PS=0.92 PD=1.9
M$10787 VGND B|X \$5329 VGND sky130_fd_pr__nfet_01v8 L=0.15 W=0.65 AS=0.169
+ AD=0.08775 PS=1.82 PD=0.92
M$10788 \$5329 A|B|Y A|Y VGND sky130_fd_pr__nfet_01v8 L=0.15 W=0.65 AS=0.08775
+ AD=0.169 PS=0.92 PD=1.82
M$10789 VGND A|Y B|C|Y VGND sky130_fd_pr__nfet_01v8 L=0.15 W=0.65 AS=0.169
+ AD=0.08775 PS=1.82 PD=0.92
M$10790 B|C|Y B|Y VGND VGND sky130_fd_pr__nfet_01v8 L=0.15 W=1.3 AS=0.1755
+ AD=0.27625 PS=1.84 PD=2.8
M$10791 VGND B|Y \$5262 VGND sky130_fd_pr__nfet_01v8 L=0.15 W=0.65 AS=0.169
+ AD=0.08775 PS=1.82 PD=0.92
M$10792 \$5262 A|X VGND VGND sky130_fd_pr__nfet_01v8 L=0.15 W=0.65 AS=0.08775
+ AD=0.08775 PS=0.92 PD=0.92
M$10793 VGND A|X \$5338 VGND sky130_fd_pr__nfet_01v8 L=0.15 W=0.65 AS=0.08775
+ AD=0.08775 PS=0.92 PD=0.92
M$10794 \$5338 B|Y B|X VGND sky130_fd_pr__nfet_01v8 L=0.15 W=0.65 AS=0.08775
+ AD=0.25025 PS=0.92 PD=1.42
M$10795 B|X \$5262 VGND VGND sky130_fd_pr__nfet_01v8 L=0.15 W=0.65 AS=0.25025
+ AD=0.208 PS=1.42 PD=1.94
M$10800 \$5495 A|B|X VGND VGND sky130_fd_pr__nfet_01v8 L=0.15 W=0.65 AS=0.16515
+ AD=0.1885 PS=1.82 PD=1.88
M$10802 B|Y B|C|Y VGND VGND sky130_fd_pr__nfet_01v8 L=0.15 W=1.3 AS=0.25675
+ AD=0.25675 PS=2.74 PD=2.74
M$10803 \$5442 \$5445 \$5444 VGND sky130_fd_pr__nfet_01v8 L=0.15 W=0.64
+ AS=0.224 AD=0.0928 PS=1.98 PD=0.93
M$10804 \$5444 B|C|Y \$5443 VGND sky130_fd_pr__nfet_01v8 L=0.15 W=0.64
+ AS=0.0928 AD=0.1728 PS=0.93 PD=1.82
M$10806 \$5445 B|C|Y VGND VGND sky130_fd_pr__nfet_01v8 L=0.15 W=0.42 AS=0.1785
+ AD=0.1165 PS=1.69 PD=1.035
M$10807 VGND \$5444 A|C|X VGND sky130_fd_pr__nfet_01v8 L=0.15 W=0.65 AS=0.1165
+ AD=0.169 PS=1.035 PD=1.82
M$10808 C|Y A|Y \$5521 VGND sky130_fd_pr__nfet_01v8 L=0.15 W=0.65 AS=0.169
+ AD=0.08775 PS=1.82 PD=0.92
M$10809 \$5521 B|C|D_N|X VGND VGND sky130_fd_pr__nfet_01v8 L=0.15 W=0.65
+ AS=0.08775 AD=0.169 PS=0.92 PD=1.82
M$10812 VGND A1|B|C|Y \$5447 VGND sky130_fd_pr__nfet_01v8 L=0.15 W=0.65
+ AS=0.169 AD=0.08775 PS=1.82 PD=0.92
M$10813 \$5447 A|C|Y VGND VGND sky130_fd_pr__nfet_01v8 L=0.15 W=0.65 AS=0.08775
+ AD=0.08775 PS=0.92 PD=0.92
M$10814 VGND A|C|Y \$5520 VGND sky130_fd_pr__nfet_01v8 L=0.15 W=0.65 AS=0.08775
+ AD=0.08775 PS=0.92 PD=0.92
M$10815 \$5520 A1|B|C|Y A0|A2|X VGND sky130_fd_pr__nfet_01v8 L=0.15 W=0.65
+ AS=0.08775 AD=0.25025 PS=0.92 PD=1.42
M$10816 A0|A2|X \$5447 VGND VGND sky130_fd_pr__nfet_01v8 L=0.15 W=0.65
+ AS=0.25025 AD=0.208 PS=1.42 PD=1.94
M$10830 A|B1|Q \$5451 VGND VGND sky130_fd_pr__nfet_01v8 L=0.15 W=0.65 AS=0.169
+ AD=0.2087 PS=1.82 PD=2.02
M$10832 \$5266 CLK|TICK VGND VGND sky130_fd_pr__nfet_01v8 L=0.15 W=0.42
+ AS=0.1092 AD=0.0567 PS=1.36 PD=0.69
M$10833 VGND \$5266 \$5267 VGND sky130_fd_pr__nfet_01v8 L=0.15 W=0.42 AS=0.0567
+ AD=0.1092 PS=0.69 PD=1.36
M$10834 \$5269 \$5266 \$5270 VGND sky130_fd_pr__nfet_01v8 L=0.15 W=0.36
+ AS=0.066 AD=0.0594 PS=0.745 PD=0.69
M$10835 \$5270 \$5267 \$5411 VGND sky130_fd_pr__nfet_01v8 L=0.15 W=0.36
+ AS=0.0594 AD=0.1401 PS=0.69 PD=1.1
M$10836 \$5414 \$5267 \$5271 VGND sky130_fd_pr__nfet_01v8 L=0.15 W=0.36
+ AS=0.0999 AD=0.0711 PS=0.985 PD=0.755
M$10837 \$5271 \$5266 \$5400 VGND sky130_fd_pr__nfet_01v8 L=0.15 W=0.36
+ AS=0.0711 AD=0.0669 PS=0.755 PD=0.75
M$10838 VGND D|Y \$5269 VGND sky130_fd_pr__nfet_01v8 L=0.15 W=0.42 AS=0.2205
+ AD=0.066 PS=1.89 PD=0.745
M$10839 \$5411 \$5414 \$5410 VGND sky130_fd_pr__nfet_01v8 L=0.15 W=0.42
+ AS=0.1401 AD=0.0441 PS=1.1 PD=0.63
M$10840 \$5410 RESET_B|X VGND VGND sky130_fd_pr__nfet_01v8 L=0.15 W=0.42
+ AS=0.0441 AD=0.1346 PS=0.63 PD=1.15
M$10841 \$5400 \$5272 VGND VGND sky130_fd_pr__nfet_01v8 L=0.15 W=0.42 AS=0.0669
+ AD=0.12495 PS=0.75 PD=1.015
M$10842 VGND RESET_B|X \$5396 VGND sky130_fd_pr__nfet_01v8 L=0.15 W=0.42
+ AS=0.12495 AD=0.06405 PS=1.015 PD=0.725
M$10843 \$5396 \$5271 \$5272 VGND sky130_fd_pr__nfet_01v8 L=0.15 W=0.42
+ AS=0.06405 AD=0.1092 PS=0.725 PD=1.36
M$10844 VGND \$5270 \$5414 VGND sky130_fd_pr__nfet_01v8 L=0.15 W=0.64 AS=0.1346
+ AD=0.0999 PS=1.15 PD=0.985
M$10845 D|Y \$5459 \$5497 VGND sky130_fd_pr__nfet_01v8 L=0.15 W=0.65 AS=0.195
+ AD=0.08775 PS=1.9 PD=0.92
M$10846 \$5497 B|Y VGND VGND sky130_fd_pr__nfet_01v8 L=0.15 W=0.65 AS=0.08775
+ AD=0.169 PS=0.92 PD=1.82
M$10847 \$5497 A|C1|Q VGND VGND sky130_fd_pr__nfet_01v8 L=0.15 W=0.65 AS=0.169
+ AD=0.08775 PS=1.82 PD=0.92
M$10848 VGND A|C1|Q \$5511 VGND sky130_fd_pr__nfet_01v8 L=0.15 W=0.65
+ AS=0.08775 AD=0.06825 PS=0.92 PD=0.86
M$10849 \$5511 B|Y \$5459 VGND sky130_fd_pr__nfet_01v8 L=0.15 W=0.65 AS=0.06825
+ AD=0.169 PS=0.86 PD=1.82
M$10850 \$5461 B|Y \$5510 VGND sky130_fd_pr__nfet_01v8 L=0.15 W=0.65 AS=0.169
+ AD=0.06825 PS=1.82 PD=0.86
M$10851 \$5510 A|D1|Q VGND VGND sky130_fd_pr__nfet_01v8 L=0.15 W=0.65
+ AS=0.06825 AD=0.08775 PS=0.86 PD=0.92
M$10852 VGND A|D1|Q \$5499 VGND sky130_fd_pr__nfet_01v8 L=0.15 W=0.65
+ AS=0.08775 AD=0.169 PS=0.92 PD=1.82
M$10853 VGND \$5272 A|C1|Q VGND sky130_fd_pr__nfet_01v8 L=0.15 W=0.65 AS=0.2087
+ AD=0.169 PS=2.02 PD=1.82
M$10854 VGND B|Y \$5499 VGND sky130_fd_pr__nfet_01v8 L=0.15 W=0.65 AS=0.169
+ AD=0.08775 PS=1.82 PD=0.92
M$10855 \$5499 \$5461 D|Y VGND sky130_fd_pr__nfet_01v8 L=0.15 W=0.65 AS=0.08775
+ AD=0.195 PS=0.92 PD=1.9
M$10858 \$5274 CLK|TICK VGND VGND sky130_fd_pr__nfet_01v8 L=0.15 W=0.42
+ AS=0.1092 AD=0.0567 PS=1.36 PD=0.69
M$10859 VGND \$5274 \$5275 VGND sky130_fd_pr__nfet_01v8 L=0.15 W=0.42 AS=0.0567
+ AD=0.1092 PS=0.69 PD=1.36
M$10860 D|Y \$5463 \$5500 VGND sky130_fd_pr__nfet_01v8 L=0.15 W=0.65 AS=0.195
+ AD=0.08775 PS=1.9 PD=0.92
M$10861 \$5500 A2|B|C|Y VGND VGND sky130_fd_pr__nfet_01v8 L=0.15 W=0.65
+ AS=0.08775 AD=0.169 PS=0.92 PD=1.82
M$10862 \$5276 \$5274 \$5277 VGND sky130_fd_pr__nfet_01v8 L=0.15 W=0.36
+ AS=0.066 AD=0.0594 PS=0.745 PD=0.69
M$10863 \$5277 \$5275 \$5370 VGND sky130_fd_pr__nfet_01v8 L=0.15 W=0.36
+ AS=0.0594 AD=0.1401 PS=0.69 PD=1.1
M$10864 \$5416 \$5275 \$5278 VGND sky130_fd_pr__nfet_01v8 L=0.15 W=0.36
+ AS=0.0999 AD=0.0711 PS=0.985 PD=0.755
M$10865 \$5278 \$5274 \$5361 VGND sky130_fd_pr__nfet_01v8 L=0.15 W=0.36
+ AS=0.0711 AD=0.0669 PS=0.755 PD=0.75
M$10866 VGND D|Y \$5276 VGND sky130_fd_pr__nfet_01v8 L=0.15 W=0.42 AS=0.2205
+ AD=0.066 PS=1.89 PD=0.745
M$10867 \$5370 \$5416 \$5367 VGND sky130_fd_pr__nfet_01v8 L=0.15 W=0.42
+ AS=0.1401 AD=0.0441 PS=1.1 PD=0.63
M$10868 \$5367 RESET_B|X VGND VGND sky130_fd_pr__nfet_01v8 L=0.15 W=0.42
+ AS=0.0441 AD=0.1346 PS=0.63 PD=1.15
M$10869 \$5361 \$5279 VGND VGND sky130_fd_pr__nfet_01v8 L=0.15 W=0.42 AS=0.0669
+ AD=0.12495 PS=0.75 PD=1.015
M$10870 VGND RESET_B|X \$5356 VGND sky130_fd_pr__nfet_01v8 L=0.15 W=0.42
+ AS=0.12495 AD=0.06405 PS=1.015 PD=0.725
M$10871 \$5356 \$5278 \$5279 VGND sky130_fd_pr__nfet_01v8 L=0.15 W=0.42
+ AS=0.06405 AD=0.1092 PS=0.725 PD=1.36
M$10872 VGND \$5277 \$5416 VGND sky130_fd_pr__nfet_01v8 L=0.15 W=0.64 AS=0.1346
+ AD=0.0999 PS=1.15 PD=0.985
M$10873 \$5500 A|Q VGND VGND sky130_fd_pr__nfet_01v8 L=0.15 W=0.65 AS=0.169
+ AD=0.08775 PS=1.82 PD=0.92
M$10874 VGND A|Q \$5509 VGND sky130_fd_pr__nfet_01v8 L=0.15 W=0.65 AS=0.08775
+ AD=0.06825 PS=0.92 PD=0.86
M$10875 \$5509 A2|B|C|Y \$5463 VGND sky130_fd_pr__nfet_01v8 L=0.15 W=0.65
+ AS=0.06825 AD=0.169 PS=0.86 PD=1.82
M$10876 VGND \$5279 A|Q VGND sky130_fd_pr__nfet_01v8 L=0.15 W=0.65 AS=0.2087
+ AD=0.169 PS=2.02 PD=1.82
M$10878 \$5282 B_N|Y VGND VGND sky130_fd_pr__nfet_01v8 L=0.15 W=0.42 AS=0.1092
+ AD=0.10025 PS=1.36 PD=0.985
M$10879 VGND A|B|Y D|Y VGND sky130_fd_pr__nfet_01v8 L=0.15 W=0.65 AS=0.10025
+ AD=0.08775 PS=0.985 PD=0.92
M$10880 D|Y \$5282 VGND VGND sky130_fd_pr__nfet_01v8 L=0.15 W=0.65 AS=0.08775
+ AD=0.169 PS=0.92 PD=1.82
M$10882 VGND A|Q B|B1|Y VGND sky130_fd_pr__nfet_01v8 L=0.15 W=0.42 AS=0.1197
+ AD=0.1092 PS=1.41 PD=1.36
M$10884 VGND \$5473 A|Q VGND sky130_fd_pr__nfet_01v8 L=0.15 W=0.65 AS=0.2087
+ AD=0.169 PS=2.02 PD=1.82
M$10885 VGND A|B|Y \$5286 VGND sky130_fd_pr__nfet_01v8 L=0.15 W=0.65 AS=0.169
+ AD=0.08775 PS=1.82 PD=0.92
M$10886 \$5286 A|Q VGND VGND sky130_fd_pr__nfet_01v8 L=0.15 W=0.65 AS=0.08775
+ AD=0.08775 PS=0.92 PD=0.92
M$10887 VGND A|Q \$5320 VGND sky130_fd_pr__nfet_01v8 L=0.15 W=0.65 AS=0.08775
+ AD=0.08775 PS=0.92 PD=0.92
M$10888 \$5320 A|B|Y D|X VGND sky130_fd_pr__nfet_01v8 L=0.15 W=0.65 AS=0.08775
+ AD=0.25025 PS=0.92 PD=1.42
M$10889 D|X \$5286 VGND VGND sky130_fd_pr__nfet_01v8 L=0.15 W=0.65 AS=0.25025
+ AD=0.208 PS=1.42 PD=1.94
M$10891 \$5287 A|Q VGND VGND sky130_fd_pr__nfet_01v8 L=0.15 W=0.42 AS=0.1134
+ AD=0.10435 PS=1.38 PD=1.01
M$10892 VGND \$5287 \$5288 VGND sky130_fd_pr__nfet_01v8 L=0.5 W=0.65 AS=0.10435
+ AD=0.169 PS=1.01 PD=1.82
M$10893 VGND \$5474 RESET_B|X VGND sky130_fd_pr__nfet_01v8 L=0.15 W=0.42
+ AS=0.097 AD=0.1491 PS=0.975 PD=1.55
M$10894 VGND \$5475 \$5474 VGND sky130_fd_pr__nfet_01v8 L=0.5 W=0.65 AS=0.097
+ AD=0.17225 PS=0.975 PD=1.83
M$10895 VGND \$5289 MID_OUT|X VGND sky130_fd_pr__nfet_01v8 L=0.15 W=0.42
+ AS=0.097 AD=0.1491 PS=0.975 PD=1.55
M$10896 \$5289 \$5288 VGND VGND sky130_fd_pr__nfet_01v8 L=0.5 W=0.65 AS=0.17225
+ AD=0.097 PS=1.83 PD=0.975
M$10897 \$5475 \$5477 VGND VGND sky130_fd_pr__nfet_01v8 L=0.5 W=0.65 AS=0.169
+ AD=0.10435 PS=1.82 PD=1.01
M$10898 VGND A|DCO_EN \$5477 VGND sky130_fd_pr__nfet_01v8 L=0.15 W=0.42
+ AS=0.10435 AD=0.1134 PS=1.01 PD=1.38
M$10908 \$5443 A|B|X \$5440 VGND sky130_fd_pr__nfet_01v8 L=0.15 W=0.64
+ AS=0.140825 AD=0.19265 PS=1.1 PD=1.285
M$10909 \$5440 \$5495 \$5442 VGND sky130_fd_pr__nfet_01v8 L=0.15 W=0.42
+ AS=0.19265 AD=0.18205 PS=1.285 PD=1.245
M$10910 \$5442 A|B|X \$5441 VGND sky130_fd_pr__nfet_01v8 L=0.15 W=0.64
+ AS=0.18205 AD=0.16275 PS=1.245 PD=1.8
M$10911 \$5440 \$5441 VGND VGND sky130_fd_pr__nfet_01v8 L=0.15 W=0.64 AS=0.1824
+ AD=0.0864 PS=1.85 PD=0.91
M$10912 VGND A|Y \$5441 VGND sky130_fd_pr__nfet_01v8 L=0.15 W=0.64 AS=0.0864
+ AD=0.11 PS=0.91 PD=0.99
M$10913 \$5443 \$5495 \$5441 VGND sky130_fd_pr__nfet_01v8 L=0.15 W=0.6
+ AS=0.140825 AD=0.11 PS=1.1 PD=0.99
M$10929 \$5451 \$5452 \$5516 VGND sky130_fd_pr__nfet_01v8 L=0.15 W=0.42
+ AS=0.1092 AD=0.06405 PS=1.36 PD=0.725
M$10930 \$5516 RESET_B|X VGND VGND sky130_fd_pr__nfet_01v8 L=0.15 W=0.42
+ AS=0.06405 AD=0.12495 PS=0.725 PD=1.015
M$10931 VGND \$5451 \$5515 VGND sky130_fd_pr__nfet_01v8 L=0.15 W=0.42
+ AS=0.12495 AD=0.0669 PS=1.015 PD=0.75
M$10932 \$5515 \$5454 \$5452 VGND sky130_fd_pr__nfet_01v8 L=0.15 W=0.36
+ AS=0.0669 AD=0.0711 PS=0.75 PD=0.755
M$10933 \$5455 \$5453 \$5452 VGND sky130_fd_pr__nfet_01v8 L=0.15 W=0.36
+ AS=0.0999 AD=0.0711 PS=0.985 PD=0.755
M$10934 \$5455 \$5457 VGND VGND sky130_fd_pr__nfet_01v8 L=0.15 W=0.64 AS=0.0999
+ AD=0.1346 PS=0.985 PD=1.15
M$10935 VGND RESET_B|X \$5514 VGND sky130_fd_pr__nfet_01v8 L=0.15 W=0.42
+ AS=0.1346 AD=0.0441 PS=1.15 PD=0.63
M$10936 \$5514 \$5455 \$5513 VGND sky130_fd_pr__nfet_01v8 L=0.15 W=0.42
+ AS=0.0441 AD=0.1401 PS=0.63 PD=1.1
M$10937 \$5513 \$5453 \$5457 VGND sky130_fd_pr__nfet_01v8 L=0.15 W=0.36
+ AS=0.1401 AD=0.0594 PS=1.1 PD=0.69
M$10938 \$5458 \$5454 \$5457 VGND sky130_fd_pr__nfet_01v8 L=0.15 W=0.36
+ AS=0.066 AD=0.0594 PS=0.745 PD=0.69
M$10939 \$5458 D|X VGND VGND sky130_fd_pr__nfet_01v8 L=0.15 W=0.42 AS=0.066
+ AD=0.2205 PS=0.745 PD=1.89
M$10940 \$5453 \$5454 VGND VGND sky130_fd_pr__nfet_01v8 L=0.15 W=0.42 AS=0.1092
+ AD=0.0567 PS=1.36 PD=0.69
M$10941 VGND CLK|TICK \$5454 VGND sky130_fd_pr__nfet_01v8 L=0.15 W=0.42
+ AS=0.0567 AD=0.1092 PS=0.69 PD=1.36
M$10945 A|A1|Y A|Q VGND VGND sky130_fd_pr__nfet_01v8 L=0.15 W=0.42 AS=0.1092
+ AD=0.1197 PS=1.36 PD=1.41
M$10946 \$5501 A|A1|Y VGND VGND sky130_fd_pr__nfet_01v8 L=0.15 W=0.42 AS=0.1113
+ AD=0.0588 PS=1.37 PD=0.7
M$10947 VGND A2|B|C|Y \$5501 VGND sky130_fd_pr__nfet_01v8 L=0.15 W=0.42
+ AS=0.0588 AD=0.0588 PS=0.7 PD=0.7
M$10948 \$5501 B|B1|Y B_N|Y VGND sky130_fd_pr__nfet_01v8 L=0.15 W=0.42
+ AS=0.0588 AD=0.1113 PS=0.7 PD=1.37
M$10949 \$5466 CLK|TICK VGND VGND sky130_fd_pr__nfet_01v8 L=0.15 W=0.42
+ AS=0.1092 AD=0.0567 PS=1.36 PD=0.69
M$10950 VGND \$5466 \$5467 VGND sky130_fd_pr__nfet_01v8 L=0.15 W=0.42 AS=0.0567
+ AD=0.1092 PS=0.69 PD=1.36
M$10951 VGND D|Y \$5468 VGND sky130_fd_pr__nfet_01v8 L=0.15 W=0.42 AS=0.2205
+ AD=0.066 PS=1.89 PD=0.745
M$10952 \$5468 \$5466 \$5469 VGND sky130_fd_pr__nfet_01v8 L=0.15 W=0.36
+ AS=0.066 AD=0.0594 PS=0.745 PD=0.69
M$10953 \$5506 \$5467 \$5469 VGND sky130_fd_pr__nfet_01v8 L=0.15 W=0.36
+ AS=0.1401 AD=0.0594 PS=1.1 PD=0.69
M$10954 \$5506 \$5471 \$5507 VGND sky130_fd_pr__nfet_01v8 L=0.15 W=0.42
+ AS=0.1401 AD=0.0441 PS=1.1 PD=0.63
M$10955 VGND RESET_B|X \$5507 VGND sky130_fd_pr__nfet_01v8 L=0.15 W=0.42
+ AS=0.1346 AD=0.0441 PS=1.15 PD=0.63
M$10956 VGND \$5469 \$5471 VGND sky130_fd_pr__nfet_01v8 L=0.15 W=0.64 AS=0.1346
+ AD=0.0999 PS=1.15 PD=0.985
M$10957 \$5471 \$5467 \$5472 VGND sky130_fd_pr__nfet_01v8 L=0.15 W=0.36
+ AS=0.0999 AD=0.0711 PS=0.985 PD=0.755
M$10958 \$5505 \$5466 \$5472 VGND sky130_fd_pr__nfet_01v8 L=0.15 W=0.36
+ AS=0.0669 AD=0.0711 PS=0.75 PD=0.755
M$10959 \$5505 \$5473 VGND VGND sky130_fd_pr__nfet_01v8 L=0.15 W=0.42 AS=0.0669
+ AD=0.12495 PS=0.75 PD=1.015
M$10960 VGND RESET_B|X \$5504 VGND sky130_fd_pr__nfet_01v8 L=0.15 W=0.42
+ AS=0.12495 AD=0.06405 PS=1.015 PD=0.725
M$10961 \$5504 \$5472 \$5473 VGND sky130_fd_pr__nfet_01v8 L=0.15 W=0.42
+ AS=0.06405 AD=0.1092 PS=0.725 PD=1.36
M$10965 VGND A|A1|B|X \$5522 VGND sky130_fd_pr__nfet_01v8 L=0.15 W=0.65
+ AS=0.169 AD=0.08775 PS=1.82 PD=0.92
M$10966 \$5522 A1|A2|X VGND VGND sky130_fd_pr__nfet_01v8 L=0.15 W=0.65
+ AS=0.08775 AD=0.08775 PS=0.92 PD=0.92
M$10967 VGND A3|SLEEP|Y \$5522 VGND sky130_fd_pr__nfet_01v8 L=0.15 W=0.65
+ AS=0.08775 AD=0.19825 PS=0.92 PD=1.26
M$10968 \$5522 A|B1|X A|Y VGND sky130_fd_pr__nfet_01v8 L=0.15 W=0.65 AS=0.19825
+ AD=0.221 PS=1.26 PD=1.98
M$10970 VGND A2|B|SLEEP|Y \$5526 VGND sky130_fd_pr__nfet_01v8 L=0.15 W=0.42
+ AS=0.10025 AD=0.0567 PS=0.985 PD=0.69
M$10971 \$5526 A|A1|X VGND VGND sky130_fd_pr__nfet_01v8 L=0.15 W=0.42 AS=0.0567
+ AD=0.1092 PS=0.69 PD=1.36
M$10972 A1|A2|X \$5526 VGND VGND sky130_fd_pr__nfet_01v8 L=0.15 W=0.65 AS=0.169
+ AD=0.10025 PS=1.82 PD=0.985
M$10973 \$5527 B1|C|Y VGND VGND sky130_fd_pr__nfet_01v8 L=0.15 W=0.42 AS=0.1092
+ AD=0.0567 PS=1.36 PD=0.69
M$10974 VGND A2|B|SLEEP|Y \$5527 VGND sky130_fd_pr__nfet_01v8 L=0.15 W=0.42
+ AS=0.0567 AD=0.0567 PS=0.69 PD=0.69
M$10975 VGND A|A1|X \$5527 VGND sky130_fd_pr__nfet_01v8 L=0.15 W=0.42
+ AS=0.101875 AD=0.0567 PS=0.99 PD=0.69
M$10976 VGND \$5527 A2|B|X VGND sky130_fd_pr__nfet_01v8 L=0.15 W=0.65
+ AS=0.101875 AD=0.182 PS=0.99 PD=1.86
M$10978 \$5529 B|B_N|X \$5585 VGND sky130_fd_pr__nfet_01v8 L=0.15 W=0.65
+ AS=0.169 AD=0.06825 PS=1.82 PD=0.86
M$10979 \$5585 A|Y VGND VGND sky130_fd_pr__nfet_01v8 L=0.15 W=0.65 AS=0.06825
+ AD=0.08775 PS=0.86 PD=0.92
M$10980 VGND A|Y \$5530 VGND sky130_fd_pr__nfet_01v8 L=0.15 W=0.65 AS=0.08775
+ AD=0.169 PS=0.92 PD=1.82
M$10981 VGND B|B_N|X \$5530 VGND sky130_fd_pr__nfet_01v8 L=0.15 W=0.65 AS=0.169
+ AD=0.08775 PS=1.82 PD=0.92
M$10982 \$5530 \$5529 A|Y VGND sky130_fd_pr__nfet_01v8 L=0.15 W=0.65 AS=0.08775
+ AD=0.195 PS=0.92 PD=1.9
M$10984 VGND B|X \$5594 VGND sky130_fd_pr__nfet_01v8 L=0.15 W=0.65 AS=0.169
+ AD=0.08775 PS=1.82 PD=0.92
M$10985 \$5594 A|X A|Y VGND sky130_fd_pr__nfet_01v8 L=0.15 W=0.65 AS=0.08775
+ AD=0.169 PS=0.92 PD=1.82
M$10987 \$5534 B|X \$5599 VGND sky130_fd_pr__nfet_01v8 L=0.15 W=0.65 AS=0.169
+ AD=0.06825 PS=1.82 PD=0.86
M$10988 \$5599 A|Y VGND VGND sky130_fd_pr__nfet_01v8 L=0.15 W=0.65 AS=0.06825
+ AD=0.08775 PS=0.86 PD=0.92
M$10989 VGND A|Y \$5535 VGND sky130_fd_pr__nfet_01v8 L=0.15 W=0.65 AS=0.08775
+ AD=0.169 PS=0.92 PD=1.82
M$10990 VGND B|X \$5535 VGND sky130_fd_pr__nfet_01v8 L=0.15 W=0.65 AS=0.169
+ AD=0.08775 PS=1.82 PD=0.92
M$10991 \$5535 \$5534 A|B|Y VGND sky130_fd_pr__nfet_01v8 L=0.15 W=0.65
+ AS=0.08775 AD=0.195 PS=0.92 PD=1.9
M$10995 VGND B|C|Y \$5613 VGND sky130_fd_pr__nfet_01v8 L=0.15 W=0.65 AS=0.169
+ AD=0.08775 PS=1.82 PD=0.92
M$10996 \$5613 A|B|X A|C|Y VGND sky130_fd_pr__nfet_01v8 L=0.15 W=0.65
+ AS=0.08775 AD=0.169 PS=0.92 PD=1.82
M$10997 D1|Y A|B|X \$5620 VGND sky130_fd_pr__nfet_01v8 L=0.15 W=0.65 AS=0.169
+ AD=0.10725 PS=1.82 PD=0.98
M$10998 \$5620 B|C|Y \$5621 VGND sky130_fd_pr__nfet_01v8 L=0.15 W=0.65
+ AS=0.10725 AD=0.08775 PS=0.98 PD=0.92
M$10999 \$5621 A1|B|C|Y VGND VGND sky130_fd_pr__nfet_01v8 L=0.15 W=0.65
+ AS=0.08775 AD=0.169 PS=0.92 PD=1.82
M$11000 B1|Y D1|Y \$5626 VGND sky130_fd_pr__nfet_01v8 L=0.15 W=0.65 AS=0.17225
+ AD=0.06825 PS=1.83 PD=0.86
M$11001 \$5626 C1|Y \$5628 VGND sky130_fd_pr__nfet_01v8 L=0.15 W=0.65
+ AS=0.06825 AD=0.12675 PS=0.86 PD=1.04
M$11002 \$5628 B1|Y \$5542 VGND sky130_fd_pr__nfet_01v8 L=0.15 W=0.65
+ AS=0.12675 AD=0.131625 PS=1.04 PD=1.055
M$11003 \$5542 A0|A2|X VGND VGND sky130_fd_pr__nfet_01v8 L=0.15 W=0.65
+ AS=0.131625 AD=0.12675 PS=1.055 PD=1.04
M$11004 VGND A1|B1|Y \$5542 VGND sky130_fd_pr__nfet_01v8 L=0.15 W=0.65
+ AS=0.12675 AD=0.17225 PS=1.04 PD=1.83
M$11005 VGND A1|B|C|Y \$5633 VGND sky130_fd_pr__nfet_01v8 L=0.15 W=0.65
+ AS=0.169 AD=0.08775 PS=1.82 PD=0.92
M$11006 \$5633 A|S|X B1|Y VGND sky130_fd_pr__nfet_01v8 L=0.15 W=0.65 AS=0.08775
+ AD=0.169 PS=0.92 PD=1.82
M$11019 \$5545 A|B1|Q \$5673 VGND sky130_fd_pr__nfet_01v8 L=0.15 W=0.42
+ AS=0.1092 AD=0.0609 PS=1.36 PD=0.71
M$11020 \$5673 A1|B|Y \$5676 VGND sky130_fd_pr__nfet_01v8 L=0.15 W=0.42
+ AS=0.0609 AD=0.0798 PS=0.71 PD=0.8
M$11021 \$5676 A2|C|Y \$5677 VGND sky130_fd_pr__nfet_01v8 L=0.15 W=0.42
+ AS=0.0798 AD=0.0693 PS=0.8 PD=0.75
M$11022 \$5677 A3|D|Y VGND VGND sky130_fd_pr__nfet_01v8 L=0.15 W=0.42 AS=0.0693
+ AD=0.196275 PS=0.75 PD=1.33
M$11023 VGND \$5545 A|A1|X VGND sky130_fd_pr__nfet_01v8 L=0.15 W=0.65
+ AS=0.196275 AD=0.169 PS=1.33 PD=1.82
M$11025 VGND A2|B|X \$5548 VGND sky130_fd_pr__nfet_01v8 L=0.15 W=0.65 AS=0.169
+ AD=0.08775 PS=1.82 PD=0.92
M$11026 \$5548 A|Y VGND VGND sky130_fd_pr__nfet_01v8 L=0.15 W=0.65 AS=0.08775
+ AD=0.08775 PS=0.92 PD=0.92
M$11027 VGND A|Y \$5684 VGND sky130_fd_pr__nfet_01v8 L=0.15 W=0.65 AS=0.08775
+ AD=0.08775 PS=0.92 PD=0.92
M$11028 \$5684 A2|B|X D|X VGND sky130_fd_pr__nfet_01v8 L=0.15 W=0.65 AS=0.08775
+ AD=0.25025 PS=0.92 PD=1.42
M$11029 D|X \$5548 VGND VGND sky130_fd_pr__nfet_01v8 L=0.15 W=0.65 AS=0.25025
+ AD=0.208 PS=1.42 PD=1.94
M$11031 \$5551 A|A1|X VGND VGND sky130_fd_pr__nfet_01v8 L=0.15 W=0.42 AS=0.1113
+ AD=0.0588 PS=1.37 PD=0.7
M$11032 VGND A2|B|X \$5551 VGND sky130_fd_pr__nfet_01v8 L=0.15 W=0.42 AS=0.0588
+ AD=0.0588 PS=0.7 PD=0.7
M$11033 \$5551 B1|B_N|X B|Y VGND sky130_fd_pr__nfet_01v8 L=0.15 W=0.42
+ AS=0.0588 AD=0.1113 PS=0.7 PD=1.37
M$11035 \$5552 A|A1|X VGND VGND sky130_fd_pr__nfet_01v8 L=0.15 W=0.65
+ AS=0.17225 AD=0.12675 PS=1.83 PD=1.04
M$11036 VGND A2|B|X \$5552 VGND sky130_fd_pr__nfet_01v8 L=0.15 W=0.65
+ AS=0.12675 AD=0.131625 PS=1.04 PD=1.055
M$11037 \$5552 B1|B_N|X \$5668 VGND sky130_fd_pr__nfet_01v8 L=0.15 W=0.65
+ AS=0.131625 AD=0.12675 PS=1.055 PD=1.04
M$11038 \$5668 A|C1|Q \$5663 VGND sky130_fd_pr__nfet_01v8 L=0.15 W=0.65
+ AS=0.12675 AD=0.06825 PS=1.04 PD=0.86
M$11039 \$5663 A|D1|Q A2|B|C|Y VGND sky130_fd_pr__nfet_01v8 L=0.15 W=0.65
+ AS=0.06825 AD=0.17225 PS=0.86 PD=1.83
M$11040 A|D1|Q \$5553 VGND VGND sky130_fd_pr__nfet_01v8 L=0.15 W=0.65 AS=0.169
+ AD=0.2087 PS=1.82 PD=2.02
M$11041 \$5646 \$5554 \$5692 VGND sky130_fd_pr__nfet_01v8 L=0.15 W=0.36
+ AS=0.0669 AD=0.0711 PS=0.75 PD=0.755
M$11042 \$5692 \$5555 \$5556 VGND sky130_fd_pr__nfet_01v8 L=0.15 W=0.36
+ AS=0.0711 AD=0.0999 PS=0.755 PD=0.985
M$11043 \$5636 \$5555 \$5557 VGND sky130_fd_pr__nfet_01v8 L=0.15 W=0.36
+ AS=0.1401 AD=0.0594 PS=1.1 PD=0.69
M$11044 \$5557 \$5554 \$5558 VGND sky130_fd_pr__nfet_01v8 L=0.15 W=0.36
+ AS=0.0594 AD=0.066 PS=0.69 PD=0.745
M$11045 \$5553 \$5692 \$5650 VGND sky130_fd_pr__nfet_01v8 L=0.15 W=0.42
+ AS=0.1092 AD=0.06405 PS=1.36 PD=0.725
M$11046 \$5650 RESET_B|X VGND VGND sky130_fd_pr__nfet_01v8 L=0.15 W=0.42
+ AS=0.06405 AD=0.12495 PS=0.725 PD=1.015
M$11047 VGND \$5553 \$5646 VGND sky130_fd_pr__nfet_01v8 L=0.15 W=0.42
+ AS=0.12495 AD=0.0669 PS=1.015 PD=0.75
M$11048 VGND RESET_B|X \$5643 VGND sky130_fd_pr__nfet_01v8 L=0.15 W=0.42
+ AS=0.1346 AD=0.0441 PS=1.15 PD=0.63
M$11049 \$5643 \$5556 \$5636 VGND sky130_fd_pr__nfet_01v8 L=0.15 W=0.42
+ AS=0.0441 AD=0.1401 PS=0.63 PD=1.1
M$11050 \$5558 D|Y VGND VGND sky130_fd_pr__nfet_01v8 L=0.15 W=0.42 AS=0.066
+ AD=0.2205 PS=0.745 PD=1.89
M$11051 \$5556 \$5557 VGND VGND sky130_fd_pr__nfet_01v8 L=0.15 W=0.64 AS=0.0999
+ AD=0.1346 PS=0.985 PD=1.15
M$11052 \$5555 \$5554 VGND VGND sky130_fd_pr__nfet_01v8 L=0.15 W=0.42 AS=0.1092
+ AD=0.0567 PS=1.36 PD=0.69
M$11053 VGND CLK|TICK \$5554 VGND sky130_fd_pr__nfet_01v8 L=0.15 W=0.42
+ AS=0.0567 AD=0.1092 PS=0.69 PD=1.36
M$11056 VGND A|A1|Y A|B|Y VGND sky130_fd_pr__nfet_01v8 L=0.15 W=0.65 AS=0.169
+ AD=0.08775 PS=1.82 PD=0.92
M$11057 A|B|Y B|B1|Y VGND VGND sky130_fd_pr__nfet_01v8 L=0.15 W=0.65 AS=0.08775
+ AD=0.08775 PS=0.92 PD=0.92
M$11058 VGND A2|B|C|Y A|B|Y VGND sky130_fd_pr__nfet_01v8 L=0.15 W=0.65
+ AS=0.08775 AD=0.169 PS=0.92 PD=1.82
M$11062 \$5784 A|FINE_MUX[12] VGND VGND sky130_fd_pr__nfet_01v8 L=0.15 W=0.42
+ AS=0.1134 AD=0.10435 PS=1.38 PD=1.01
M$11063 VGND \$5784 \$5785 VGND sky130_fd_pr__nfet_01v8 L=0.5 W=0.65 AS=0.10435
+ AD=0.169 PS=1.01 PD=1.82
M$11064 VGND A|FINE_MUX[11] \$5718 VGND sky130_fd_pr__nfet_01v8 L=0.15 W=0.42
+ AS=0.10435 AD=0.1134 PS=1.01 PD=1.38
M$11065 VGND \$5718 \$5719 VGND sky130_fd_pr__nfet_01v8 L=0.5 W=0.65 AS=0.10435
+ AD=0.169 PS=1.01 PD=1.82
M$11066 \$5720 \$5719 VGND VGND sky130_fd_pr__nfet_01v8 L=0.5 W=0.65 AS=0.17225
+ AD=0.097 PS=1.83 PD=0.975
M$11067 VGND \$5720 A|B1|X VGND sky130_fd_pr__nfet_01v8 L=0.15 W=0.42 AS=0.097
+ AD=0.1491 PS=0.975 PD=1.55
M$11068 VGND \$5786 A|B|B1|X VGND sky130_fd_pr__nfet_01v8 L=0.15 W=0.42
+ AS=0.097 AD=0.1491 PS=0.975 PD=1.55
M$11069 \$5786 \$5785 VGND VGND sky130_fd_pr__nfet_01v8 L=0.5 W=0.65 AS=0.17225
+ AD=0.097 PS=1.83 PD=0.975
M$11072 VGND A|A1|B|X B|C|Y VGND sky130_fd_pr__nfet_01v8 L=0.15 W=0.42
+ AS=0.1197 AD=0.1092 PS=1.41 PD=1.36
M$11073 \$5788 B|C|Y \$5827 VGND sky130_fd_pr__nfet_01v8 L=0.15 W=0.42
+ AS=0.1092 AD=0.0441 PS=1.36 PD=0.63
M$11074 \$5827 A|B1|X VGND VGND sky130_fd_pr__nfet_01v8 L=0.15 W=0.42 AS=0.0441
+ AD=0.0567 PS=0.63 PD=0.69
M$11075 VGND A|B1|X \$5829 VGND sky130_fd_pr__nfet_01v8 L=0.15 W=0.42 AS=0.0567
+ AD=0.0441 PS=0.69 PD=0.63
M$11076 \$5829 A|B|B1|X \$5788 VGND sky130_fd_pr__nfet_01v8 L=0.15 W=0.42
+ AS=0.0441 AD=0.0567 PS=0.63 PD=0.69
M$11077 \$5788 A|B|B1|X \$5830 VGND sky130_fd_pr__nfet_01v8 L=0.15 W=0.42
+ AS=0.0567 AD=0.0441 PS=0.69 PD=0.63
M$11078 \$5830 B|C|Y VGND VGND sky130_fd_pr__nfet_01v8 L=0.15 W=0.42 AS=0.0441
+ AD=0.1474 PS=0.63 PD=1.215
M$11079 VGND \$5788 A2|B|X VGND sky130_fd_pr__nfet_01v8 L=0.15 W=0.65 AS=0.1474
+ AD=0.23725 PS=1.215 PD=2.03
M$11080 VGND A|A1|B|X \$5723 VGND sky130_fd_pr__nfet_01v8 L=0.15 W=0.65
+ AS=0.169 AD=0.08775 PS=1.82 PD=0.92
M$11081 \$5723 A|B1|X VGND VGND sky130_fd_pr__nfet_01v8 L=0.15 W=0.65
+ AS=0.08775 AD=0.08775 PS=0.92 PD=0.92
M$11082 VGND A|B1|X \$5772 VGND sky130_fd_pr__nfet_01v8 L=0.15 W=0.65
+ AS=0.08775 AD=0.08775 PS=0.92 PD=0.92
M$11083 \$5772 A|A1|B|X A|B|X VGND sky130_fd_pr__nfet_01v8 L=0.15 W=0.65
+ AS=0.08775 AD=0.25025 PS=0.92 PD=1.42
M$11084 A|B|X \$5723 VGND VGND sky130_fd_pr__nfet_01v8 L=0.15 W=0.65 AS=0.25025
+ AD=0.208 PS=1.42 PD=1.94
M$11085 VGND B|D|X \$5775 VGND sky130_fd_pr__nfet_01v8 L=0.15 W=0.65 AS=0.169
+ AD=0.08775 PS=1.82 PD=0.92
M$11086 \$5775 A|A1|C|Y \$5777 VGND sky130_fd_pr__nfet_01v8 L=0.15 W=0.65
+ AS=0.08775 AD=0.08775 PS=0.92 PD=0.92
M$11087 \$5777 B|C|Y \$5776 VGND sky130_fd_pr__nfet_01v8 L=0.15 W=0.65
+ AS=0.08775 AD=0.10725 PS=0.92 PD=0.98
M$11088 \$5776 A|B1|X B1|C|Y VGND sky130_fd_pr__nfet_01v8 L=0.15 W=0.65
+ AS=0.10725 AD=0.195 PS=0.98 PD=1.9
M$11089 VGND A|B|X \$5789 VGND sky130_fd_pr__nfet_01v8 L=0.15 W=0.42 AS=0.1092
+ AD=0.0567 PS=1.36 PD=0.69
M$11090 \$5789 A3|SLEEP|Y VGND VGND sky130_fd_pr__nfet_01v8 L=0.15 W=0.42
+ AS=0.0567 AD=0.10025 PS=0.69 PD=0.985
M$11091 VGND \$5789 A2|SLEEP|X VGND sky130_fd_pr__nfet_01v8 L=0.15 W=0.65
+ AS=0.10025 AD=0.169 PS=0.985 PD=1.82
M$11092 A3|SLEEP|Y A|A1|C|Y \$5779 VGND sky130_fd_pr__nfet_01v8 L=0.15 W=0.65
+ AS=0.169 AD=0.08775 PS=1.82 PD=0.92
M$11093 \$5779 B|D|X VGND VGND sky130_fd_pr__nfet_01v8 L=0.15 W=0.65 AS=0.08775
+ AD=0.169 PS=0.92 PD=1.82
M$11096 \$5766 A1|A2|X VGND VGND sky130_fd_pr__nfet_01v8 L=0.15 W=0.42
+ AS=0.1113 AD=0.0588 PS=1.37 PD=0.7
M$11097 VGND A2|SLEEP|X \$5766 VGND sky130_fd_pr__nfet_01v8 L=0.15 W=0.42
+ AS=0.0588 AD=0.0588 PS=0.7 PD=0.7
M$11098 \$5766 A|B|B1|X B|SLEEP|Y VGND sky130_fd_pr__nfet_01v8 L=0.15 W=0.42
+ AS=0.0588 AD=0.1113 PS=0.7 PD=1.37
M$11099 \$5767 A|A1|X VGND VGND sky130_fd_pr__nfet_01v8 L=0.15 W=0.42 AS=0.1113
+ AD=0.0588 PS=1.37 PD=0.7
M$11100 VGND A2|B|SLEEP|Y \$5767 VGND sky130_fd_pr__nfet_01v8 L=0.15 W=0.42
+ AS=0.0588 AD=0.0588 PS=0.7 PD=0.7
M$11101 \$5767 B1|C|Y A|A1|Y VGND sky130_fd_pr__nfet_01v8 L=0.15 W=0.42
+ AS=0.0588 AD=0.1113 PS=0.7 PD=1.37
M$11102 \$5790 A|B|B1|X VGND VGND sky130_fd_pr__nfet_01v8 L=0.15 W=0.42
+ AS=0.1092 AD=0.10025 PS=1.36 PD=0.985
M$11103 VGND A2|SLEEP|X B1|C|X VGND sky130_fd_pr__nfet_01v8 L=0.15 W=0.65
+ AS=0.10025 AD=0.08775 PS=0.985 PD=0.92
M$11104 B1|C|X \$5790 VGND VGND sky130_fd_pr__nfet_01v8 L=0.15 W=0.65
+ AS=0.08775 AD=0.169 PS=0.92 PD=1.82
M$11109 VGND B|SLEEP|Y \$5791 VGND sky130_fd_pr__nfet_01v8 L=0.15 W=0.65
+ AS=0.169 AD=0.08775 PS=1.82 PD=0.92
M$11110 \$5791 A|Y VGND VGND sky130_fd_pr__nfet_01v8 L=0.15 W=0.65 AS=0.08775
+ AD=0.08775 PS=0.92 PD=0.92
M$11111 VGND A|Y \$5858 VGND sky130_fd_pr__nfet_01v8 L=0.15 W=0.65 AS=0.08775
+ AD=0.08775 PS=0.92 PD=0.92
M$11112 \$5858 B|SLEEP|Y A|X VGND sky130_fd_pr__nfet_01v8 L=0.15 W=0.65
+ AS=0.08775 AD=0.25025 PS=0.92 PD=1.42
M$11113 A|X \$5791 VGND VGND sky130_fd_pr__nfet_01v8 L=0.15 W=0.65 AS=0.25025
+ AD=0.208 PS=1.42 PD=1.94
M$11114 VGND A|Y \$5730 VGND sky130_fd_pr__nfet_01v8 L=0.15 W=0.42 AS=0.10025
+ AD=0.1092 PS=0.985 PD=1.36
M$11115 VGND B|SLEEP|Y A|X VGND sky130_fd_pr__nfet_01v8 L=0.15 W=0.65
+ AS=0.10025 AD=0.08775 PS=0.985 PD=0.92
M$11116 A|X \$5730 VGND VGND sky130_fd_pr__nfet_01v8 L=0.15 W=0.65 AS=0.08775
+ AD=0.169 PS=0.92 PD=1.82
M$11122 \$5795 B|C|X \$5869 VGND sky130_fd_pr__nfet_01v8 L=0.15 W=0.65 AS=0.169
+ AD=0.06825 PS=1.82 PD=0.86
M$11123 \$5869 A|B|Y VGND VGND sky130_fd_pr__nfet_01v8 L=0.15 W=0.65 AS=0.06825
+ AD=0.08775 PS=0.86 PD=0.92
M$11124 VGND A|B|Y \$5796 VGND sky130_fd_pr__nfet_01v8 L=0.15 W=0.65 AS=0.08775
+ AD=0.169 PS=0.92 PD=1.82
M$11125 VGND B|C|X \$5796 VGND sky130_fd_pr__nfet_01v8 L=0.15 W=0.65 AS=0.169
+ AD=0.08775 PS=1.82 PD=0.92
M$11126 \$5796 \$5795 B|Y VGND sky130_fd_pr__nfet_01v8 L=0.15 W=0.65 AS=0.08775
+ AD=0.195 PS=0.92 PD=1.9
M$11128 A|Y B|C|X VGND VGND sky130_fd_pr__nfet_01v8 L=0.15 W=0.65 AS=0.08775
+ AD=0.08775 PS=0.92 PD=0.92
M$11129 VGND A|C|X A|Y VGND sky130_fd_pr__nfet_01v8 L=0.15 W=0.65 AS=0.08775
+ AD=0.169 PS=0.92 PD=1.82
M$11130 VGND B|C|D_N|X \$5798 VGND sky130_fd_pr__nfet_01v8 L=0.15 W=0.42
+ AS=0.10025 AD=0.1092 PS=0.985 PD=1.36
M$11131 VGND A|B|Y B|C|Y VGND sky130_fd_pr__nfet_01v8 L=0.15 W=0.65 AS=0.10025
+ AD=0.08775 PS=0.985 PD=0.92
M$11133 VGND A|C|X B|C|Y VGND sky130_fd_pr__nfet_01v8 L=0.15 W=0.65 AS=0.10725
+ AD=0.08775 PS=0.98 PD=0.92
M$11134 B|C|Y \$5798 VGND VGND sky130_fd_pr__nfet_01v8 L=0.15 W=0.65 AS=0.08775
+ AD=0.182 PS=0.92 PD=1.86
M$11137 \$5799 \$5802 \$5804 VGND sky130_fd_pr__nfet_01v8 L=0.15 W=0.42
+ AS=0.19265 AD=0.18365 PS=1.285 PD=1.25
M$11138 \$5800 \$5802 \$5803 VGND sky130_fd_pr__nfet_01v8 L=0.15 W=0.6 AS=0.11
+ AD=0.140825 PS=0.99 PD=1.1
M$11139 \$5799 \$5800 VGND VGND sky130_fd_pr__nfet_01v8 L=0.15 W=0.64 AS=0.1824
+ AD=0.0864 PS=1.85 PD=0.91
M$11140 VGND A|B|X \$5800 VGND sky130_fd_pr__nfet_01v8 L=0.15 W=0.64 AS=0.0864
+ AD=0.11 PS=0.91 PD=0.99
M$11141 \$5803 A|B|X \$5799 VGND sky130_fd_pr__nfet_01v8 L=0.15 W=0.64
+ AS=0.140825 AD=0.19265 PS=1.1 PD=1.285
M$11142 \$5804 A|B|X \$5800 VGND sky130_fd_pr__nfet_01v8 L=0.15 W=0.64
+ AS=0.18365 AD=0.1628 PS=1.25 PD=1.8
M$11144 \$5802 A|B|X VGND VGND sky130_fd_pr__nfet_01v8 L=0.15 W=0.65 AS=0.1653
+ AD=0.195 PS=1.82 PD=1.9
M$11145 VGND A|B|X A_N|Y VGND sky130_fd_pr__nfet_01v8 L=0.15 W=0.65 AS=0.169
+ AD=0.08775 PS=1.82 PD=0.92
M$11146 A_N|Y B|C|Y VGND VGND sky130_fd_pr__nfet_01v8 L=0.15 W=0.65 AS=0.08775
+ AD=0.169 PS=0.92 PD=1.82
M$11147 VGND A_N|Y \$5735 VGND sky130_fd_pr__nfet_01v8 L=0.15 W=0.42 AS=0.1092
+ AD=0.10785 PS=1.36 PD=1.36
M$11148 VGND B|C|Y \$5805 VGND sky130_fd_pr__nfet_01v8 L=0.15 W=0.42
+ AS=0.144125 AD=0.1764 PS=1.12 PD=1.68
M$11149 VGND \$5806 B|X VGND sky130_fd_pr__nfet_01v8 L=0.15 W=0.65 AS=0.144125
+ AD=0.169 PS=1.12 PD=1.82
M$11150 \$5736 \$5735 \$5782 VGND sky130_fd_pr__nfet_01v8 L=0.15 W=0.42
+ AS=0.107825 AD=0.0441 PS=1.36 PD=0.63
M$11151 \$5782 A|B|X \$5781 VGND sky130_fd_pr__nfet_01v8 L=0.15 W=0.42
+ AS=0.0441 AD=0.05355 PS=0.63 PD=0.675
M$11152 VGND A|C|Y \$5781 VGND sky130_fd_pr__nfet_01v8 L=0.15 W=0.42
+ AS=0.122275 AD=0.05355 PS=1.08 PD=0.675
M$11153 VGND \$5736 A|S|X VGND sky130_fd_pr__nfet_01v8 L=0.15 W=0.65
+ AS=0.122275 AD=0.169 PS=1.08 PD=1.82
M$11156 \$5763 A0|A2|X A|A2|Y VGND sky130_fd_pr__nfet_01v8 L=0.15 W=0.65
+ AS=0.169 AD=0.08775 PS=1.82 PD=0.92
M$11157 A|A2|Y A1|B|C|Y \$5764 VGND sky130_fd_pr__nfet_01v8 L=0.15 W=0.65
+ AS=0.08775 AD=0.182 PS=0.92 PD=1.86
M$11159 \$5763 \$5740 VGND VGND sky130_fd_pr__nfet_01v8 L=0.15 W=0.65 AS=0.169
+ AD=0.08775 PS=1.82 PD=0.92
M$11160 VGND A|S|X \$5764 VGND sky130_fd_pr__nfet_01v8 L=0.15 W=0.65 AS=0.08775
+ AD=0.169 PS=0.92 PD=1.82
M$11161 \$5740 A|S|X VGND VGND sky130_fd_pr__nfet_01v8 L=0.15 W=0.65 AS=0.169
+ AD=0.169 PS=1.82 PD=1.82
M$11180 \$5809 A|B1|X VGND VGND sky130_fd_pr__nfet_01v8 L=0.15 W=0.42 AS=0.1092
+ AD=0.10025 PS=1.36 PD=0.985
M$11181 VGND B|SLEEP|X A1|X VGND sky130_fd_pr__nfet_01v8 L=0.15 W=0.65
+ AS=0.10025 AD=0.08775 PS=0.985 PD=0.92
M$11182 A1|X \$5809 VGND VGND sky130_fd_pr__nfet_01v8 L=0.15 W=0.65 AS=0.08775
+ AD=0.169 PS=0.92 PD=1.82
M$11183 \$5812 A1|X VGND VGND sky130_fd_pr__nfet_01v8 L=0.15 W=0.42 AS=0.1113
+ AD=0.0588 PS=1.37 PD=0.7
M$11184 VGND A2|Y \$5812 VGND sky130_fd_pr__nfet_01v8 L=0.15 W=0.42 AS=0.0588
+ AD=0.0588 PS=0.7 PD=0.7
M$11185 \$5812 B1|Y A3|D|Y VGND sky130_fd_pr__nfet_01v8 L=0.15 W=0.42 AS=0.0588
+ AD=0.1113 PS=0.7 PD=1.37
M$11190 VGND B|X \$5933 VGND sky130_fd_pr__nfet_01v8 L=0.15 W=0.65 AS=0.169
+ AD=0.08775 PS=1.82 PD=0.92
M$11191 \$5933 A|Y A1|B|Y VGND sky130_fd_pr__nfet_01v8 L=0.15 W=0.65 AS=0.08775
+ AD=0.169 PS=0.92 PD=1.82
M$11193 VGND A|B1|Q \$5741 VGND sky130_fd_pr__nfet_01v8 L=0.15 W=0.65 AS=0.208
+ AD=0.10725 PS=1.94 PD=0.98
M$11194 \$5741 A1|B|Y \$5774 VGND sky130_fd_pr__nfet_01v8 L=0.15 W=0.65
+ AS=0.10725 AD=0.10725 PS=0.98 PD=0.98
M$11195 \$5774 A2|C|Y \$5773 VGND sky130_fd_pr__nfet_01v8 L=0.15 W=0.65
+ AS=0.10725 AD=0.104 PS=0.98 PD=0.97
M$11196 \$5773 A3|D|Y VGND VGND sky130_fd_pr__nfet_01v8 L=0.15 W=0.65 AS=0.104
+ AD=0.112125 PS=0.97 PD=0.995
M$11197 VGND \$5741 B1|B_N|X VGND sky130_fd_pr__nfet_01v8 L=0.15 W=0.65
+ AS=0.112125 AD=0.17225 PS=0.995 PD=1.83
M$11198 VGND B1|B_N|X \$5744 VGND sky130_fd_pr__nfet_01v8 L=0.15 W=0.42
+ AS=0.10025 AD=0.1092 PS=0.985 PD=1.36
M$11200 A|Y \$5744 VGND VGND sky130_fd_pr__nfet_01v8 L=0.15 W=0.65 AS=0.08775
+ AD=0.169 PS=0.92 PD=1.82
M$11207 \$5765 A|A1|X VGND VGND sky130_fd_pr__nfet_01v8 L=0.15 W=0.65
+ AS=0.17225 AD=0.12675 PS=1.83 PD=1.04
M$11208 VGND A2|B|X \$5765 VGND sky130_fd_pr__nfet_01v8 L=0.15 W=0.65
+ AS=0.12675 AD=0.12675 PS=1.04 PD=1.04
M$11209 \$5765 B1|B_N|X \$5771 VGND sky130_fd_pr__nfet_01v8 L=0.15 W=0.65
+ AS=0.12675 AD=0.06825 PS=1.04 PD=0.86
M$11210 \$5771 A|C1|Q B|Y VGND sky130_fd_pr__nfet_01v8 L=0.15 W=0.65 AS=0.06825
+ AD=0.39325 PS=0.86 PD=2.51
M$11225 VGND A|B|X \$5960 VGND sky130_fd_pr__nfet_01v8 L=0.15 W=0.65 AS=0.169
+ AD=0.08775 PS=1.82 PD=0.92
M$11226 \$5960 A|B|B1|X VGND VGND sky130_fd_pr__nfet_01v8 L=0.15 W=0.65
+ AS=0.08775 AD=0.08775 PS=0.92 PD=0.92
M$11227 VGND A|B|B1|X \$6084 VGND sky130_fd_pr__nfet_01v8 L=0.15 W=0.65
+ AS=0.08775 AD=0.08775 PS=0.92 PD=0.92
M$11228 \$6084 A|B|X A|A1|B|X VGND sky130_fd_pr__nfet_01v8 L=0.15 W=0.65
+ AS=0.08775 AD=0.25025 PS=0.92 PD=1.42
M$11229 A|A1|B|X \$5960 VGND VGND sky130_fd_pr__nfet_01v8 L=0.15 W=0.65
+ AS=0.25025 AD=0.208 PS=1.42 PD=1.94
M$11230 VGND B1|C|X \$6085 VGND sky130_fd_pr__nfet_01v8 L=0.15 W=0.65 AS=0.169
+ AD=0.08775 PS=1.82 PD=0.92
M$11231 \$6085 A2|B|X \$6086 VGND sky130_fd_pr__nfet_01v8 L=0.15 W=0.65
+ AS=0.08775 AD=0.10725 PS=0.92 PD=0.98
M$11232 \$6086 A|A1|Y B|C_N|Y VGND sky130_fd_pr__nfet_01v8 L=0.15 W=0.65
+ AS=0.10725 AD=0.169 PS=0.98 PD=1.82
M$11233 VGND B1|C|X A_N|B|Y VGND sky130_fd_pr__nfet_01v8 L=0.15 W=0.65
+ AS=0.17225 AD=0.091 PS=1.83 PD=0.93
M$11234 A_N|B|Y A|A1|Y \$6087 VGND sky130_fd_pr__nfet_01v8 L=0.15 W=0.65
+ AS=0.091 AD=0.095875 PS=0.93 PD=0.945
M$11235 \$6087 A2|B|X VGND VGND sky130_fd_pr__nfet_01v8 L=0.15 W=0.65
+ AS=0.095875 AD=0.17225 PS=0.945 PD=1.83
M$11236 VGND A2|B|X \$6088 VGND sky130_fd_pr__nfet_01v8 L=0.15 W=0.65 AS=0.169
+ AD=0.08775 PS=1.82 PD=0.92
M$11237 \$6088 A|A1|Y B|Y VGND sky130_fd_pr__nfet_01v8 L=0.15 W=0.65 AS=0.08775
+ AD=0.169 PS=0.92 PD=1.82
M$11238 \$6032 B|SLEEP|Y VGND VGND sky130_fd_pr__nfet_01v8 L=0.15 W=0.65
+ AS=0.16515 AD=0.1885 PS=1.82 PD=1.88
M$11239 \$5969 \$5972 \$5971 VGND sky130_fd_pr__nfet_01v8 L=0.15 W=0.64
+ AS=0.224 AD=0.0928 PS=1.98 PD=0.93
M$11240 \$5971 B|C|Y \$5970 VGND sky130_fd_pr__nfet_01v8 L=0.15 W=0.64
+ AS=0.0928 AD=0.1728 PS=0.93 PD=1.82
M$11241 \$5972 B|C|Y VGND VGND sky130_fd_pr__nfet_01v8 L=0.15 W=0.42 AS=0.1785
+ AD=0.1165 PS=1.69 PD=1.035
M$11242 VGND \$5971 A|A1|X VGND sky130_fd_pr__nfet_01v8 L=0.15 W=0.65 AS=0.1165
+ AD=0.169 PS=1.035 PD=1.82
M$11243 \$5793 A|C|Y VGND VGND sky130_fd_pr__nfet_01v8 L=0.15 W=0.42 AS=0.1092
+ AD=0.0567 PS=1.36 PD=0.69
M$11244 VGND B|C|Y \$5793 VGND sky130_fd_pr__nfet_01v8 L=0.15 W=0.42 AS=0.0567
+ AD=0.0567 PS=0.69 PD=0.69
M$11245 VGND A|X \$5793 VGND sky130_fd_pr__nfet_01v8 L=0.15 W=0.42 AS=0.101875
+ AD=0.0567 PS=0.99 PD=0.69
M$11246 VGND \$5793 B|C|X VGND sky130_fd_pr__nfet_01v8 L=0.15 W=0.65
+ AS=0.101875 AD=0.182 PS=0.99 PD=1.86
M$11247 \$5974 B|Y \$6090 VGND sky130_fd_pr__nfet_01v8 L=0.15 W=0.65 AS=0.169
+ AD=0.06825 PS=1.82 PD=0.86
M$11248 \$6090 A|C|Y VGND VGND sky130_fd_pr__nfet_01v8 L=0.15 W=0.65 AS=0.06825
+ AD=0.08775 PS=0.86 PD=0.92
M$11249 VGND A|C|Y \$6069 VGND sky130_fd_pr__nfet_01v8 L=0.15 W=0.65 AS=0.08775
+ AD=0.169 PS=0.92 PD=1.82
M$11250 VGND B|Y \$6069 VGND sky130_fd_pr__nfet_01v8 L=0.15 W=0.65 AS=0.169
+ AD=0.08775 PS=1.82 PD=0.92
M$11251 \$6069 \$5974 A_N|B1|C|Y VGND sky130_fd_pr__nfet_01v8 L=0.15 W=0.65
+ AS=0.08775 AD=0.195 PS=0.92 PD=1.9
M$11252 VGND A|C|X B1|Y VGND sky130_fd_pr__nfet_01v8 L=0.15 W=1.3 AS=0.338
+ AD=0.1755 PS=3.64 PD=1.84
M$11254 \$5803 \$5805 \$5806 VGND sky130_fd_pr__nfet_01v8 L=0.15 W=0.64
+ AS=0.3168 AD=0.128 PS=2.27 PD=1.04
M$11255 \$5806 B|C|Y \$5804 VGND sky130_fd_pr__nfet_01v8 L=0.15 W=0.64 AS=0.128
+ AD=0.1728 PS=1.04 PD=1.82
M$11256 VGND B|X \$6099 VGND sky130_fd_pr__nfet_01v8 L=0.15 W=0.65 AS=0.169
+ AD=0.08775 PS=1.82 PD=0.92
M$11257 \$6099 A|X A1|B1|Y VGND sky130_fd_pr__nfet_01v8 L=0.15 W=0.65
+ AS=0.08775 AD=0.169 PS=0.92 PD=1.82
M$11258 VGND B1|Y B1|Y VGND sky130_fd_pr__nfet_01v8 L=0.15 W=0.65 AS=0.17225
+ AD=0.091 PS=1.83 PD=0.93
M$11259 B1|Y A1|Y \$6102 VGND sky130_fd_pr__nfet_01v8 L=0.15 W=0.65 AS=0.091
+ AD=0.095875 PS=0.93 PD=0.945
M$11260 \$6102 A|A2|Y VGND VGND sky130_fd_pr__nfet_01v8 L=0.15 W=0.65
+ AS=0.095875 AD=0.17225 PS=0.945 PD=1.83
M$11261 \$5983 B|Y \$6103 VGND sky130_fd_pr__nfet_01v8 L=0.15 W=0.65 AS=0.169
+ AD=0.06825 PS=1.82 PD=0.86
M$11262 \$6103 A|A2|Y VGND VGND sky130_fd_pr__nfet_01v8 L=0.15 W=0.65
+ AS=0.06825 AD=0.08775 PS=0.86 PD=0.92
M$11263 VGND A|A2|Y \$6071 VGND sky130_fd_pr__nfet_01v8 L=0.15 W=0.65
+ AS=0.08775 AD=0.169 PS=0.92 PD=1.82
M$11264 VGND B|Y \$6071 VGND sky130_fd_pr__nfet_01v8 L=0.15 W=0.65 AS=0.169
+ AD=0.08775 PS=1.82 PD=0.92
M$11265 \$6071 \$5983 A2|B|C|Y VGND sky130_fd_pr__nfet_01v8 L=0.15 W=0.65
+ AS=0.08775 AD=0.195 PS=0.92 PD=1.9
M$11266 \$6074 A1|Y VGND VGND sky130_fd_pr__nfet_01v8 L=0.15 W=0.65 AS=0.17225
+ AD=0.12675 PS=1.83 PD=1.04
M$11267 VGND A2|Y \$6074 VGND sky130_fd_pr__nfet_01v8 L=0.15 W=0.65 AS=0.12675
+ AD=0.12675 PS=1.04 PD=1.04
M$11268 \$6074 B1|Y \$6105 VGND sky130_fd_pr__nfet_01v8 L=0.15 W=0.65
+ AS=0.12675 AD=0.06825 PS=1.04 PD=0.86
M$11269 \$6105 A2|C1|X B1|Y VGND sky130_fd_pr__nfet_01v8 L=0.15 W=0.65
+ AS=0.06825 AD=0.39325 PS=0.86 PD=2.51
M$11270 \$6075 A|A1|Y VGND VGND sky130_fd_pr__nfet_01v8 L=0.15 W=0.65
+ AS=0.17225 AD=0.12675 PS=1.83 PD=1.04
M$11271 VGND A2|B|Y \$6075 VGND sky130_fd_pr__nfet_01v8 L=0.15 W=0.65
+ AS=0.12675 AD=0.131625 PS=1.04 PD=1.055
M$11272 \$6075 B1|Y \$6109 VGND sky130_fd_pr__nfet_01v8 L=0.15 W=0.65
+ AS=0.131625 AD=0.12675 PS=1.055 PD=1.04
M$11273 \$6109 C1|Y \$6108 VGND sky130_fd_pr__nfet_01v8 L=0.15 W=0.65
+ AS=0.12675 AD=0.06825 PS=1.04 PD=0.86
M$11274 \$6108 D1|Y A2|Y VGND sky130_fd_pr__nfet_01v8 L=0.15 W=0.65 AS=0.06825
+ AD=0.17225 PS=0.86 PD=1.83
M$11275 \$5991 B|Y \$6110 VGND sky130_fd_pr__nfet_01v8 L=0.15 W=0.65 AS=0.169
+ AD=0.06825 PS=1.82 PD=0.86
M$11276 \$6110 A|C|X VGND VGND sky130_fd_pr__nfet_01v8 L=0.15 W=0.65 AS=0.06825
+ AD=0.08775 PS=0.86 PD=0.92
M$11277 VGND A|C|X \$6076 VGND sky130_fd_pr__nfet_01v8 L=0.15 W=0.65 AS=0.08775
+ AD=0.169 PS=0.92 PD=1.82
M$11278 VGND B|Y \$6076 VGND sky130_fd_pr__nfet_01v8 L=0.15 W=0.65 AS=0.169
+ AD=0.08775 PS=1.82 PD=0.92
M$11279 \$6076 \$5991 A|Y VGND sky130_fd_pr__nfet_01v8 L=0.15 W=0.65 AS=0.08775
+ AD=0.195 PS=0.92 PD=1.9
M$11280 C1|Y A|Y \$6112 VGND sky130_fd_pr__nfet_01v8 L=0.15 W=0.65 AS=0.169
+ AD=0.08775 PS=1.82 PD=0.92
M$11281 \$6112 B|X VGND VGND sky130_fd_pr__nfet_01v8 L=0.15 W=0.65 AS=0.08775
+ AD=0.169 PS=0.92 PD=1.82
M$11282 VGND B|X \$5993 VGND sky130_fd_pr__nfet_01v8 L=0.15 W=0.65 AS=0.169
+ AD=0.08775 PS=1.82 PD=0.92
M$11283 \$5993 A|Y VGND VGND sky130_fd_pr__nfet_01v8 L=0.15 W=0.65 AS=0.08775
+ AD=0.08775 PS=0.92 PD=0.92
M$11284 VGND A|Y \$6114 VGND sky130_fd_pr__nfet_01v8 L=0.15 W=0.65 AS=0.08775
+ AD=0.08775 PS=0.92 PD=0.92
M$11285 \$6114 B|X A|B1|X VGND sky130_fd_pr__nfet_01v8 L=0.15 W=0.65 AS=0.08775
+ AD=0.25025 PS=0.92 PD=1.42
M$11286 A|B1|X \$5993 VGND VGND sky130_fd_pr__nfet_01v8 L=0.15 W=0.65
+ AS=0.25025 AD=0.208 PS=1.42 PD=1.94
M$11287 VGND A|B|Y A1|Y VGND sky130_fd_pr__nfet_01v8 L=0.15 W=1.72 AS=0.4577
+ AD=0.2847 PS=5.05 PD=3.2
M$11288 A1|Y B|C|X VGND VGND sky130_fd_pr__nfet_01v8 L=0.15 W=0.65 AS=0.08775
+ AD=0.169 PS=0.92 PD=1.82
M$11289 \$6077 A1|Y VGND VGND sky130_fd_pr__nfet_01v8 L=0.15 W=0.65 AS=0.17225
+ AD=0.12675 PS=1.83 PD=1.04
M$11290 VGND A2|Y \$6077 VGND sky130_fd_pr__nfet_01v8 L=0.15 W=0.65 AS=0.12675
+ AD=0.12675 PS=1.04 PD=1.04
M$11291 \$6077 A|B1|X \$6115 VGND sky130_fd_pr__nfet_01v8 L=0.15 W=0.65
+ AS=0.12675 AD=0.06825 PS=1.04 PD=0.86
M$11292 \$6115 C1|Y B1|Y VGND sky130_fd_pr__nfet_01v8 L=0.15 W=0.65 AS=0.06825
+ AD=0.39325 PS=0.86 PD=2.51
M$11293 \$5997 B|SLEEP|X \$6116 VGND sky130_fd_pr__nfet_01v8 L=0.15 W=0.65
+ AS=0.169 AD=0.06825 PS=1.82 PD=0.86
M$11294 \$6116 A|B1|X VGND VGND sky130_fd_pr__nfet_01v8 L=0.15 W=0.65
+ AS=0.06825 AD=0.08775 PS=0.86 PD=0.92
M$11295 VGND A|B1|X \$6078 VGND sky130_fd_pr__nfet_01v8 L=0.15 W=0.65
+ AS=0.08775 AD=0.169 PS=0.92 PD=1.82
M$11296 VGND B|SLEEP|X \$6078 VGND sky130_fd_pr__nfet_01v8 L=0.15 W=0.65
+ AS=0.169 AD=0.08775 PS=1.82 PD=0.92
M$11297 \$6078 \$5997 A|Y VGND sky130_fd_pr__nfet_01v8 L=0.15 W=0.65 AS=0.08775
+ AD=0.195 PS=0.92 PD=1.9
M$11298 VGND B|X \$6000 VGND sky130_fd_pr__nfet_01v8 L=0.15 W=0.65 AS=0.169
+ AD=0.08775 PS=1.82 PD=0.92
M$11299 \$6000 A|Y VGND VGND sky130_fd_pr__nfet_01v8 L=0.15 W=0.65 AS=0.08775
+ AD=0.08775 PS=0.92 PD=0.92
M$11300 VGND A|Y \$6121 VGND sky130_fd_pr__nfet_01v8 L=0.15 W=0.65 AS=0.08775
+ AD=0.08775 PS=0.92 PD=0.92
M$11301 \$6121 B|X B|C|X VGND sky130_fd_pr__nfet_01v8 L=0.15 W=0.65 AS=0.08775
+ AD=0.25025 PS=0.92 PD=1.42
M$11302 B|C|X \$6000 VGND VGND sky130_fd_pr__nfet_01v8 L=0.15 W=0.65 AS=0.25025
+ AD=0.208 PS=1.42 PD=1.94
M$11303 \$6004 B|X \$6122 VGND sky130_fd_pr__nfet_01v8 L=0.15 W=0.65 AS=0.169
+ AD=0.06825 PS=1.82 PD=0.86
M$11304 \$6122 A|B|Y VGND VGND sky130_fd_pr__nfet_01v8 L=0.15 W=0.65 AS=0.06825
+ AD=0.08775 PS=0.86 PD=0.92
M$11305 VGND A|B|Y \$6080 VGND sky130_fd_pr__nfet_01v8 L=0.15 W=0.65 AS=0.08775
+ AD=0.169 PS=0.92 PD=1.82
M$11306 VGND B|X \$6080 VGND sky130_fd_pr__nfet_01v8 L=0.15 W=0.65 AS=0.169
+ AD=0.08775 PS=1.82 PD=0.92
M$11307 \$6080 \$6004 B|Y VGND sky130_fd_pr__nfet_01v8 L=0.15 W=0.65 AS=0.08775
+ AD=0.195 PS=0.92 PD=1.9
M$11308 VGND \$6013 A|Q VGND sky130_fd_pr__nfet_01v8 L=0.15 W=0.65 AS=0.2087
+ AD=0.169 PS=2.02 PD=1.82
M$11309 A2|B|X \$6015 VGND VGND sky130_fd_pr__nfet_01v8 L=0.15 W=0.65
+ AS=0.23725 AD=0.1474 PS=2.03 PD=1.215
M$11310 VGND C|X \$6101 VGND sky130_fd_pr__nfet_01v8 L=0.15 W=0.42 AS=0.1474
+ AD=0.0441 PS=1.215 PD=0.63
M$11311 \$6101 B|X \$6015 VGND sky130_fd_pr__nfet_01v8 L=0.15 W=0.42 AS=0.0441
+ AD=0.0567 PS=0.63 PD=0.69
M$11312 \$6015 B|X \$6100 VGND sky130_fd_pr__nfet_01v8 L=0.15 W=0.42 AS=0.0567
+ AD=0.0441 PS=0.69 PD=0.63
M$11313 \$6100 A|Q VGND VGND sky130_fd_pr__nfet_01v8 L=0.15 W=0.42 AS=0.0441
+ AD=0.0567 PS=0.63 PD=0.69
M$11314 VGND A|Q \$6098 VGND sky130_fd_pr__nfet_01v8 L=0.15 W=0.42 AS=0.0567
+ AD=0.0441 PS=0.69 PD=0.63
M$11315 \$6098 C|X \$6015 VGND sky130_fd_pr__nfet_01v8 L=0.15 W=0.42 AS=0.0441
+ AD=0.1092 PS=0.63 PD=1.36
M$11316 \$6017 B|Y \$6095 VGND sky130_fd_pr__nfet_01v8 L=0.15 W=0.65 AS=0.169
+ AD=0.06825 PS=1.82 PD=0.86
M$11317 \$6095 A|Q VGND VGND sky130_fd_pr__nfet_01v8 L=0.15 W=0.65 AS=0.06825
+ AD=0.08775 PS=0.86 PD=0.92
M$11318 VGND A|Q \$6081 VGND sky130_fd_pr__nfet_01v8 L=0.15 W=0.65 AS=0.08775
+ AD=0.169 PS=0.92 PD=1.82
M$11319 VGND B|Y \$6081 VGND sky130_fd_pr__nfet_01v8 L=0.15 W=0.65 AS=0.169
+ AD=0.08775 PS=1.82 PD=0.92
M$11320 \$6081 \$6017 A|Y VGND sky130_fd_pr__nfet_01v8 L=0.15 W=0.65 AS=0.08775
+ AD=0.195 PS=0.92 PD=1.9
M$11330 A3|Y \$6124 \$6196 VGND sky130_fd_pr__nfet_01v8 L=0.15 W=0.65 AS=0.169
+ AD=0.08775 PS=1.82 PD=0.92
M$11331 \$6196 B|C_N|Y VGND VGND sky130_fd_pr__nfet_01v8 L=0.15 W=0.65
+ AS=0.08775 AD=0.10025 PS=0.92 PD=0.985
M$11332 VGND A_N|B|Y \$6124 VGND sky130_fd_pr__nfet_01v8 L=0.15 W=0.42
+ AS=0.10025 AD=0.1092 PS=0.985 PD=1.36
M$11335 \$5970 B|SLEEP|Y \$5967 VGND sky130_fd_pr__nfet_01v8 L=0.15 W=0.64
+ AS=0.140825 AD=0.19265 PS=1.1 PD=1.285
M$11336 \$5967 \$6032 \$5969 VGND sky130_fd_pr__nfet_01v8 L=0.15 W=0.42
+ AS=0.19265 AD=0.18205 PS=1.285 PD=1.245
M$11337 \$5969 B|SLEEP|Y \$5968 VGND sky130_fd_pr__nfet_01v8 L=0.15 W=0.64
+ AS=0.18205 AD=0.16275 PS=1.245 PD=1.8
M$11338 \$5967 \$5968 VGND VGND sky130_fd_pr__nfet_01v8 L=0.15 W=0.64 AS=0.1824
+ AD=0.0864 PS=1.85 PD=0.91
M$11339 VGND A|Y \$5968 VGND sky130_fd_pr__nfet_01v8 L=0.15 W=0.64 AS=0.0864
+ AD=0.11 PS=0.91 PD=0.99
M$11340 \$5970 \$6032 \$5968 VGND sky130_fd_pr__nfet_01v8 L=0.15 W=0.6
+ AS=0.140825 AD=0.11 PS=1.1 PD=0.99
M$11345 \$6125 \$6127 \$6129 VGND sky130_fd_pr__nfet_01v8 L=0.15 W=0.42
+ AS=0.19265 AD=0.18205 PS=1.285 PD=1.245
M$11346 \$6126 \$6127 \$6128 VGND sky130_fd_pr__nfet_01v8 L=0.15 W=0.6 AS=0.11
+ AD=0.140825 PS=0.99 PD=1.1
M$11347 \$6125 \$6126 VGND VGND sky130_fd_pr__nfet_01v8 L=0.15 W=0.64 AS=0.1824
+ AD=0.0864 PS=1.85 PD=0.91
M$11348 VGND A|B|Y \$6126 VGND sky130_fd_pr__nfet_01v8 L=0.15 W=0.64 AS=0.0864
+ AD=0.11 PS=0.91 PD=0.99
M$11349 \$6128 A|B|Y \$6125 VGND sky130_fd_pr__nfet_01v8 L=0.15 W=0.64
+ AS=0.140825 AD=0.19265 PS=1.1 PD=1.285
M$11350 \$6129 A|B|Y \$6126 VGND sky130_fd_pr__nfet_01v8 L=0.15 W=0.64
+ AS=0.18205 AD=0.16275 PS=1.245 PD=1.8
M$11352 \$6127 A|B|Y VGND VGND sky130_fd_pr__nfet_01v8 L=0.15 W=0.65 AS=0.16515
+ AD=0.1885 PS=1.82 PD=1.88
M$11353 \$5975 B|C|X \$6092 VGND sky130_fd_pr__nfet_01v8 L=0.15 W=0.42
+ AS=0.1092 AD=0.0441 PS=1.36 PD=0.63
M$11354 \$6092 A|B|Y VGND VGND sky130_fd_pr__nfet_01v8 L=0.15 W=0.42 AS=0.0441
+ AD=0.0567 PS=0.63 PD=0.69
M$11355 VGND A|B|Y \$6093 VGND sky130_fd_pr__nfet_01v8 L=0.15 W=0.42 AS=0.0567
+ AD=0.0441 PS=0.69 PD=0.63
M$11356 \$6093 A|B|Y \$5975 VGND sky130_fd_pr__nfet_01v8 L=0.15 W=0.42
+ AS=0.0441 AD=0.0567 PS=0.63 PD=0.69
M$11357 \$5975 A|B|Y \$6094 VGND sky130_fd_pr__nfet_01v8 L=0.15 W=0.42
+ AS=0.0567 AD=0.0441 PS=0.69 PD=0.63
M$11358 VGND B|C|X \$6094 VGND sky130_fd_pr__nfet_01v8 L=0.15 W=0.42 AS=0.1474
+ AD=0.0441 PS=1.215 PD=0.63
M$11359 VGND \$5975 B|X VGND sky130_fd_pr__nfet_01v8 L=0.15 W=0.65 AS=0.1474
+ AD=0.23725 PS=1.215 PD=2.03
M$11360 VGND B|C|X \$6131 VGND sky130_fd_pr__nfet_01v8 L=0.15 W=0.42 AS=0.1165
+ AD=0.1785 PS=1.035 PD=1.69
M$11361 VGND \$6130 B|B_N|C|X VGND sky130_fd_pr__nfet_01v8 L=0.15 W=0.65
+ AS=0.1165 AD=0.169 PS=1.035 PD=1.82
M$11362 VGND B|X \$6133 VGND sky130_fd_pr__nfet_01v8 L=0.15 W=0.65 AS=0.169
+ AD=0.08775 PS=1.82 PD=0.92
M$11363 \$6133 A|C|X VGND VGND sky130_fd_pr__nfet_01v8 L=0.15 W=0.65 AS=0.08775
+ AD=0.08775 PS=0.92 PD=0.92
M$11364 VGND A|C|X \$6222 VGND sky130_fd_pr__nfet_01v8 L=0.15 W=0.65 AS=0.08775
+ AD=0.08775 PS=0.92 PD=0.92
M$11365 \$6222 B|X A2|B|C|X VGND sky130_fd_pr__nfet_01v8 L=0.15 W=0.65
+ AS=0.08775 AD=0.25025 PS=0.92 PD=1.42
M$11366 A2|B|C|X \$6133 VGND VGND sky130_fd_pr__nfet_01v8 L=0.15 W=0.65
+ AS=0.25025 AD=0.208 PS=1.42 PD=1.94
M$11369 A|Y A|A1|B1|Y \$6224 VGND sky130_fd_pr__nfet_01v8 L=0.15 W=0.65
+ AS=0.091 AD=0.095875 PS=0.93 PD=0.945
M$11370 \$6224 A2|B|C|X VGND VGND sky130_fd_pr__nfet_01v8 L=0.15 W=0.65
+ AS=0.095875 AD=0.17225 PS=0.945 PD=1.83
M$11371 \$5979 A|A1|B1|Y \$6097 VGND sky130_fd_pr__nfet_01v8 L=0.15 W=0.42
+ AS=0.1092 AD=0.0441 PS=1.36 PD=0.63
M$11372 \$6097 A2|B|C|X \$6096 VGND sky130_fd_pr__nfet_01v8 L=0.15 W=0.42
+ AS=0.0441 AD=0.0441 PS=0.63 PD=0.63
M$11373 VGND B|C|D_N|X \$6096 VGND sky130_fd_pr__nfet_01v8 L=0.15 W=0.42
+ AS=0.13165 AD=0.0441 PS=1.14 PD=0.63
M$11374 VGND \$5979 A|B|X VGND sky130_fd_pr__nfet_01v8 L=0.15 W=0.65 AS=0.13165
+ AD=0.169 PS=1.14 PD=1.82
M$11375 VGND B|C|D_N|X \$6135 VGND sky130_fd_pr__nfet_01v8 L=0.15 W=0.65
+ AS=0.169 AD=0.08775 PS=1.82 PD=0.92
M$11376 \$6135 A|Y VGND VGND sky130_fd_pr__nfet_01v8 L=0.15 W=0.65 AS=0.08775
+ AD=0.08775 PS=0.92 PD=0.92
M$11377 VGND A|Y \$6230 VGND sky130_fd_pr__nfet_01v8 L=0.15 W=0.65 AS=0.08775
+ AD=0.08775 PS=0.92 PD=0.92
M$11378 \$6230 B|C|D_N|X A2|B|SLEEP|X VGND sky130_fd_pr__nfet_01v8 L=0.15
+ W=0.65 AS=0.08775 AD=0.25025 PS=0.92 PD=1.42
M$11379 A2|B|SLEEP|X \$6135 VGND VGND sky130_fd_pr__nfet_01v8 L=0.15 W=0.65
+ AS=0.25025 AD=0.208 PS=1.42 PD=1.94
M$11383 \$6137 B|X \$6238 VGND sky130_fd_pr__nfet_01v8 L=0.15 W=0.65 AS=0.169
+ AD=0.06825 PS=1.82 PD=0.86
M$11384 \$6238 A|X VGND VGND sky130_fd_pr__nfet_01v8 L=0.15 W=0.65 AS=0.06825
+ AD=0.08775 PS=0.86 PD=0.92
M$11385 VGND A|X \$6138 VGND sky130_fd_pr__nfet_01v8 L=0.15 W=0.65 AS=0.08775
+ AD=0.169 PS=0.92 PD=1.82
M$11386 VGND B|X \$6138 VGND sky130_fd_pr__nfet_01v8 L=0.15 W=0.65 AS=0.169
+ AD=0.08775 PS=1.82 PD=0.92
M$11387 \$6138 \$6137 A3|B|C|Y VGND sky130_fd_pr__nfet_01v8 L=0.15 W=0.65
+ AS=0.08775 AD=0.195 PS=0.92 PD=1.9
M$11389 VGND A|A1|Y \$6140 VGND sky130_fd_pr__nfet_01v8 L=0.15 W=0.65 AS=0.169
+ AD=0.08775 PS=1.82 PD=0.92
M$11390 \$6140 A2|B|SLEEP|X VGND VGND sky130_fd_pr__nfet_01v8 L=0.15 W=0.65
+ AS=0.08775 AD=0.08775 PS=0.92 PD=0.92
M$11391 VGND A3|B|C|Y \$6140 VGND sky130_fd_pr__nfet_01v8 L=0.15 W=0.65
+ AS=0.08775 AD=0.19825 PS=0.92 PD=1.26
M$11392 \$6140 A1|B1|Y B|Y VGND sky130_fd_pr__nfet_01v8 L=0.15 W=0.65
+ AS=0.19825 AD=0.221 PS=1.26 PD=1.98
M$11393 A1|Y A3|B|C|Y VGND VGND sky130_fd_pr__nfet_01v8 L=0.15 W=0.65 AS=0.169
+ AD=0.08775 PS=1.82 PD=0.92
M$11394 VGND A2|B|SLEEP|X A1|Y VGND sky130_fd_pr__nfet_01v8 L=0.15 W=0.65
+ AS=0.08775 AD=0.08775 PS=0.92 PD=0.92
M$11395 A1|Y A|A1|Y VGND VGND sky130_fd_pr__nfet_01v8 L=0.15 W=1.07 AS=0.19695
+ AD=0.2887 PS=2.28 PD=3.23
M$11398 VGND A|X \$6141 VGND sky130_fd_pr__nfet_01v8 L=0.15 W=0.42 AS=0.1092
+ AD=0.0567 PS=1.36 PD=0.69
M$11399 \$6141 B|SLEEP|X VGND VGND sky130_fd_pr__nfet_01v8 L=0.15 W=0.42
+ AS=0.0567 AD=0.10025 PS=0.69 PD=0.985
M$11400 VGND \$6141 A|A1|X VGND sky130_fd_pr__nfet_01v8 L=0.15 W=0.65
+ AS=0.10025 AD=0.169 PS=0.985 PD=1.82
M$11401 A2|Y B1|Y \$6072 VGND sky130_fd_pr__nfet_01v8 L=0.15 W=0.42 AS=0.1113
+ AD=0.0588 PS=1.37 PD=0.7
M$11402 \$6072 A2|B|C|Y VGND VGND sky130_fd_pr__nfet_01v8 L=0.15 W=0.42
+ AS=0.0588 AD=0.0588 PS=0.7 PD=0.7
M$11403 VGND A|A1|X \$6072 VGND sky130_fd_pr__nfet_01v8 L=0.15 W=0.42 AS=0.0588
+ AD=0.1113 PS=0.7 PD=1.37
M$11404 VGND A2|B|C|Y \$6142 VGND sky130_fd_pr__nfet_01v8 L=0.15 W=0.65
+ AS=0.169 AD=0.08775 PS=1.82 PD=0.92
M$11405 \$6142 A|A1|X VGND VGND sky130_fd_pr__nfet_01v8 L=0.15 W=0.65
+ AS=0.08775 AD=0.08775 PS=0.92 PD=0.92
M$11406 VGND A|A1|X \$6258 VGND sky130_fd_pr__nfet_01v8 L=0.15 W=0.65
+ AS=0.08775 AD=0.08775 PS=0.92 PD=0.92
M$11407 \$6258 A2|B|C|Y A2|C1|X VGND sky130_fd_pr__nfet_01v8 L=0.15 W=0.65
+ AS=0.08775 AD=0.25025 PS=0.92 PD=1.42
M$11408 A2|C1|X \$6142 VGND VGND sky130_fd_pr__nfet_01v8 L=0.15 W=0.65
+ AS=0.25025 AD=0.208 PS=1.42 PD=1.94
M$11409 \$6073 A1|B1_N|Y VGND VGND sky130_fd_pr__nfet_01v8 L=0.15 W=0.42
+ AS=0.1113 AD=0.0588 PS=1.37 PD=0.7
M$11410 VGND A2|Y \$6073 VGND sky130_fd_pr__nfet_01v8 L=0.15 W=0.42 AS=0.0588
+ AD=0.0588 PS=0.7 PD=0.7
M$11411 \$6073 B1|Y D1|Y VGND sky130_fd_pr__nfet_01v8 L=0.15 W=0.42 AS=0.0588
+ AD=0.1113 PS=0.7 PD=1.37
M$11412 A1|B1_N|Y A2|B|C|Y VGND VGND sky130_fd_pr__nfet_01v8 L=0.15 W=0.65
+ AS=0.169 AD=0.08775 PS=1.82 PD=0.92
M$11413 VGND B|X A1|B1_N|Y VGND sky130_fd_pr__nfet_01v8 L=0.15 W=0.65
+ AS=0.08775 AD=0.08775 PS=0.92 PD=0.92
M$11414 A1|B1_N|Y A|B|Y VGND VGND sky130_fd_pr__nfet_01v8 L=0.15 W=0.65
+ AS=0.08775 AD=0.169 PS=0.92 PD=1.82
M$11415 A2|B|Y \$6144 \$6146 VGND sky130_fd_pr__nfet_01v8 L=0.15 W=0.65
+ AS=0.169 AD=0.10075 PS=1.82 PD=0.96
M$11416 \$6146 A2|C1|X VGND VGND sky130_fd_pr__nfet_01v8 L=0.15 W=0.65
+ AS=0.10075 AD=0.08775 PS=0.96 PD=0.92
M$11417 VGND A1|Y \$6146 VGND sky130_fd_pr__nfet_01v8 L=0.15 W=0.65 AS=0.08775
+ AD=0.169 PS=0.92 PD=1.82
M$11419 VGND B|X \$6148 VGND sky130_fd_pr__nfet_01v8 L=0.15 W=0.65 AS=0.169
+ AD=0.08775 PS=1.82 PD=0.92
M$11420 \$6148 A|B|Y VGND VGND sky130_fd_pr__nfet_01v8 L=0.15 W=0.65 AS=0.08775
+ AD=0.08775 PS=0.92 PD=0.92
M$11421 VGND A|B|Y \$6266 VGND sky130_fd_pr__nfet_01v8 L=0.15 W=0.65 AS=0.08775
+ AD=0.08775 PS=0.92 PD=0.92
M$11422 \$6266 B|X B|C|X VGND sky130_fd_pr__nfet_01v8 L=0.15 W=0.65 AS=0.08775
+ AD=0.25025 PS=0.92 PD=1.42
M$11423 B|C|X \$6148 VGND VGND sky130_fd_pr__nfet_01v8 L=0.15 W=0.65 AS=0.25025
+ AD=0.208 PS=1.42 PD=1.94
M$11425 VGND A2|B|Y \$6150 VGND sky130_fd_pr__nfet_01v8 L=0.15 W=0.65 AS=0.169
+ AD=0.08775 PS=1.82 PD=0.92
M$11426 \$6150 A|A1|Y VGND VGND sky130_fd_pr__nfet_01v8 L=0.15 W=0.65
+ AS=0.08775 AD=0.08775 PS=0.92 PD=0.92
M$11427 VGND A|A1|Y \$6273 VGND sky130_fd_pr__nfet_01v8 L=0.15 W=0.65
+ AS=0.08775 AD=0.08775 PS=0.92 PD=0.92
M$11428 \$6273 A2|B|Y A|C|X VGND sky130_fd_pr__nfet_01v8 L=0.15 W=0.65
+ AS=0.08775 AD=0.25025 PS=0.92 PD=1.42
M$11429 A|C|X \$6150 VGND VGND sky130_fd_pr__nfet_01v8 L=0.15 W=0.65 AS=0.25025
+ AD=0.208 PS=1.42 PD=1.94
M$11431 B1|Y A|Y \$6279 VGND sky130_fd_pr__nfet_01v8 L=0.15 W=0.65 AS=0.169
+ AD=0.10725 PS=1.82 PD=0.98
M$11432 \$6279 B|C|X \$6281 VGND sky130_fd_pr__nfet_01v8 L=0.15 W=0.65
+ AS=0.10725 AD=0.08775 PS=0.98 PD=0.92
M$11433 \$6281 A|C|X VGND VGND sky130_fd_pr__nfet_01v8 L=0.15 W=0.65 AS=0.08775
+ AD=0.169 PS=0.92 PD=1.82
M$11434 VGND B|C|X \$6151 VGND sky130_fd_pr__nfet_01v8 L=0.15 W=0.65 AS=0.169
+ AD=0.08775 PS=1.82 PD=0.92
M$11435 \$6151 A|B|X VGND VGND sky130_fd_pr__nfet_01v8 L=0.15 W=0.65 AS=0.08775
+ AD=0.08775 PS=0.92 PD=0.92
M$11436 VGND A|B|X \$6285 VGND sky130_fd_pr__nfet_01v8 L=0.15 W=0.65 AS=0.08775
+ AD=0.08775 PS=0.92 PD=0.92
M$11437 \$6285 B|C|X B|X VGND sky130_fd_pr__nfet_01v8 L=0.15 W=0.65 AS=0.08775
+ AD=0.25025 PS=0.92 PD=1.42
M$11438 B|X \$6151 VGND VGND sky130_fd_pr__nfet_01v8 L=0.15 W=0.65 AS=0.25025
+ AD=0.208 PS=1.42 PD=1.94
M$11440 \$6153 B|C|X \$6290 VGND sky130_fd_pr__nfet_01v8 L=0.15 W=0.42
+ AS=0.1092 AD=0.0441 PS=1.36 PD=0.63
M$11441 \$6290 A|Y VGND VGND sky130_fd_pr__nfet_01v8 L=0.15 W=0.42 AS=0.0441
+ AD=0.0567 PS=0.63 PD=0.69
M$11442 VGND A|Y \$6292 VGND sky130_fd_pr__nfet_01v8 L=0.15 W=0.42 AS=0.0567
+ AD=0.0441 PS=0.69 PD=0.63
M$11443 \$6292 B|X \$6153 VGND sky130_fd_pr__nfet_01v8 L=0.15 W=0.42 AS=0.0441
+ AD=0.0567 PS=0.63 PD=0.69
M$11444 \$6153 B|X \$6294 VGND sky130_fd_pr__nfet_01v8 L=0.15 W=0.42 AS=0.0567
+ AD=0.0441 PS=0.69 PD=0.63
M$11445 \$6294 B|C|X VGND VGND sky130_fd_pr__nfet_01v8 L=0.15 W=0.42 AS=0.0441
+ AD=0.1474 PS=0.63 PD=1.215
M$11446 VGND \$6153 B|X VGND sky130_fd_pr__nfet_01v8 L=0.15 W=0.65 AS=0.1474
+ AD=0.23725 PS=1.215 PD=2.03
M$11449 VGND B|C|X \$6154 VGND sky130_fd_pr__nfet_01v8 L=0.15 W=0.65 AS=0.169
+ AD=0.08775 PS=1.82 PD=0.92
M$11450 \$6154 A|B|X VGND VGND sky130_fd_pr__nfet_01v8 L=0.15 W=0.65 AS=0.08775
+ AD=0.08775 PS=0.92 PD=0.92
M$11451 VGND A|B|X \$6302 VGND sky130_fd_pr__nfet_01v8 L=0.15 W=0.65 AS=0.08775
+ AD=0.08775 PS=0.92 PD=0.92
M$11452 \$6302 B|C|X B|C|X VGND sky130_fd_pr__nfet_01v8 L=0.15 W=0.65
+ AS=0.08775 AD=0.25025 PS=0.92 PD=1.42
M$11453 B|C|X \$6154 VGND VGND sky130_fd_pr__nfet_01v8 L=0.15 W=0.65 AS=0.25025
+ AD=0.208 PS=1.42 PD=1.94
M$11455 VGND B|C|X \$6307 VGND sky130_fd_pr__nfet_01v8 L=0.15 W=0.42 AS=0.1474
+ AD=0.0441 PS=1.215 PD=0.63
M$11456 \$6307 A|B|Y \$6155 VGND sky130_fd_pr__nfet_01v8 L=0.15 W=0.42
+ AS=0.0441 AD=0.0567 PS=0.63 PD=0.69
M$11457 \$6155 A|B|Y \$6308 VGND sky130_fd_pr__nfet_01v8 L=0.15 W=0.42
+ AS=0.0567 AD=0.0441 PS=0.69 PD=0.63
M$11458 \$6308 A|Y VGND VGND sky130_fd_pr__nfet_01v8 L=0.15 W=0.42 AS=0.0441
+ AD=0.0567 PS=0.63 PD=0.69
M$11459 VGND A|Y \$6309 VGND sky130_fd_pr__nfet_01v8 L=0.15 W=0.42 AS=0.0567
+ AD=0.0441 PS=0.69 PD=0.63
M$11460 \$6309 B|C|X \$6155 VGND sky130_fd_pr__nfet_01v8 L=0.15 W=0.42
+ AS=0.0441 AD=0.1092 PS=0.63 PD=1.36
M$11461 B|SLEEP|X \$6155 VGND VGND sky130_fd_pr__nfet_01v8 L=0.15 W=0.65
+ AS=0.23725 AD=0.1474 PS=2.03 PD=1.215
M$11462 VGND B|B_N|X \$6341 VGND sky130_fd_pr__nfet_01v8 L=0.15 W=0.42
+ AS=0.10025 AD=0.1092 PS=0.985 PD=1.36
M$11463 VGND \$6341 C1|Y VGND sky130_fd_pr__nfet_01v8 L=0.15 W=0.65 AS=0.169
+ AD=0.08775 PS=1.82 PD=0.92
M$11464 C1|Y A|Y VGND VGND sky130_fd_pr__nfet_01v8 L=0.15 W=0.65 AS=0.08775
+ AD=0.10025 PS=0.92 PD=0.985
M$11467 \$6156 \$6158 \$6160 VGND sky130_fd_pr__nfet_01v8 L=0.15 W=0.42
+ AS=0.19265 AD=0.18205 PS=1.285 PD=1.245
M$11468 \$6157 \$6158 \$6159 VGND sky130_fd_pr__nfet_01v8 L=0.15 W=0.6 AS=0.11
+ AD=0.140825 PS=0.99 PD=1.1
M$11469 \$6156 \$6157 VGND VGND sky130_fd_pr__nfet_01v8 L=0.15 W=0.64 AS=0.1824
+ AD=0.0864 PS=1.85 PD=0.91
M$11470 VGND A|C|Y \$6157 VGND sky130_fd_pr__nfet_01v8 L=0.15 W=0.64 AS=0.0864
+ AD=0.11 PS=0.91 PD=0.99
M$11471 \$6159 A|B|Y \$6156 VGND sky130_fd_pr__nfet_01v8 L=0.15 W=0.64
+ AS=0.140825 AD=0.19265 PS=1.1 PD=1.285
M$11472 \$6160 A|B|Y \$6157 VGND sky130_fd_pr__nfet_01v8 L=0.15 W=0.64
+ AS=0.18205 AD=0.16275 PS=1.245 PD=1.8
M$11473 \$5999 C|Y \$6118 VGND sky130_fd_pr__nfet_01v8 L=0.15 W=0.42 AS=0.1092
+ AD=0.0441 PS=1.36 PD=0.63
M$11474 \$6118 A|C|Y VGND VGND sky130_fd_pr__nfet_01v8 L=0.15 W=0.42 AS=0.0441
+ AD=0.0567 PS=0.63 PD=0.69
M$11475 VGND A|C|Y \$6120 VGND sky130_fd_pr__nfet_01v8 L=0.15 W=0.42 AS=0.0567
+ AD=0.0441 PS=0.69 PD=0.63
M$11476 \$6120 B|Y \$5999 VGND sky130_fd_pr__nfet_01v8 L=0.15 W=0.42 AS=0.0441
+ AD=0.0567 PS=0.63 PD=0.69
M$11477 \$5999 B|Y \$6119 VGND sky130_fd_pr__nfet_01v8 L=0.15 W=0.42 AS=0.0567
+ AD=0.0441 PS=0.69 PD=0.63
M$11478 VGND C|Y \$6119 VGND sky130_fd_pr__nfet_01v8 L=0.15 W=0.42 AS=0.1474
+ AD=0.0441 PS=1.215 PD=0.63
M$11479 VGND \$5999 B|X VGND sky130_fd_pr__nfet_01v8 L=0.15 W=0.65 AS=0.1474
+ AD=0.23725 PS=1.215 PD=2.03
M$11480 \$6158 A|B|Y VGND VGND sky130_fd_pr__nfet_01v8 L=0.15 W=0.65 AS=0.16515
+ AD=0.1885 PS=1.82 PD=1.88
M$11481 VGND C|Y \$6162 VGND sky130_fd_pr__nfet_01v8 L=0.15 W=0.42 AS=0.1165
+ AD=0.1785 PS=1.035 PD=1.69
M$11482 VGND \$6161 B|X VGND sky130_fd_pr__nfet_01v8 L=0.15 W=0.65 AS=0.1165
+ AD=0.169 PS=1.035 PD=1.82
M$11484 VGND B|C|X \$6322 VGND sky130_fd_pr__nfet_01v8 L=0.15 W=0.65 AS=0.169
+ AD=0.08775 PS=1.82 PD=0.92
M$11485 \$6322 B|X \$6323 VGND sky130_fd_pr__nfet_01v8 L=0.15 W=0.65 AS=0.08775
+ AD=0.10725 PS=0.92 PD=0.98
M$11486 \$6323 A|B|Y A2|C|Y VGND sky130_fd_pr__nfet_01v8 L=0.15 W=0.65
+ AS=0.10725 AD=0.169 PS=0.98 PD=1.82
M$11488 VGND B|C|X \$6163 VGND sky130_fd_pr__nfet_01v8 L=0.15 W=0.65 AS=0.169
+ AD=0.08775 PS=1.82 PD=0.92
M$11489 \$6163 A|Y VGND VGND sky130_fd_pr__nfet_01v8 L=0.15 W=0.65 AS=0.08775
+ AD=0.08775 PS=0.92 PD=0.92
M$11490 VGND A|Y \$6327 VGND sky130_fd_pr__nfet_01v8 L=0.15 W=0.65 AS=0.08775
+ AD=0.08775 PS=0.92 PD=0.92
M$11491 \$6327 B|C|X C|X VGND sky130_fd_pr__nfet_01v8 L=0.15 W=0.65 AS=0.08775
+ AD=0.25025 PS=0.92 PD=1.42
M$11492 C|X \$6163 VGND VGND sky130_fd_pr__nfet_01v8 L=0.15 W=0.65 AS=0.25025
+ AD=0.208 PS=1.42 PD=1.94
M$11494 \$6005 CLK|TICK VGND VGND sky130_fd_pr__nfet_01v8 L=0.15 W=0.42
+ AS=0.1092 AD=0.0567 PS=1.36 PD=0.69
M$11495 VGND \$6005 \$6006 VGND sky130_fd_pr__nfet_01v8 L=0.15 W=0.42 AS=0.0567
+ AD=0.1092 PS=0.69 PD=1.36
M$11496 VGND D|X \$6008 VGND sky130_fd_pr__nfet_01v8 L=0.15 W=0.42 AS=0.2205
+ AD=0.066 PS=1.89 PD=0.745
M$11497 \$6008 \$6005 \$6009 VGND sky130_fd_pr__nfet_01v8 L=0.15 W=0.36
+ AS=0.066 AD=0.0594 PS=0.745 PD=0.69
M$11498 \$6111 \$6006 \$6009 VGND sky130_fd_pr__nfet_01v8 L=0.15 W=0.36
+ AS=0.1401 AD=0.0594 PS=1.1 PD=0.69
M$11499 \$6111 \$6011 \$6113 VGND sky130_fd_pr__nfet_01v8 L=0.15 W=0.42
+ AS=0.1401 AD=0.0441 PS=1.1 PD=0.63
M$11500 VGND RESET_B|X \$6113 VGND sky130_fd_pr__nfet_01v8 L=0.15 W=0.42
+ AS=0.1346 AD=0.0441 PS=1.15 PD=0.63
M$11501 VGND \$6009 \$6011 VGND sky130_fd_pr__nfet_01v8 L=0.15 W=0.64 AS=0.1346
+ AD=0.0999 PS=1.15 PD=0.985
M$11502 \$6011 \$6006 \$6012 VGND sky130_fd_pr__nfet_01v8 L=0.15 W=0.36
+ AS=0.0999 AD=0.0711 PS=0.985 PD=0.755
M$11503 \$6107 \$6005 \$6012 VGND sky130_fd_pr__nfet_01v8 L=0.15 W=0.36
+ AS=0.0669 AD=0.0711 PS=0.75 PD=0.755
M$11504 \$6107 \$6013 VGND VGND sky130_fd_pr__nfet_01v8 L=0.15 W=0.42 AS=0.0669
+ AD=0.12495 PS=0.75 PD=1.015
M$11505 VGND RESET_B|X \$6106 VGND sky130_fd_pr__nfet_01v8 L=0.15 W=0.42
+ AS=0.12495 AD=0.06405 PS=1.015 PD=0.725
M$11506 \$6106 \$6012 \$6013 VGND sky130_fd_pr__nfet_01v8 L=0.15 W=0.42
+ AS=0.06405 AD=0.1092 PS=0.725 PD=1.36
M$11507 D|X \$6164 VGND VGND sky130_fd_pr__nfet_01v8 L=0.15 W=0.65 AS=0.169
+ AD=0.144125 PS=1.82 PD=1.12
M$11508 VGND C|X \$6166 VGND sky130_fd_pr__nfet_01v8 L=0.15 W=0.42 AS=0.144125
+ AD=0.1764 PS=1.12 PD=1.68
M$11509 VGND B|X \$6169 VGND sky130_fd_pr__nfet_01v8 L=0.15 W=0.65 AS=0.195
+ AD=0.1653 PS=1.9 PD=1.82
M$11510 \$6167 \$6169 \$6171 VGND sky130_fd_pr__nfet_01v8 L=0.15 W=0.42
+ AS=0.18365 AD=0.19265 PS=1.25 PD=1.285
M$11511 \$6168 \$6169 \$6170 VGND sky130_fd_pr__nfet_01v8 L=0.15 W=0.6
+ AS=0.140825 AD=0.11 PS=1.1 PD=0.99
M$11512 \$6170 A|Q VGND VGND sky130_fd_pr__nfet_01v8 L=0.15 W=0.64 AS=0.11
+ AD=0.0864 PS=0.99 PD=0.91
M$11513 VGND \$6170 \$6171 VGND sky130_fd_pr__nfet_01v8 L=0.15 W=0.64 AS=0.0864
+ AD=0.1824 PS=0.91 PD=1.85
M$11514 \$6170 B|X \$6167 VGND sky130_fd_pr__nfet_01v8 L=0.15 W=0.64 AS=0.1628
+ AD=0.18365 PS=1.8 PD=1.25
M$11515 \$6168 B|X \$6171 VGND sky130_fd_pr__nfet_01v8 L=0.15 W=0.64
+ AS=0.140825 AD=0.19265 PS=1.1 PD=1.285
M$11516 A|Q \$6173 VGND VGND sky130_fd_pr__nfet_01v8 L=0.15 W=0.65 AS=0.169
+ AD=0.2087 PS=1.82 PD=2.02
M$11517 \$6276 \$6174 \$6354 VGND sky130_fd_pr__nfet_01v8 L=0.15 W=0.36
+ AS=0.0669 AD=0.0711 PS=0.75 PD=0.755
M$11518 \$6354 \$6175 \$6176 VGND sky130_fd_pr__nfet_01v8 L=0.15 W=0.36
+ AS=0.0711 AD=0.0999 PS=0.755 PD=0.985
M$11519 \$6262 \$6175 \$6177 VGND sky130_fd_pr__nfet_01v8 L=0.15 W=0.36
+ AS=0.1401 AD=0.0594 PS=1.1 PD=0.69
M$11520 \$6177 \$6174 \$6178 VGND sky130_fd_pr__nfet_01v8 L=0.15 W=0.36
+ AS=0.0594 AD=0.066 PS=0.69 PD=0.745
M$11521 \$6173 \$6354 \$6278 VGND sky130_fd_pr__nfet_01v8 L=0.15 W=0.42
+ AS=0.1092 AD=0.06405 PS=1.36 PD=0.725
M$11522 \$6278 RESET_B|X VGND VGND sky130_fd_pr__nfet_01v8 L=0.15 W=0.42
+ AS=0.06405 AD=0.12495 PS=0.725 PD=1.015
M$11523 VGND \$6173 \$6276 VGND sky130_fd_pr__nfet_01v8 L=0.15 W=0.42
+ AS=0.12495 AD=0.0669 PS=1.015 PD=0.75
M$11524 VGND RESET_B|X \$6267 VGND sky130_fd_pr__nfet_01v8 L=0.15 W=0.42
+ AS=0.1346 AD=0.0441 PS=1.15 PD=0.63
M$11525 \$6267 \$6176 \$6262 VGND sky130_fd_pr__nfet_01v8 L=0.15 W=0.42
+ AS=0.0441 AD=0.1401 PS=0.63 PD=1.1
M$11526 \$6178 D|Y VGND VGND sky130_fd_pr__nfet_01v8 L=0.15 W=0.42 AS=0.066
+ AD=0.2205 PS=0.745 PD=1.89
M$11527 \$6176 \$6177 VGND VGND sky130_fd_pr__nfet_01v8 L=0.15 W=0.64 AS=0.0999
+ AD=0.1346 PS=0.985 PD=1.15
M$11529 \$6175 \$6174 VGND VGND sky130_fd_pr__nfet_01v8 L=0.15 W=0.42 AS=0.1092
+ AD=0.0567 PS=1.36 PD=0.69
M$11530 VGND CLK|TICK \$6174 VGND sky130_fd_pr__nfet_01v8 L=0.15 W=0.42
+ AS=0.0567 AD=0.1092 PS=0.69 PD=1.36
M$11542 \$6468 A|FINE_MUX[13] VGND VGND sky130_fd_pr__nfet_01v8 L=0.15 W=0.42
+ AS=0.1134 AD=0.10435 PS=1.38 PD=1.01
M$11543 VGND \$6468 \$6469 VGND sky130_fd_pr__nfet_01v8 L=0.5 W=0.65 AS=0.10435
+ AD=0.169 PS=1.01 PD=1.82
M$11544 VGND \$6470 A|B1|X VGND sky130_fd_pr__nfet_01v8 L=0.15 W=0.42 AS=0.097
+ AD=0.1491 PS=0.975 PD=1.55
M$11545 \$6470 \$6469 VGND VGND sky130_fd_pr__nfet_01v8 L=0.5 W=0.65 AS=0.17225
+ AD=0.097 PS=1.83 PD=0.975
M$11548 VGND A2|B|X \$6504 VGND sky130_fd_pr__nfet_01v8 L=0.15 W=0.65
+ AS=0.17225 AD=0.095875 PS=1.83 PD=0.945
M$11549 \$6504 A|A1|C|Y A|Y VGND sky130_fd_pr__nfet_01v8 L=0.15 W=0.65
+ AS=0.095875 AD=0.091 PS=0.945 PD=0.93
M$11551 VGND A2|B|X \$6475 VGND sky130_fd_pr__nfet_01v8 L=0.15 W=0.65 AS=0.169
+ AD=0.08775 PS=1.82 PD=0.92
M$11552 \$6475 A|A1|C|Y VGND VGND sky130_fd_pr__nfet_01v8 L=0.15 W=0.65
+ AS=0.08775 AD=0.08775 PS=0.92 PD=0.92
M$11553 VGND A|A1|C|Y \$6511 VGND sky130_fd_pr__nfet_01v8 L=0.15 W=0.65
+ AS=0.08775 AD=0.08775 PS=0.92 PD=0.92
M$11554 \$6511 A2|B|X A|A2|B|B_N|X VGND sky130_fd_pr__nfet_01v8 L=0.15 W=0.65
+ AS=0.08775 AD=0.25025 PS=0.92 PD=1.42
M$11555 A|A2|B|B_N|X \$6475 VGND VGND sky130_fd_pr__nfet_01v8 L=0.15 W=0.65
+ AS=0.25025 AD=0.208 PS=1.42 PD=1.94
M$11557 VGND B|D|X \$6460 VGND sky130_fd_pr__nfet_01v8 L=0.15 W=0.65 AS=0.169
+ AD=0.08775 PS=1.82 PD=0.92
M$11558 \$6460 A|A2|B|B_N|X A2|B|Y VGND sky130_fd_pr__nfet_01v8 L=0.15 W=0.65
+ AS=0.08775 AD=0.169 PS=0.92 PD=1.82
M$11559 VGND A|A2|B|B_N|X \$6476 VGND sky130_fd_pr__nfet_01v8 L=0.15 W=0.42
+ AS=0.10025 AD=0.1092 PS=0.985 PD=1.36
M$11560 VGND \$6476 B1|Y VGND sky130_fd_pr__nfet_01v8 L=0.15 W=0.65 AS=0.169
+ AD=0.08775 PS=1.82 PD=0.92
M$11561 B1|Y A|Y VGND VGND sky130_fd_pr__nfet_01v8 L=0.15 W=1.3 AS=0.1755
+ AD=0.26925 PS=1.84 PD=2.805
M$11564 VGND A|A1|B|X \$6478 VGND sky130_fd_pr__nfet_01v8 L=0.15 W=0.65
+ AS=0.169 AD=0.08775 PS=1.82 PD=0.92
M$11565 \$6478 A|B1|X VGND VGND sky130_fd_pr__nfet_01v8 L=0.15 W=0.65
+ AS=0.08775 AD=0.08775 PS=0.92 PD=0.92
M$11566 VGND A|B1|X \$6521 VGND sky130_fd_pr__nfet_01v8 L=0.15 W=0.65
+ AS=0.08775 AD=0.08775 PS=0.92 PD=0.92
M$11567 \$6521 A|A1|B|X A1|B|SLEEP|X VGND sky130_fd_pr__nfet_01v8 L=0.15 W=0.65
+ AS=0.08775 AD=0.25025 PS=0.92 PD=1.42
M$11568 A1|B|SLEEP|X \$6478 VGND VGND sky130_fd_pr__nfet_01v8 L=0.15 W=0.65
+ AS=0.25025 AD=0.208 PS=1.42 PD=1.94
M$11569 VGND A|A1|B|X \$6446 VGND sky130_fd_pr__nfet_01v8 L=0.15 W=0.65
+ AS=0.169 AD=0.08775 PS=1.82 PD=0.92
M$11570 \$6446 A2|B|Y VGND VGND sky130_fd_pr__nfet_01v8 L=0.15 W=0.65
+ AS=0.08775 AD=0.08775 PS=0.92 PD=0.92
M$11571 VGND A3|Y \$6446 VGND sky130_fd_pr__nfet_01v8 L=0.15 W=0.65 AS=0.08775
+ AD=0.19825 PS=0.92 PD=1.26
M$11572 \$6446 A|B1|X B|C|Y VGND sky130_fd_pr__nfet_01v8 L=0.15 W=0.65
+ AS=0.19825 AD=0.221 PS=1.26 PD=1.98
M$11576 VGND B|C_N|Y \$6394 VGND sky130_fd_pr__nfet_01v8 L=0.15 W=0.42
+ AS=0.1092 AD=0.1092 PS=1.36 PD=1.36
M$11577 \$6395 \$6394 VGND VGND sky130_fd_pr__nfet_01v8 L=0.15 W=0.42 AS=0.1092
+ AD=0.0567 PS=1.36 PD=0.69
M$11578 VGND A_N|B|Y \$6395 VGND sky130_fd_pr__nfet_01v8 L=0.15 W=0.42
+ AS=0.0567 AD=0.0567 PS=0.69 PD=0.69
M$11579 VGND A|Y \$6395 VGND sky130_fd_pr__nfet_01v8 L=0.15 W=0.42 AS=0.10025
+ AD=0.0567 PS=0.985 PD=0.69
M$11580 VGND \$6395 A2|B|C|X VGND sky130_fd_pr__nfet_01v8 L=0.15 W=0.65
+ AS=0.10025 AD=0.17875 PS=0.985 PD=1.85
M$11581 VGND B|Y \$6531 VGND sky130_fd_pr__nfet_01v8 L=0.15 W=0.65 AS=0.169
+ AD=0.08775 PS=1.82 PD=0.92
M$11582 \$6531 A|Y A|A1|B|Y VGND sky130_fd_pr__nfet_01v8 L=0.15 W=0.65
+ AS=0.08775 AD=0.169 PS=0.92 PD=1.82
M$11587 \$6481 A|A1|X VGND VGND sky130_fd_pr__nfet_01v8 L=0.15 W=0.42 AS=0.1113
+ AD=0.0588 PS=1.37 PD=0.7
M$11588 VGND A2|B|Y \$6481 VGND sky130_fd_pr__nfet_01v8 L=0.15 W=0.42 AS=0.0588
+ AD=0.0588 PS=0.7 PD=0.7
M$11589 \$6481 A_N|B1|C|Y C|Y VGND sky130_fd_pr__nfet_01v8 L=0.15 W=0.42
+ AS=0.0588 AD=0.1113 PS=0.7 PD=1.37
M$11594 \$6129 \$6131 \$6130 VGND sky130_fd_pr__nfet_01v8 L=0.15 W=0.64
+ AS=0.224 AD=0.0928 PS=1.98 PD=0.93
M$11595 \$6130 B|C|X \$6128 VGND sky130_fd_pr__nfet_01v8 L=0.15 W=0.64
+ AS=0.0928 AD=0.1728 PS=0.93 PD=1.82
M$11599 \$6484 A|A1|B|X \$6552 VGND sky130_fd_pr__nfet_01v8 L=0.15 W=0.42
+ AS=0.1092 AD=0.0441 PS=1.36 PD=0.63
M$11600 \$6552 A2|B|Y \$6553 VGND sky130_fd_pr__nfet_01v8 L=0.15 W=0.42
+ AS=0.0441 AD=0.0441 PS=0.63 PD=0.63
M$11601 \$6553 A2|B|C|X VGND VGND sky130_fd_pr__nfet_01v8 L=0.15 W=0.42
+ AS=0.0441 AD=0.13165 PS=0.63 PD=1.14
M$11602 VGND \$6484 A|B1|X VGND sky130_fd_pr__nfet_01v8 L=0.15 W=0.65
+ AS=0.13165 AD=0.169 PS=1.14 PD=1.82
M$11605 VGND A|B1|X \$6398 VGND sky130_fd_pr__nfet_01v8 L=0.15 W=0.42
+ AS=0.10025 AD=0.1092 PS=0.985 PD=1.36
M$11606 VGND A2|B|SLEEP|X A|X VGND sky130_fd_pr__nfet_01v8 L=0.15 W=0.65
+ AS=0.10025 AD=0.08775 PS=0.985 PD=0.92
M$11607 A|X \$6398 VGND VGND sky130_fd_pr__nfet_01v8 L=0.15 W=0.65 AS=0.08775
+ AD=0.169 PS=0.92 PD=1.82
M$11611 A|Y A2|B|SLEEP|X VGND VGND sky130_fd_pr__nfet_01v8 L=0.15 W=0.65
+ AS=0.08775 AD=0.169 PS=0.92 PD=1.82
M$11613 VGND A3|B|C|Y \$6400 VGND sky130_fd_pr__nfet_01v8 L=0.15 W=0.65
+ AS=0.169 AD=0.08775 PS=1.82 PD=0.92
M$11614 \$6400 A|Y VGND VGND sky130_fd_pr__nfet_01v8 L=0.15 W=0.65 AS=0.08775
+ AD=0.08775 PS=0.92 PD=0.92
M$11615 VGND A|Y \$6467 VGND sky130_fd_pr__nfet_01v8 L=0.15 W=0.65 AS=0.08775
+ AD=0.08775 PS=0.92 PD=0.92
M$11616 \$6467 A3|B|C|Y A|X VGND sky130_fd_pr__nfet_01v8 L=0.15 W=0.65
+ AS=0.08775 AD=0.25025 PS=0.92 PD=1.42
M$11617 A|X \$6400 VGND VGND sky130_fd_pr__nfet_01v8 L=0.15 W=0.65 AS=0.25025
+ AD=0.208 PS=1.42 PD=1.94
M$11620 \$6403 B|SLEEP|X \$6466 VGND sky130_fd_pr__nfet_01v8 L=0.15 W=0.65
+ AS=0.169 AD=0.06825 PS=1.82 PD=0.86
M$11621 \$6466 A|X VGND VGND sky130_fd_pr__nfet_01v8 L=0.15 W=0.65 AS=0.06825
+ AD=0.08775 PS=0.86 PD=0.92
M$11622 VGND A|X \$6447 VGND sky130_fd_pr__nfet_01v8 L=0.15 W=0.65 AS=0.08775
+ AD=0.169 PS=0.92 PD=1.82
M$11623 VGND B|SLEEP|X \$6447 VGND sky130_fd_pr__nfet_01v8 L=0.15 W=0.65
+ AS=0.169 AD=0.08775 PS=1.82 PD=0.92
M$11624 \$6447 \$6403 A|B|Y VGND sky130_fd_pr__nfet_01v8 L=0.15 W=0.65
+ AS=0.08775 AD=0.195 PS=0.92 PD=1.9
M$11627 VGND A1|B1_N|Y \$6144 VGND sky130_fd_pr__nfet_01v8 L=0.15 W=0.42
+ AS=0.1092 AD=0.1092 PS=1.36 PD=1.36
M$11632 A1|Y B|X VGND VGND sky130_fd_pr__nfet_01v8 L=0.15 W=0.65 AS=0.08775
+ AD=0.169 PS=0.92 PD=1.82
M$11636 A|A1|Y A|B|Y \$6586 VGND sky130_fd_pr__nfet_01v8 L=0.15 W=0.65 AS=0.169
+ AD=0.10725 PS=1.82 PD=0.98
M$11637 \$6586 B|C|X \$6588 VGND sky130_fd_pr__nfet_01v8 L=0.15 W=0.65
+ AS=0.10725 AD=0.08775 PS=0.98 PD=0.92
M$11638 \$6588 B|C|X VGND VGND sky130_fd_pr__nfet_01v8 L=0.15 W=0.65 AS=0.08775
+ AD=0.169 PS=0.92 PD=1.82
M$11640 VGND B|C|X \$6464 VGND sky130_fd_pr__nfet_01v8 L=0.15 W=0.65 AS=0.169
+ AD=0.08775 PS=1.82 PD=0.92
M$11641 \$6464 A|Y B|Y VGND sky130_fd_pr__nfet_01v8 L=0.15 W=0.65 AS=0.08775
+ AD=0.169 PS=0.92 PD=1.82
M$11642 \$6410 A|B|X \$6406 VGND sky130_fd_pr__nfet_01v8 L=0.15 W=0.64
+ AS=0.140825 AD=0.19265 PS=1.1 PD=1.285
M$11643 \$6406 \$6448 \$6409 VGND sky130_fd_pr__nfet_01v8 L=0.15 W=0.42
+ AS=0.19265 AD=0.18205 PS=1.285 PD=1.245
M$11644 \$6409 A|B|X \$6407 VGND sky130_fd_pr__nfet_01v8 L=0.15 W=0.64
+ AS=0.18205 AD=0.16275 PS=1.245 PD=1.8
M$11645 \$6406 \$6407 VGND VGND sky130_fd_pr__nfet_01v8 L=0.15 W=0.64 AS=0.1824
+ AD=0.0864 PS=1.85 PD=0.91
M$11646 VGND A|Y \$6407 VGND sky130_fd_pr__nfet_01v8 L=0.15 W=0.64 AS=0.0864
+ AD=0.11 PS=0.91 PD=0.99
M$11647 \$6410 \$6448 \$6407 VGND sky130_fd_pr__nfet_01v8 L=0.15 W=0.6
+ AS=0.140825 AD=0.11 PS=1.1 PD=0.99
M$11649 \$6448 A|B|X VGND VGND sky130_fd_pr__nfet_01v8 L=0.15 W=0.65 AS=0.16515
+ AD=0.1885 PS=1.82 PD=1.88
M$11651 \$6409 \$6412 \$6411 VGND sky130_fd_pr__nfet_01v8 L=0.15 W=0.64
+ AS=0.224 AD=0.0928 PS=1.98 PD=0.93
M$11652 \$6411 B|C|X \$6410 VGND sky130_fd_pr__nfet_01v8 L=0.15 W=0.64
+ AS=0.0928 AD=0.1728 PS=0.93 PD=1.82
M$11653 \$6412 B|C|X VGND VGND sky130_fd_pr__nfet_01v8 L=0.15 W=0.42 AS=0.1785
+ AD=0.1165 PS=1.69 PD=1.035
M$11654 VGND \$6411 A|B|X VGND sky130_fd_pr__nfet_01v8 L=0.15 W=0.65 AS=0.1165
+ AD=0.169 PS=1.035 PD=1.82
M$11655 \$6417 A|B|X \$6414 VGND sky130_fd_pr__nfet_01v8 L=0.15 W=0.64
+ AS=0.140825 AD=0.19265 PS=1.1 PD=1.285
M$11656 \$6414 \$6449 \$6416 VGND sky130_fd_pr__nfet_01v8 L=0.15 W=0.42
+ AS=0.19265 AD=0.18365 PS=1.285 PD=1.25
M$11657 \$6416 A|B|X \$6415 VGND sky130_fd_pr__nfet_01v8 L=0.15 W=0.64
+ AS=0.18365 AD=0.1628 PS=1.25 PD=1.8
M$11658 \$6414 \$6415 VGND VGND sky130_fd_pr__nfet_01v8 L=0.15 W=0.64 AS=0.1824
+ AD=0.0864 PS=1.85 PD=0.91
M$11659 VGND A|B|Y \$6415 VGND sky130_fd_pr__nfet_01v8 L=0.15 W=0.64 AS=0.0864
+ AD=0.11 PS=0.91 PD=0.99
M$11660 \$6417 \$6449 \$6415 VGND sky130_fd_pr__nfet_01v8 L=0.15 W=0.6
+ AS=0.140825 AD=0.11 PS=1.1 PD=0.99
M$11662 \$6449 A|B|X VGND VGND sky130_fd_pr__nfet_01v8 L=0.15 W=0.65 AS=0.1653
+ AD=0.195 PS=1.82 PD=1.9
M$11663 \$6417 \$6419 \$6418 VGND sky130_fd_pr__nfet_01v8 L=0.15 W=0.64
+ AS=0.3168 AD=0.128 PS=2.27 PD=1.04
M$11664 \$6418 B|C|X \$6416 VGND sky130_fd_pr__nfet_01v8 L=0.15 W=0.64 AS=0.128
+ AD=0.1728 PS=1.04 PD=1.82
M$11666 \$6419 B|C|X VGND VGND sky130_fd_pr__nfet_01v8 L=0.15 W=0.42 AS=0.1764
+ AD=0.144125 PS=1.68 PD=1.12
M$11667 VGND \$6418 B|B_N|X VGND sky130_fd_pr__nfet_01v8 L=0.15 W=0.65
+ AS=0.144125 AD=0.169 PS=1.12 PD=1.82
M$11669 \$6421 B|B_N|X \$6462 VGND sky130_fd_pr__nfet_01v8 L=0.15 W=0.65
+ AS=0.169 AD=0.06825 PS=1.82 PD=0.86
M$11670 \$6462 A|Y VGND VGND sky130_fd_pr__nfet_01v8 L=0.15 W=0.65 AS=0.06825
+ AD=0.08775 PS=0.86 PD=0.92
M$11671 VGND A|Y \$6450 VGND sky130_fd_pr__nfet_01v8 L=0.15 W=0.65 AS=0.08775
+ AD=0.169 PS=0.92 PD=1.82
M$11673 VGND B|B_N|X \$6450 VGND sky130_fd_pr__nfet_01v8 L=0.15 W=0.65 AS=0.169
+ AD=0.08775 PS=1.82 PD=0.92
M$11674 \$6450 \$6421 C|Y VGND sky130_fd_pr__nfet_01v8 L=0.15 W=0.65 AS=0.08775
+ AD=0.195 PS=0.92 PD=1.9
M$11677 B|Y A|B|Y VGND VGND sky130_fd_pr__nfet_01v8 L=0.15 W=0.84 AS=0.2184
+ AD=0.2394 PS=2.72 PD=2.82
M$11678 \$6160 \$6162 \$6161 VGND sky130_fd_pr__nfet_01v8 L=0.15 W=0.64
+ AS=0.224 AD=0.0928 PS=1.98 PD=0.93
M$11679 \$6161 C|Y \$6159 VGND sky130_fd_pr__nfet_01v8 L=0.15 W=0.64 AS=0.0928
+ AD=0.1728 PS=0.93 PD=1.82
M$11682 VGND B|C|Y A|B|Y VGND sky130_fd_pr__nfet_01v8 L=0.15 W=0.65 AS=0.169
+ AD=0.08775 PS=1.82 PD=0.92
M$11684 VGND B|X \$6459 VGND sky130_fd_pr__nfet_01v8 L=0.15 W=0.65 AS=0.169
+ AD=0.08775 PS=1.82 PD=0.92
M$11685 \$6459 A|B|Y A|Y VGND sky130_fd_pr__nfet_01v8 L=0.15 W=0.65 AS=0.08775
+ AD=0.169 PS=0.92 PD=1.82
M$11691 \$6167 C|X \$6164 VGND sky130_fd_pr__nfet_01v8 L=0.15 W=0.64 AS=0.1728
+ AD=0.128 PS=1.82 PD=1.04
M$11692 \$6164 \$6166 \$6168 VGND sky130_fd_pr__nfet_01v8 L=0.15 W=0.64
+ AS=0.128 AD=0.3168 PS=1.04 PD=2.27
M$11695 B|X \$6422 VGND VGND sky130_fd_pr__nfet_01v8 L=0.15 W=0.65 AS=0.23725
+ AD=0.1474 PS=2.03 PD=1.215
M$11696 VGND B|C|X \$6457 VGND sky130_fd_pr__nfet_01v8 L=0.15 W=0.42 AS=0.1474
+ AD=0.0441 PS=1.215 PD=0.63
M$11697 \$6457 B|Y \$6422 VGND sky130_fd_pr__nfet_01v8 L=0.15 W=0.42 AS=0.0441
+ AD=0.0567 PS=0.63 PD=0.69
M$11698 \$6422 B|Y \$6458 VGND sky130_fd_pr__nfet_01v8 L=0.15 W=0.42 AS=0.0567
+ AD=0.0441 PS=0.69 PD=0.63
M$11699 \$6458 A|Q VGND VGND sky130_fd_pr__nfet_01v8 L=0.15 W=0.42 AS=0.0441
+ AD=0.0567 PS=0.63 PD=0.69
M$11700 VGND A|Q \$6456 VGND sky130_fd_pr__nfet_01v8 L=0.15 W=0.42 AS=0.0567
+ AD=0.0441 PS=0.69 PD=0.63
M$11701 \$6456 B|C|X \$6422 VGND sky130_fd_pr__nfet_01v8 L=0.15 W=0.42
+ AS=0.0441 AD=0.1092 PS=0.63 PD=1.36
M$11702 \$6491 B|Y \$6575 VGND sky130_fd_pr__nfet_01v8 L=0.15 W=0.65 AS=0.169
+ AD=0.06825 PS=1.82 PD=0.86
M$11703 \$6575 A|B|X VGND VGND sky130_fd_pr__nfet_01v8 L=0.15 W=0.65 AS=0.06825
+ AD=0.08775 PS=0.86 PD=0.92
M$11704 VGND A|B|X \$6493 VGND sky130_fd_pr__nfet_01v8 L=0.15 W=0.65 AS=0.08775
+ AD=0.169 PS=0.92 PD=1.82
M$11705 VGND B|Y \$6493 VGND sky130_fd_pr__nfet_01v8 L=0.15 W=0.65 AS=0.169
+ AD=0.08775 PS=1.82 PD=0.92
M$11706 \$6493 \$6491 D|Y VGND sky130_fd_pr__nfet_01v8 L=0.15 W=0.65 AS=0.08775
+ AD=0.195 PS=0.92 PD=1.9
M$11707 \$6424 B|C|X \$6455 VGND sky130_fd_pr__nfet_01v8 L=0.15 W=0.65 AS=0.169
+ AD=0.06825 PS=1.82 PD=0.86
M$11708 \$6455 A|Y VGND VGND sky130_fd_pr__nfet_01v8 L=0.15 W=0.65 AS=0.06825
+ AD=0.08775 PS=0.86 PD=0.92
M$11709 VGND A|Y \$6451 VGND sky130_fd_pr__nfet_01v8 L=0.15 W=0.65 AS=0.08775
+ AD=0.169 PS=0.92 PD=1.82
M$11711 VGND B|C|X \$6451 VGND sky130_fd_pr__nfet_01v8 L=0.15 W=0.65 AS=0.169
+ AD=0.08775 PS=1.82 PD=0.92
M$11712 \$6451 \$6424 D|Y VGND sky130_fd_pr__nfet_01v8 L=0.15 W=0.65 AS=0.08775
+ AD=0.195 PS=0.92 PD=1.9
M$11728 \$6640 B|D|X \$6734 VGND sky130_fd_pr__nfet_01v8 L=0.15 W=0.65 AS=0.169
+ AD=0.06825 PS=1.82 PD=0.86
M$11729 \$6734 A|Y VGND VGND sky130_fd_pr__nfet_01v8 L=0.15 W=0.65 AS=0.06825
+ AD=0.08775 PS=0.86 PD=0.92
M$11730 VGND A|Y \$6724 VGND sky130_fd_pr__nfet_01v8 L=0.15 W=0.65 AS=0.08775
+ AD=0.169 PS=0.92 PD=1.82
M$11731 VGND B|D|X \$6724 VGND sky130_fd_pr__nfet_01v8 L=0.15 W=0.65 AS=0.169
+ AD=0.08775 PS=1.82 PD=0.92
M$11732 \$6724 \$6640 A|B1|Y VGND sky130_fd_pr__nfet_01v8 L=0.15 W=0.65
+ AS=0.08775 AD=0.195 PS=0.92 PD=1.9
M$11733 A|Y A|B1|X \$6735 VGND sky130_fd_pr__nfet_01v8 L=0.15 W=0.65 AS=0.169
+ AD=0.08775 PS=1.82 PD=0.92
M$11734 \$6735 B|Y VGND VGND sky130_fd_pr__nfet_01v8 L=0.15 W=0.65 AS=0.08775
+ AD=0.169 PS=0.92 PD=1.82
M$11738 VGND A|A1|X A|B|Y VGND sky130_fd_pr__nfet_01v8 L=0.15 W=0.65 AS=0.169
+ AD=0.08775 PS=1.82 PD=0.92
M$11739 A|B|Y A2|B|Y VGND VGND sky130_fd_pr__nfet_01v8 L=0.15 W=0.65 AS=0.08775
+ AD=0.169 PS=0.92 PD=1.82
M$11741 \$6645 A_N|B1|C|Y VGND VGND sky130_fd_pr__nfet_01v8 L=0.15 W=0.42
+ AS=0.1092 AD=0.10025 PS=1.36 PD=0.985
M$11742 VGND A1|B|Y \$6738 VGND sky130_fd_pr__nfet_01v8 L=0.15 W=0.65
+ AS=0.10025 AD=0.08775 PS=0.985 PD=0.92
M$11743 \$6738 \$6645 A|B1|Y VGND sky130_fd_pr__nfet_01v8 L=0.15 W=0.65
+ AS=0.08775 AD=0.169 PS=0.92 PD=1.82
M$11744 \$6647 A_N|B1|C|Y VGND VGND sky130_fd_pr__nfet_01v8 L=0.15 W=0.42
+ AS=0.1092 AD=0.10025 PS=1.36 PD=0.985
M$11745 VGND A|B|Y \$6740 VGND sky130_fd_pr__nfet_01v8 L=0.15 W=0.65 AS=0.10025
+ AD=0.08775 PS=0.985 PD=0.92
M$11746 \$6740 \$6647 A|B|Y VGND sky130_fd_pr__nfet_01v8 L=0.15 W=0.65
+ AS=0.08775 AD=0.169 PS=0.92 PD=1.82
M$11748 VGND B|B_N|C|X \$6649 VGND sky130_fd_pr__nfet_01v8 L=0.15 W=0.42
+ AS=0.10025 AD=0.1092 PS=0.985 PD=1.36
M$11749 VGND A|B1|Y A|A1|B1|Y VGND sky130_fd_pr__nfet_01v8 L=0.15 W=0.65
+ AS=0.10025 AD=0.08775 PS=0.985 PD=0.92
M$11750 A|A1|B1|Y \$6649 VGND VGND sky130_fd_pr__nfet_01v8 L=0.15 W=0.65
+ AS=0.08775 AD=0.169 PS=0.92 PD=1.82
M$11751 \$6650 B|B_N|C|X \$6746 VGND sky130_fd_pr__nfet_01v8 L=0.15 W=0.65
+ AS=0.169 AD=0.06825 PS=1.82 PD=0.86
M$11752 \$6746 A|B1|Y VGND VGND sky130_fd_pr__nfet_01v8 L=0.15 W=0.65
+ AS=0.06825 AD=0.08775 PS=0.86 PD=0.92
M$11753 VGND A|B1|Y \$6726 VGND sky130_fd_pr__nfet_01v8 L=0.15 W=0.65
+ AS=0.08775 AD=0.169 PS=0.92 PD=1.82
M$11754 VGND B|B_N|C|X \$6726 VGND sky130_fd_pr__nfet_01v8 L=0.15 W=0.65
+ AS=0.169 AD=0.08775 PS=1.82 PD=0.92
M$11755 \$6726 \$6650 A2|B|Y VGND sky130_fd_pr__nfet_01v8 L=0.15 W=0.65
+ AS=0.08775 AD=0.195 PS=0.92 PD=1.9
M$11756 \$6651 A2|B|C|X \$6747 VGND sky130_fd_pr__nfet_01v8 L=0.15 W=0.65
+ AS=0.169 AD=0.06825 PS=1.82 PD=0.86
M$11757 \$6747 A|Y VGND VGND sky130_fd_pr__nfet_01v8 L=0.15 W=0.65 AS=0.06825
+ AD=0.08775 PS=0.86 PD=0.92
M$11758 VGND A|Y \$6727 VGND sky130_fd_pr__nfet_01v8 L=0.15 W=0.65 AS=0.08775
+ AD=0.169 PS=0.92 PD=1.82
M$11759 VGND A2|B|C|X \$6727 VGND sky130_fd_pr__nfet_01v8 L=0.15 W=0.65
+ AS=0.169 AD=0.08775 PS=1.82 PD=0.92
M$11760 \$6727 \$6651 A2|B|Y VGND sky130_fd_pr__nfet_01v8 L=0.15 W=0.65
+ AS=0.08775 AD=0.195 PS=0.92 PD=1.9
M$11763 A|Y A|A1|B1|X \$6748 VGND sky130_fd_pr__nfet_01v8 L=0.15 W=0.65
+ AS=0.091 AD=0.095875 PS=0.93 PD=0.945
M$11764 \$6748 A2|B|Y VGND VGND sky130_fd_pr__nfet_01v8 L=0.15 W=0.65
+ AS=0.095875 AD=0.17225 PS=0.945 PD=1.83
M$11765 VGND A2|B|Y \$6750 VGND sky130_fd_pr__nfet_01v8 L=0.15 W=0.65 AS=0.169
+ AD=0.08775 PS=1.82 PD=0.92
M$11766 \$6750 A|A1|B1|X A|A1|Y VGND sky130_fd_pr__nfet_01v8 L=0.15 W=0.65
+ AS=0.08775 AD=0.169 PS=0.92 PD=1.82
M$11767 \$6655 A2|B|SLEEP|X \$6751 VGND sky130_fd_pr__nfet_01v8 L=0.15 W=0.65
+ AS=0.169 AD=0.06825 PS=1.82 PD=0.86
M$11768 \$6751 A|Y VGND VGND sky130_fd_pr__nfet_01v8 L=0.15 W=0.65 AS=0.06825
+ AD=0.08775 PS=0.86 PD=0.92
M$11769 VGND A|Y \$6728 VGND sky130_fd_pr__nfet_01v8 L=0.15 W=0.65 AS=0.08775
+ AD=0.169 PS=0.92 PD=1.82
M$11770 VGND A2|B|SLEEP|X \$6728 VGND sky130_fd_pr__nfet_01v8 L=0.15 W=0.65
+ AS=0.169 AD=0.08775 PS=1.82 PD=0.92
M$11771 \$6728 \$6655 B|C|Y VGND sky130_fd_pr__nfet_01v8 L=0.15 W=0.65
+ AS=0.08775 AD=0.195 PS=0.92 PD=1.9
M$11773 \$6658 B|Y \$6754 VGND sky130_fd_pr__nfet_01v8 L=0.15 W=0.65 AS=0.169
+ AD=0.06825 PS=1.82 PD=0.86
M$11774 \$6754 A|B|Y VGND VGND sky130_fd_pr__nfet_01v8 L=0.15 W=0.65 AS=0.06825
+ AD=0.08775 PS=0.86 PD=0.92
M$11775 VGND A|B|Y \$6729 VGND sky130_fd_pr__nfet_01v8 L=0.15 W=0.65 AS=0.08775
+ AD=0.169 PS=0.92 PD=1.82
M$11776 VGND B|Y \$6729 VGND sky130_fd_pr__nfet_01v8 L=0.15 W=0.65 AS=0.169
+ AD=0.08775 PS=1.82 PD=0.92
M$11777 \$6729 \$6658 B|Y VGND sky130_fd_pr__nfet_01v8 L=0.15 W=0.65 AS=0.08775
+ AD=0.195 PS=0.92 PD=1.9
M$11782 A|Y A|X \$6757 VGND sky130_fd_pr__nfet_01v8 L=0.15 W=0.65 AS=0.169
+ AD=0.08775 PS=1.82 PD=0.92
M$11783 \$6757 B|Y VGND VGND sky130_fd_pr__nfet_01v8 L=0.15 W=0.65 AS=0.08775
+ AD=0.169 PS=0.92 PD=1.82
M$11784 \$6662 A|B|C|Y \$6758 VGND sky130_fd_pr__nfet_01v8 L=0.15 W=0.65
+ AS=0.169 AD=0.06825 PS=1.82 PD=0.86
M$11785 \$6758 A|X VGND VGND sky130_fd_pr__nfet_01v8 L=0.15 W=0.65 AS=0.06825
+ AD=0.08775 PS=0.86 PD=0.92
M$11786 VGND A|X \$6730 VGND sky130_fd_pr__nfet_01v8 L=0.15 W=0.65 AS=0.08775
+ AD=0.169 PS=0.92 PD=1.82
M$11787 VGND A|B|C|Y \$6730 VGND sky130_fd_pr__nfet_01v8 L=0.15 W=0.65 AS=0.169
+ AD=0.08775 PS=1.82 PD=0.92
M$11788 \$6730 \$6662 A|B|Y VGND sky130_fd_pr__nfet_01v8 L=0.15 W=0.65
+ AS=0.08775 AD=0.195 PS=0.92 PD=1.9
M$11793 VGND B|C|Y \$6764 VGND sky130_fd_pr__nfet_01v8 L=0.15 W=0.65 AS=0.169
+ AD=0.08775 PS=1.82 PD=0.92
M$11794 \$6764 A2|B|C|Y \$6765 VGND sky130_fd_pr__nfet_01v8 L=0.15 W=0.65
+ AS=0.08775 AD=0.10725 PS=0.92 PD=0.98
M$11795 \$6765 A|A1|B1|Y A|B|Y VGND sky130_fd_pr__nfet_01v8 L=0.15 W=0.65
+ AS=0.10725 AD=0.169 PS=0.98 PD=1.82
M$11797 VGND B|Y \$6766 VGND sky130_fd_pr__nfet_01v8 L=0.15 W=0.65 AS=0.169
+ AD=0.08775 PS=1.82 PD=0.92
M$11798 \$6766 A|B1_N|X A|Y VGND sky130_fd_pr__nfet_01v8 L=0.15 W=0.65
+ AS=0.08775 AD=0.169 PS=0.92 PD=1.82
M$11801 VGND B|Y \$6768 VGND sky130_fd_pr__nfet_01v8 L=0.15 W=0.65 AS=0.169
+ AD=0.08775 PS=1.82 PD=0.92
M$11802 \$6768 A|A_N|Y A|B|Y VGND sky130_fd_pr__nfet_01v8 L=0.15 W=0.65
+ AS=0.08775 AD=0.169 PS=0.92 PD=1.82
M$11803 VGND A|A1|Y A|A_N|Y VGND sky130_fd_pr__nfet_01v8 L=0.15 W=0.65 AS=0.169
+ AD=0.08775 PS=1.82 PD=0.92
M$11804 A|A_N|Y A2|B|C|X VGND VGND sky130_fd_pr__nfet_01v8 L=0.15 W=0.65
+ AS=0.08775 AD=0.169 PS=0.92 PD=1.82
M$11806 VGND A|Y A|C|Y VGND sky130_fd_pr__nfet_01v8 L=0.15 W=0.65 AS=0.169
+ AD=0.08775 PS=1.82 PD=0.92
M$11807 A|C|Y B|C|Y VGND VGND sky130_fd_pr__nfet_01v8 L=0.15 W=0.65 AS=0.08775
+ AD=0.169 PS=0.92 PD=1.82
M$11809 VGND \$6681 A|Q VGND sky130_fd_pr__nfet_01v8 L=0.15 W=0.65 AS=0.2087
+ AD=0.169 PS=2.02 PD=1.82
M$11818 \$6770 A|FINE_MUX[14] VGND VGND sky130_fd_pr__nfet_01v8 L=0.15 W=0.42
+ AS=0.1134 AD=0.10435 PS=1.38 PD=1.01
M$11819 VGND \$6770 \$6771 VGND sky130_fd_pr__nfet_01v8 L=0.5 W=0.65 AS=0.10435
+ AD=0.169 PS=1.01 PD=1.82
M$11820 VGND \$6772 A|B1|X VGND sky130_fd_pr__nfet_01v8 L=0.15 W=0.42 AS=0.097
+ AD=0.1491 PS=0.975 PD=1.55
M$11821 \$6772 \$6771 VGND VGND sky130_fd_pr__nfet_01v8 L=0.5 W=0.65 AS=0.17225
+ AD=0.097 PS=1.83 PD=0.975
M$11826 VGND A1|B|SLEEP|X \$6774 VGND sky130_fd_pr__nfet_01v8 L=0.15 W=0.65
+ AS=0.169 AD=0.08775 PS=1.82 PD=0.92
M$11827 \$6774 A2|B|Y VGND VGND sky130_fd_pr__nfet_01v8 L=0.15 W=0.65
+ AS=0.08775 AD=0.08775 PS=0.92 PD=0.92
M$11828 VGND A3|A4|X \$6774 VGND sky130_fd_pr__nfet_01v8 L=0.15 W=0.65
+ AS=0.08775 AD=0.19825 PS=0.92 PD=1.26
M$11829 \$6774 A|B1|X A2|B|Y VGND sky130_fd_pr__nfet_01v8 L=0.15 W=0.65
+ AS=0.19825 AD=0.221 PS=1.26 PD=1.98
M$11831 \$6775 \$6777 \$6779 VGND sky130_fd_pr__nfet_01v8 L=0.15 W=0.42
+ AS=0.19265 AD=0.18205 PS=1.285 PD=1.245
M$11832 \$6776 \$6777 \$6778 VGND sky130_fd_pr__nfet_01v8 L=0.15 W=0.6 AS=0.11
+ AD=0.140825 PS=0.99 PD=1.1
M$11833 \$6775 \$6776 VGND VGND sky130_fd_pr__nfet_01v8 L=0.15 W=0.64 AS=0.1824
+ AD=0.0864 PS=1.85 PD=0.91
M$11834 VGND A|A1|X \$6776 VGND sky130_fd_pr__nfet_01v8 L=0.15 W=0.64 AS=0.0864
+ AD=0.11 PS=0.91 PD=0.99
M$11835 \$6778 A2|B|Y \$6775 VGND sky130_fd_pr__nfet_01v8 L=0.15 W=0.64
+ AS=0.140825 AD=0.19265 PS=1.1 PD=1.285
M$11836 \$6779 A2|B|Y \$6776 VGND sky130_fd_pr__nfet_01v8 L=0.15 W=0.64
+ AS=0.18205 AD=0.16275 PS=1.245 PD=1.8
M$11837 \$6642 A|A1|X \$6737 VGND sky130_fd_pr__nfet_01v8 L=0.15 W=0.42
+ AS=0.1113 AD=0.0441 PS=1.37 PD=0.63
M$11838 \$6737 A2|B|Y VGND VGND sky130_fd_pr__nfet_01v8 L=0.15 W=0.42 AS=0.0441
+ AD=0.0966 PS=0.63 PD=0.88
M$11839 VGND \$6642 B|X VGND sky130_fd_pr__nfet_01v8 L=0.15 W=0.42 AS=0.0966
+ AD=0.1113 PS=0.88 PD=1.37
M$11840 \$6777 A2|B|Y VGND VGND sky130_fd_pr__nfet_01v8 L=0.15 W=0.65
+ AS=0.16515 AD=0.1885 PS=1.82 PD=1.88
M$11841 VGND C|Y \$6782 VGND sky130_fd_pr__nfet_01v8 L=0.15 W=0.42 AS=0.1165
+ AD=0.1785 PS=1.035 PD=1.69
M$11842 VGND \$6781 A|X VGND sky130_fd_pr__nfet_01v8 L=0.15 W=0.65 AS=0.1165
+ AD=0.169 PS=1.035 PD=1.82
M$11844 A2|X \$6785 VGND VGND sky130_fd_pr__nfet_01v8 L=0.15 W=0.65 AS=0.169
+ AD=0.1165 PS=1.82 PD=1.035
M$11845 VGND A_N|B1|C|Y \$6786 VGND sky130_fd_pr__nfet_01v8 L=0.15 W=0.42
+ AS=0.1165 AD=0.1785 PS=1.035 PD=1.69
M$11846 VGND A|B|X \$6789 VGND sky130_fd_pr__nfet_01v8 L=0.15 W=0.65 AS=0.1885
+ AD=0.16515 PS=1.88 PD=1.82
M$11847 \$6648 A|B|X \$6741 VGND sky130_fd_pr__nfet_01v8 L=0.15 W=0.42
+ AS=0.1092 AD=0.0441 PS=1.36 PD=0.63
M$11848 \$6741 A|B|Y \$6742 VGND sky130_fd_pr__nfet_01v8 L=0.15 W=0.42
+ AS=0.0441 AD=0.0441 PS=0.63 PD=0.63
M$11849 VGND C|Y \$6742 VGND sky130_fd_pr__nfet_01v8 L=0.15 W=0.42 AS=0.13165
+ AD=0.0441 PS=1.14 PD=0.63
M$11850 VGND \$6648 A|A1|B|X VGND sky130_fd_pr__nfet_01v8 L=0.15 W=0.65
+ AS=0.13165 AD=0.169 PS=1.14 PD=1.82
M$11851 \$6788 \$6789 \$6791 VGND sky130_fd_pr__nfet_01v8 L=0.15 W=0.42
+ AS=0.18205 AD=0.19265 PS=1.245 PD=1.285
M$11852 \$6787 \$6789 \$6790 VGND sky130_fd_pr__nfet_01v8 L=0.15 W=0.6
+ AS=0.140825 AD=0.11 PS=1.1 PD=0.99
M$11853 \$6790 A|B|Y VGND VGND sky130_fd_pr__nfet_01v8 L=0.15 W=0.64 AS=0.11
+ AD=0.0864 PS=0.99 PD=0.91
M$11854 VGND \$6790 \$6791 VGND sky130_fd_pr__nfet_01v8 L=0.15 W=0.64 AS=0.0864
+ AD=0.1824 PS=0.91 PD=1.85
M$11855 \$6790 A|B|X \$6788 VGND sky130_fd_pr__nfet_01v8 L=0.15 W=0.64
+ AS=0.16275 AD=0.18205 PS=1.8 PD=1.245
M$11856 \$6787 A|B|X \$6791 VGND sky130_fd_pr__nfet_01v8 L=0.15 W=0.64
+ AS=0.140825 AD=0.19265 PS=1.1 PD=1.285
M$11858 VGND A|A1|B1|Y A|Y VGND sky130_fd_pr__nfet_01v8 L=0.15 W=0.65
+ AS=0.17225 AD=0.091 PS=1.83 PD=0.93
M$11859 A|Y A|A1|B|X \$6883 VGND sky130_fd_pr__nfet_01v8 L=0.15 W=0.65 AS=0.091
+ AD=0.095875 PS=0.93 PD=0.945
M$11860 \$6883 A2|B|Y VGND VGND sky130_fd_pr__nfet_01v8 L=0.15 W=0.65
+ AS=0.095875 AD=0.17225 PS=0.945 PD=1.83
M$11863 VGND A2|B|Y \$6792 VGND sky130_fd_pr__nfet_01v8 L=0.15 W=0.65 AS=0.169
+ AD=0.08775 PS=1.82 PD=0.92
M$11864 \$6792 A|A1|B1|X VGND VGND sky130_fd_pr__nfet_01v8 L=0.15 W=0.65
+ AS=0.08775 AD=0.08775 PS=0.92 PD=0.92
M$11865 VGND A|A1|B1|X \$6895 VGND sky130_fd_pr__nfet_01v8 L=0.15 W=0.65
+ AS=0.08775 AD=0.08775 PS=0.92 PD=0.92
M$11866 \$6895 A2|B|Y B|X VGND sky130_fd_pr__nfet_01v8 L=0.15 W=0.65 AS=0.08775
+ AD=0.25025 PS=0.92 PD=1.42
M$11867 B|X \$6792 VGND VGND sky130_fd_pr__nfet_01v8 L=0.15 W=0.65 AS=0.25025
+ AD=0.208 PS=1.42 PD=1.94
M$11869 VGND A|A_N|Y \$6793 VGND sky130_fd_pr__nfet_01v8 L=0.15 W=0.42
+ AS=0.10025 AD=0.1092 PS=0.985 PD=1.36
M$11870 VGND B|X \$6902 VGND sky130_fd_pr__nfet_01v8 L=0.15 W=0.65 AS=0.10025
+ AD=0.08775 PS=0.985 PD=0.92
M$11871 \$6902 \$6793 A|Y VGND sky130_fd_pr__nfet_01v8 L=0.15 W=0.65 AS=0.08775
+ AD=0.169 PS=0.92 PD=1.82
M$11872 \$6795 B|C|Y \$6904 VGND sky130_fd_pr__nfet_01v8 L=0.15 W=0.42
+ AS=0.1092 AD=0.0441 PS=1.36 PD=0.63
M$11873 \$6904 A|Y VGND VGND sky130_fd_pr__nfet_01v8 L=0.15 W=0.42 AS=0.0441
+ AD=0.0567 PS=0.63 PD=0.69
M$11874 VGND A|Y \$6906 VGND sky130_fd_pr__nfet_01v8 L=0.15 W=0.42 AS=0.0567
+ AD=0.0441 PS=0.69 PD=0.63
M$11875 \$6906 A|B|Y \$6795 VGND sky130_fd_pr__nfet_01v8 L=0.15 W=0.42
+ AS=0.0441 AD=0.0567 PS=0.63 PD=0.69
M$11876 \$6795 A|B|Y \$6907 VGND sky130_fd_pr__nfet_01v8 L=0.15 W=0.42
+ AS=0.0567 AD=0.0441 PS=0.69 PD=0.63
M$11877 \$6907 B|C|Y VGND VGND sky130_fd_pr__nfet_01v8 L=0.15 W=0.42 AS=0.0441
+ AD=0.1474 PS=0.63 PD=1.215
M$11878 VGND \$6795 B|SLEEP|X VGND sky130_fd_pr__nfet_01v8 L=0.15 W=0.65
+ AS=0.1474 AD=0.23725 PS=1.215 PD=2.03
M$11880 VGND B|Y \$6796 VGND sky130_fd_pr__nfet_01v8 L=0.15 W=0.65 AS=0.169
+ AD=0.08775 PS=1.82 PD=0.92
M$11881 \$6796 A|Y VGND VGND sky130_fd_pr__nfet_01v8 L=0.15 W=0.65 AS=0.08775
+ AD=0.08775 PS=0.92 PD=0.92
M$11882 VGND A|Y \$6914 VGND sky130_fd_pr__nfet_01v8 L=0.15 W=0.65 AS=0.08775
+ AD=0.08775 PS=0.92 PD=0.92
M$11883 \$6914 B|Y A|X VGND sky130_fd_pr__nfet_01v8 L=0.15 W=0.65 AS=0.08775
+ AD=0.25025 PS=0.92 PD=1.42
M$11884 A|X \$6796 VGND VGND sky130_fd_pr__nfet_01v8 L=0.15 W=0.65 AS=0.25025
+ AD=0.208 PS=1.42 PD=1.94
M$11885 \$6797 A|B|C|Y \$6916 VGND sky130_fd_pr__nfet_01v8 L=0.15 W=0.42
+ AS=0.1092 AD=0.0441 PS=1.36 PD=0.63
M$11886 \$6916 A|Y VGND VGND sky130_fd_pr__nfet_01v8 L=0.15 W=0.42 AS=0.0441
+ AD=0.0567 PS=0.63 PD=0.69
M$11887 VGND A|Y \$6919 VGND sky130_fd_pr__nfet_01v8 L=0.15 W=0.42 AS=0.0567
+ AD=0.0441 PS=0.69 PD=0.63
M$11888 \$6919 B|Y \$6797 VGND sky130_fd_pr__nfet_01v8 L=0.15 W=0.42 AS=0.0441
+ AD=0.0567 PS=0.63 PD=0.69
M$11889 \$6797 B|Y \$6920 VGND sky130_fd_pr__nfet_01v8 L=0.15 W=0.42 AS=0.0567
+ AD=0.0441 PS=0.69 PD=0.63
M$11890 \$6920 A|B|C|Y VGND VGND sky130_fd_pr__nfet_01v8 L=0.15 W=0.42
+ AS=0.0441 AD=0.1474 PS=0.63 PD=1.215
M$11891 VGND \$6797 B|X VGND sky130_fd_pr__nfet_01v8 L=0.15 W=0.65 AS=0.1474
+ AD=0.23725 PS=1.215 PD=2.03
M$11892 \$6798 \$6800 \$6802 VGND sky130_fd_pr__nfet_01v8 L=0.15 W=0.42
+ AS=0.19265 AD=0.18205 PS=1.285 PD=1.245
M$11893 \$6799 \$6800 \$6801 VGND sky130_fd_pr__nfet_01v8 L=0.15 W=0.6 AS=0.11
+ AD=0.140825 PS=0.99 PD=1.1
M$11894 \$6798 \$6799 VGND VGND sky130_fd_pr__nfet_01v8 L=0.15 W=0.64 AS=0.1824
+ AD=0.0864 PS=1.85 PD=0.91
M$11895 VGND A|X \$6799 VGND sky130_fd_pr__nfet_01v8 L=0.15 W=0.64 AS=0.0864
+ AD=0.11 PS=0.91 PD=0.99
M$11896 \$6801 B|Y \$6798 VGND sky130_fd_pr__nfet_01v8 L=0.15 W=0.64
+ AS=0.140825 AD=0.19265 PS=1.1 PD=1.285
M$11897 \$6802 B|Y \$6799 VGND sky130_fd_pr__nfet_01v8 L=0.15 W=0.64 AS=0.18205
+ AD=0.16275 PS=1.245 PD=1.8
M$11898 \$6800 B|Y VGND VGND sky130_fd_pr__nfet_01v8 L=0.15 W=0.65 AS=0.16515
+ AD=0.1885 PS=1.82 PD=1.88
M$11899 VGND B|C|X \$6804 VGND sky130_fd_pr__nfet_01v8 L=0.15 W=0.42 AS=0.1165
+ AD=0.1785 PS=1.035 PD=1.69
M$11900 VGND \$6803 A|B|C|X VGND sky130_fd_pr__nfet_01v8 L=0.15 W=0.65
+ AS=0.1165 AD=0.169 PS=1.035 PD=1.82
M$11902 \$6664 B|C|X \$6760 VGND sky130_fd_pr__nfet_01v8 L=0.15 W=0.42
+ AS=0.1092 AD=0.0441 PS=1.36 PD=0.63
M$11903 \$6760 A|Y VGND VGND sky130_fd_pr__nfet_01v8 L=0.15 W=0.42 AS=0.0441
+ AD=0.0567 PS=0.63 PD=0.69
M$11904 VGND A|Y \$6759 VGND sky130_fd_pr__nfet_01v8 L=0.15 W=0.42 AS=0.0567
+ AD=0.0441 PS=0.69 PD=0.63
M$11905 \$6759 A|B|Y \$6664 VGND sky130_fd_pr__nfet_01v8 L=0.15 W=0.42
+ AS=0.0441 AD=0.0567 PS=0.63 PD=0.69
M$11906 \$6664 A|B|Y \$6761 VGND sky130_fd_pr__nfet_01v8 L=0.15 W=0.42
+ AS=0.0567 AD=0.0441 PS=0.69 PD=0.63
M$11907 VGND B|C|X \$6761 VGND sky130_fd_pr__nfet_01v8 L=0.15 W=0.42 AS=0.1474
+ AD=0.0441 PS=1.215 PD=0.63
M$11908 VGND \$6664 A|B|X VGND sky130_fd_pr__nfet_01v8 L=0.15 W=0.65 AS=0.1474
+ AD=0.23725 PS=1.215 PD=2.03
M$11910 VGND A|B|C|X A|Y VGND sky130_fd_pr__nfet_01v8 L=0.15 W=1.95 AS=0.42575
+ AD=0.3445 PS=4.56 PD=3.66
M$11912 \$6806 B|C|Y \$6942 VGND sky130_fd_pr__nfet_01v8 L=0.15 W=0.65 AS=0.169
+ AD=0.06825 PS=1.82 PD=0.86
M$11913 \$6942 A|Y VGND VGND sky130_fd_pr__nfet_01v8 L=0.15 W=0.65 AS=0.06825
+ AD=0.08775 PS=0.86 PD=0.92
M$11914 VGND A|Y \$6807 VGND sky130_fd_pr__nfet_01v8 L=0.15 W=0.65 AS=0.08775
+ AD=0.169 PS=0.92 PD=1.82
M$11915 VGND B|C|Y \$6807 VGND sky130_fd_pr__nfet_01v8 L=0.15 W=0.65 AS=0.169
+ AD=0.08775 PS=1.82 PD=0.92
M$11916 \$6807 \$6806 A2|B|Y VGND sky130_fd_pr__nfet_01v8 L=0.15 W=0.65
+ AS=0.08775 AD=0.195 PS=0.92 PD=1.9
M$11917 VGND A|A1|B|C|Y A|Y VGND sky130_fd_pr__nfet_01v8 L=0.15 W=0.65 AS=0.169
+ AD=0.08775 PS=1.82 PD=0.92
M$11920 B|Y A|B1|Y \$6731 VGND sky130_fd_pr__nfet_01v8 L=0.15 W=0.42 AS=0.1113
+ AD=0.0588 PS=1.37 PD=0.7
M$11921 \$6731 A2|B|Y VGND VGND sky130_fd_pr__nfet_01v8 L=0.15 W=0.42 AS=0.0588
+ AD=0.0588 PS=0.7 PD=0.7
M$11922 VGND A|A1|B|C|Y \$6731 VGND sky130_fd_pr__nfet_01v8 L=0.15 W=0.42
+ AS=0.0588 AD=0.1113 PS=0.7 PD=1.37
M$11923 \$6809 B|Y \$6949 VGND sky130_fd_pr__nfet_01v8 L=0.15 W=0.65 AS=0.169
+ AD=0.06825 PS=1.82 PD=0.86
M$11924 \$6949 A|B|C|X VGND VGND sky130_fd_pr__nfet_01v8 L=0.15 W=0.65
+ AS=0.06825 AD=0.08775 PS=0.86 PD=0.92
M$11925 VGND A|B|C|X \$6810 VGND sky130_fd_pr__nfet_01v8 L=0.15 W=0.65
+ AS=0.08775 AD=0.169 PS=0.92 PD=1.82
M$11926 VGND B|Y \$6810 VGND sky130_fd_pr__nfet_01v8 L=0.15 W=0.65 AS=0.169
+ AD=0.08775 PS=1.82 PD=0.92
M$11927 \$6810 \$6809 B|C|Y VGND sky130_fd_pr__nfet_01v8 L=0.15 W=0.65
+ AS=0.08775 AD=0.195 PS=0.92 PD=1.9
M$11929 B|C|X \$6812 VGND VGND sky130_fd_pr__nfet_01v8 L=0.15 W=0.42 AS=0.1113
+ AD=0.0966 PS=1.37 PD=0.88
M$11930 VGND B|C|Y \$6954 VGND sky130_fd_pr__nfet_01v8 L=0.15 W=0.42 AS=0.0966
+ AD=0.0441 PS=0.88 PD=0.63
M$11931 \$6954 A|B1|Y \$6812 VGND sky130_fd_pr__nfet_01v8 L=0.15 W=0.42
+ AS=0.0441 AD=0.1113 PS=0.63 PD=1.37
M$11932 \$6813 B|C|Y \$6959 VGND sky130_fd_pr__nfet_01v8 L=0.15 W=0.65 AS=0.169
+ AD=0.06825 PS=1.82 PD=0.86
M$11933 \$6959 A|Y VGND VGND sky130_fd_pr__nfet_01v8 L=0.15 W=0.65 AS=0.06825
+ AD=0.08775 PS=0.86 PD=0.92
M$11934 VGND A|Y \$6814 VGND sky130_fd_pr__nfet_01v8 L=0.15 W=0.65 AS=0.08775
+ AD=0.169 PS=0.92 PD=1.82
M$11935 VGND B|C|Y \$6814 VGND sky130_fd_pr__nfet_01v8 L=0.15 W=0.65 AS=0.169
+ AD=0.08775 PS=1.82 PD=0.92
M$11936 \$6814 \$6813 B|Y VGND sky130_fd_pr__nfet_01v8 L=0.15 W=0.65 AS=0.08775
+ AD=0.195 PS=0.92 PD=1.9
M$11938 A|Y \$6815 \$6817 VGND sky130_fd_pr__nfet_01v8 L=0.15 W=0.65 AS=0.169
+ AD=0.10075 PS=1.82 PD=0.96
M$11939 \$6817 A2|B|C|X VGND VGND sky130_fd_pr__nfet_01v8 L=0.15 W=0.65
+ AS=0.10075 AD=0.08775 PS=0.96 PD=0.92
M$11940 VGND A|A1|Y \$6817 VGND sky130_fd_pr__nfet_01v8 L=0.15 W=0.65
+ AS=0.08775 AD=0.169 PS=0.92 PD=1.82
M$11941 \$6819 B|Y \$6971 VGND sky130_fd_pr__nfet_01v8 L=0.15 W=0.65 AS=0.169
+ AD=0.06825 PS=1.82 PD=0.86
M$11942 \$6971 A|Y VGND VGND sky130_fd_pr__nfet_01v8 L=0.15 W=0.65 AS=0.06825
+ AD=0.08775 PS=0.86 PD=0.92
M$11943 VGND A|Y \$6820 VGND sky130_fd_pr__nfet_01v8 L=0.15 W=0.65 AS=0.08775
+ AD=0.169 PS=0.92 PD=1.82
M$11944 VGND B|Y \$6820 VGND sky130_fd_pr__nfet_01v8 L=0.15 W=0.65 AS=0.169
+ AD=0.08775 PS=1.82 PD=0.92
M$11945 \$6820 \$6819 B|C|Y VGND sky130_fd_pr__nfet_01v8 L=0.15 W=0.65
+ AS=0.08775 AD=0.195 PS=0.92 PD=1.9
M$11946 VGND A|A_N|Y \$6821 VGND sky130_fd_pr__nfet_01v8 L=0.15 W=0.42
+ AS=0.10025 AD=0.1092 PS=0.985 PD=1.36
M$11947 VGND B|C|X \$6980 VGND sky130_fd_pr__nfet_01v8 L=0.15 W=0.65 AS=0.10025
+ AD=0.08775 PS=0.985 PD=0.92
M$11948 \$6980 B|Y \$6979 VGND sky130_fd_pr__nfet_01v8 L=0.15 W=0.65 AS=0.08775
+ AD=0.125125 PS=0.92 PD=1.035
M$11949 \$6979 \$6821 A|Y VGND sky130_fd_pr__nfet_01v8 L=0.15 W=0.65
+ AS=0.125125 AD=0.182 PS=1.035 PD=1.86
M$11950 B|Y A|A1|Y \$6981 VGND sky130_fd_pr__nfet_01v8 L=0.15 W=0.65 AS=0.169
+ AD=0.08775 PS=1.82 PD=0.92
M$11951 \$6981 A2|B|C|X VGND VGND sky130_fd_pr__nfet_01v8 L=0.15 W=0.65
+ AS=0.08775 AD=0.169 PS=0.92 PD=1.82
M$11953 \$6669 A|Y \$6763 VGND sky130_fd_pr__nfet_01v8 L=0.15 W=0.42 AS=0.1092
+ AD=0.0441 PS=1.36 PD=0.63
M$11954 \$6763 A|B|Y \$6762 VGND sky130_fd_pr__nfet_01v8 L=0.15 W=0.42
+ AS=0.0441 AD=0.0441 PS=0.63 PD=0.63
M$11955 VGND B|C|Y \$6762 VGND sky130_fd_pr__nfet_01v8 L=0.15 W=0.42 AS=0.13165
+ AD=0.0441 PS=1.14 PD=0.63
M$11956 VGND \$6669 A|X VGND sky130_fd_pr__nfet_01v8 L=0.15 W=0.65 AS=0.13165
+ AD=0.169 PS=1.14 PD=1.82
M$11957 \$6671 A|C|Y VGND VGND sky130_fd_pr__nfet_01v8 L=0.15 W=0.42 AS=0.1092
+ AD=0.0567 PS=1.36 PD=0.69
M$11958 VGND A|B|Y \$6671 VGND sky130_fd_pr__nfet_01v8 L=0.15 W=0.42 AS=0.0567
+ AD=0.0567 PS=0.69 PD=0.69
M$11959 VGND A|X \$6671 VGND sky130_fd_pr__nfet_01v8 L=0.15 W=0.42 AS=0.101875
+ AD=0.0567 PS=0.99 PD=0.69
M$11960 VGND \$6671 B|C|X VGND sky130_fd_pr__nfet_01v8 L=0.15 W=0.65
+ AS=0.101875 AD=0.182 PS=0.99 PD=1.86
M$11962 \$6673 CLK|TICK VGND VGND sky130_fd_pr__nfet_01v8 L=0.15 W=0.42
+ AS=0.1092 AD=0.0567 PS=1.36 PD=0.69
M$11963 VGND \$6673 \$6674 VGND sky130_fd_pr__nfet_01v8 L=0.15 W=0.42 AS=0.0567
+ AD=0.1092 PS=0.69 PD=1.36
M$11964 VGND D|X \$6676 VGND sky130_fd_pr__nfet_01v8 L=0.15 W=0.42 AS=0.2205
+ AD=0.066 PS=1.89 PD=0.745
M$11965 \$6676 \$6673 \$6677 VGND sky130_fd_pr__nfet_01v8 L=0.15 W=0.36
+ AS=0.066 AD=0.0594 PS=0.745 PD=0.69
M$11966 \$6755 \$6674 \$6677 VGND sky130_fd_pr__nfet_01v8 L=0.15 W=0.36
+ AS=0.1401 AD=0.0594 PS=1.1 PD=0.69
M$11967 \$6755 \$6679 \$6753 VGND sky130_fd_pr__nfet_01v8 L=0.15 W=0.42
+ AS=0.1401 AD=0.0441 PS=1.1 PD=0.63
M$11968 VGND RESET_B|X \$6753 VGND sky130_fd_pr__nfet_01v8 L=0.15 W=0.42
+ AS=0.1346 AD=0.0441 PS=1.15 PD=0.63
M$11969 VGND \$6677 \$6679 VGND sky130_fd_pr__nfet_01v8 L=0.15 W=0.64 AS=0.1346
+ AD=0.0999 PS=1.15 PD=0.985
M$11970 \$6679 \$6674 \$6680 VGND sky130_fd_pr__nfet_01v8 L=0.15 W=0.36
+ AS=0.0999 AD=0.0711 PS=0.985 PD=0.755
M$11971 \$6752 \$6673 \$6680 VGND sky130_fd_pr__nfet_01v8 L=0.15 W=0.36
+ AS=0.0669 AD=0.0711 PS=0.75 PD=0.755
M$11972 \$6752 \$6681 VGND VGND sky130_fd_pr__nfet_01v8 L=0.15 W=0.42 AS=0.0669
+ AD=0.12495 PS=0.75 PD=1.015
M$11973 VGND RESET_B|X \$6749 VGND sky130_fd_pr__nfet_01v8 L=0.15 W=0.42
+ AS=0.12495 AD=0.06405 PS=1.015 PD=0.725
M$11974 \$6749 \$6680 \$6681 VGND sky130_fd_pr__nfet_01v8 L=0.15 W=0.42
+ AS=0.06405 AD=0.1092 PS=0.725 PD=1.36
M$11976 D|X \$6822 VGND VGND sky130_fd_pr__nfet_01v8 L=0.15 W=0.65 AS=0.169
+ AD=0.144125 PS=1.82 PD=1.12
M$11977 VGND C|Y \$6824 VGND sky130_fd_pr__nfet_01v8 L=0.15 W=0.42 AS=0.144125
+ AD=0.1764 PS=1.12 PD=1.68
M$11978 VGND B|X \$6827 VGND sky130_fd_pr__nfet_01v8 L=0.15 W=0.65 AS=0.195
+ AD=0.1653 PS=1.9 PD=1.82
M$11979 \$6825 \$6827 \$6829 VGND sky130_fd_pr__nfet_01v8 L=0.15 W=0.42
+ AS=0.18365 AD=0.19265 PS=1.25 PD=1.285
M$11980 \$6826 \$6827 \$6828 VGND sky130_fd_pr__nfet_01v8 L=0.15 W=0.6
+ AS=0.140825 AD=0.11 PS=1.1 PD=0.99
M$11981 \$6828 A|Q VGND VGND sky130_fd_pr__nfet_01v8 L=0.15 W=0.64 AS=0.11
+ AD=0.0864 PS=0.99 PD=0.91
M$11982 VGND \$6828 \$6829 VGND sky130_fd_pr__nfet_01v8 L=0.15 W=0.64 AS=0.0864
+ AD=0.1824 PS=0.91 PD=1.85
M$11983 \$6828 B|X \$6825 VGND sky130_fd_pr__nfet_01v8 L=0.15 W=0.64 AS=0.1628
+ AD=0.18365 PS=1.8 PD=1.25
M$11984 \$6826 B|X \$6829 VGND sky130_fd_pr__nfet_01v8 L=0.15 W=0.64
+ AS=0.140825 AD=0.19265 PS=1.1 PD=1.285
M$11985 \$6683 B|C|X \$6745 VGND sky130_fd_pr__nfet_01v8 L=0.15 W=0.42
+ AS=0.1092 AD=0.0441 PS=1.36 PD=0.63
M$11986 \$6745 A|Q VGND VGND sky130_fd_pr__nfet_01v8 L=0.15 W=0.42 AS=0.0441
+ AD=0.0567 PS=0.63 PD=0.69
M$11987 VGND A|Q \$6744 VGND sky130_fd_pr__nfet_01v8 L=0.15 W=0.42 AS=0.0567
+ AD=0.0441 PS=0.69 PD=0.63
M$11988 \$6744 A|B|X \$6683 VGND sky130_fd_pr__nfet_01v8 L=0.15 W=0.42
+ AS=0.0441 AD=0.0567 PS=0.63 PD=0.69
M$11989 \$6683 A|B|X \$6743 VGND sky130_fd_pr__nfet_01v8 L=0.15 W=0.42
+ AS=0.0567 AD=0.0441 PS=0.69 PD=0.63
M$11990 VGND B|C|X \$6743 VGND sky130_fd_pr__nfet_01v8 L=0.15 W=0.42 AS=0.1474
+ AD=0.0441 PS=1.215 PD=0.63
M$11991 VGND \$6683 B|C|X VGND sky130_fd_pr__nfet_01v8 L=0.15 W=0.65 AS=0.1474
+ AD=0.23725 PS=1.215 PD=2.03
M$11992 A|Q \$6830 VGND VGND sky130_fd_pr__nfet_01v8 L=0.15 W=0.65 AS=0.169
+ AD=0.2087 PS=1.82 PD=2.02
M$11993 \$6929 \$6831 \$7006 VGND sky130_fd_pr__nfet_01v8 L=0.15 W=0.36
+ AS=0.0669 AD=0.0711 PS=0.75 PD=0.755
M$11994 \$7006 \$6832 \$6833 VGND sky130_fd_pr__nfet_01v8 L=0.15 W=0.36
+ AS=0.0711 AD=0.0999 PS=0.755 PD=0.985
M$11995 \$6923 \$6832 \$6834 VGND sky130_fd_pr__nfet_01v8 L=0.15 W=0.36
+ AS=0.1401 AD=0.0594 PS=1.1 PD=0.69
M$11996 \$6834 \$6831 \$6835 VGND sky130_fd_pr__nfet_01v8 L=0.15 W=0.36
+ AS=0.0594 AD=0.066 PS=0.69 PD=0.745
M$11997 \$6830 \$7006 \$6936 VGND sky130_fd_pr__nfet_01v8 L=0.15 W=0.42
+ AS=0.1092 AD=0.06405 PS=1.36 PD=0.725
M$11998 \$6936 RESET_B|X VGND VGND sky130_fd_pr__nfet_01v8 L=0.15 W=0.42
+ AS=0.06405 AD=0.12495 PS=0.725 PD=1.015
M$11999 VGND \$6830 \$6929 VGND sky130_fd_pr__nfet_01v8 L=0.15 W=0.42
+ AS=0.12495 AD=0.0669 PS=1.015 PD=0.75
M$12000 VGND RESET_B|X \$6926 VGND sky130_fd_pr__nfet_01v8 L=0.15 W=0.42
+ AS=0.1346 AD=0.0441 PS=1.15 PD=0.63
M$12001 \$6926 \$6833 \$6923 VGND sky130_fd_pr__nfet_01v8 L=0.15 W=0.42
+ AS=0.0441 AD=0.1401 PS=0.63 PD=1.1
M$12002 \$6835 D|Y VGND VGND sky130_fd_pr__nfet_01v8 L=0.15 W=0.42 AS=0.066
+ AD=0.2205 PS=0.745 PD=1.89
M$12003 \$6833 \$6834 VGND VGND sky130_fd_pr__nfet_01v8 L=0.15 W=0.64 AS=0.0999
+ AD=0.1346 PS=0.985 PD=1.15
M$12004 \$6832 \$6831 VGND VGND sky130_fd_pr__nfet_01v8 L=0.15 W=0.42 AS=0.1092
+ AD=0.0567 PS=1.36 PD=0.69
M$12005 VGND CLK|TICK \$6831 VGND sky130_fd_pr__nfet_01v8 L=0.15 W=0.42
+ AS=0.0567 AD=0.1092 PS=0.69 PD=1.36
M$12014 VGND A|A2|B|B_N|X \$7114 VGND sky130_fd_pr__nfet_01v8 L=0.15 W=0.65
+ AS=0.169 AD=0.08775 PS=1.82 PD=0.92
M$12015 \$7114 A|A1|X B1|SLEEP|Y VGND sky130_fd_pr__nfet_01v8 L=0.15 W=0.65
+ AS=0.08775 AD=0.169 PS=0.92 PD=1.82
M$12016 VGND \$7035 A|A1|X VGND sky130_fd_pr__nfet_01v8 L=0.15 W=0.65 AS=0.169
+ AD=0.08775 PS=1.82 PD=0.92
M$12017 A|A1|X A1|B|SLEEP|X VGND VGND sky130_fd_pr__nfet_01v8 L=0.15 W=0.65
+ AS=0.08775 AD=0.10025 PS=0.92 PD=0.985
M$12018 VGND A|B1|X \$7035 VGND sky130_fd_pr__nfet_01v8 L=0.15 W=0.42
+ AS=0.10025 AD=0.1092 PS=0.985 PD=1.36
M$12020 \$7036 A1|B|SLEEP|X \$7117 VGND sky130_fd_pr__nfet_01v8 L=0.15 W=0.65
+ AS=0.169 AD=0.06825 PS=1.82 PD=0.86
M$12021 \$7117 A|B1|X VGND VGND sky130_fd_pr__nfet_01v8 L=0.15 W=0.65
+ AS=0.06825 AD=0.08775 PS=0.86 PD=0.92
M$12022 VGND A|B1|X \$7094 VGND sky130_fd_pr__nfet_01v8 L=0.15 W=0.65
+ AS=0.08775 AD=0.169 PS=0.92 PD=1.82
M$12023 VGND A1|B|SLEEP|X \$7094 VGND sky130_fd_pr__nfet_01v8 L=0.15 W=0.65
+ AS=0.169 AD=0.08775 PS=1.82 PD=0.92
M$12024 \$7094 \$7036 A|B|Y VGND sky130_fd_pr__nfet_01v8 L=0.15 W=0.65
+ AS=0.08775 AD=0.195 PS=0.92 PD=1.9
M$12027 A1|B|Y C|Y VGND VGND sky130_fd_pr__nfet_01v8 L=0.15 W=0.65 AS=0.169
+ AD=0.08775 PS=1.82 PD=0.92
M$12028 VGND B|X A1|B|Y VGND sky130_fd_pr__nfet_01v8 L=0.15 W=0.65 AS=0.08775
+ AD=0.08775 PS=0.92 PD=0.92
M$12029 A1|B|Y A|B|Y VGND VGND sky130_fd_pr__nfet_01v8 L=0.15 W=0.65 AS=0.08775
+ AD=0.169 PS=0.92 PD=1.82
M$12030 \$6779 \$6782 \$6781 VGND sky130_fd_pr__nfet_01v8 L=0.15 W=0.64
+ AS=0.224 AD=0.0928 PS=1.98 PD=0.93
M$12031 \$6781 C|Y \$6778 VGND sky130_fd_pr__nfet_01v8 L=0.15 W=0.64 AS=0.0928
+ AD=0.1728 PS=0.93 PD=1.82
M$12033 \$7096 A1|B|Y VGND VGND sky130_fd_pr__nfet_01v8 L=0.15 W=0.65 AS=0.169
+ AD=0.08775 PS=1.82 PD=0.92
M$12034 VGND A2|X \$7096 VGND sky130_fd_pr__nfet_01v8 L=0.15 W=0.65 AS=0.08775
+ AD=0.10075 PS=0.92 PD=0.96
M$12035 \$7096 A|B1|Y \$7040 VGND sky130_fd_pr__nfet_01v8 L=0.15 W=0.65
+ AS=0.10075 AD=0.169 PS=0.96 PD=1.82
M$12036 VGND \$7040 A|B|X VGND sky130_fd_pr__nfet_01v8 L=0.15 W=0.65 AS=0.169
+ AD=0.169 PS=1.82 PD=1.82
M$12037 \$6787 A_N|B1|C|Y \$6785 VGND sky130_fd_pr__nfet_01v8 L=0.15 W=0.64
+ AS=0.1728 AD=0.0928 PS=1.82 PD=0.93
M$12038 \$6785 \$6786 \$6788 VGND sky130_fd_pr__nfet_01v8 L=0.15 W=0.64
+ AS=0.0928 AD=0.224 PS=0.93 PD=1.98
M$12040 \$7045 A|A1|B|X \$7042 VGND sky130_fd_pr__nfet_01v8 L=0.15 W=0.64
+ AS=0.140825 AD=0.19265 PS=1.1 PD=1.285
M$12041 \$7042 \$7089 \$7044 VGND sky130_fd_pr__nfet_01v8 L=0.15 W=0.42
+ AS=0.19265 AD=0.18205 PS=1.285 PD=1.245
M$12042 \$7044 A|A1|B|X \$7043 VGND sky130_fd_pr__nfet_01v8 L=0.15 W=0.64
+ AS=0.18205 AD=0.16275 PS=1.245 PD=1.8
M$12043 \$7042 \$7043 VGND VGND sky130_fd_pr__nfet_01v8 L=0.15 W=0.64 AS=0.1824
+ AD=0.0864 PS=1.85 PD=0.91
M$12044 VGND A|B1|Y \$7043 VGND sky130_fd_pr__nfet_01v8 L=0.15 W=0.64 AS=0.0864
+ AD=0.11 PS=0.91 PD=0.99
M$12045 \$7045 \$7089 \$7043 VGND sky130_fd_pr__nfet_01v8 L=0.15 W=0.6
+ AS=0.140825 AD=0.11 PS=1.1 PD=0.99
M$12046 \$7089 A|A1|B|X VGND VGND sky130_fd_pr__nfet_01v8 L=0.15 W=0.65
+ AS=0.16515 AD=0.1885 PS=1.82 PD=1.88
M$12047 \$7044 \$7047 \$7046 VGND sky130_fd_pr__nfet_01v8 L=0.15 W=0.64
+ AS=0.224 AD=0.0928 PS=1.98 PD=0.93
M$12048 \$7046 B|B_N|C|X \$7045 VGND sky130_fd_pr__nfet_01v8 L=0.15 W=0.64
+ AS=0.0928 AD=0.1728 PS=0.93 PD=1.82
M$12049 \$7047 B|B_N|C|X VGND VGND sky130_fd_pr__nfet_01v8 L=0.15 W=0.42
+ AS=0.1785 AD=0.1165 PS=1.69 PD=1.035
M$12050 VGND \$7046 B|C|X VGND sky130_fd_pr__nfet_01v8 L=0.15 W=0.65 AS=0.1165
+ AD=0.169 PS=1.035 PD=1.82
M$12053 VGND A|B|X \$7118 VGND sky130_fd_pr__nfet_01v8 L=0.15 W=0.65 AS=0.169
+ AD=0.08775 PS=1.82 PD=0.92
M$12054 \$7118 A|Y A1|Y VGND sky130_fd_pr__nfet_01v8 L=0.15 W=0.65 AS=0.08775
+ AD=0.169 PS=0.92 PD=1.82
M$12057 \$7050 B|X \$7116 VGND sky130_fd_pr__nfet_01v8 L=0.15 W=0.65 AS=0.169
+ AD=0.06825 PS=1.82 PD=0.86
M$12058 \$7116 A|A_N|Y VGND VGND sky130_fd_pr__nfet_01v8 L=0.15 W=0.65
+ AS=0.06825 AD=0.08775 PS=0.86 PD=0.92
M$12059 VGND A|A_N|Y \$7097 VGND sky130_fd_pr__nfet_01v8 L=0.15 W=0.65
+ AS=0.08775 AD=0.169 PS=0.92 PD=1.82
M$12060 VGND B|X \$7097 VGND sky130_fd_pr__nfet_01v8 L=0.15 W=0.65 AS=0.169
+ AD=0.08775 PS=1.82 PD=0.92
M$12061 \$7097 \$7050 B|C|Y VGND sky130_fd_pr__nfet_01v8 L=0.15 W=0.65
+ AS=0.08775 AD=0.195 PS=0.92 PD=1.9
M$12062 \$7051 B|C|Y \$7115 VGND sky130_fd_pr__nfet_01v8 L=0.15 W=0.65 AS=0.169
+ AD=0.06825 PS=1.82 PD=0.86
M$12063 \$7115 A|Y VGND VGND sky130_fd_pr__nfet_01v8 L=0.15 W=0.65 AS=0.06825
+ AD=0.08775 PS=0.86 PD=0.92
M$12064 VGND A|Y \$7098 VGND sky130_fd_pr__nfet_01v8 L=0.15 W=0.65 AS=0.08775
+ AD=0.169 PS=0.92 PD=1.82
M$12065 VGND B|C|Y \$7098 VGND sky130_fd_pr__nfet_01v8 L=0.15 W=0.65 AS=0.169
+ AD=0.08775 PS=1.82 PD=0.92
M$12066 \$7098 \$7051 B|Y VGND sky130_fd_pr__nfet_01v8 L=0.15 W=0.65 AS=0.08775
+ AD=0.195 PS=0.92 PD=1.9
M$12071 \$6802 \$6804 \$6803 VGND sky130_fd_pr__nfet_01v8 L=0.15 W=0.64
+ AS=0.224 AD=0.0928 PS=1.98 PD=0.93
M$12072 \$6803 B|C|X \$6801 VGND sky130_fd_pr__nfet_01v8 L=0.15 W=0.64
+ AS=0.0928 AD=0.1728 PS=0.93 PD=1.82
M$12074 \$7055 A|A1|B|C|Y \$7052 VGND sky130_fd_pr__nfet_01v8 L=0.15 W=0.64
+ AS=0.140825 AD=0.19265 PS=1.1 PD=1.285
M$12075 \$7052 \$7090 \$7054 VGND sky130_fd_pr__nfet_01v8 L=0.15 W=0.42
+ AS=0.19265 AD=0.18365 PS=1.285 PD=1.25
M$12076 \$7054 A|A1|B|C|Y \$7053 VGND sky130_fd_pr__nfet_01v8 L=0.15 W=0.64
+ AS=0.18365 AD=0.1628 PS=1.25 PD=1.8
M$12077 \$7052 \$7053 VGND VGND sky130_fd_pr__nfet_01v8 L=0.15 W=0.64 AS=0.1824
+ AD=0.0864 PS=1.85 PD=0.91
M$12078 VGND A|Y \$7053 VGND sky130_fd_pr__nfet_01v8 L=0.15 W=0.64 AS=0.0864
+ AD=0.11 PS=0.91 PD=0.99
M$12079 \$7055 \$7090 \$7053 VGND sky130_fd_pr__nfet_01v8 L=0.15 W=0.6
+ AS=0.140825 AD=0.11 PS=1.1 PD=0.99
M$12080 \$7090 A|A1|B|C|Y VGND VGND sky130_fd_pr__nfet_01v8 L=0.15 W=0.65
+ AS=0.1653 AD=0.195 PS=1.82 PD=1.9
M$12081 \$7055 \$7057 \$7056 VGND sky130_fd_pr__nfet_01v8 L=0.15 W=0.64
+ AS=0.3168 AD=0.128 PS=2.27 PD=1.04
M$12082 \$7056 B|C|Y \$7054 VGND sky130_fd_pr__nfet_01v8 L=0.15 W=0.64 AS=0.128
+ AD=0.1728 PS=1.04 PD=1.82
M$12083 \$7057 B|C|Y VGND VGND sky130_fd_pr__nfet_01v8 L=0.15 W=0.42 AS=0.1764
+ AD=0.144125 PS=1.68 PD=1.12
M$12084 VGND \$7056 A|B|X VGND sky130_fd_pr__nfet_01v8 L=0.15 W=0.65
+ AS=0.144125 AD=0.169 PS=1.12 PD=1.82
M$12088 A|Y A|A1|B1|Y \$7113 VGND sky130_fd_pr__nfet_01v8 L=0.15 W=0.65
+ AS=0.091 AD=0.095875 PS=0.93 PD=0.945
M$12089 \$7113 A2|B|C|Y VGND VGND sky130_fd_pr__nfet_01v8 L=0.15 W=0.65
+ AS=0.095875 AD=0.17225 PS=0.945 PD=1.83
M$12091 VGND A|B1_N|X \$6815 VGND sky130_fd_pr__nfet_01v8 L=0.15 W=0.42
+ AS=0.1092 AD=0.1092 PS=1.36 PD=1.36
M$12092 \$7063 B|C|X \$7060 VGND sky130_fd_pr__nfet_01v8 L=0.15 W=0.64
+ AS=0.140825 AD=0.19265 PS=1.1 PD=1.285
M$12093 \$7060 \$7092 \$7062 VGND sky130_fd_pr__nfet_01v8 L=0.15 W=0.42
+ AS=0.19265 AD=0.18365 PS=1.285 PD=1.25
M$12094 \$7062 B|C|X \$7061 VGND sky130_fd_pr__nfet_01v8 L=0.15 W=0.64
+ AS=0.18365 AD=0.1628 PS=1.25 PD=1.8
M$12095 \$7060 \$7061 VGND VGND sky130_fd_pr__nfet_01v8 L=0.15 W=0.64 AS=0.1824
+ AD=0.0864 PS=1.85 PD=0.91
M$12096 VGND A|A1|Y \$7061 VGND sky130_fd_pr__nfet_01v8 L=0.15 W=0.64 AS=0.0864
+ AD=0.11 PS=0.91 PD=0.99
M$12097 \$7063 \$7092 \$7061 VGND sky130_fd_pr__nfet_01v8 L=0.15 W=0.6
+ AS=0.140825 AD=0.11 PS=1.1 PD=0.99
M$12098 \$7092 B|C|X VGND VGND sky130_fd_pr__nfet_01v8 L=0.15 W=0.65 AS=0.1653
+ AD=0.195 PS=1.82 PD=1.9
M$12099 \$7063 \$7065 \$7064 VGND sky130_fd_pr__nfet_01v8 L=0.15 W=0.64
+ AS=0.3168 AD=0.128 PS=2.27 PD=1.04
M$12100 \$7064 A2|B|C|X \$7062 VGND sky130_fd_pr__nfet_01v8 L=0.15 W=0.64
+ AS=0.128 AD=0.1728 PS=1.04 PD=1.82
M$12101 \$7065 A2|B|C|X VGND VGND sky130_fd_pr__nfet_01v8 L=0.15 W=0.42
+ AS=0.1764 AD=0.144125 PS=1.68 PD=1.12
M$12102 VGND \$7064 B|X VGND sky130_fd_pr__nfet_01v8 L=0.15 W=0.65 AS=0.144125
+ AD=0.169 PS=1.12 PD=1.82
M$12104 VGND B|X \$7112 VGND sky130_fd_pr__nfet_01v8 L=0.15 W=0.65 AS=0.169
+ AD=0.08775 PS=1.82 PD=0.92
M$12105 \$7112 A|Y A|B|Y VGND sky130_fd_pr__nfet_01v8 L=0.15 W=0.65 AS=0.08775
+ AD=0.169 PS=0.92 PD=1.82
M$12106 \$7067 B|X \$7111 VGND sky130_fd_pr__nfet_01v8 L=0.15 W=0.65 AS=0.169
+ AD=0.06825 PS=1.82 PD=0.86
M$12107 \$7111 A|Y VGND VGND sky130_fd_pr__nfet_01v8 L=0.15 W=0.65 AS=0.06825
+ AD=0.08775 PS=0.86 PD=0.92
M$12108 VGND A|Y \$7099 VGND sky130_fd_pr__nfet_01v8 L=0.15 W=0.65 AS=0.08775
+ AD=0.169 PS=0.92 PD=1.82
M$12109 VGND B|X \$7099 VGND sky130_fd_pr__nfet_01v8 L=0.15 W=0.65 AS=0.169
+ AD=0.08775 PS=1.82 PD=0.92
M$12110 \$7099 \$7067 C|Y VGND sky130_fd_pr__nfet_01v8 L=0.15 W=0.65 AS=0.08775
+ AD=0.195 PS=0.92 PD=1.9
M$12113 \$6825 C|Y \$6822 VGND sky130_fd_pr__nfet_01v8 L=0.15 W=0.64 AS=0.1728
+ AD=0.128 PS=1.82 PD=1.04
M$12114 \$6822 \$6824 \$6826 VGND sky130_fd_pr__nfet_01v8 L=0.15 W=0.64
+ AS=0.128 AD=0.3168 PS=1.04 PD=2.27
M$12115 \$7069 B|C|X \$7107 VGND sky130_fd_pr__nfet_01v8 L=0.15 W=0.65 AS=0.169
+ AD=0.06825 PS=1.82 PD=0.86
M$12116 \$7107 A|Q VGND VGND sky130_fd_pr__nfet_01v8 L=0.15 W=0.65 AS=0.06825
+ AD=0.08775 PS=0.86 PD=0.92
M$12117 VGND A|Q \$7100 VGND sky130_fd_pr__nfet_01v8 L=0.15 W=0.65 AS=0.08775
+ AD=0.169 PS=0.92 PD=1.82
M$12118 VGND B|C|X \$7100 VGND sky130_fd_pr__nfet_01v8 L=0.15 W=0.65 AS=0.169
+ AD=0.08775 PS=1.82 PD=0.92
M$12119 \$7100 \$7069 B|Y VGND sky130_fd_pr__nfet_01v8 L=0.15 W=0.65 AS=0.08775
+ AD=0.195 PS=0.92 PD=1.9
M$12130 VGND A|A2|B|B_N|X \$7153 VGND sky130_fd_pr__nfet_01v8 L=0.15 W=0.65
+ AS=0.17225 AD=0.095875 PS=1.83 PD=0.945
M$12131 \$7153 A|A1|X A2|B|Y VGND sky130_fd_pr__nfet_01v8 L=0.15 W=0.65
+ AS=0.095875 AD=0.091 PS=0.945 PD=0.93
M$12132 A2|B|Y A|B1|Y VGND VGND sky130_fd_pr__nfet_01v8 L=0.15 W=1.3 AS=0.17875
+ AD=0.34125 PS=1.85 PD=3.65
M$12133 \$7121 A|A2|B|B_N|X \$7159 VGND sky130_fd_pr__nfet_01v8 L=0.15 W=0.65
+ AS=0.169 AD=0.06825 PS=1.82 PD=0.86
M$12134 \$7159 A|Y VGND VGND sky130_fd_pr__nfet_01v8 L=0.15 W=0.65 AS=0.06825
+ AD=0.08775 PS=0.86 PD=0.92
M$12135 VGND A|Y \$7122 VGND sky130_fd_pr__nfet_01v8 L=0.15 W=0.65 AS=0.08775
+ AD=0.169 PS=0.92 PD=1.82
M$12136 VGND A|A2|B|B_N|X \$7122 VGND sky130_fd_pr__nfet_01v8 L=0.15 W=0.65
+ AS=0.169 AD=0.08775 PS=1.82 PD=0.92
M$12137 \$7122 \$7121 A2|B|C|Y VGND sky130_fd_pr__nfet_01v8 L=0.15 W=0.65
+ AS=0.08775 AD=0.195 PS=0.92 PD=1.9
M$12138 VGND A|B1|Y \$7297 VGND sky130_fd_pr__nfet_01v8 L=0.15 W=0.42
+ AS=0.10025 AD=0.1092 PS=0.985 PD=1.36
M$12139 VGND B1|SLEEP|Y A|A1|B1|X VGND sky130_fd_pr__nfet_01v8 L=0.15 W=0.65
+ AS=0.10025 AD=0.08775 PS=0.985 PD=0.92
M$12140 A|A1|B1|X \$7297 VGND VGND sky130_fd_pr__nfet_01v8 L=0.15 W=0.65
+ AS=0.08775 AD=0.169 PS=0.92 PD=1.82
M$12142 VGND A2|B|C|Y \$7172 VGND sky130_fd_pr__nfet_01v8 L=0.15 W=0.65
+ AS=0.169 AD=0.08775 PS=1.82 PD=0.92
M$12143 \$7172 A|B|Y A3|Y VGND sky130_fd_pr__nfet_01v8 L=0.15 W=0.65 AS=0.08775
+ AD=0.169 PS=0.92 PD=1.82
M$12144 VGND A|A1|B1|X A2|D|Y VGND sky130_fd_pr__nfet_01v8 L=0.15 W=0.65
+ AS=0.169 AD=0.08775 PS=1.82 PD=0.92
M$12145 A2|D|Y A2|B|Y VGND VGND sky130_fd_pr__nfet_01v8 L=0.15 W=0.65
+ AS=0.08775 AD=0.169 PS=0.92 PD=1.82
M$12146 \$7126 A|A1|B1|X VGND VGND sky130_fd_pr__nfet_01v8 L=0.15 W=0.65
+ AS=0.182 AD=0.11375 PS=1.86 PD=1
M$12147 VGND A2|B|Y \$7126 VGND sky130_fd_pr__nfet_01v8 L=0.15 W=0.65
+ AS=0.11375 AD=0.08775 PS=1 PD=0.92
M$12148 \$7126 A3|Y VGND VGND sky130_fd_pr__nfet_01v8 L=0.15 W=0.65 AS=0.08775
+ AD=0.08775 PS=0.92 PD=0.92
M$12149 VGND A3|A4|X \$7126 VGND sky130_fd_pr__nfet_01v8 L=0.15 W=0.65
+ AS=0.08775 AD=0.203125 PS=0.92 PD=1.275
M$12150 \$7126 A|B1|X C|Y VGND sky130_fd_pr__nfet_01v8 L=0.15 W=0.65
+ AS=0.203125 AD=0.169 PS=1.275 PD=1.82
M$12151 A3|A4|X \$7038 VGND VGND sky130_fd_pr__nfet_01v8 L=0.15 W=0.42
+ AS=0.1113 AD=0.0966 PS=1.37 PD=0.88
M$12152 VGND A2|B|C|X \$7119 VGND sky130_fd_pr__nfet_01v8 L=0.15 W=0.42
+ AS=0.0966 AD=0.0441 PS=0.88 PD=0.63
M$12153 \$7119 A|A1|B|Y \$7038 VGND sky130_fd_pr__nfet_01v8 L=0.15 W=0.42
+ AS=0.0441 AD=0.1113 PS=0.63 PD=1.37
M$12154 VGND A2|B|C|X \$7379 VGND sky130_fd_pr__nfet_01v8 L=0.15 W=0.65
+ AS=0.17225 AD=0.091 PS=1.83 PD=0.93
M$12155 \$7379 A|A1|B|Y \$7301 VGND sky130_fd_pr__nfet_01v8 L=0.15 W=0.65
+ AS=0.091 AD=0.089375 PS=0.93 PD=0.925
M$12156 \$7301 A|A1|B1|X VGND VGND sky130_fd_pr__nfet_01v8 L=0.15 W=0.65
+ AS=0.089375 AD=0.25675 PS=0.925 PD=1.44
M$12157 VGND \$7301 A2|C|X VGND sky130_fd_pr__nfet_01v8 L=0.15 W=0.65
+ AS=0.25675 AD=0.169 PS=1.44 PD=1.82
M$12159 VGND A2|B|C|X \$7381 VGND sky130_fd_pr__nfet_01v8 L=0.15 W=0.65
+ AS=0.169 AD=0.08775 PS=1.82 PD=0.92
M$12160 \$7381 A|A1|B|Y \$7382 VGND sky130_fd_pr__nfet_01v8 L=0.15 W=0.65
+ AS=0.08775 AD=0.10725 PS=0.92 PD=0.98
M$12161 \$7382 A|A1|B1|X A1|B|Y VGND sky130_fd_pr__nfet_01v8 L=0.15 W=0.65
+ AS=0.10725 AD=0.169 PS=0.98 PD=1.82
M$12164 \$7128 A|X VGND VGND sky130_fd_pr__nfet_01v8 L=0.15 W=0.42 AS=0.1092
+ AD=0.10025 PS=1.36 PD=0.985
M$12165 VGND B|SLEEP|Y A|B|X VGND sky130_fd_pr__nfet_01v8 L=0.15 W=1.3 AS=0.188
+ AD=0.188 PS=1.905 PD=1.905
M$12166 A|B|X \$7128 VGND VGND sky130_fd_pr__nfet_01v8 L=0.15 W=0.65 AS=0.08775
+ AD=0.169 PS=0.92 PD=1.82
M$12167 VGND B|SLEEP|Y \$7304 VGND sky130_fd_pr__nfet_01v8 L=0.15 W=0.65
+ AS=0.169 AD=0.08775 PS=1.82 PD=0.92
M$12168 \$7304 A|X VGND VGND sky130_fd_pr__nfet_01v8 L=0.15 W=0.65 AS=0.08775
+ AD=0.08775 PS=0.92 PD=0.92
M$12169 VGND A|X \$7386 VGND sky130_fd_pr__nfet_01v8 L=0.15 W=0.65 AS=0.08775
+ AD=0.08775 PS=0.92 PD=0.92
M$12170 \$7386 B|SLEEP|Y A|X VGND sky130_fd_pr__nfet_01v8 L=0.15 W=0.65
+ AS=0.08775 AD=0.25025 PS=0.92 PD=1.42
M$12171 A|X \$7304 VGND VGND sky130_fd_pr__nfet_01v8 L=0.15 W=0.65 AS=0.25025
+ AD=0.208 PS=1.42 PD=1.94
M$12176 \$7276 A|Y \$7198 VGND sky130_fd_pr__nfet_01v8 L=0.15 W=0.42 AS=0.1092
+ AD=0.0441 PS=1.36 PD=0.63
M$12177 \$7198 A|B|X \$7196 VGND sky130_fd_pr__nfet_01v8 L=0.15 W=0.42
+ AS=0.0441 AD=0.0441 PS=0.63 PD=0.63
M$12178 \$7196 B|B_N|C|X VGND VGND sky130_fd_pr__nfet_01v8 L=0.15 W=0.42
+ AS=0.0441 AD=0.13165 PS=0.63 PD=1.14
M$12179 VGND \$7276 A|A1|B1|X VGND sky130_fd_pr__nfet_01v8 L=0.15 W=0.65
+ AS=0.13165 AD=0.169 PS=1.14 PD=1.82
M$12181 VGND B|C|X \$7205 VGND sky130_fd_pr__nfet_01v8 L=0.15 W=0.65 AS=0.169
+ AD=0.08775 PS=1.82 PD=0.92
M$12182 \$7205 A|B|X \$7206 VGND sky130_fd_pr__nfet_01v8 L=0.15 W=0.65
+ AS=0.08775 AD=0.10725 PS=0.92 PD=0.98
M$12183 \$7206 A|B|X A|A_N|Y VGND sky130_fd_pr__nfet_01v8 L=0.15 W=0.65
+ AS=0.10725 AD=0.169 PS=0.98 PD=1.82
M$12184 VGND A|B|X \$7390 VGND sky130_fd_pr__nfet_01v8 L=0.15 W=0.65 AS=0.169
+ AD=0.08775 PS=1.82 PD=0.92
M$12185 \$7390 A|B|X A|Y VGND sky130_fd_pr__nfet_01v8 L=0.15 W=0.65 AS=0.08775
+ AD=0.169 PS=0.92 PD=1.82
M$12186 VGND B|C|X \$7132 VGND sky130_fd_pr__nfet_01v8 L=0.15 W=0.65 AS=0.169
+ AD=0.08775 PS=1.82 PD=0.92
M$12187 \$7132 A|Y VGND VGND sky130_fd_pr__nfet_01v8 L=0.15 W=0.65 AS=0.08775
+ AD=0.08775 PS=0.92 PD=0.92
M$12188 VGND A|Y \$7214 VGND sky130_fd_pr__nfet_01v8 L=0.15 W=0.65 AS=0.08775
+ AD=0.08775 PS=0.92 PD=0.92
M$12189 \$7214 B|C|X A2|X VGND sky130_fd_pr__nfet_01v8 L=0.15 W=0.65 AS=0.08775
+ AD=0.25025 PS=0.92 PD=1.42
M$12190 A2|X \$7132 VGND VGND sky130_fd_pr__nfet_01v8 L=0.15 W=0.65 AS=0.25025
+ AD=0.208 PS=1.42 PD=1.94
M$12193 VGND B|Y \$7308 VGND sky130_fd_pr__nfet_01v8 L=0.15 W=0.65 AS=0.169
+ AD=0.08775 PS=1.82 PD=0.92
M$12194 \$7308 A|B|X VGND VGND sky130_fd_pr__nfet_01v8 L=0.15 W=0.65 AS=0.08775
+ AD=0.08775 PS=0.92 PD=0.92
M$12195 VGND A|B|X \$7391 VGND sky130_fd_pr__nfet_01v8 L=0.15 W=0.65 AS=0.08775
+ AD=0.08775 PS=0.92 PD=0.92
M$12196 \$7391 B|Y A_N|B|B1|C|X VGND sky130_fd_pr__nfet_01v8 L=0.15 W=0.65
+ AS=0.08775 AD=0.25025 PS=0.92 PD=1.42
M$12197 A_N|B|B1|C|X \$7308 VGND VGND sky130_fd_pr__nfet_01v8 L=0.15 W=0.65
+ AS=0.25025 AD=0.208 PS=1.42 PD=1.94
M$12198 VGND A2|X \$7217 VGND sky130_fd_pr__nfet_01v8 L=0.15 W=0.65 AS=0.17225
+ AD=0.095875 PS=1.83 PD=0.945
M$12199 \$7217 A1|Y A|B|C|Y VGND sky130_fd_pr__nfet_01v8 L=0.15 W=0.65
+ AS=0.095875 AD=0.091 PS=0.945 PD=0.93
M$12200 A|B|C|Y A|A1|B1|X VGND VGND sky130_fd_pr__nfet_01v8 L=0.15 W=0.65
+ AS=0.091 AD=0.17225 PS=0.93 PD=1.83
M$12202 \$7311 A_N|B|B1|C|X VGND VGND sky130_fd_pr__nfet_01v8 L=0.15 W=0.42
+ AS=0.1113 AD=0.118125 PS=1.37 PD=1.04
M$12203 VGND A|D|Y \$7392 VGND sky130_fd_pr__nfet_01v8 L=0.15 W=0.65
+ AS=0.118125 AD=0.08775 PS=1.04 PD=0.92
M$12204 \$7392 B|C|Y \$7393 VGND sky130_fd_pr__nfet_01v8 L=0.15 W=0.65
+ AS=0.08775 AD=0.125125 PS=0.92 PD=1.035
M$12205 \$7393 A|B|C|Y \$7394 VGND sky130_fd_pr__nfet_01v8 L=0.15 W=0.65
+ AS=0.125125 AD=0.12675 PS=1.035 PD=1.04
M$12206 \$7394 \$7311 A|B|Y VGND sky130_fd_pr__nfet_01v8 L=0.15 W=0.65
+ AS=0.12675 AD=0.2275 PS=1.04 PD=2
M$12209 A|Y A_N|B|B1|C|X VGND VGND sky130_fd_pr__nfet_01v8 L=0.15 W=0.65
+ AS=0.08775 AD=0.169 PS=0.92 PD=1.82
M$12210 A|Y A|Y \$7229 VGND sky130_fd_pr__nfet_01v8 L=0.15 W=0.65 AS=0.169
+ AD=0.10725 PS=1.82 PD=0.98
M$12211 \$7229 A|B|C|Y \$7230 VGND sky130_fd_pr__nfet_01v8 L=0.15 W=0.65
+ AS=0.10725 AD=0.08775 PS=0.98 PD=0.92
M$12212 \$7230 B|C|Y VGND VGND sky130_fd_pr__nfet_01v8 L=0.15 W=0.65 AS=0.08775
+ AD=0.169 PS=0.92 PD=1.82
M$12214 A|Y A|B1|SLEEP|Y \$7397 VGND sky130_fd_pr__nfet_01v8 L=0.15 W=0.65
+ AS=0.169 AD=0.08775 PS=1.82 PD=0.92
M$12215 \$7397 A|B|C|Y VGND VGND sky130_fd_pr__nfet_01v8 L=0.15 W=0.65
+ AS=0.08775 AD=0.169 PS=0.92 PD=1.82
M$12217 \$7313 B|C|Y \$7398 VGND sky130_fd_pr__nfet_01v8 L=0.15 W=0.65 AS=0.169
+ AD=0.06825 PS=1.82 PD=0.86
M$12218 \$7398 A|Y VGND VGND sky130_fd_pr__nfet_01v8 L=0.15 W=0.65 AS=0.06825
+ AD=0.08775 PS=0.86 PD=0.92
M$12219 VGND A|Y \$7368 VGND sky130_fd_pr__nfet_01v8 L=0.15 W=0.65 AS=0.08775
+ AD=0.169 PS=0.92 PD=1.82
M$12220 VGND B|C|Y \$7241 VGND sky130_fd_pr__nfet_01v8 L=0.15 W=0.65 AS=0.169
+ AD=0.08775 PS=1.82 PD=0.92
M$12221 \$7241 A|B1|X A|B|C|Y VGND sky130_fd_pr__nfet_01v8 L=0.15 W=0.65
+ AS=0.08775 AD=0.169 PS=0.92 PD=1.82
M$12222 VGND B|C|Y \$7368 VGND sky130_fd_pr__nfet_01v8 L=0.15 W=0.65 AS=0.169
+ AD=0.08775 PS=1.82 PD=0.92
M$12223 \$7368 \$7313 A|C|Y VGND sky130_fd_pr__nfet_01v8 L=0.15 W=0.65
+ AS=0.08775 AD=0.195 PS=0.92 PD=1.9
M$12225 VGND A|B|C|Y B|Y VGND sky130_fd_pr__nfet_01v8 L=0.15 W=0.42 AS=0.1197
+ AD=0.1092 PS=1.41 PD=1.36
M$12226 B|C|X \$7316 VGND VGND sky130_fd_pr__nfet_01v8 L=0.15 W=0.65 AS=0.169
+ AD=0.13165 PS=1.82 PD=1.14
M$12227 VGND A|C|Y \$7401 VGND sky130_fd_pr__nfet_01v8 L=0.15 W=0.42 AS=0.13165
+ AD=0.0441 PS=1.14 PD=0.63
M$12228 \$7401 A2|B|Y \$7400 VGND sky130_fd_pr__nfet_01v8 L=0.15 W=0.42
+ AS=0.0441 AD=0.0441 PS=0.63 PD=0.63
M$12229 \$7400 A|A1|Y \$7316 VGND sky130_fd_pr__nfet_01v8 L=0.15 W=0.42
+ AS=0.0441 AD=0.1092 PS=0.63 PD=1.36
M$12230 VGND A|B1|X B|Y VGND sky130_fd_pr__nfet_01v8 L=0.15 W=0.65 AS=0.17225
+ AD=0.091 PS=1.83 PD=0.93
M$12231 B|Y A|A1|Y \$7252 VGND sky130_fd_pr__nfet_01v8 L=0.15 W=0.65 AS=0.091
+ AD=0.095875 PS=0.93 PD=0.945
M$12232 \$7252 A2|B|Y VGND VGND sky130_fd_pr__nfet_01v8 L=0.15 W=0.65
+ AS=0.095875 AD=0.17225 PS=0.945 PD=1.83
M$12233 \$7317 B|Y \$7399 VGND sky130_fd_pr__nfet_01v8 L=0.15 W=0.65 AS=0.169
+ AD=0.06825 PS=1.82 PD=0.86
M$12234 \$7399 A|C|Y VGND VGND sky130_fd_pr__nfet_01v8 L=0.15 W=0.65 AS=0.06825
+ AD=0.08775 PS=0.86 PD=0.92
M$12235 VGND A|C|Y \$7369 VGND sky130_fd_pr__nfet_01v8 L=0.15 W=0.65 AS=0.08775
+ AD=0.169 PS=0.92 PD=1.82
M$12237 VGND B|Y \$7369 VGND sky130_fd_pr__nfet_01v8 L=0.15 W=0.65 AS=0.169
+ AD=0.08775 PS=1.82 PD=0.92
M$12238 \$7369 \$7317 B|C|Y VGND sky130_fd_pr__nfet_01v8 L=0.15 W=0.65
+ AS=0.08775 AD=0.195 PS=0.92 PD=1.9
M$12239 A|B1|Y A|Y \$7256 VGND sky130_fd_pr__nfet_01v8 L=0.15 W=0.65 AS=0.169
+ AD=0.08775 PS=1.82 PD=0.92
M$12240 \$7256 B|C|Y VGND VGND sky130_fd_pr__nfet_01v8 L=0.15 W=0.65 AS=0.08775
+ AD=0.169 PS=0.92 PD=1.82
M$12243 VGND A|B|X \$7395 VGND sky130_fd_pr__nfet_01v8 L=0.15 W=0.65 AS=0.169
+ AD=0.08775 PS=1.82 PD=0.92
M$12244 \$7395 A|Y A|B|B1|Y VGND sky130_fd_pr__nfet_01v8 L=0.15 W=0.65
+ AS=0.08775 AD=0.169 PS=0.92 PD=1.82
M$12245 VGND A|B|B1|Y A|B1|Y VGND sky130_fd_pr__nfet_01v8 L=0.15 W=0.65
+ AS=0.169 AD=0.08775 PS=1.82 PD=0.92
M$12246 A|B1|Y A|B|X VGND VGND sky130_fd_pr__nfet_01v8 L=0.15 W=0.65 AS=0.08775
+ AD=0.169 PS=0.92 PD=1.82
M$12248 VGND A|A2|B|Y A2|B|C|Y VGND sky130_fd_pr__nfet_01v8 L=0.15 W=0.65
+ AS=0.169 AD=0.08775 PS=1.82 PD=0.92
M$12249 A2|B|C|Y A|B|X VGND VGND sky130_fd_pr__nfet_01v8 L=0.15 W=0.65
+ AS=0.08775 AD=0.169 PS=0.92 PD=1.82
M$12250 VGND B|Y \$7141 VGND sky130_fd_pr__nfet_01v8 L=0.15 W=0.65 AS=0.169
+ AD=0.08775 PS=1.82 PD=0.92
M$12251 \$7141 A|B|X VGND VGND sky130_fd_pr__nfet_01v8 L=0.15 W=0.65 AS=0.08775
+ AD=0.08775 PS=0.92 PD=0.92
M$12252 VGND A|B|X \$7272 VGND sky130_fd_pr__nfet_01v8 L=0.15 W=0.65 AS=0.08775
+ AD=0.08775 PS=0.92 PD=0.92
M$12253 \$7272 B|Y A2|B|C|X VGND sky130_fd_pr__nfet_01v8 L=0.15 W=0.65
+ AS=0.08775 AD=0.25025 PS=0.92 PD=1.42
M$12254 A2|B|C|X \$7141 VGND VGND sky130_fd_pr__nfet_01v8 L=0.15 W=0.65
+ AS=0.25025 AD=0.208 PS=1.42 PD=1.94
M$12255 VGND A|A1|B1|Y A|A1|Y VGND sky130_fd_pr__nfet_01v8 L=0.15 W=0.65
+ AS=0.17225 AD=0.091 PS=1.83 PD=0.93
M$12256 A|A1|Y A|A1|Y \$7389 VGND sky130_fd_pr__nfet_01v8 L=0.15 W=0.65
+ AS=0.091 AD=0.095875 PS=0.93 PD=0.945
M$12257 \$7389 A|A2|B|C_N|Y VGND VGND sky130_fd_pr__nfet_01v8 L=0.15 W=0.65
+ AS=0.095875 AD=0.17225 PS=0.945 PD=1.83
M$12261 B|Y A|A1|X \$7387 VGND sky130_fd_pr__nfet_01v8 L=0.15 W=0.65 AS=0.091
+ AD=0.095875 PS=0.93 PD=0.945
M$12262 \$7387 A|A2|B|Y VGND VGND sky130_fd_pr__nfet_01v8 L=0.15 W=0.65
+ AS=0.095875 AD=0.17225 PS=0.945 PD=1.83
M$12266 VGND \$7331 A|Q VGND sky130_fd_pr__nfet_01v8 L=0.15 W=0.65 AS=0.2087
+ AD=0.169 PS=2.02 PD=1.82
M$12267 \$7068 C|Y \$7110 VGND sky130_fd_pr__nfet_01v8 L=0.15 W=0.42 AS=0.1092
+ AD=0.0441 PS=1.36 PD=0.63
M$12268 \$7110 A|Q VGND VGND sky130_fd_pr__nfet_01v8 L=0.15 W=0.42 AS=0.0441
+ AD=0.0567 PS=0.63 PD=0.69
M$12269 VGND A|Q \$7108 VGND sky130_fd_pr__nfet_01v8 L=0.15 W=0.42 AS=0.0567
+ AD=0.0441 PS=0.69 PD=0.63
M$12270 \$7108 B|X \$7068 VGND sky130_fd_pr__nfet_01v8 L=0.15 W=0.42 AS=0.0441
+ AD=0.0567 PS=0.63 PD=0.69
M$12271 \$7068 B|X \$7109 VGND sky130_fd_pr__nfet_01v8 L=0.15 W=0.42 AS=0.0567
+ AD=0.0441 PS=0.69 PD=0.63
M$12272 VGND C|Y \$7109 VGND sky130_fd_pr__nfet_01v8 L=0.15 W=0.42 AS=0.1474
+ AD=0.0441 PS=1.215 PD=0.63
M$12273 VGND \$7068 A|B|X VGND sky130_fd_pr__nfet_01v8 L=0.15 W=0.65 AS=0.1474
+ AD=0.23725 PS=1.215 PD=2.03
M$12275 B|X \$7335 VGND VGND sky130_fd_pr__nfet_01v8 L=0.15 W=0.65 AS=0.23725
+ AD=0.1474 PS=2.03 PD=1.215
M$12276 VGND B|C|X \$7377 VGND sky130_fd_pr__nfet_01v8 L=0.15 W=0.42 AS=0.1474
+ AD=0.0441 PS=1.215 PD=0.63
M$12277 \$7377 A|B|X \$7335 VGND sky130_fd_pr__nfet_01v8 L=0.15 W=0.42
+ AS=0.0441 AD=0.0567 PS=0.63 PD=0.69
M$12278 \$7335 A|B|X \$7376 VGND sky130_fd_pr__nfet_01v8 L=0.15 W=0.42
+ AS=0.0567 AD=0.0441 PS=0.69 PD=0.63
M$12279 \$7376 A|Q VGND VGND sky130_fd_pr__nfet_01v8 L=0.15 W=0.42 AS=0.0441
+ AD=0.0567 PS=0.63 PD=0.69
M$12280 VGND A|Q \$7375 VGND sky130_fd_pr__nfet_01v8 L=0.15 W=0.42 AS=0.0567
+ AD=0.0441 PS=0.69 PD=0.63
M$12281 \$7375 B|C|X \$7335 VGND sky130_fd_pr__nfet_01v8 L=0.15 W=0.42
+ AS=0.0441 AD=0.1092 PS=0.63 PD=1.36
M$12291 \$7367 A|A1|X VGND VGND sky130_fd_pr__nfet_01v8 L=0.15 W=0.42 AS=0.1113
+ AD=0.0588 PS=1.37 PD=0.7
M$12292 VGND A2|B|C|Y \$7367 VGND sky130_fd_pr__nfet_01v8 L=0.15 W=0.42
+ AS=0.0588 AD=0.0588 PS=0.7 PD=0.7
M$12293 \$7367 B1|SLEEP|Y A|A0|B|Y VGND sky130_fd_pr__nfet_01v8 L=0.15 W=0.42
+ AS=0.0588 AD=0.1113 PS=0.7 PD=1.37
M$12308 B|Y A|B|B1|Y \$7370 VGND sky130_fd_pr__nfet_01v8 L=0.15 W=0.42
+ AS=0.1113 AD=0.0588 PS=1.37 PD=0.7
M$12309 \$7370 A|A2|B|Y VGND VGND sky130_fd_pr__nfet_01v8 L=0.15 W=0.42
+ AS=0.0588 AD=0.0588 PS=0.7 PD=0.7
M$12310 VGND A|A1|Y \$7370 VGND sky130_fd_pr__nfet_01v8 L=0.15 W=0.42 AS=0.0588
+ AD=0.1113 PS=0.7 PD=1.37
M$12316 \$7323 CLK|TICK VGND VGND sky130_fd_pr__nfet_01v8 L=0.15 W=0.42
+ AS=0.1092 AD=0.0567 PS=1.36 PD=0.69
M$12317 VGND \$7323 \$7324 VGND sky130_fd_pr__nfet_01v8 L=0.15 W=0.42 AS=0.0567
+ AD=0.1092 PS=0.69 PD=1.36
M$12318 VGND D|X \$7326 VGND sky130_fd_pr__nfet_01v8 L=0.15 W=0.42 AS=0.2205
+ AD=0.066 PS=1.89 PD=0.745
M$12319 \$7326 \$7323 \$7327 VGND sky130_fd_pr__nfet_01v8 L=0.15 W=0.36
+ AS=0.066 AD=0.0594 PS=0.745 PD=0.69
M$12320 \$7384 \$7324 \$7327 VGND sky130_fd_pr__nfet_01v8 L=0.15 W=0.36
+ AS=0.1401 AD=0.0594 PS=1.1 PD=0.69
M$12321 \$7384 \$7329 \$7383 VGND sky130_fd_pr__nfet_01v8 L=0.15 W=0.42
+ AS=0.1401 AD=0.0441 PS=1.1 PD=0.63
M$12322 VGND RESET_B|X \$7383 VGND sky130_fd_pr__nfet_01v8 L=0.15 W=0.42
+ AS=0.1346 AD=0.0441 PS=1.15 PD=0.63
M$12323 VGND \$7327 \$7329 VGND sky130_fd_pr__nfet_01v8 L=0.15 W=0.64 AS=0.1346
+ AD=0.0999 PS=1.15 PD=0.985
M$12324 \$7329 \$7324 \$7330 VGND sky130_fd_pr__nfet_01v8 L=0.15 W=0.36
+ AS=0.0999 AD=0.0711 PS=0.985 PD=0.755
M$12325 \$7380 \$7323 \$7330 VGND sky130_fd_pr__nfet_01v8 L=0.15 W=0.36
+ AS=0.0669 AD=0.0711 PS=0.75 PD=0.755
M$12326 \$7380 \$7331 VGND VGND sky130_fd_pr__nfet_01v8 L=0.15 W=0.42 AS=0.0669
+ AD=0.12495 PS=0.75 PD=1.015
M$12327 VGND RESET_B|X \$7378 VGND sky130_fd_pr__nfet_01v8 L=0.15 W=0.42
+ AS=0.12495 AD=0.06405 PS=1.015 PD=0.725
M$12328 \$7378 \$7330 \$7331 VGND sky130_fd_pr__nfet_01v8 L=0.15 W=0.42
+ AS=0.06405 AD=0.1092 PS=0.725 PD=1.36
M$12341 VGND A2|D|Y \$7469 VGND sky130_fd_pr__nfet_01v8 L=0.15 W=0.65 AS=0.169
+ AD=0.08775 PS=1.82 PD=0.92
M$12342 \$7469 A2|B|C|Y \$7471 VGND sky130_fd_pr__nfet_01v8 L=0.15 W=0.65
+ AS=0.08775 AD=0.08775 PS=0.92 PD=0.92
M$12343 \$7471 A|B|Y \$7470 VGND sky130_fd_pr__nfet_01v8 L=0.15 W=0.65
+ AS=0.08775 AD=0.10725 PS=0.92 PD=0.98
M$12344 \$7470 A|B1|X A|B1|Y VGND sky130_fd_pr__nfet_01v8 L=0.15 W=0.65
+ AS=0.10725 AD=0.195 PS=0.98 PD=1.9
M$12346 VGND A2|C|X \$7478 VGND sky130_fd_pr__nfet_01v8 L=0.15 W=0.65
+ AS=0.17225 AD=0.095875 PS=1.83 PD=0.945
M$12347 \$7478 A1|B|Y A2|A4|Y VGND sky130_fd_pr__nfet_01v8 L=0.15 W=0.65
+ AS=0.095875 AD=0.091 PS=0.945 PD=0.93
M$12348 A2|A4|Y A|B1|Y VGND VGND sky130_fd_pr__nfet_01v8 L=0.15 W=0.65 AS=0.091
+ AD=0.17225 PS=0.93 PD=1.83
M$12349 \$7404 A|B1|Y \$7483 VGND sky130_fd_pr__nfet_01v8 L=0.15 W=0.42
+ AS=0.1092 AD=0.0441 PS=1.36 PD=0.63
M$12350 \$7483 A1|B|Y \$7482 VGND sky130_fd_pr__nfet_01v8 L=0.15 W=0.42
+ AS=0.0441 AD=0.0441 PS=0.63 PD=0.63
M$12351 \$7482 A2|C|X VGND VGND sky130_fd_pr__nfet_01v8 L=0.15 W=0.42 AS=0.0441
+ AD=0.13165 PS=0.63 PD=1.14
M$12352 VGND \$7404 A1|A3|X VGND sky130_fd_pr__nfet_01v8 L=0.15 W=0.65
+ AS=0.13165 AD=0.169 PS=1.14 PD=1.82
M$12353 VGND A|A0|B|Y \$7407 VGND sky130_fd_pr__nfet_01v8 L=0.15 W=0.42
+ AS=0.1092 AD=0.0567 PS=1.36 PD=0.69
M$12354 \$7407 B|C|SLEEP|Y VGND VGND sky130_fd_pr__nfet_01v8 L=0.15 W=0.42
+ AS=0.0567 AD=0.10025 PS=0.69 PD=0.985
M$12355 VGND \$7407 A2|X VGND sky130_fd_pr__nfet_01v8 L=0.15 W=0.65 AS=0.10025
+ AD=0.169 PS=0.985 PD=1.82
M$12358 VGND B|X \$7409 VGND sky130_fd_pr__nfet_01v8 L=0.15 W=0.65 AS=0.169
+ AD=0.08775 PS=1.82 PD=0.92
M$12359 \$7409 A|X VGND VGND sky130_fd_pr__nfet_01v8 L=0.15 W=0.65 AS=0.08775
+ AD=0.08775 PS=0.92 PD=0.92
M$12360 VGND A|X \$7496 VGND sky130_fd_pr__nfet_01v8 L=0.15 W=0.65 AS=0.08775
+ AD=0.08775 PS=0.92 PD=0.92
M$12361 \$7496 B|X A|X VGND sky130_fd_pr__nfet_01v8 L=0.15 W=0.65 AS=0.08775
+ AD=0.25025 PS=0.92 PD=1.42
M$12362 A|X \$7409 VGND VGND sky130_fd_pr__nfet_01v8 L=0.15 W=0.65 AS=0.25025
+ AD=0.208 PS=1.42 PD=1.94
M$12364 \$7411 A|X \$7502 VGND sky130_fd_pr__nfet_01v8 L=0.15 W=0.42 AS=0.1113
+ AD=0.0441 PS=1.37 PD=0.63
M$12365 \$7502 B|X VGND VGND sky130_fd_pr__nfet_01v8 L=0.15 W=0.42 AS=0.0441
+ AD=0.0966 PS=0.63 PD=0.88
M$12366 VGND \$7411 A|B|X VGND sky130_fd_pr__nfet_01v8 L=0.15 W=0.42 AS=0.0966
+ AD=0.1113 PS=0.88 PD=1.37
M$12369 A|A1|Y A|D|Y VGND VGND sky130_fd_pr__nfet_01v8 L=0.15 W=0.42 AS=0.1092
+ AD=0.1197 PS=1.36 PD=1.41
M$12370 VGND A_N|B|B1|C|X \$7519 VGND sky130_fd_pr__nfet_01v8 L=0.15 W=0.65
+ AS=0.169 AD=0.08775 PS=1.82 PD=0.92
M$12371 \$7519 A|A2|B|X \$7520 VGND sky130_fd_pr__nfet_01v8 L=0.15 W=0.65
+ AS=0.08775 AD=0.10725 PS=0.92 PD=0.98
M$12372 \$7520 A|A1|Y A|A2|Y VGND sky130_fd_pr__nfet_01v8 L=0.15 W=0.65
+ AS=0.10725 AD=0.169 PS=0.98 PD=1.82
M$12373 VGND A|A2|B|X \$7523 VGND sky130_fd_pr__nfet_01v8 L=0.15 W=0.65
+ AS=0.17225 AD=0.095875 PS=1.83 PD=0.945
M$12374 \$7523 A|A1|Y A|B1|SLEEP|Y VGND sky130_fd_pr__nfet_01v8 L=0.15 W=0.65
+ AS=0.095875 AD=0.091 PS=0.945 PD=0.93
M$12375 A|B1|SLEEP|Y A_N|B|B1|C|X VGND VGND sky130_fd_pr__nfet_01v8 L=0.15
+ W=0.65 AS=0.091 AD=0.17225 PS=0.93 PD=1.83
M$12377 \$7414 A|A2|Y VGND VGND sky130_fd_pr__nfet_01v8 L=0.15 W=0.42 AS=0.1092
+ AD=0.10025 PS=1.36 PD=0.985
M$12378 VGND A|B1|SLEEP|Y A|B|B_N|X VGND sky130_fd_pr__nfet_01v8 L=0.15 W=0.65
+ AS=0.10025 AD=0.08775 PS=0.985 PD=0.92
M$12379 A|B|B_N|X \$7414 VGND VGND sky130_fd_pr__nfet_01v8 L=0.15 W=0.65
+ AS=0.08775 AD=0.169 PS=0.92 PD=1.82
M$12380 \$7416 B|Y \$7535 VGND sky130_fd_pr__nfet_01v8 L=0.15 W=0.65 AS=0.169
+ AD=0.06825 PS=1.82 PD=0.86
M$12381 \$7535 A|B|C|Y VGND VGND sky130_fd_pr__nfet_01v8 L=0.15 W=0.65
+ AS=0.06825 AD=0.08775 PS=0.86 PD=0.92
M$12382 VGND A|B|C|Y \$7417 VGND sky130_fd_pr__nfet_01v8 L=0.15 W=0.65
+ AS=0.08775 AD=0.169 PS=0.92 PD=1.82
M$12383 VGND B|Y \$7417 VGND sky130_fd_pr__nfet_01v8 L=0.15 W=0.65 AS=0.169
+ AD=0.08775 PS=1.82 PD=0.92
M$12384 \$7417 \$7416 A2|B|Y VGND sky130_fd_pr__nfet_01v8 L=0.15 W=0.65
+ AS=0.08775 AD=0.195 PS=0.92 PD=1.9
M$12386 \$7418 A2|B|Y \$7544 VGND sky130_fd_pr__nfet_01v8 L=0.15 W=0.65
+ AS=0.169 AD=0.06825 PS=1.82 PD=0.86
M$12387 \$7544 A|A1|Y VGND VGND sky130_fd_pr__nfet_01v8 L=0.15 W=0.65
+ AS=0.06825 AD=0.08775 PS=0.86 PD=0.92
M$12388 VGND A|A1|Y \$7419 VGND sky130_fd_pr__nfet_01v8 L=0.15 W=0.65
+ AS=0.08775 AD=0.169 PS=0.92 PD=1.82
M$12389 VGND A2|B|Y \$7419 VGND sky130_fd_pr__nfet_01v8 L=0.15 W=0.65 AS=0.169
+ AD=0.08775 PS=1.82 PD=0.92
M$12390 \$7419 \$7418 B|Y VGND sky130_fd_pr__nfet_01v8 L=0.15 W=0.65 AS=0.08775
+ AD=0.195 PS=0.92 PD=1.9
M$12394 VGND B|Y \$7420 VGND sky130_fd_pr__nfet_01v8 L=0.15 W=0.65 AS=0.169
+ AD=0.08775 PS=1.82 PD=0.92
M$12395 \$7420 A|X VGND VGND sky130_fd_pr__nfet_01v8 L=0.15 W=0.65 AS=0.08775
+ AD=0.08775 PS=0.92 PD=0.92
M$12396 VGND A|X \$7554 VGND sky130_fd_pr__nfet_01v8 L=0.15 W=0.65 AS=0.08775
+ AD=0.08775 PS=0.92 PD=0.92
M$12397 \$7554 B|Y A|B|X VGND sky130_fd_pr__nfet_01v8 L=0.15 W=0.65 AS=0.08775
+ AD=0.25025 PS=0.92 PD=1.42
M$12398 A|B|X \$7420 VGND VGND sky130_fd_pr__nfet_01v8 L=0.15 W=0.65 AS=0.25025
+ AD=0.208 PS=1.42 PD=1.94
M$12399 A|A1|B|C|Y A|B|X \$7555 VGND sky130_fd_pr__nfet_01v8 L=0.15 W=0.65
+ AS=0.169 AD=0.08775 PS=1.82 PD=0.92
M$12400 \$7555 B|C|Y VGND VGND sky130_fd_pr__nfet_01v8 L=0.15 W=0.65 AS=0.08775
+ AD=0.169 PS=0.92 PD=1.82
M$12401 VGND A|A1|B|C|Y \$7566 VGND sky130_fd_pr__nfet_01v8 L=0.15 W=0.65
+ AS=0.169 AD=0.08775 PS=1.82 PD=0.92
M$12402 \$7566 A|B|B1|Y \$7567 VGND sky130_fd_pr__nfet_01v8 L=0.15 W=0.65
+ AS=0.08775 AD=0.10725 PS=0.92 PD=0.98
M$12403 \$7567 A|X A|A2|B|Y VGND sky130_fd_pr__nfet_01v8 L=0.15 W=0.65
+ AS=0.10725 AD=0.169 PS=0.98 PD=1.82
M$12405 VGND A|A2|B|Y \$7423 VGND sky130_fd_pr__nfet_01v8 L=0.15 W=0.65
+ AS=0.169 AD=0.08775 PS=1.82 PD=0.92
M$12406 \$7423 A|A1|Y VGND VGND sky130_fd_pr__nfet_01v8 L=0.15 W=0.65
+ AS=0.08775 AD=0.08775 PS=0.92 PD=0.92
M$12407 VGND A|A1|Y \$7578 VGND sky130_fd_pr__nfet_01v8 L=0.15 W=0.65
+ AS=0.08775 AD=0.08775 PS=0.92 PD=0.92
M$12408 \$7578 A|A2|B|Y A|B|C|X VGND sky130_fd_pr__nfet_01v8 L=0.15 W=0.65
+ AS=0.08775 AD=0.25025 PS=0.92 PD=1.42
M$12409 A|B|C|X \$7423 VGND VGND sky130_fd_pr__nfet_01v8 L=0.15 W=0.65
+ AS=0.25025 AD=0.208 PS=1.42 PD=1.94
M$12410 VGND A2|B|C|Y \$7581 VGND sky130_fd_pr__nfet_01v8 L=0.15 W=0.42
+ AS=0.13165 AD=0.0441 PS=1.14 PD=0.63
M$12411 \$7581 A|A2|B|C_N|Y \$7580 VGND sky130_fd_pr__nfet_01v8 L=0.15 W=0.42
+ AS=0.0441 AD=0.0441 PS=0.63 PD=0.63
M$12412 \$7580 A|A1|Y \$7425 VGND sky130_fd_pr__nfet_01v8 L=0.15 W=0.42
+ AS=0.0441 AD=0.1092 PS=0.63 PD=1.36
M$12413 A|B1_N|X \$7425 VGND VGND sky130_fd_pr__nfet_01v8 L=0.15 W=0.65
+ AS=0.169 AD=0.13165 PS=1.82 PD=1.14
M$12415 VGND A|B|C|X \$7586 VGND sky130_fd_pr__nfet_01v8 L=0.15 W=0.65 AS=0.169
+ AD=0.08775 PS=1.82 PD=0.92
M$12416 \$7586 A|B1|Y A|A1|Y VGND sky130_fd_pr__nfet_01v8 L=0.15 W=0.65
+ AS=0.08775 AD=0.169 PS=0.92 PD=1.82
M$12417 \$7426 A|A1|X \$7589 VGND sky130_fd_pr__nfet_01v8 L=0.15 W=0.42
+ AS=0.1092 AD=0.0441 PS=1.36 PD=0.63
M$12418 \$7589 A|A2|B|Y \$7588 VGND sky130_fd_pr__nfet_01v8 L=0.15 W=0.42
+ AS=0.0441 AD=0.0441 PS=0.63 PD=0.63
M$12419 \$7588 A|B|C|X VGND VGND sky130_fd_pr__nfet_01v8 L=0.15 W=0.42
+ AS=0.0441 AD=0.13165 PS=0.63 PD=1.14
M$12420 VGND \$7426 B|C|X VGND sky130_fd_pr__nfet_01v8 L=0.15 W=0.65 AS=0.13165
+ AD=0.169 PS=1.14 PD=1.82
M$12421 \$7428 B|Y \$7591 VGND sky130_fd_pr__nfet_01v8 L=0.15 W=0.65 AS=0.169
+ AD=0.06825 PS=1.82 PD=0.86
M$12422 \$7591 A|B|C|X VGND VGND sky130_fd_pr__nfet_01v8 L=0.15 W=0.65
+ AS=0.06825 AD=0.08775 PS=0.86 PD=0.92
M$12423 VGND A|B|C|X \$7429 VGND sky130_fd_pr__nfet_01v8 L=0.15 W=0.65
+ AS=0.08775 AD=0.169 PS=0.92 PD=1.82
M$12424 VGND B|Y \$7429 VGND sky130_fd_pr__nfet_01v8 L=0.15 W=0.65 AS=0.169
+ AD=0.08775 PS=1.82 PD=0.92
M$12425 \$7429 \$7428 B|B_N|Y VGND sky130_fd_pr__nfet_01v8 L=0.15 W=0.65
+ AS=0.08775 AD=0.195 PS=0.92 PD=1.9
M$12426 \$7430 B|B_N|Y VGND VGND sky130_fd_pr__nfet_01v8 L=0.15 W=0.42
+ AS=0.1092 AD=0.10025 PS=1.36 PD=0.985
M$12428 A|Y \$7430 VGND VGND sky130_fd_pr__nfet_01v8 L=0.15 W=0.65 AS=0.08775
+ AD=0.169 PS=0.92 PD=1.82
M$12429 VGND B|B_N|Y \$7431 VGND sky130_fd_pr__nfet_01v8 L=0.15 W=0.65 AS=0.169
+ AD=0.08775 PS=1.82 PD=0.92
M$12430 \$7431 A|Y VGND VGND sky130_fd_pr__nfet_01v8 L=0.15 W=0.65 AS=0.08775
+ AD=0.08775 PS=0.92 PD=0.92
M$12431 VGND A|Y \$7600 VGND sky130_fd_pr__nfet_01v8 L=0.15 W=0.65 AS=0.08775
+ AD=0.08775 PS=0.92 PD=0.92
M$12432 \$7600 B|B_N|Y C|X VGND sky130_fd_pr__nfet_01v8 L=0.15 W=0.65
+ AS=0.08775 AD=0.25025 PS=0.92 PD=1.42
M$12433 C|X \$7431 VGND VGND sky130_fd_pr__nfet_01v8 L=0.15 W=0.65 AS=0.25025
+ AD=0.208 PS=1.42 PD=1.94
M$12435 D|X \$7433 VGND VGND sky130_fd_pr__nfet_01v8 L=0.15 W=0.65 AS=0.169
+ AD=0.144125 PS=1.82 PD=1.12
M$12436 VGND C|X \$7434 VGND sky130_fd_pr__nfet_01v8 L=0.15 W=0.42 AS=0.144125
+ AD=0.1764 PS=1.12 PD=1.68
M$12437 VGND B|X \$7437 VGND sky130_fd_pr__nfet_01v8 L=0.15 W=0.65 AS=0.195
+ AD=0.1653 PS=1.9 PD=1.82
M$12438 \$7435 \$7437 \$7439 VGND sky130_fd_pr__nfet_01v8 L=0.15 W=0.42
+ AS=0.18365 AD=0.19265 PS=1.25 PD=1.285
M$12439 \$7436 \$7437 \$7438 VGND sky130_fd_pr__nfet_01v8 L=0.15 W=0.6
+ AS=0.140825 AD=0.11 PS=1.1 PD=0.99
M$12440 \$7438 A|Q VGND VGND sky130_fd_pr__nfet_01v8 L=0.15 W=0.64 AS=0.11
+ AD=0.0864 PS=0.99 PD=0.91
M$12441 VGND \$7438 \$7439 VGND sky130_fd_pr__nfet_01v8 L=0.15 W=0.64 AS=0.0864
+ AD=0.1824 PS=0.91 PD=1.85
M$12442 \$7438 B|X \$7435 VGND sky130_fd_pr__nfet_01v8 L=0.15 W=0.64 AS=0.1628
+ AD=0.18365 PS=1.8 PD=1.25
M$12443 \$7436 B|X \$7439 VGND sky130_fd_pr__nfet_01v8 L=0.15 W=0.64
+ AS=0.140825 AD=0.19265 PS=1.1 PD=1.285
M$12444 A|Q \$7440 VGND VGND sky130_fd_pr__nfet_01v8 L=0.15 W=0.65 AS=0.169
+ AD=0.2087 PS=1.82 PD=2.02
M$12445 \$7561 \$7441 \$7623 VGND sky130_fd_pr__nfet_01v8 L=0.15 W=0.36
+ AS=0.0669 AD=0.0711 PS=0.75 PD=0.755
M$12446 \$7623 \$7442 \$7443 VGND sky130_fd_pr__nfet_01v8 L=0.15 W=0.36
+ AS=0.0711 AD=0.0999 PS=0.755 PD=0.985
M$12447 \$7547 \$7442 \$7444 VGND sky130_fd_pr__nfet_01v8 L=0.15 W=0.36
+ AS=0.1401 AD=0.0594 PS=1.1 PD=0.69
M$12448 \$7444 \$7441 \$7445 VGND sky130_fd_pr__nfet_01v8 L=0.15 W=0.36
+ AS=0.0594 AD=0.066 PS=0.69 PD=0.745
M$12449 \$7440 \$7623 \$7564 VGND sky130_fd_pr__nfet_01v8 L=0.15 W=0.42
+ AS=0.1092 AD=0.06405 PS=1.36 PD=0.725
M$12450 \$7564 RESET_B|X VGND VGND sky130_fd_pr__nfet_01v8 L=0.15 W=0.42
+ AS=0.06405 AD=0.12495 PS=0.725 PD=1.015
M$12451 VGND \$7440 \$7561 VGND sky130_fd_pr__nfet_01v8 L=0.15 W=0.42
+ AS=0.12495 AD=0.0669 PS=1.015 PD=0.75
M$12452 VGND RESET_B|X \$7548 VGND sky130_fd_pr__nfet_01v8 L=0.15 W=0.42
+ AS=0.1346 AD=0.0441 PS=1.15 PD=0.63
M$12453 \$7548 \$7443 \$7547 VGND sky130_fd_pr__nfet_01v8 L=0.15 W=0.42
+ AS=0.0441 AD=0.1401 PS=0.63 PD=1.1
M$12454 \$7445 D|Y VGND VGND sky130_fd_pr__nfet_01v8 L=0.15 W=0.42 AS=0.066
+ AD=0.2205 PS=0.745 PD=1.89
M$12455 \$7443 \$7444 VGND VGND sky130_fd_pr__nfet_01v8 L=0.15 W=0.64 AS=0.0999
+ AD=0.1346 PS=0.985 PD=1.15
M$12456 \$7442 \$7441 VGND VGND sky130_fd_pr__nfet_01v8 L=0.15 W=0.42 AS=0.1092
+ AD=0.0567 PS=1.36 PD=0.69
M$12457 VGND CLK|TICK \$7441 VGND sky130_fd_pr__nfet_01v8 L=0.15 W=0.42
+ AS=0.0567 AD=0.1092 PS=0.69 PD=1.36
M$12473 VGND A|A0|B|Y A1|Y VGND sky130_fd_pr__nfet_01v8 L=0.15 W=0.65 AS=0.169
+ AD=0.08775 PS=1.82 PD=0.92
M$12475 A|Y A|B1|X \$7716 VGND sky130_fd_pr__nfet_01v8 L=0.15 W=0.65 AS=0.169
+ AD=0.08775 PS=1.82 PD=0.92
M$12476 \$7716 A|B|Y VGND VGND sky130_fd_pr__nfet_01v8 L=0.15 W=0.65 AS=0.08775
+ AD=0.169 PS=0.92 PD=1.82
M$12477 \$7717 A|B|Y \$7777 VGND sky130_fd_pr__nfet_01v8 L=0.15 W=0.65 AS=0.169
+ AD=0.06825 PS=1.82 PD=0.86
M$12478 \$7777 A|B1|X VGND VGND sky130_fd_pr__nfet_01v8 L=0.15 W=0.65
+ AS=0.06825 AD=0.08775 PS=0.86 PD=0.92
M$12479 VGND A|B1|X \$7718 VGND sky130_fd_pr__nfet_01v8 L=0.15 W=0.65
+ AS=0.08775 AD=0.169 PS=0.92 PD=1.82
M$12480 \$7693 A1|Y VGND VGND sky130_fd_pr__nfet_01v8 L=0.15 W=0.42 AS=0.1113
+ AD=0.0588 PS=1.37 PD=0.7
M$12481 VGND A2|D|Y \$7693 VGND sky130_fd_pr__nfet_01v8 L=0.15 W=0.42 AS=0.0588
+ AD=0.0588 PS=0.7 PD=0.7
M$12482 \$7693 A|B1|Y B|C|SLEEP|Y VGND sky130_fd_pr__nfet_01v8 L=0.15 W=0.42
+ AS=0.0588 AD=0.1113 PS=0.7 PD=1.37
M$12483 VGND A|B|Y \$7718 VGND sky130_fd_pr__nfet_01v8 L=0.15 W=0.65 AS=0.169
+ AD=0.08775 PS=1.82 PD=0.92
M$12484 \$7718 \$7717 A|A1|B|Y VGND sky130_fd_pr__nfet_01v8 L=0.15 W=0.65
+ AS=0.08775 AD=0.195 PS=0.92 PD=1.9
M$12488 VGND A2|C|X \$7715 VGND sky130_fd_pr__nfet_01v8 L=0.15 W=0.65
+ AS=0.17225 AD=0.091 PS=1.83 PD=0.93
M$12489 \$7715 A1|B|Y \$7650 VGND sky130_fd_pr__nfet_01v8 L=0.15 W=0.65
+ AS=0.091 AD=0.089375 PS=0.93 PD=0.925
M$12490 \$7650 B1|X VGND VGND sky130_fd_pr__nfet_01v8 L=0.15 W=0.65 AS=0.089375
+ AD=0.25675 PS=0.925 PD=1.44
M$12491 VGND \$7650 A2|A3|C|X VGND sky130_fd_pr__nfet_01v8 L=0.15 W=0.65
+ AS=0.25675 AD=0.169 PS=1.44 PD=1.82
M$12492 VGND A|S|Y A|Y VGND sky130_fd_pr__nfet_01v8 L=0.15 W=0.65 AS=0.169
+ AD=0.08775 PS=1.82 PD=0.92
M$12493 A|Y A|A0|B|Y VGND VGND sky130_fd_pr__nfet_01v8 L=0.15 W=0.65 AS=0.08775
+ AD=0.169 PS=0.92 PD=1.82
M$12494 A1|A2|B|Y B1|X \$7722 VGND sky130_fd_pr__nfet_01v8 L=0.15 W=0.42
+ AS=0.1113 AD=0.0588 PS=1.37 PD=0.7
M$12495 \$7722 A2|A4|Y VGND VGND sky130_fd_pr__nfet_01v8 L=0.15 W=0.42
+ AS=0.0588 AD=0.0588 PS=0.7 PD=0.7
M$12496 VGND A1|A3|X \$7722 VGND sky130_fd_pr__nfet_01v8 L=0.15 W=0.42
+ AS=0.0588 AD=0.1113 PS=0.7 PD=1.37
M$12497 \$7694 A|A1|B|Y VGND VGND sky130_fd_pr__nfet_01v8 L=0.15 W=0.65
+ AS=0.182 AD=0.11375 PS=1.86 PD=1
M$12498 VGND A2|X \$7694 VGND sky130_fd_pr__nfet_01v8 L=0.15 W=0.65 AS=0.11375
+ AD=0.08775 PS=1 PD=0.92
M$12499 \$7694 A1|A3|X VGND VGND sky130_fd_pr__nfet_01v8 L=0.15 W=0.65
+ AS=0.08775 AD=0.08775 PS=0.92 PD=0.92
M$12500 VGND A2|A4|Y \$7694 VGND sky130_fd_pr__nfet_01v8 L=0.15 W=0.65
+ AS=0.08775 AD=0.203125 PS=0.92 PD=1.275
M$12501 \$7694 A|B1|X B|SLEEP|Y VGND sky130_fd_pr__nfet_01v8 L=0.15 W=0.65
+ AS=0.203125 AD=0.169 PS=1.275 PD=1.82
M$12506 B|X \$7723 VGND VGND sky130_fd_pr__nfet_01v8 L=0.15 W=0.65 AS=0.17225
+ AD=0.112125 PS=1.83 PD=0.995
M$12507 VGND A2|A3|C|X \$7802 VGND sky130_fd_pr__nfet_01v8 L=0.15 W=0.65
+ AS=0.112125 AD=0.104 PS=0.995 PD=0.97
M$12508 \$7802 A1|A2|B|Y \$7801 VGND sky130_fd_pr__nfet_01v8 L=0.15 W=0.65
+ AS=0.104 AD=0.10725 PS=0.97 PD=0.98
M$12509 \$7801 A1|X \$7723 VGND sky130_fd_pr__nfet_01v8 L=0.15 W=0.65
+ AS=0.10725 AD=0.10725 PS=0.98 PD=0.98
M$12510 \$7723 B1|Y VGND VGND sky130_fd_pr__nfet_01v8 L=0.15 W=0.65 AS=0.10725
+ AD=0.208 PS=0.98 PD=1.94
M$12515 \$7655 B|X \$7714 VGND sky130_fd_pr__nfet_01v8 L=0.15 W=0.65 AS=0.169
+ AD=0.06825 PS=1.82 PD=0.86
M$12516 \$7714 A|X VGND VGND sky130_fd_pr__nfet_01v8 L=0.15 W=0.65 AS=0.06825
+ AD=0.08775 PS=0.86 PD=0.92
M$12517 VGND A|X \$7695 VGND sky130_fd_pr__nfet_01v8 L=0.15 W=0.65 AS=0.08775
+ AD=0.169 PS=0.92 PD=1.82
M$12519 VGND B|X \$7695 VGND sky130_fd_pr__nfet_01v8 L=0.15 W=0.65 AS=0.169
+ AD=0.08775 PS=1.82 PD=0.92
M$12520 \$7695 \$7655 A|Y VGND sky130_fd_pr__nfet_01v8 L=0.15 W=0.65 AS=0.08775
+ AD=0.195 PS=0.92 PD=1.9
M$12524 C_N|Y A|Y \$7713 VGND sky130_fd_pr__nfet_01v8 L=0.15 W=0.65 AS=0.169
+ AD=0.08775 PS=1.82 PD=0.92
M$12525 \$7713 B|X VGND VGND sky130_fd_pr__nfet_01v8 L=0.15 W=0.65 AS=0.08775
+ AD=0.169 PS=0.92 PD=1.82
M$12526 VGND A|Y A|D|Y VGND sky130_fd_pr__nfet_01v8 L=0.15 W=0.65 AS=0.169
+ AD=0.08775 PS=1.82 PD=0.92
M$12527 A|D|Y B|X VGND VGND sky130_fd_pr__nfet_01v8 L=0.15 W=0.65 AS=0.08775
+ AD=0.169 PS=0.92 PD=1.82
M$12528 VGND C_N|Y \$7659 VGND sky130_fd_pr__nfet_01v8 L=0.15 W=0.42 AS=0.1092
+ AD=0.1092 PS=1.36 PD=1.36
M$12529 \$7661 \$7659 VGND VGND sky130_fd_pr__nfet_01v8 L=0.15 W=0.42 AS=0.1092
+ AD=0.0567 PS=1.36 PD=0.69
M$12530 VGND B|C|X \$7661 VGND sky130_fd_pr__nfet_01v8 L=0.15 W=0.42 AS=0.0567
+ AD=0.0567 PS=0.69 PD=0.69
M$12531 VGND A|D|Y \$7661 VGND sky130_fd_pr__nfet_01v8 L=0.15 W=0.42 AS=0.10025
+ AD=0.0567 PS=0.985 PD=0.69
M$12532 VGND \$7661 A|A2|B|X VGND sky130_fd_pr__nfet_01v8 L=0.15 W=0.65
+ AS=0.10025 AD=0.17875 PS=0.985 PD=1.85
M$12536 VGND A|A2|Y \$7712 VGND sky130_fd_pr__nfet_01v8 L=0.15 W=0.65
+ AS=0.17225 AD=0.095875 PS=1.83 PD=0.945
M$12537 \$7712 A|A1|Y B|Y VGND sky130_fd_pr__nfet_01v8 L=0.15 W=0.65
+ AS=0.095875 AD=0.091 PS=0.945 PD=0.93
M$12538 B|Y A|B1|SLEEP|Y VGND VGND sky130_fd_pr__nfet_01v8 L=0.15 W=0.65
+ AS=0.091 AD=0.17225 PS=0.93 PD=1.83
M$12539 \$7664 A|A1|Y \$7711 VGND sky130_fd_pr__nfet_01v8 L=0.15 W=0.42
+ AS=0.1092 AD=0.0441 PS=1.36 PD=0.63
M$12540 \$7711 A|B|B_N|X \$7710 VGND sky130_fd_pr__nfet_01v8 L=0.15 W=0.42
+ AS=0.0441 AD=0.0441 PS=0.63 PD=0.63
M$12541 VGND A|B|C|Y \$7710 VGND sky130_fd_pr__nfet_01v8 L=0.15 W=0.42
+ AS=0.13165 AD=0.0441 PS=1.14 PD=0.63
M$12542 VGND \$7664 A|B1|X VGND sky130_fd_pr__nfet_01v8 L=0.15 W=0.65
+ AS=0.13165 AD=0.169 PS=1.14 PD=1.82
M$12546 B|Y A|Y \$7838 VGND sky130_fd_pr__nfet_01v8 L=0.15 W=0.65 AS=0.169
+ AD=0.08775 PS=1.82 PD=0.92
M$12547 \$7838 A|B|X VGND VGND sky130_fd_pr__nfet_01v8 L=0.15 W=0.65 AS=0.08775
+ AD=0.169 PS=0.92 PD=1.82
M$12548 VGND A|B|B_N|X \$7665 VGND sky130_fd_pr__nfet_01v8 L=0.15 W=0.42
+ AS=0.10025 AD=0.1092 PS=0.985 PD=1.36
M$12549 VGND A|B|X A|A1|Y VGND sky130_fd_pr__nfet_01v8 L=0.15 W=0.65 AS=0.10025
+ AD=0.08775 PS=0.985 PD=0.92
M$12550 A|A1|Y \$7665 VGND VGND sky130_fd_pr__nfet_01v8 L=0.15 W=0.65
+ AS=0.08775 AD=0.169 PS=0.92 PD=1.82
M$12551 \$7727 B|Y \$7841 VGND sky130_fd_pr__nfet_01v8 L=0.15 W=0.65 AS=0.169
+ AD=0.06825 PS=1.82 PD=0.86
M$12552 \$7841 A|B|B_N|X VGND VGND sky130_fd_pr__nfet_01v8 L=0.15 W=0.65
+ AS=0.06825 AD=0.08775 PS=0.86 PD=0.92
M$12553 VGND A|B|B_N|X \$7728 VGND sky130_fd_pr__nfet_01v8 L=0.15 W=0.65
+ AS=0.08775 AD=0.169 PS=0.92 PD=1.82
M$12555 VGND B|Y \$7728 VGND sky130_fd_pr__nfet_01v8 L=0.15 W=0.65 AS=0.169
+ AD=0.08775 PS=1.82 PD=0.92
M$12556 \$7728 \$7727 A|C|SLEEP|Y VGND sky130_fd_pr__nfet_01v8 L=0.15 W=0.65
+ AS=0.08775 AD=0.195 PS=0.92 PD=1.9
M$12559 VGND A|B1|Y \$7731 VGND sky130_fd_pr__nfet_01v8 L=0.15 W=0.42 AS=0.1092
+ AD=0.0567 PS=1.36 PD=0.69
M$12560 \$7731 A|C|SLEEP|Y VGND VGND sky130_fd_pr__nfet_01v8 L=0.15 W=0.42
+ AS=0.0567 AD=0.10025 PS=0.69 PD=0.985
M$12561 VGND \$7731 A|X VGND sky130_fd_pr__nfet_01v8 L=0.15 W=0.65 AS=0.10025
+ AD=0.169 PS=0.985 PD=1.82
M$12562 VGND A|A1|X B|C|Y VGND sky130_fd_pr__nfet_01v8 L=0.15 W=0.65 AS=0.169
+ AD=0.08775 PS=1.82 PD=0.92
M$12563 B|C|Y A2|B|Y VGND VGND sky130_fd_pr__nfet_01v8 L=0.15 W=0.65 AS=0.08775
+ AD=0.08775 PS=0.92 PD=0.92
M$12564 VGND A|C|SLEEP|Y B|C|Y VGND sky130_fd_pr__nfet_01v8 L=0.15 W=0.65
+ AS=0.08775 AD=0.169 PS=0.92 PD=1.82
M$12566 VGND B|Y \$7735 VGND sky130_fd_pr__nfet_01v8 L=0.15 W=0.65 AS=0.169
+ AD=0.08775 PS=1.82 PD=0.92
M$12567 \$7735 A|C|SLEEP|Y VGND VGND sky130_fd_pr__nfet_01v8 L=0.15 W=0.65
+ AS=0.08775 AD=0.08775 PS=0.92 PD=0.92
M$12568 VGND A|C|SLEEP|Y \$7856 VGND sky130_fd_pr__nfet_01v8 L=0.15 W=0.65
+ AS=0.08775 AD=0.08775 PS=0.92 PD=0.92
M$12569 \$7856 B|Y A|B|C|X VGND sky130_fd_pr__nfet_01v8 L=0.15 W=0.65
+ AS=0.08775 AD=0.25025 PS=0.92 PD=1.42
M$12570 A|B|C|X \$7735 VGND VGND sky130_fd_pr__nfet_01v8 L=0.15 W=0.65
+ AS=0.25025 AD=0.208 PS=1.42 PD=1.94
M$12571 \$7422 B|C|Y VGND VGND sky130_fd_pr__nfet_01v8 L=0.15 W=0.42 AS=0.1092
+ AD=0.0567 PS=1.36 PD=0.69
M$12572 VGND A|B|X \$7422 VGND sky130_fd_pr__nfet_01v8 L=0.15 W=0.42 AS=0.0567
+ AD=0.0567 PS=0.69 PD=0.69
M$12573 VGND A|Y \$7422 VGND sky130_fd_pr__nfet_01v8 L=0.15 W=0.42 AS=0.101875
+ AD=0.0567 PS=0.99 PD=0.69
M$12574 VGND \$7422 A|X VGND sky130_fd_pr__nfet_01v8 L=0.15 W=0.65 AS=0.101875
+ AD=0.182 PS=0.99 PD=1.86
M$12581 B|Y A|B1|Y \$7738 VGND sky130_fd_pr__nfet_01v8 L=0.15 W=0.42 AS=0.1113
+ AD=0.0588 PS=1.37 PD=0.7
M$12582 \$7738 A2|B|Y VGND VGND sky130_fd_pr__nfet_01v8 L=0.15 W=0.42 AS=0.0588
+ AD=0.0588 PS=0.7 PD=0.7
M$12583 VGND A|A1|X \$7738 VGND sky130_fd_pr__nfet_01v8 L=0.15 W=0.42 AS=0.0588
+ AD=0.1113 PS=0.7 PD=1.37
M$12587 \$7740 B|X \$7877 VGND sky130_fd_pr__nfet_01v8 L=0.15 W=0.65 AS=0.169
+ AD=0.06825 PS=1.82 PD=0.86
M$12588 \$7877 A|A2|B|C_N|Y VGND VGND sky130_fd_pr__nfet_01v8 L=0.15 W=0.65
+ AS=0.06825 AD=0.08775 PS=0.86 PD=0.92
M$12589 VGND A|A2|B|C_N|Y \$7742 VGND sky130_fd_pr__nfet_01v8 L=0.15 W=0.65
+ AS=0.08775 AD=0.169 PS=0.92 PD=1.82
M$12590 VGND B|X \$7742 VGND sky130_fd_pr__nfet_01v8 L=0.15 W=0.65 AS=0.169
+ AD=0.08775 PS=1.82 PD=0.92
M$12591 \$7742 \$7740 A|A2|B|Y VGND sky130_fd_pr__nfet_01v8 L=0.15 W=0.65
+ AS=0.08775 AD=0.195 PS=0.92 PD=1.9
M$12594 VGND A|A2|B|Y \$7709 VGND sky130_fd_pr__nfet_01v8 L=0.15 W=0.65
+ AS=0.169 AD=0.08775 PS=1.82 PD=0.92
M$12595 \$7709 A|B|X A|Y VGND sky130_fd_pr__nfet_01v8 L=0.15 W=0.65 AS=0.08775
+ AD=0.169 PS=0.92 PD=1.82
M$12596 VGND B|Y \$7668 VGND sky130_fd_pr__nfet_01v8 L=0.15 W=0.65 AS=0.169
+ AD=0.08775 PS=1.82 PD=0.92
M$12597 \$7668 A|A2|B|Y VGND VGND sky130_fd_pr__nfet_01v8 L=0.15 W=0.65
+ AS=0.08775 AD=0.08775 PS=0.92 PD=0.92
M$12598 VGND A|A2|B|Y \$7708 VGND sky130_fd_pr__nfet_01v8 L=0.15 W=0.65
+ AS=0.08775 AD=0.08775 PS=0.92 PD=0.92
M$12599 \$7708 B|Y B|C|X VGND sky130_fd_pr__nfet_01v8 L=0.15 W=0.65 AS=0.08775
+ AD=0.25025 PS=0.92 PD=1.42
M$12600 B|C|X \$7668 VGND VGND sky130_fd_pr__nfet_01v8 L=0.15 W=0.65 AS=0.25025
+ AD=0.208 PS=1.42 PD=1.94
M$12608 \$7435 C|X \$7433 VGND sky130_fd_pr__nfet_01v8 L=0.15 W=0.64 AS=0.1728
+ AD=0.128 PS=1.82 PD=1.04
M$12609 \$7433 \$7434 \$7436 VGND sky130_fd_pr__nfet_01v8 L=0.15 W=0.64
+ AS=0.128 AD=0.3168 PS=1.04 PD=2.27
M$12610 B|X \$7671 VGND VGND sky130_fd_pr__nfet_01v8 L=0.15 W=0.65 AS=0.23725
+ AD=0.1474 PS=2.03 PD=1.215
M$12611 VGND C|X \$7707 VGND sky130_fd_pr__nfet_01v8 L=0.15 W=0.42 AS=0.1474
+ AD=0.0441 PS=1.215 PD=0.63
M$12612 \$7707 B|X \$7671 VGND sky130_fd_pr__nfet_01v8 L=0.15 W=0.42 AS=0.0441
+ AD=0.0567 PS=0.63 PD=0.69
M$12613 \$7671 B|X \$7706 VGND sky130_fd_pr__nfet_01v8 L=0.15 W=0.42 AS=0.0567
+ AD=0.0441 PS=0.69 PD=0.63
M$12614 \$7706 A|Q VGND VGND sky130_fd_pr__nfet_01v8 L=0.15 W=0.42 AS=0.0441
+ AD=0.0567 PS=0.63 PD=0.69
M$12615 VGND A|Q \$7705 VGND sky130_fd_pr__nfet_01v8 L=0.15 W=0.42 AS=0.0567
+ AD=0.0441 PS=0.69 PD=0.63
M$12616 \$7705 C|X \$7671 VGND sky130_fd_pr__nfet_01v8 L=0.15 W=0.42 AS=0.0441
+ AD=0.1092 PS=0.63 PD=1.36
M$12618 \$7672 B|C|X \$7704 VGND sky130_fd_pr__nfet_01v8 L=0.15 W=0.65 AS=0.169
+ AD=0.06825 PS=1.82 PD=0.86
M$12619 \$7704 A|Q VGND VGND sky130_fd_pr__nfet_01v8 L=0.15 W=0.65 AS=0.06825
+ AD=0.08775 PS=0.86 PD=0.92
M$12620 VGND A|Q \$7696 VGND sky130_fd_pr__nfet_01v8 L=0.15 W=0.65 AS=0.08775
+ AD=0.169 PS=0.92 PD=1.82
M$12621 \$7743 B|Y \$7858 VGND sky130_fd_pr__nfet_01v8 L=0.15 W=0.65 AS=0.169
+ AD=0.06825 PS=1.82 PD=0.86
M$12622 \$7858 A|B|X VGND VGND sky130_fd_pr__nfet_01v8 L=0.15 W=0.65 AS=0.06825
+ AD=0.08775 PS=0.86 PD=0.92
M$12623 VGND A|B|X \$7744 VGND sky130_fd_pr__nfet_01v8 L=0.15 W=0.65 AS=0.08775
+ AD=0.169 PS=0.92 PD=1.82
M$12624 VGND B|C|X \$7696 VGND sky130_fd_pr__nfet_01v8 L=0.15 W=0.65 AS=0.169
+ AD=0.08775 PS=1.82 PD=0.92
M$12625 \$7696 \$7672 B|Y VGND sky130_fd_pr__nfet_01v8 L=0.15 W=0.65 AS=0.08775
+ AD=0.195 PS=0.92 PD=1.9
M$12626 VGND B|Y \$7744 VGND sky130_fd_pr__nfet_01v8 L=0.15 W=0.65 AS=0.169
+ AD=0.08775 PS=1.82 PD=0.92
M$12627 \$7744 \$7743 D|Y VGND sky130_fd_pr__nfet_01v8 L=0.15 W=0.65 AS=0.08775
+ AD=0.195 PS=0.92 PD=1.9
M$12630 \$7745 B|C|Y \$7843 VGND sky130_fd_pr__nfet_01v8 L=0.15 W=0.65 AS=0.169
+ AD=0.06825 PS=1.82 PD=0.86
M$12631 \$7843 A|Q VGND VGND sky130_fd_pr__nfet_01v8 L=0.15 W=0.65 AS=0.06825
+ AD=0.08775 PS=0.86 PD=0.92
M$12632 VGND A|Q \$7748 VGND sky130_fd_pr__nfet_01v8 L=0.15 W=0.65 AS=0.08775
+ AD=0.169 PS=0.92 PD=1.82
M$12633 VGND B|C|Y \$7748 VGND sky130_fd_pr__nfet_01v8 L=0.15 W=0.65 AS=0.169
+ AD=0.08775 PS=1.82 PD=0.92
M$12634 \$7748 \$7745 B|Y VGND sky130_fd_pr__nfet_01v8 L=0.15 W=0.65 AS=0.08775
+ AD=0.195 PS=0.92 PD=1.9
M$12636 A|Q \$7749 VGND VGND sky130_fd_pr__nfet_01v8 L=0.15 W=0.65 AS=0.169
+ AD=0.2087 PS=1.82 PD=2.02
M$12637 \$7818 \$7750 \$7893 VGND sky130_fd_pr__nfet_01v8 L=0.15 W=0.36
+ AS=0.0669 AD=0.0711 PS=0.75 PD=0.755
M$12638 \$7893 \$7751 \$7752 VGND sky130_fd_pr__nfet_01v8 L=0.15 W=0.36
+ AS=0.0711 AD=0.0999 PS=0.755 PD=0.985
M$12639 \$7806 \$7751 \$7753 VGND sky130_fd_pr__nfet_01v8 L=0.15 W=0.36
+ AS=0.1401 AD=0.0594 PS=1.1 PD=0.69
M$12640 \$7753 \$7750 \$7755 VGND sky130_fd_pr__nfet_01v8 L=0.15 W=0.36
+ AS=0.0594 AD=0.066 PS=0.69 PD=0.745
M$12641 \$7749 \$7893 \$7825 VGND sky130_fd_pr__nfet_01v8 L=0.15 W=0.42
+ AS=0.1092 AD=0.06405 PS=1.36 PD=0.725
M$12642 \$7825 RESET_B|X VGND VGND sky130_fd_pr__nfet_01v8 L=0.15 W=0.42
+ AS=0.06405 AD=0.12495 PS=0.725 PD=1.015
M$12643 VGND \$7749 \$7818 VGND sky130_fd_pr__nfet_01v8 L=0.15 W=0.42
+ AS=0.12495 AD=0.0669 PS=1.015 PD=0.75
M$12644 VGND RESET_B|X \$7812 VGND sky130_fd_pr__nfet_01v8 L=0.15 W=0.42
+ AS=0.1346 AD=0.0441 PS=1.15 PD=0.63
M$12645 \$7812 \$7752 \$7806 VGND sky130_fd_pr__nfet_01v8 L=0.15 W=0.42
+ AS=0.0441 AD=0.1401 PS=0.63 PD=1.1
M$12646 \$7755 D|Y VGND VGND sky130_fd_pr__nfet_01v8 L=0.15 W=0.42 AS=0.066
+ AD=0.2205 PS=0.745 PD=1.89
M$12647 \$7752 \$7753 VGND VGND sky130_fd_pr__nfet_01v8 L=0.15 W=0.64 AS=0.0999
+ AD=0.1346 PS=0.985 PD=1.15
M$12649 \$7751 \$7750 VGND VGND sky130_fd_pr__nfet_01v8 L=0.15 W=0.42 AS=0.1092
+ AD=0.0567 PS=1.36 PD=0.69
M$12650 VGND CLK|TICK \$7750 VGND sky130_fd_pr__nfet_01v8 L=0.15 W=0.42
+ AS=0.0567 AD=0.1092 PS=0.69 PD=1.36
M$12665 VGND A|A0|B|Y \$7922 VGND sky130_fd_pr__nfet_01v8 L=0.15 W=0.65
+ AS=0.169 AD=0.08775 PS=1.82 PD=0.92
M$12666 \$7922 A|Y VGND VGND sky130_fd_pr__nfet_01v8 L=0.15 W=0.65 AS=0.08775
+ AD=0.08775 PS=0.92 PD=0.92
M$12667 VGND A|Y \$8019 VGND sky130_fd_pr__nfet_01v8 L=0.15 W=0.65 AS=0.08775
+ AD=0.08775 PS=0.92 PD=0.92
M$12668 \$8019 A|A0|B|Y A1|B|C|X VGND sky130_fd_pr__nfet_01v8 L=0.15 W=0.65
+ AS=0.08775 AD=0.25025 PS=0.92 PD=1.42
M$12669 A1|B|C|X \$7922 VGND VGND sky130_fd_pr__nfet_01v8 L=0.15 W=0.65
+ AS=0.25025 AD=0.208 PS=1.42 PD=1.94
M$12671 \$7925 B|C|SLEEP|Y VGND VGND sky130_fd_pr__nfet_01v8 L=0.15 W=0.42
+ AS=0.1092 AD=0.0567 PS=1.36 PD=0.69
M$12672 VGND A|A0|B|Y \$7925 VGND sky130_fd_pr__nfet_01v8 L=0.15 W=0.42
+ AS=0.0567 AD=0.0567 PS=0.69 PD=0.69
M$12673 VGND A|S|Y \$7925 VGND sky130_fd_pr__nfet_01v8 L=0.15 W=0.42
+ AS=0.101875 AD=0.0567 PS=0.99 PD=0.69
M$12674 VGND \$7925 B1|X VGND sky130_fd_pr__nfet_01v8 L=0.15 W=0.65 AS=0.101875
+ AD=0.182 PS=0.99 PD=1.86
M$12676 VGND B|Y \$8024 VGND sky130_fd_pr__nfet_01v8 L=0.15 W=0.65 AS=0.169
+ AD=0.08775 PS=1.82 PD=0.92
M$12677 \$8024 A|B1|X A|S|Y VGND sky130_fd_pr__nfet_01v8 L=0.15 W=0.65
+ AS=0.08775 AD=0.169 PS=0.92 PD=1.82
M$12679 \$7927 A|A1|B|Y \$8025 VGND sky130_fd_pr__nfet_01v8 L=0.15 W=0.65
+ AS=0.169 AD=0.06825 PS=1.82 PD=0.86
M$12680 \$8025 A|B1|X VGND VGND sky130_fd_pr__nfet_01v8 L=0.15 W=0.65
+ AS=0.06825 AD=0.08775 PS=0.86 PD=0.92
M$12681 VGND A|B1|X \$8004 VGND sky130_fd_pr__nfet_01v8 L=0.15 W=0.65
+ AS=0.08775 AD=0.169 PS=0.92 PD=1.82
M$12682 VGND A|A1|B|Y \$8004 VGND sky130_fd_pr__nfet_01v8 L=0.15 W=0.65
+ AS=0.169 AD=0.08775 PS=1.82 PD=0.92
M$12683 \$8004 \$7927 A|B|Y VGND sky130_fd_pr__nfet_01v8 L=0.15 W=0.65
+ AS=0.08775 AD=0.195 PS=0.92 PD=1.9
M$12684 \$7929 A|B|Y \$8026 VGND sky130_fd_pr__nfet_01v8 L=0.15 W=0.42
+ AS=0.1092 AD=0.0441 PS=1.36 PD=0.63
M$12685 \$8026 A1|B|C|X \$8027 VGND sky130_fd_pr__nfet_01v8 L=0.15 W=0.42
+ AS=0.0441 AD=0.0441 PS=0.63 PD=0.63
M$12686 VGND A2|C|D|Y \$8027 VGND sky130_fd_pr__nfet_01v8 L=0.15 W=0.42
+ AS=0.13165 AD=0.0441 PS=1.14 PD=0.63
M$12687 VGND \$7929 A1|X VGND sky130_fd_pr__nfet_01v8 L=0.15 W=0.65 AS=0.13165
+ AD=0.169 PS=1.14 PD=1.82
M$12689 A|B1|Y A|B1|Y VGND VGND sky130_fd_pr__nfet_01v8 L=0.15 W=0.42 AS=0.1092
+ AD=0.1197 PS=1.36 PD=1.41
M$12690 VGND A2|A3|C|X \$8028 VGND sky130_fd_pr__nfet_01v8 L=0.15 W=0.65
+ AS=0.17225 AD=0.095875 PS=1.83 PD=0.945
M$12691 \$8028 A1|A2|B|Y A3|B1|Y VGND sky130_fd_pr__nfet_01v8 L=0.15 W=0.65
+ AS=0.095875 AD=0.091 PS=0.945 PD=0.93
M$12692 A3|B1|Y A|B1|Y VGND VGND sky130_fd_pr__nfet_01v8 L=0.15 W=0.65 AS=0.091
+ AD=0.17225 PS=0.93 PD=1.83
M$12693 \$7933 A|B1|Y \$8030 VGND sky130_fd_pr__nfet_01v8 L=0.15 W=0.42
+ AS=0.1092 AD=0.0441 PS=1.36 PD=0.63
M$12694 \$8030 A1|A2|B|Y \$8029 VGND sky130_fd_pr__nfet_01v8 L=0.15 W=0.42
+ AS=0.0441 AD=0.0441 PS=0.63 PD=0.63
M$12695 VGND A2|A3|C|X \$8029 VGND sky130_fd_pr__nfet_01v8 L=0.15 W=0.42
+ AS=0.13165 AD=0.0441 PS=1.14 PD=0.63
M$12696 VGND \$7933 A4|B2|X VGND sky130_fd_pr__nfet_01v8 L=0.15 W=0.65
+ AS=0.13165 AD=0.169 PS=1.14 PD=1.82
M$12697 \$8005 A|A1|Y VGND VGND sky130_fd_pr__nfet_01v8 L=0.15 W=0.65 AS=0.169
+ AD=0.08775 PS=1.82 PD=0.92
M$12698 VGND A2|X \$8005 VGND sky130_fd_pr__nfet_01v8 L=0.15 W=0.65 AS=0.08775
+ AD=0.115375 PS=0.92 PD=1.005
M$12699 \$8005 A4|B2|X A2|A3|C|Y VGND sky130_fd_pr__nfet_01v8 L=0.15 W=0.65
+ AS=0.115375 AD=0.092625 PS=1.005 PD=0.935
M$12700 A2|A3|C|Y A3|B1|Y \$8005 VGND sky130_fd_pr__nfet_01v8 L=0.15 W=0.65
+ AS=0.092625 AD=0.169 PS=0.935 PD=1.82
M$12701 VGND A2|A3|C|X \$8031 VGND sky130_fd_pr__nfet_01v8 L=0.15 W=0.65
+ AS=0.169 AD=0.08775 PS=1.82 PD=0.92
M$12702 \$8031 A1|A2|B|Y \$8032 VGND sky130_fd_pr__nfet_01v8 L=0.15 W=0.65
+ AS=0.08775 AD=0.10725 PS=0.92 PD=0.98
M$12703 \$8032 A|Y A1|A2|B|Y VGND sky130_fd_pr__nfet_01v8 L=0.15 W=0.65
+ AS=0.10725 AD=0.169 PS=0.98 PD=1.82
M$12705 \$7941 B|X \$7938 VGND sky130_fd_pr__nfet_01v8 L=0.15 W=0.64
+ AS=0.140825 AD=0.19265 PS=1.1 PD=1.285
M$12706 \$7938 \$7996 \$7940 VGND sky130_fd_pr__nfet_01v8 L=0.15 W=0.42
+ AS=0.19265 AD=0.18205 PS=1.285 PD=1.245
M$12707 \$7940 B|X \$7939 VGND sky130_fd_pr__nfet_01v8 L=0.15 W=0.64 AS=0.18205
+ AD=0.16275 PS=1.245 PD=1.8
M$12708 \$7938 \$7939 VGND VGND sky130_fd_pr__nfet_01v8 L=0.15 W=0.64 AS=0.1824
+ AD=0.0864 PS=1.85 PD=0.91
M$12709 VGND A|Y \$7939 VGND sky130_fd_pr__nfet_01v8 L=0.15 W=0.64 AS=0.0864
+ AD=0.11 PS=0.91 PD=0.99
M$12710 \$7941 \$7996 \$7939 VGND sky130_fd_pr__nfet_01v8 L=0.15 W=0.6
+ AS=0.140825 AD=0.11 PS=1.1 PD=0.99
M$12711 \$7996 B|X VGND VGND sky130_fd_pr__nfet_01v8 L=0.15 W=0.65 AS=0.16515
+ AD=0.1885 PS=1.82 PD=1.88
M$12712 \$7940 \$7943 \$7942 VGND sky130_fd_pr__nfet_01v8 L=0.15 W=0.64
+ AS=0.224 AD=0.0928 PS=1.98 PD=0.93
M$12713 \$7942 B|C|X \$7941 VGND sky130_fd_pr__nfet_01v8 L=0.15 W=0.64
+ AS=0.0928 AD=0.1728 PS=0.93 PD=1.82
M$12714 \$7943 B|C|X VGND VGND sky130_fd_pr__nfet_01v8 L=0.15 W=0.42 AS=0.1785
+ AD=0.1165 PS=1.69 PD=1.035
M$12715 VGND \$7942 A|B1|X VGND sky130_fd_pr__nfet_01v8 L=0.15 W=0.65 AS=0.1165
+ AD=0.169 PS=1.035 PD=1.82
M$12717 VGND A|A1|Y \$8006 VGND sky130_fd_pr__nfet_01v8 L=0.15 W=0.65 AS=0.169
+ AD=0.08775 PS=1.82 PD=0.92
M$12718 \$8006 A2|SLEEP|X VGND VGND sky130_fd_pr__nfet_01v8 L=0.15 W=0.65
+ AS=0.08775 AD=0.08775 PS=0.92 PD=0.92
M$12719 VGND A2|A3|X \$8006 VGND sky130_fd_pr__nfet_01v8 L=0.15 W=0.65
+ AS=0.08775 AD=0.19825 PS=0.92 PD=1.26
M$12720 \$8006 A|B1|C1|X B|Y VGND sky130_fd_pr__nfet_01v8 L=0.15 W=0.65
+ AS=0.19825 AD=0.221 PS=1.26 PD=1.98
M$12724 B|Y A|B1|Y \$8007 VGND sky130_fd_pr__nfet_01v8 L=0.15 W=0.42 AS=0.1113
+ AD=0.0588 PS=1.37 PD=0.7
M$12725 \$8007 A2|B|Y VGND VGND sky130_fd_pr__nfet_01v8 L=0.15 W=0.42 AS=0.0588
+ AD=0.0588 PS=0.7 PD=0.7
M$12726 VGND A|A1|X \$8007 VGND sky130_fd_pr__nfet_01v8 L=0.15 W=0.42 AS=0.0588
+ AD=0.1113 PS=0.7 PD=1.37
M$12729 A|A1|B1|Y A|B|C|X VGND VGND sky130_fd_pr__nfet_01v8 L=0.15 W=0.65
+ AS=0.169 AD=0.08775 PS=1.82 PD=0.92
M$12730 VGND A2|B|Y A|A1|B1|Y VGND sky130_fd_pr__nfet_01v8 L=0.15 W=0.65
+ AS=0.08775 AD=0.08775 PS=0.92 PD=0.92
M$12731 A|A1|B1|Y A|A1|X VGND VGND sky130_fd_pr__nfet_01v8 L=0.15 W=0.65
+ AS=0.08775 AD=0.169 PS=0.92 PD=1.82
M$12732 \$7947 B|Y \$8035 VGND sky130_fd_pr__nfet_01v8 L=0.15 W=0.65 AS=0.169
+ AD=0.06825 PS=1.82 PD=0.86
M$12733 \$8035 A|B|C|X VGND VGND sky130_fd_pr__nfet_01v8 L=0.15 W=0.65
+ AS=0.06825 AD=0.08775 PS=0.86 PD=0.92
M$12734 VGND A|B|C|X \$8008 VGND sky130_fd_pr__nfet_01v8 L=0.15 W=0.65
+ AS=0.08775 AD=0.169 PS=0.92 PD=1.82
M$12735 VGND B|Y \$8008 VGND sky130_fd_pr__nfet_01v8 L=0.15 W=0.65 AS=0.169
+ AD=0.08775 PS=1.82 PD=0.92
M$12736 \$8008 \$7947 A|A2|B|C_N|Y VGND sky130_fd_pr__nfet_01v8 L=0.15 W=0.65
+ AS=0.08775 AD=0.195 PS=0.92 PD=1.9
M$12738 D_N|Y A|Y \$8033 VGND sky130_fd_pr__nfet_01v8 L=0.15 W=0.65 AS=0.169
+ AD=0.08775 PS=1.82 PD=0.92
M$12739 \$8033 B|Y VGND VGND sky130_fd_pr__nfet_01v8 L=0.15 W=0.65 AS=0.08775
+ AD=0.169 PS=0.92 PD=1.82
M$12740 \$7949 A|A2|B|C_N|Y VGND VGND sky130_fd_pr__nfet_01v8 L=0.15 W=0.42
+ AS=0.1092 AD=0.0609 PS=1.36 PD=0.71
M$12741 VGND D_N|Y \$7950 VGND sky130_fd_pr__nfet_01v8 L=0.15 W=0.42 AS=0.0609
+ AD=0.1092 PS=0.71 PD=1.36
M$12742 VGND \$7950 A|B1|Y VGND sky130_fd_pr__nfet_01v8 L=0.15 W=0.65 AS=0.169
+ AD=0.08775 PS=1.82 PD=0.92
M$12743 A|B1|Y \$7949 VGND VGND sky130_fd_pr__nfet_01v8 L=0.15 W=0.65
+ AS=0.08775 AD=0.10725 PS=0.92 PD=0.98
M$12744 VGND B|C|Y A|B1|Y VGND sky130_fd_pr__nfet_01v8 L=0.15 W=0.65 AS=0.10725
+ AD=0.08775 PS=0.98 PD=0.92
M$12745 A|B1|Y A|A1|Y VGND VGND sky130_fd_pr__nfet_01v8 L=0.15 W=1.3 AS=0.25675
+ AD=0.25675 PS=2.74 PD=2.74
M$12749 VGND A|X \$7952 VGND sky130_fd_pr__nfet_01v8 L=0.15 W=0.42 AS=0.10025
+ AD=0.1092 PS=0.985 PD=1.36
M$12751 A|A1|X \$7952 VGND VGND sky130_fd_pr__nfet_01v8 L=0.15 W=0.65
+ AS=0.08775 AD=0.169 PS=0.92 PD=1.82
M$12752 VGND \$7953 A|B|X VGND sky130_fd_pr__nfet_01v8 L=0.15 W=0.65 AS=0.169
+ AD=0.08775 PS=1.82 PD=0.92
M$12754 VGND A|Y \$7953 VGND sky130_fd_pr__nfet_01v8 L=0.15 W=0.42 AS=0.10025
+ AD=0.1092 PS=0.985 PD=1.36
M$12756 D|Y \$7955 \$8009 VGND sky130_fd_pr__nfet_01v8 L=0.15 W=0.65 AS=0.195
+ AD=0.08775 PS=1.9 PD=0.92
M$12757 \$8009 B|Y VGND VGND sky130_fd_pr__nfet_01v8 L=0.15 W=0.65 AS=0.08775
+ AD=0.169 PS=0.92 PD=1.82
M$12758 \$8009 A|B|X VGND VGND sky130_fd_pr__nfet_01v8 L=0.15 W=0.65 AS=0.169
+ AD=0.08775 PS=1.82 PD=0.92
M$12759 VGND A|B|X \$8022 VGND sky130_fd_pr__nfet_01v8 L=0.15 W=0.65 AS=0.08775
+ AD=0.06825 PS=0.92 PD=0.86
M$12760 \$8022 B|Y \$7955 VGND sky130_fd_pr__nfet_01v8 L=0.15 W=0.65 AS=0.06825
+ AD=0.169 PS=0.86 PD=1.82
M$12761 \$7959 B|C|X \$8021 VGND sky130_fd_pr__nfet_01v8 L=0.15 W=0.42
+ AS=0.1092 AD=0.0441 PS=1.36 PD=0.63
M$12762 \$8021 A|Q VGND VGND sky130_fd_pr__nfet_01v8 L=0.15 W=0.42 AS=0.0441
+ AD=0.0567 PS=0.63 PD=0.69
M$12763 VGND A|Q \$8020 VGND sky130_fd_pr__nfet_01v8 L=0.15 W=0.42 AS=0.0567
+ AD=0.0441 PS=0.69 PD=0.63
M$12764 \$8020 A|B|X \$7959 VGND sky130_fd_pr__nfet_01v8 L=0.15 W=0.42
+ AS=0.0441 AD=0.0567 PS=0.63 PD=0.69
M$12765 \$7959 A|B|X \$8018 VGND sky130_fd_pr__nfet_01v8 L=0.15 W=0.42
+ AS=0.0567 AD=0.0441 PS=0.69 PD=0.63
M$12766 VGND B|C|X \$8018 VGND sky130_fd_pr__nfet_01v8 L=0.15 W=0.42 AS=0.1474
+ AD=0.0441 PS=1.215 PD=0.63
M$12767 VGND \$7959 A|B|X VGND sky130_fd_pr__nfet_01v8 L=0.15 W=0.65 AS=0.1474
+ AD=0.23725 PS=1.215 PD=2.03
M$12769 A|B|X \$7960 VGND VGND sky130_fd_pr__nfet_01v8 L=0.15 W=0.65 AS=0.23725
+ AD=0.1474 PS=2.03 PD=1.215
M$12770 VGND B|C|Y \$8017 VGND sky130_fd_pr__nfet_01v8 L=0.15 W=0.42 AS=0.1474
+ AD=0.0441 PS=1.215 PD=0.63
M$12771 \$8017 A|B|X \$7960 VGND sky130_fd_pr__nfet_01v8 L=0.15 W=0.42
+ AS=0.0441 AD=0.0567 PS=0.63 PD=0.69
M$12772 \$7960 A|B|X \$8016 VGND sky130_fd_pr__nfet_01v8 L=0.15 W=0.42
+ AS=0.0567 AD=0.0441 PS=0.69 PD=0.63
M$12773 \$8016 A|Q VGND VGND sky130_fd_pr__nfet_01v8 L=0.15 W=0.42 AS=0.0441
+ AD=0.0567 PS=0.63 PD=0.69
M$12774 VGND A|Q \$8015 VGND sky130_fd_pr__nfet_01v8 L=0.15 W=0.42 AS=0.0567
+ AD=0.0441 PS=0.69 PD=0.63
M$12775 \$8015 B|C|Y \$7960 VGND sky130_fd_pr__nfet_01v8 L=0.15 W=0.42
+ AS=0.0441 AD=0.1092 PS=0.63 PD=1.36
M$12777 \$7961 B|Y \$8013 VGND sky130_fd_pr__nfet_01v8 L=0.15 W=0.65 AS=0.169
+ AD=0.06825 PS=1.82 PD=0.86
M$12778 \$8013 A|B|X VGND VGND sky130_fd_pr__nfet_01v8 L=0.15 W=0.65 AS=0.06825
+ AD=0.08775 PS=0.86 PD=0.92
M$12779 VGND A|B|X \$8010 VGND sky130_fd_pr__nfet_01v8 L=0.15 W=0.65 AS=0.08775
+ AD=0.169 PS=0.92 PD=1.82
M$12780 VGND B|Y \$8010 VGND sky130_fd_pr__nfet_01v8 L=0.15 W=0.65 AS=0.169
+ AD=0.08775 PS=1.82 PD=0.92
M$12781 \$8010 \$7961 D|Y VGND sky130_fd_pr__nfet_01v8 L=0.15 W=0.65 AS=0.08775
+ AD=0.195 PS=0.92 PD=1.9
M$12794 \$8037 A|A0|B|Y A|B|SLEEP|Y VGND sky130_fd_pr__nfet_01v8 L=0.15 W=0.65
+ AS=0.169 AD=0.08775 PS=1.82 PD=0.92
M$12795 A|B|SLEEP|Y A1|B|C|X \$8039 VGND sky130_fd_pr__nfet_01v8 L=0.15 W=0.65
+ AS=0.08775 AD=0.182 PS=0.92 PD=1.86
M$12796 \$8037 \$8040 VGND VGND sky130_fd_pr__nfet_01v8 L=0.15 W=0.65 AS=0.169
+ AD=0.08775 PS=1.82 PD=0.92
M$12797 VGND A|S|Y \$8039 VGND sky130_fd_pr__nfet_01v8 L=0.15 W=0.65 AS=0.08775
+ AD=0.169 PS=0.92 PD=1.82
M$12798 \$8040 A|S|Y VGND VGND sky130_fd_pr__nfet_01v8 L=0.15 W=0.65 AS=0.169
+ AD=0.169 PS=1.82 PD=1.82
M$12799 \$8041 B|C|SLEEP|Y \$8122 VGND sky130_fd_pr__nfet_01v8 L=0.15 W=0.65
+ AS=0.169 AD=0.06825 PS=1.82 PD=0.86
M$12800 \$8122 A|Y VGND VGND sky130_fd_pr__nfet_01v8 L=0.15 W=0.65 AS=0.06825
+ AD=0.08775 PS=0.86 PD=0.92
M$12801 VGND A|Y \$8042 VGND sky130_fd_pr__nfet_01v8 L=0.15 W=0.65 AS=0.08775
+ AD=0.169 PS=0.92 PD=1.82
M$12802 VGND B|C|SLEEP|Y \$8042 VGND sky130_fd_pr__nfet_01v8 L=0.15 W=0.65
+ AS=0.169 AD=0.08775 PS=1.82 PD=0.92
M$12803 \$8042 \$8041 A2|C|D|Y VGND sky130_fd_pr__nfet_01v8 L=0.15 W=0.65
+ AS=0.08775 AD=0.195 PS=0.92 PD=1.9
M$12805 VGND A2|C|D|Y \$8130 VGND sky130_fd_pr__nfet_01v8 L=0.15 W=0.65
+ AS=0.169 AD=0.08775 PS=1.82 PD=0.92
M$12806 \$8130 A1|B|C|X \$8131 VGND sky130_fd_pr__nfet_01v8 L=0.15 W=0.65
+ AS=0.08775 AD=0.08775 PS=0.92 PD=0.92
M$12807 \$8131 A|B|Y \$8132 VGND sky130_fd_pr__nfet_01v8 L=0.15 W=0.65
+ AS=0.08775 AD=0.10725 PS=0.92 PD=0.98
M$12808 \$8132 A|X A|B1|Y VGND sky130_fd_pr__nfet_01v8 L=0.15 W=0.65 AS=0.10725
+ AD=0.195 PS=0.98 PD=1.9
M$12811 B|X \$8044 VGND VGND sky130_fd_pr__nfet_01v8 L=0.15 W=0.65 AS=0.247
+ AD=0.169 PS=2.06 PD=1.82
M$12812 \$8044 A|B1|X \$8045 VGND sky130_fd_pr__nfet_01v8 L=0.15 W=0.65
+ AS=0.169 AD=0.08775 PS=1.82 PD=0.92
M$12813 \$8045 A4|B2|X VGND VGND sky130_fd_pr__nfet_01v8 L=0.15 W=0.65
+ AS=0.08775 AD=0.1235 PS=0.92 PD=1.03
M$12814 VGND A3|B1|Y \$8045 VGND sky130_fd_pr__nfet_01v8 L=0.15 W=0.65
+ AS=0.1235 AD=0.12675 PS=1.03 PD=1.04
M$12815 \$8045 A2|X VGND VGND sky130_fd_pr__nfet_01v8 L=0.15 W=0.65 AS=0.12675
+ AD=0.12675 PS=1.04 PD=1.04
M$12816 VGND A|A1|B|Y \$8045 VGND sky130_fd_pr__nfet_01v8 L=0.15 W=0.65
+ AS=0.12675 AD=0.195 PS=1.04 PD=1.9
M$12819 VGND A2|A3|C|Y \$8162 VGND sky130_fd_pr__nfet_01v8 L=0.15 W=0.65
+ AS=0.17225 AD=0.095875 PS=1.83 PD=0.945
M$12820 \$8162 A1|A2|B|Y A|A1|Y VGND sky130_fd_pr__nfet_01v8 L=0.15 W=0.65
+ AS=0.095875 AD=0.091 PS=0.945 PD=0.93
M$12821 A|A1|Y A|B1|Y VGND VGND sky130_fd_pr__nfet_01v8 L=0.15 W=0.65 AS=0.091
+ AD=0.17225 PS=0.93 PD=1.83
M$12822 \$8242 A|B1|Y \$8168 VGND sky130_fd_pr__nfet_01v8 L=0.15 W=0.42
+ AS=0.1092 AD=0.0441 PS=1.36 PD=0.63
M$12823 \$8168 A1|A2|B|Y \$8165 VGND sky130_fd_pr__nfet_01v8 L=0.15 W=0.42
+ AS=0.0441 AD=0.0441 PS=0.63 PD=0.63
M$12824 \$8165 A2|A3|C|Y VGND VGND sky130_fd_pr__nfet_01v8 L=0.15 W=0.42
+ AS=0.0441 AD=0.13165 PS=0.63 PD=1.14
M$12825 VGND \$8242 A2|SLEEP|X VGND sky130_fd_pr__nfet_01v8 L=0.15 W=0.65
+ AS=0.13165 AD=0.169 PS=1.14 PD=1.82
M$12826 \$8048 A1|A3|B|X VGND VGND sky130_fd_pr__nfet_01v8 L=0.15 W=0.65
+ AS=0.17225 AD=0.12675 PS=1.83 PD=1.04
M$12827 VGND A2|A3|X \$8048 VGND sky130_fd_pr__nfet_01v8 L=0.15 W=0.65
+ AS=0.12675 AD=0.12675 PS=1.04 PD=1.04
M$12828 \$8048 A|B1|X \$8176 VGND sky130_fd_pr__nfet_01v8 L=0.15 W=0.65
+ AS=0.12675 AD=0.06825 PS=1.04 PD=0.86
M$12829 \$8176 A|B1|C1|X A|Y VGND sky130_fd_pr__nfet_01v8 L=0.15 W=0.65
+ AS=0.06825 AD=0.39325 PS=0.86 PD=2.51
M$12830 VGND B|Y \$8050 VGND sky130_fd_pr__nfet_01v8 L=0.15 W=0.65 AS=0.169
+ AD=0.08775 PS=1.82 PD=0.92
M$12831 \$8050 A|B1|X VGND VGND sky130_fd_pr__nfet_01v8 L=0.15 W=0.65
+ AS=0.08775 AD=0.08775 PS=0.92 PD=0.92
M$12832 VGND A|B1|X \$8179 VGND sky130_fd_pr__nfet_01v8 L=0.15 W=0.65
+ AS=0.08775 AD=0.08775 PS=0.92 PD=0.92
M$12833 \$8179 B|Y A|X VGND sky130_fd_pr__nfet_01v8 L=0.15 W=0.65 AS=0.08775
+ AD=0.25025 PS=0.92 PD=1.42
M$12834 A|X \$8050 VGND VGND sky130_fd_pr__nfet_01v8 L=0.15 W=0.65 AS=0.25025
+ AD=0.208 PS=1.42 PD=1.94
M$12835 VGND A|X \$8052 VGND sky130_fd_pr__nfet_01v8 L=0.15 W=0.42 AS=0.1092
+ AD=0.0567 PS=1.36 PD=0.69
M$12836 \$8052 B|SLEEP|Y VGND VGND sky130_fd_pr__nfet_01v8 L=0.15 W=0.42
+ AS=0.0567 AD=0.10025 PS=0.69 PD=0.985
M$12837 VGND \$8052 A|B|X VGND sky130_fd_pr__nfet_01v8 L=0.15 W=0.65 AS=0.10025
+ AD=0.169 PS=0.985 PD=1.82
M$12838 VGND B|SLEEP|Y \$8054 VGND sky130_fd_pr__nfet_01v8 L=0.15 W=0.65
+ AS=0.169 AD=0.08775 PS=1.82 PD=0.92
M$12839 \$8054 A|X VGND VGND sky130_fd_pr__nfet_01v8 L=0.15 W=0.65 AS=0.08775
+ AD=0.08775 PS=0.92 PD=0.92
M$12840 VGND A|X \$8185 VGND sky130_fd_pr__nfet_01v8 L=0.15 W=0.65 AS=0.08775
+ AD=0.08775 PS=0.92 PD=0.92
M$12841 \$8185 B|SLEEP|Y A|B1|X VGND sky130_fd_pr__nfet_01v8 L=0.15 W=0.65
+ AS=0.08775 AD=0.25025 PS=0.92 PD=1.42
M$12842 A|B1|X \$8054 VGND VGND sky130_fd_pr__nfet_01v8 L=0.15 W=0.65
+ AS=0.25025 AD=0.208 PS=1.42 PD=1.94
M$12844 VGND B|Y \$8057 VGND sky130_fd_pr__nfet_01v8 L=0.15 W=0.65 AS=0.169
+ AD=0.08775 PS=1.82 PD=0.92
M$12845 \$8057 A|B1|X VGND VGND sky130_fd_pr__nfet_01v8 L=0.15 W=0.65
+ AS=0.08775 AD=0.08775 PS=0.92 PD=0.92
M$12846 VGND A|B1|X \$8191 VGND sky130_fd_pr__nfet_01v8 L=0.15 W=0.65
+ AS=0.08775 AD=0.08775 PS=0.92 PD=0.92
M$12847 \$8191 B|Y A|A1|X VGND sky130_fd_pr__nfet_01v8 L=0.15 W=0.65 AS=0.08775
+ AD=0.25025 PS=0.92 PD=1.42
M$12848 A|A1|X \$8057 VGND VGND sky130_fd_pr__nfet_01v8 L=0.15 W=0.65
+ AS=0.25025 AD=0.208 PS=1.42 PD=1.94
M$12850 VGND A2|B|Y \$8058 VGND sky130_fd_pr__nfet_01v8 L=0.15 W=0.65 AS=0.169
+ AD=0.08775 PS=1.82 PD=0.92
M$12851 \$8058 A|A1|X VGND VGND sky130_fd_pr__nfet_01v8 L=0.15 W=0.65
+ AS=0.08775 AD=0.08775 PS=0.92 PD=0.92
M$12852 VGND A|A1|X \$8202 VGND sky130_fd_pr__nfet_01v8 L=0.15 W=0.65
+ AS=0.08775 AD=0.08775 PS=0.92 PD=0.92
M$12853 \$8202 A2|B|Y A|B|X VGND sky130_fd_pr__nfet_01v8 L=0.15 W=0.65
+ AS=0.08775 AD=0.25025 PS=0.92 PD=1.42
M$12854 A|B|X \$8058 VGND VGND sky130_fd_pr__nfet_01v8 L=0.15 W=0.65 AS=0.25025
+ AD=0.208 PS=1.42 PD=1.94
M$12856 A|B1|Y A|X \$8209 VGND sky130_fd_pr__nfet_01v8 L=0.15 W=0.65 AS=0.169
+ AD=0.10725 PS=1.82 PD=0.98
M$12857 \$8209 A|B|X \$8210 VGND sky130_fd_pr__nfet_01v8 L=0.15 W=0.65
+ AS=0.10725 AD=0.08775 PS=0.98 PD=0.92
M$12858 \$8210 B|C|X VGND VGND sky130_fd_pr__nfet_01v8 L=0.15 W=0.65 AS=0.08775
+ AD=0.169 PS=0.92 PD=1.82
M$12859 VGND B|Y \$8063 VGND sky130_fd_pr__nfet_01v8 L=0.15 W=0.65 AS=0.169
+ AD=0.08775 PS=1.82 PD=0.92
M$12860 \$8063 A|B|X VGND VGND sky130_fd_pr__nfet_01v8 L=0.15 W=0.65 AS=0.08775
+ AD=0.08775 PS=0.92 PD=0.92
M$12861 VGND A|B|X \$8213 VGND sky130_fd_pr__nfet_01v8 L=0.15 W=0.65 AS=0.08775
+ AD=0.08775 PS=0.92 PD=0.92
M$12862 \$8213 B|Y A|A1|X VGND sky130_fd_pr__nfet_01v8 L=0.15 W=0.65 AS=0.08775
+ AD=0.25025 PS=0.92 PD=1.42
M$12863 A|A1|X \$8063 VGND VGND sky130_fd_pr__nfet_01v8 L=0.15 W=0.65
+ AS=0.25025 AD=0.208 PS=1.42 PD=1.94
M$12865 \$8064 A2|B|Y \$8220 VGND sky130_fd_pr__nfet_01v8 L=0.15 W=0.65
+ AS=0.169 AD=0.06825 PS=1.82 PD=0.86
M$12866 \$8220 A|A1|X VGND VGND sky130_fd_pr__nfet_01v8 L=0.15 W=0.65
+ AS=0.06825 AD=0.08775 PS=0.86 PD=0.92
M$12867 VGND A|A1|X \$8065 VGND sky130_fd_pr__nfet_01v8 L=0.15 W=0.65
+ AS=0.08775 AD=0.169 PS=0.92 PD=1.82
M$12868 VGND A2|B|Y \$8065 VGND sky130_fd_pr__nfet_01v8 L=0.15 W=0.65 AS=0.169
+ AD=0.08775 PS=1.82 PD=0.92
M$12869 \$8065 \$8064 A|Y VGND sky130_fd_pr__nfet_01v8 L=0.15 W=0.65 AS=0.08775
+ AD=0.195 PS=0.92 PD=1.9
M$12871 \$8066 \$8068 \$8070 VGND sky130_fd_pr__nfet_01v8 L=0.15 W=0.42
+ AS=0.19265 AD=0.18205 PS=1.285 PD=1.245
M$12872 \$8067 \$8068 \$8069 VGND sky130_fd_pr__nfet_01v8 L=0.15 W=0.6 AS=0.11
+ AD=0.140825 PS=0.99 PD=1.1
M$12873 \$8066 \$8067 VGND VGND sky130_fd_pr__nfet_01v8 L=0.15 W=0.64 AS=0.1824
+ AD=0.0864 PS=1.85 PD=0.91
M$12874 VGND A|Y \$8067 VGND sky130_fd_pr__nfet_01v8 L=0.15 W=0.64 AS=0.0864
+ AD=0.11 PS=0.91 PD=0.99
M$12875 \$8069 B|Y \$8066 VGND sky130_fd_pr__nfet_01v8 L=0.15 W=0.64
+ AS=0.140825 AD=0.19265 PS=1.1 PD=1.285
M$12876 \$8070 B|Y \$8067 VGND sky130_fd_pr__nfet_01v8 L=0.15 W=0.64 AS=0.18205
+ AD=0.16275 PS=1.245 PD=1.8
M$12877 \$8068 B|Y VGND VGND sky130_fd_pr__nfet_01v8 L=0.15 W=0.65 AS=0.16515
+ AD=0.1885 PS=1.82 PD=1.88
M$12878 \$8070 \$8071 \$8072 VGND sky130_fd_pr__nfet_01v8 L=0.15 W=0.64
+ AS=0.224 AD=0.0928 PS=1.98 PD=0.93
M$12879 \$8072 B|C|Y \$8069 VGND sky130_fd_pr__nfet_01v8 L=0.15 W=0.64
+ AS=0.0928 AD=0.1728 PS=0.93 PD=1.82
M$12880 VGND B|C|Y \$8071 VGND sky130_fd_pr__nfet_01v8 L=0.15 W=0.42 AS=0.1165
+ AD=0.1785 PS=1.035 PD=1.69
M$12881 VGND \$8072 A|X VGND sky130_fd_pr__nfet_01v8 L=0.15 W=0.65 AS=0.1165
+ AD=0.169 PS=1.035 PD=1.82
M$12882 \$8073 B|SLEEP|Y \$8231 VGND sky130_fd_pr__nfet_01v8 L=0.15 W=0.65
+ AS=0.169 AD=0.06825 PS=1.82 PD=0.86
M$12883 \$8231 A|X VGND VGND sky130_fd_pr__nfet_01v8 L=0.15 W=0.65 AS=0.06825
+ AD=0.08775 PS=0.86 PD=0.92
M$12884 VGND A|X \$8075 VGND sky130_fd_pr__nfet_01v8 L=0.15 W=0.65 AS=0.08775
+ AD=0.169 PS=0.92 PD=1.82
M$12885 VGND B|SLEEP|Y \$8075 VGND sky130_fd_pr__nfet_01v8 L=0.15 W=0.65
+ AS=0.169 AD=0.08775 PS=1.82 PD=0.92
M$12886 \$8075 \$8073 A|Y VGND sky130_fd_pr__nfet_01v8 L=0.15 W=0.65 AS=0.08775
+ AD=0.195 PS=0.92 PD=1.9
M$12887 VGND B|SLEEP|Y \$8076 VGND sky130_fd_pr__nfet_01v8 L=0.15 W=0.65
+ AS=0.169 AD=0.08775 PS=1.82 PD=0.92
M$12888 \$8076 A|Y VGND VGND sky130_fd_pr__nfet_01v8 L=0.15 W=0.65 AS=0.08775
+ AD=0.08775 PS=0.92 PD=0.92
M$12889 VGND A|Y \$8214 VGND sky130_fd_pr__nfet_01v8 L=0.15 W=0.65 AS=0.08775
+ AD=0.08775 PS=0.92 PD=0.92
M$12890 \$8214 B|SLEEP|Y B|C|X VGND sky130_fd_pr__nfet_01v8 L=0.15 W=0.65
+ AS=0.08775 AD=0.25025 PS=0.92 PD=1.42
M$12891 B|C|X \$8076 VGND VGND sky130_fd_pr__nfet_01v8 L=0.15 W=0.65 AS=0.25025
+ AD=0.208 PS=1.42 PD=1.94
M$12892 \$8078 CLK|TICK VGND VGND sky130_fd_pr__nfet_01v8 L=0.15 W=0.42
+ AS=0.1092 AD=0.0567 PS=1.36 PD=0.69
M$12893 VGND \$8078 \$8079 VGND sky130_fd_pr__nfet_01v8 L=0.15 W=0.42 AS=0.0567
+ AD=0.1092 PS=0.69 PD=1.36
M$12894 \$8080 \$8078 \$8081 VGND sky130_fd_pr__nfet_01v8 L=0.15 W=0.36
+ AS=0.066 AD=0.0594 PS=0.745 PD=0.69
M$12895 \$8081 \$8079 \$8194 VGND sky130_fd_pr__nfet_01v8 L=0.15 W=0.36
+ AS=0.0594 AD=0.1401 PS=0.69 PD=1.1
M$12896 \$8244 \$8079 \$8082 VGND sky130_fd_pr__nfet_01v8 L=0.15 W=0.36
+ AS=0.0999 AD=0.0711 PS=0.985 PD=0.755
M$12897 \$8082 \$8078 \$8187 VGND sky130_fd_pr__nfet_01v8 L=0.15 W=0.36
+ AS=0.0711 AD=0.0669 PS=0.755 PD=0.75
M$12898 VGND D|Y \$8080 VGND sky130_fd_pr__nfet_01v8 L=0.15 W=0.42 AS=0.2205
+ AD=0.066 PS=1.89 PD=0.745
M$12899 \$8194 \$8244 \$8193 VGND sky130_fd_pr__nfet_01v8 L=0.15 W=0.42
+ AS=0.1401 AD=0.0441 PS=1.1 PD=0.63
M$12900 \$8193 RESET_B|X VGND VGND sky130_fd_pr__nfet_01v8 L=0.15 W=0.42
+ AS=0.0441 AD=0.1346 PS=0.63 PD=1.15
M$12901 \$8187 \$8083 VGND VGND sky130_fd_pr__nfet_01v8 L=0.15 W=0.42 AS=0.0669
+ AD=0.12495 PS=0.75 PD=1.015
M$12902 VGND RESET_B|X \$8181 VGND sky130_fd_pr__nfet_01v8 L=0.15 W=0.42
+ AS=0.12495 AD=0.06405 PS=1.015 PD=0.725
M$12903 \$8181 \$8082 \$8083 VGND sky130_fd_pr__nfet_01v8 L=0.15 W=0.42
+ AS=0.06405 AD=0.1092 PS=0.725 PD=1.36
M$12904 VGND \$8081 \$8244 VGND sky130_fd_pr__nfet_01v8 L=0.15 W=0.64 AS=0.1346
+ AD=0.0999 PS=1.15 PD=0.985
M$12905 VGND \$8083 A|Q VGND sky130_fd_pr__nfet_01v8 L=0.15 W=0.65 AS=0.2087
+ AD=0.169 PS=2.02 PD=1.82
M$12907 \$8084 B|C|X \$8161 VGND sky130_fd_pr__nfet_01v8 L=0.15 W=0.42
+ AS=0.1092 AD=0.0441 PS=1.36 PD=0.63
M$12908 \$8161 A|Q VGND VGND sky130_fd_pr__nfet_01v8 L=0.15 W=0.42 AS=0.0441
+ AD=0.0567 PS=0.63 PD=0.69
M$12909 VGND A|Q \$8160 VGND sky130_fd_pr__nfet_01v8 L=0.15 W=0.42 AS=0.0567
+ AD=0.0441 PS=0.69 PD=0.63
M$12910 \$8160 A|B|Y \$8084 VGND sky130_fd_pr__nfet_01v8 L=0.15 W=0.42
+ AS=0.0441 AD=0.0567 PS=0.63 PD=0.69
M$12911 \$8084 A|B|Y \$8154 VGND sky130_fd_pr__nfet_01v8 L=0.15 W=0.42
+ AS=0.0567 AD=0.0441 PS=0.69 PD=0.63
M$12912 \$8154 B|C|X VGND VGND sky130_fd_pr__nfet_01v8 L=0.15 W=0.42 AS=0.0441
+ AD=0.1474 PS=0.63 PD=1.215
M$12913 VGND \$8084 A|B|X VGND sky130_fd_pr__nfet_01v8 L=0.15 W=0.65 AS=0.1474
+ AD=0.23725 PS=1.215 PD=2.03
M$12937 VGND A|B|Y \$8449 VGND sky130_fd_pr__nfet_01v8 L=0.15 W=0.65 AS=0.169
+ AD=0.08775 PS=1.82 PD=0.92
M$12938 \$8449 A|X A|Y VGND sky130_fd_pr__nfet_01v8 L=0.15 W=0.65 AS=0.08775
+ AD=0.169 PS=0.92 PD=1.82
M$12939 VGND A|B|SLEEP|Y A1|Y VGND sky130_fd_pr__nfet_01v8 L=0.15 W=0.65
+ AS=0.169 AD=0.08775 PS=1.82 PD=0.92
M$12941 \$8353 A1|Y VGND VGND sky130_fd_pr__nfet_01v8 L=0.15 W=0.42 AS=0.1113
+ AD=0.0588 PS=1.37 PD=0.7
M$12942 VGND A2|C|D|Y \$8353 VGND sky130_fd_pr__nfet_01v8 L=0.15 W=0.42
+ AS=0.0588 AD=0.0588 PS=0.7 PD=0.7
M$12943 \$8353 A|B1|Y B|SLEEP|Y VGND sky130_fd_pr__nfet_01v8 L=0.15 W=0.42
+ AS=0.0588 AD=0.1113 PS=0.7 PD=1.37
M$12944 \$8381 A|B|Y \$8457 VGND sky130_fd_pr__nfet_01v8 L=0.15 W=0.65 AS=0.169
+ AD=0.06825 PS=1.82 PD=0.86
M$12945 \$8457 A|X VGND VGND sky130_fd_pr__nfet_01v8 L=0.15 W=0.65 AS=0.06825
+ AD=0.08775 PS=0.86 PD=0.92
M$12946 VGND A|X \$8382 VGND sky130_fd_pr__nfet_01v8 L=0.15 W=0.65 AS=0.08775
+ AD=0.169 PS=0.92 PD=1.82
M$12947 VGND A|B|SLEEP|Y \$8280 VGND sky130_fd_pr__nfet_01v8 L=0.15 W=0.65
+ AS=0.169 AD=0.08775 PS=1.82 PD=0.92
M$12948 \$8280 A|Y VGND VGND sky130_fd_pr__nfet_01v8 L=0.15 W=0.65 AS=0.08775
+ AD=0.08775 PS=0.92 PD=0.92
M$12949 VGND A|Y \$8377 VGND sky130_fd_pr__nfet_01v8 L=0.15 W=0.65 AS=0.08775
+ AD=0.08775 PS=0.92 PD=0.92
M$12950 \$8377 A|B|SLEEP|Y A2|B|C|X VGND sky130_fd_pr__nfet_01v8 L=0.15 W=0.65
+ AS=0.08775 AD=0.25025 PS=0.92 PD=1.42
M$12951 A2|B|C|X \$8280 VGND VGND sky130_fd_pr__nfet_01v8 L=0.15 W=0.65
+ AS=0.25025 AD=0.208 PS=1.42 PD=1.94
M$12952 VGND A|B|Y \$8382 VGND sky130_fd_pr__nfet_01v8 L=0.15 W=0.65 AS=0.169
+ AD=0.08775 PS=1.82 PD=0.92
M$12953 \$8382 \$8381 A|A1|B|Y VGND sky130_fd_pr__nfet_01v8 L=0.15 W=0.65
+ AS=0.08775 AD=0.195 PS=0.92 PD=1.9
M$12957 VGND A|B|SLEEP|Y \$8283 VGND sky130_fd_pr__nfet_01v8 L=0.15 W=0.42
+ AS=0.1092 AD=0.0567 PS=1.36 PD=0.69
M$12958 VGND B|SLEEP|Y \$8283 VGND sky130_fd_pr__nfet_01v8 L=0.15 W=0.42
+ AS=0.10025 AD=0.0567 PS=0.985 PD=0.69
M$12959 VGND \$8283 A2|X VGND sky130_fd_pr__nfet_01v8 L=0.15 W=0.65 AS=0.10025
+ AD=0.169 PS=0.985 PD=1.82
M$12960 VGND A|A1|Y \$8383 VGND sky130_fd_pr__nfet_01v8 L=0.15 W=0.42 AS=0.1092
+ AD=0.0567 PS=1.36 PD=0.69
M$12961 \$8383 A|B|SLEEP|Y VGND VGND sky130_fd_pr__nfet_01v8 L=0.15 W=0.42
+ AS=0.0567 AD=0.10025 PS=0.69 PD=0.985
M$12962 VGND \$8383 A|B1|X VGND sky130_fd_pr__nfet_01v8 L=0.15 W=0.65
+ AS=0.10025 AD=0.169 PS=0.985 PD=1.82
M$12964 A|Y B|SLEEP|Y VGND VGND sky130_fd_pr__nfet_01v8 L=0.15 W=0.65
+ AS=0.08775 AD=0.169 PS=0.92 PD=1.82
M$12966 VGND B|SLEEP|Y \$8384 VGND sky130_fd_pr__nfet_01v8 L=0.15 W=0.65
+ AS=0.169 AD=0.08775 PS=1.82 PD=0.92
M$12967 \$8384 A|B1|X VGND VGND sky130_fd_pr__nfet_01v8 L=0.15 W=0.65
+ AS=0.08775 AD=0.08775 PS=0.92 PD=0.92
M$12968 VGND A|B1|X \$8474 VGND sky130_fd_pr__nfet_01v8 L=0.15 W=0.65
+ AS=0.08775 AD=0.08775 PS=0.92 PD=0.92
M$12969 \$8474 B|SLEEP|Y A2|C|D|X VGND sky130_fd_pr__nfet_01v8 L=0.15 W=0.65
+ AS=0.08775 AD=0.25025 PS=0.92 PD=1.42
M$12970 A2|C|D|X \$8384 VGND VGND sky130_fd_pr__nfet_01v8 L=0.15 W=0.65
+ AS=0.25025 AD=0.208 PS=1.42 PD=1.94
M$12972 B|X \$8341 VGND VGND sky130_fd_pr__nfet_01v8 L=0.15 W=0.65 AS=0.17225
+ AD=0.112125 PS=1.83 PD=0.995
M$12973 VGND A2|A3|C|Y \$8379 VGND sky130_fd_pr__nfet_01v8 L=0.15 W=0.65
+ AS=0.112125 AD=0.104 PS=0.995 PD=0.97
M$12974 \$8379 A1|A2|B|Y \$8380 VGND sky130_fd_pr__nfet_01v8 L=0.15 W=0.65
+ AS=0.104 AD=0.10725 PS=0.97 PD=0.98
M$12975 \$8380 A1|X \$8341 VGND sky130_fd_pr__nfet_01v8 L=0.15 W=0.65
+ AS=0.10725 AD=0.10725 PS=0.98 PD=0.98
M$12976 \$8341 B1|Y VGND VGND sky130_fd_pr__nfet_01v8 L=0.15 W=0.65 AS=0.10725
+ AD=0.208 PS=0.98 PD=1.94
M$12977 B|C|X \$8342 VGND VGND sky130_fd_pr__nfet_01v8 L=0.15 W=0.65 AS=0.17225
+ AD=0.112125 PS=1.83 PD=0.995
M$12978 VGND A3|Y \$8378 VGND sky130_fd_pr__nfet_01v8 L=0.15 W=0.65 AS=0.112125
+ AD=0.104 PS=0.995 PD=0.97
M$12979 \$8378 A2|A3|C|Y \$8376 VGND sky130_fd_pr__nfet_01v8 L=0.15 W=0.65
+ AS=0.104 AD=0.10725 PS=0.97 PD=0.98
M$12980 \$8376 A1|A2|B|Y \$8342 VGND sky130_fd_pr__nfet_01v8 L=0.15 W=0.65
+ AS=0.10725 AD=0.10725 PS=0.98 PD=0.98
M$12981 \$8342 A|A1|B1|Y VGND VGND sky130_fd_pr__nfet_01v8 L=0.15 W=0.65
+ AS=0.10725 AD=0.208 PS=0.98 PD=1.94
M$12986 VGND A|A1|Y \$8290 VGND sky130_fd_pr__nfet_01v8 L=0.15 W=0.42 AS=0.1092
+ AD=0.0567 PS=1.36 PD=0.69
M$12987 VGND A2|SLEEP|X \$8290 VGND sky130_fd_pr__nfet_01v8 L=0.15 W=0.42
+ AS=0.10025 AD=0.0567 PS=0.985 PD=0.69
M$12988 VGND \$8290 A1|A3|B|X VGND sky130_fd_pr__nfet_01v8 L=0.15 W=0.65
+ AS=0.10025 AD=0.169 PS=0.985 PD=1.82
M$12991 \$8387 \$8390 \$8392 VGND sky130_fd_pr__nfet_01v8 L=0.15 W=0.42
+ AS=0.19265 AD=0.18205 PS=1.285 PD=1.245
M$12992 \$8388 \$8390 \$8391 VGND sky130_fd_pr__nfet_01v8 L=0.15 W=0.6 AS=0.11
+ AD=0.140825 PS=0.99 PD=1.1
M$12993 \$8387 \$8388 VGND VGND sky130_fd_pr__nfet_01v8 L=0.15 W=0.64 AS=0.1824
+ AD=0.0864 PS=1.85 PD=0.91
M$12994 VGND A|Y \$8388 VGND sky130_fd_pr__nfet_01v8 L=0.15 W=0.64 AS=0.0864
+ AD=0.11 PS=0.91 PD=0.99
M$12995 \$8391 A1|A3|B|X \$8387 VGND sky130_fd_pr__nfet_01v8 L=0.15 W=0.64
+ AS=0.140825 AD=0.19265 PS=1.1 PD=1.285
M$12996 \$8392 A1|A3|B|X \$8388 VGND sky130_fd_pr__nfet_01v8 L=0.15 W=0.64
+ AS=0.18205 AD=0.16275 PS=1.245 PD=1.8
M$12998 \$8390 A1|A3|B|X VGND VGND sky130_fd_pr__nfet_01v8 L=0.15 W=0.65
+ AS=0.16515 AD=0.1885 PS=1.82 PD=1.88
M$12999 VGND C|Y \$8393 VGND sky130_fd_pr__nfet_01v8 L=0.15 W=0.42 AS=0.1165
+ AD=0.1785 PS=1.035 PD=1.69
M$13000 VGND \$8394 A3|B|X VGND sky130_fd_pr__nfet_01v8 L=0.15 W=0.65 AS=0.1165
+ AD=0.169 PS=1.035 PD=1.82
M$13003 VGND A|A1|B|Y \$8396 VGND sky130_fd_pr__nfet_01v8 L=0.15 W=0.65
+ AS=0.169 AD=0.08775 PS=1.82 PD=0.92
M$13004 \$8396 A2|Y VGND VGND sky130_fd_pr__nfet_01v8 L=0.15 W=0.65 AS=0.08775
+ AD=0.08775 PS=0.92 PD=0.92
M$13005 VGND A3|B|X \$8396 VGND sky130_fd_pr__nfet_01v8 L=0.15 W=0.65
+ AS=0.08775 AD=0.19825 PS=0.92 PD=1.26
M$13006 \$8396 A|B1|C1|X B|Y VGND sky130_fd_pr__nfet_01v8 L=0.15 W=0.65
+ AS=0.19825 AD=0.221 PS=1.26 PD=1.98
M$13007 VGND A|A1|B|Y \$8354 VGND sky130_fd_pr__nfet_01v8 L=0.15 W=0.42
+ AS=0.1176 AD=0.0567 PS=1.4 PD=0.69
M$13008 \$8354 A2|Y VGND VGND sky130_fd_pr__nfet_01v8 L=0.15 W=0.42 AS=0.0567
+ AD=0.0567 PS=0.69 PD=0.69
M$13009 VGND A3|B|X \$8354 VGND sky130_fd_pr__nfet_01v8 L=0.15 W=0.42 AS=0.0567
+ AD=0.1281 PS=0.69 PD=1.03
M$13010 \$8354 A|B1|X \$8374 VGND sky130_fd_pr__nfet_01v8 L=0.15 W=0.42
+ AS=0.1281 AD=0.0441 PS=1.03 PD=0.63
M$13011 \$8374 A|B1|C1|X A|B1|Y VGND sky130_fd_pr__nfet_01v8 L=0.15 W=0.42
+ AS=0.0441 AD=0.1176 PS=0.63 PD=1.4
M$13013 \$8397 A|A1|B|Y \$8507 VGND sky130_fd_pr__nfet_01v8 L=0.15 W=0.65
+ AS=0.169 AD=0.06825 PS=1.82 PD=0.86
M$13014 \$8507 A|B1|C1|X VGND VGND sky130_fd_pr__nfet_01v8 L=0.15 W=0.65
+ AS=0.06825 AD=0.08775 PS=0.86 PD=0.92
M$13015 VGND A|B1|C1|X \$8398 VGND sky130_fd_pr__nfet_01v8 L=0.15 W=0.65
+ AS=0.08775 AD=0.169 PS=0.92 PD=1.82
M$13016 VGND A1|Y \$8351 VGND sky130_fd_pr__nfet_01v8 L=0.15 W=0.65 AS=0.169
+ AD=0.08775 PS=1.82 PD=0.92
M$13017 \$8351 A2|Y VGND VGND sky130_fd_pr__nfet_01v8 L=0.15 W=0.65 AS=0.08775
+ AD=0.08775 PS=0.92 PD=0.92
M$13018 VGND A3|B|X \$8351 VGND sky130_fd_pr__nfet_01v8 L=0.15 W=0.65
+ AS=0.08775 AD=0.19825 PS=0.92 PD=1.26
M$13019 \$8351 A|B1|X A2|B|Y VGND sky130_fd_pr__nfet_01v8 L=0.15 W=0.65
+ AS=0.19825 AD=0.221 PS=1.26 PD=1.98
M$13020 VGND A|A1|B|Y \$8398 VGND sky130_fd_pr__nfet_01v8 L=0.15 W=0.65
+ AS=0.169 AD=0.08775 PS=1.82 PD=0.92
M$13021 \$8398 \$8397 A|B|Y VGND sky130_fd_pr__nfet_01v8 L=0.15 W=0.65
+ AS=0.08775 AD=0.195 PS=0.92 PD=1.9
M$13025 \$8400 A|B|Y \$8516 VGND sky130_fd_pr__nfet_01v8 L=0.15 W=0.65 AS=0.169
+ AD=0.06825 PS=1.82 PD=0.86
M$13026 \$8516 A|B1|X VGND VGND sky130_fd_pr__nfet_01v8 L=0.15 W=0.65
+ AS=0.06825 AD=0.08775 PS=0.86 PD=0.92
M$13027 VGND A|B1|X \$8401 VGND sky130_fd_pr__nfet_01v8 L=0.15 W=0.65
+ AS=0.08775 AD=0.169 PS=0.92 PD=1.82
M$13028 VGND A|B|Y \$8401 VGND sky130_fd_pr__nfet_01v8 L=0.15 W=0.65 AS=0.169
+ AD=0.08775 PS=1.82 PD=0.92
M$13029 \$8401 \$8400 A|B|Y VGND sky130_fd_pr__nfet_01v8 L=0.15 W=0.65
+ AS=0.08775 AD=0.195 PS=0.92 PD=1.9
M$13032 VGND B|C|X \$8372 VGND sky130_fd_pr__nfet_01v8 L=0.15 W=0.65 AS=0.169
+ AD=0.08775 PS=1.82 PD=0.92
M$13033 \$8372 A|X B|Y VGND sky130_fd_pr__nfet_01v8 L=0.15 W=0.65 AS=0.08775
+ AD=0.169 PS=0.92 PD=1.82
M$13036 VGND B|Y \$8528 VGND sky130_fd_pr__nfet_01v8 L=0.15 W=0.65 AS=0.169
+ AD=0.08775 PS=1.82 PD=0.92
M$13037 \$8528 A|X A2|B|Y VGND sky130_fd_pr__nfet_01v8 L=0.15 W=0.65 AS=0.08775
+ AD=0.169 PS=0.92 PD=1.82
M$13040 \$8294 B|C|Y \$8370 VGND sky130_fd_pr__nfet_01v8 L=0.15 W=0.42
+ AS=0.1092 AD=0.0441 PS=1.36 PD=0.63
M$13041 \$8370 A|Y VGND VGND sky130_fd_pr__nfet_01v8 L=0.15 W=0.42 AS=0.0441
+ AD=0.0567 PS=0.63 PD=0.69
M$13042 VGND A|Y \$8369 VGND sky130_fd_pr__nfet_01v8 L=0.15 W=0.42 AS=0.0567
+ AD=0.0441 PS=0.69 PD=0.63
M$13043 \$8369 B|Y \$8294 VGND sky130_fd_pr__nfet_01v8 L=0.15 W=0.42 AS=0.0441
+ AD=0.0567 PS=0.63 PD=0.69
M$13044 \$8294 B|Y \$8368 VGND sky130_fd_pr__nfet_01v8 L=0.15 W=0.42 AS=0.0567
+ AD=0.0441 PS=0.69 PD=0.63
M$13045 VGND B|C|Y \$8368 VGND sky130_fd_pr__nfet_01v8 L=0.15 W=0.42 AS=0.1474
+ AD=0.0441 PS=1.215 PD=0.63
M$13046 VGND \$8294 B|X VGND sky130_fd_pr__nfet_01v8 L=0.15 W=0.65 AS=0.1474
+ AD=0.23725 PS=1.215 PD=2.03
M$13055 B|Y \$8295 \$8352 VGND sky130_fd_pr__nfet_01v8 L=0.15 W=0.65 AS=0.195
+ AD=0.08775 PS=1.9 PD=0.92
M$13056 \$8352 B|C|X VGND VGND sky130_fd_pr__nfet_01v8 L=0.15 W=0.65 AS=0.08775
+ AD=0.169 PS=0.92 PD=1.82
M$13057 \$8352 A|Q VGND VGND sky130_fd_pr__nfet_01v8 L=0.15 W=0.65 AS=0.169
+ AD=0.08775 PS=1.82 PD=0.92
M$13058 VGND A|Q \$8367 VGND sky130_fd_pr__nfet_01v8 L=0.15 W=0.65 AS=0.08775
+ AD=0.06825 PS=0.92 PD=0.86
M$13059 \$8367 B|C|X \$8295 VGND sky130_fd_pr__nfet_01v8 L=0.15 W=0.65
+ AS=0.06825 AD=0.169 PS=0.86 PD=1.82
M$13062 \$8296 CLK|TICK VGND VGND sky130_fd_pr__nfet_01v8 L=0.15 W=0.42
+ AS=0.1092 AD=0.0567 PS=1.36 PD=0.69
M$13063 VGND \$8296 \$8297 VGND sky130_fd_pr__nfet_01v8 L=0.15 W=0.42 AS=0.0567
+ AD=0.1092 PS=0.69 PD=1.36
M$13064 VGND D|Y \$8299 VGND sky130_fd_pr__nfet_01v8 L=0.15 W=0.42 AS=0.2205
+ AD=0.066 PS=1.89 PD=0.745
M$13065 \$8299 \$8296 \$8300 VGND sky130_fd_pr__nfet_01v8 L=0.15 W=0.36
+ AS=0.066 AD=0.0594 PS=0.745 PD=0.69
M$13066 \$8366 \$8297 \$8300 VGND sky130_fd_pr__nfet_01v8 L=0.15 W=0.36
+ AS=0.1401 AD=0.0594 PS=1.1 PD=0.69
M$13067 \$8366 \$8302 \$8365 VGND sky130_fd_pr__nfet_01v8 L=0.15 W=0.42
+ AS=0.1401 AD=0.0441 PS=1.1 PD=0.63
M$13068 VGND RESET_B|X \$8365 VGND sky130_fd_pr__nfet_01v8 L=0.15 W=0.42
+ AS=0.1346 AD=0.0441 PS=1.15 PD=0.63
M$13069 VGND \$8300 \$8302 VGND sky130_fd_pr__nfet_01v8 L=0.15 W=0.64 AS=0.1346
+ AD=0.0999 PS=1.15 PD=0.985
M$13070 \$8302 \$8297 \$8303 VGND sky130_fd_pr__nfet_01v8 L=0.15 W=0.36
+ AS=0.0999 AD=0.0711 PS=0.985 PD=0.755
M$13071 \$8364 \$8296 \$8303 VGND sky130_fd_pr__nfet_01v8 L=0.15 W=0.36
+ AS=0.0669 AD=0.0711 PS=0.75 PD=0.755
M$13072 \$8364 \$8346 VGND VGND sky130_fd_pr__nfet_01v8 L=0.15 W=0.42 AS=0.0669
+ AD=0.12495 PS=0.75 PD=1.015
M$13073 VGND RESET_B|X \$8363 VGND sky130_fd_pr__nfet_01v8 L=0.15 W=0.42
+ AS=0.12495 AD=0.06405 PS=1.015 PD=0.725
M$13074 \$8363 \$8303 \$8346 VGND sky130_fd_pr__nfet_01v8 L=0.15 W=0.42
+ AS=0.06405 AD=0.1092 PS=0.725 PD=1.36
M$13076 \$8405 B|C|X \$8500 VGND sky130_fd_pr__nfet_01v8 L=0.15 W=0.65 AS=0.169
+ AD=0.06825 PS=1.82 PD=0.86
M$13077 \$8500 A|Q VGND VGND sky130_fd_pr__nfet_01v8 L=0.15 W=0.65 AS=0.06825
+ AD=0.08775 PS=0.86 PD=0.92
M$13078 VGND A|Q \$8406 VGND sky130_fd_pr__nfet_01v8 L=0.15 W=0.65 AS=0.08775
+ AD=0.169 PS=0.92 PD=1.82
M$13079 VGND \$8346 A|Q VGND sky130_fd_pr__nfet_01v8 L=0.15 W=0.65 AS=0.2087
+ AD=0.169 PS=2.02 PD=1.82
M$13080 VGND B|C|X \$8406 VGND sky130_fd_pr__nfet_01v8 L=0.15 W=0.65 AS=0.169
+ AD=0.08775 PS=1.82 PD=0.92
M$13081 \$8406 \$8405 B|Y VGND sky130_fd_pr__nfet_01v8 L=0.15 W=0.65 AS=0.08775
+ AD=0.195 PS=0.92 PD=1.9
M$13085 A|B|Y B1|Y \$8408 VGND sky130_fd_pr__nfet_01v8 L=0.15 W=0.42 AS=0.1113
+ AD=0.0588 PS=1.37 PD=0.7
M$13086 \$8408 A2|B|X VGND VGND sky130_fd_pr__nfet_01v8 L=0.15 W=0.42 AS=0.0588
+ AD=0.0588 PS=0.7 PD=0.7
M$13087 VGND A1|Y \$8408 VGND sky130_fd_pr__nfet_01v8 L=0.15 W=0.42 AS=0.0588
+ AD=0.1113 PS=0.7 PD=1.37
M$13088 VGND A|Q A1|Y VGND sky130_fd_pr__nfet_01v8 L=0.15 W=0.42 AS=0.1197
+ AD=0.1092 PS=1.41 PD=1.36
M$13089 \$8411 CLK|TICK VGND VGND sky130_fd_pr__nfet_01v8 L=0.15 W=0.42
+ AS=0.1092 AD=0.0567 PS=1.36 PD=0.69
M$13090 VGND \$8411 \$8412 VGND sky130_fd_pr__nfet_01v8 L=0.15 W=0.42 AS=0.0567
+ AD=0.1092 PS=0.69 PD=1.36
M$13091 VGND A|X D|Y VGND sky130_fd_pr__nfet_01v8 L=0.15 W=0.65 AS=0.169
+ AD=0.08775 PS=1.82 PD=0.92
M$13092 D|Y B|Y VGND VGND sky130_fd_pr__nfet_01v8 L=0.15 W=0.65 AS=0.08775
+ AD=0.169 PS=0.92 PD=1.82
M$13093 \$8413 \$8411 \$8414 VGND sky130_fd_pr__nfet_01v8 L=0.15 W=0.36
+ AS=0.066 AD=0.0594 PS=0.745 PD=0.69
M$13094 \$8414 \$8412 \$8460 VGND sky130_fd_pr__nfet_01v8 L=0.15 W=0.36
+ AS=0.0594 AD=0.1401 PS=0.69 PD=1.1
M$13095 \$8543 \$8412 \$8415 VGND sky130_fd_pr__nfet_01v8 L=0.15 W=0.36
+ AS=0.0999 AD=0.0711 PS=0.985 PD=0.755
M$13096 \$8415 \$8411 \$8454 VGND sky130_fd_pr__nfet_01v8 L=0.15 W=0.36
+ AS=0.0711 AD=0.0669 PS=0.755 PD=0.75
M$13097 VGND D|Y \$8413 VGND sky130_fd_pr__nfet_01v8 L=0.15 W=0.42 AS=0.2205
+ AD=0.066 PS=1.89 PD=0.745
M$13098 \$8460 \$8543 \$8458 VGND sky130_fd_pr__nfet_01v8 L=0.15 W=0.42
+ AS=0.1401 AD=0.0441 PS=1.1 PD=0.63
M$13099 \$8458 RESET_B|X VGND VGND sky130_fd_pr__nfet_01v8 L=0.15 W=0.42
+ AS=0.0441 AD=0.1346 PS=0.63 PD=1.15
M$13100 \$8454 \$8416 VGND VGND sky130_fd_pr__nfet_01v8 L=0.15 W=0.42 AS=0.0669
+ AD=0.12495 PS=0.75 PD=1.015
M$13101 VGND RESET_B|X \$8451 VGND sky130_fd_pr__nfet_01v8 L=0.15 W=0.42
+ AS=0.12495 AD=0.06405 PS=1.015 PD=0.725
M$13102 \$8451 \$8415 \$8416 VGND sky130_fd_pr__nfet_01v8 L=0.15 W=0.42
+ AS=0.06405 AD=0.1092 PS=0.725 PD=1.36
M$13103 VGND \$8414 \$8543 VGND sky130_fd_pr__nfet_01v8 L=0.15 W=0.64 AS=0.1346
+ AD=0.0999 PS=1.15 PD=0.985
M$13104 VGND B|Y \$8306 VGND sky130_fd_pr__nfet_01v8 L=0.15 W=0.65 AS=0.169
+ AD=0.08775 PS=1.82 PD=0.92
M$13105 \$8306 A|X VGND VGND sky130_fd_pr__nfet_01v8 L=0.15 W=0.65 AS=0.08775
+ AD=0.08775 PS=0.92 PD=0.92
M$13106 VGND A|X \$8361 VGND sky130_fd_pr__nfet_01v8 L=0.15 W=0.65 AS=0.08775
+ AD=0.08775 PS=0.92 PD=0.92
M$13107 \$8361 B|Y D|X VGND sky130_fd_pr__nfet_01v8 L=0.15 W=0.65 AS=0.08775
+ AD=0.25025 PS=0.92 PD=1.42
M$13108 D|X \$8306 VGND VGND sky130_fd_pr__nfet_01v8 L=0.15 W=0.65 AS=0.25025
+ AD=0.208 PS=1.42 PD=1.94
M$13109 A|Q \$8349 VGND VGND sky130_fd_pr__nfet_01v8 L=0.15 W=0.65 AS=0.169
+ AD=0.2087 PS=1.82 PD=2.02
M$13110 \$8349 \$8309 \$8360 VGND sky130_fd_pr__nfet_01v8 L=0.15 W=0.42
+ AS=0.1092 AD=0.06405 PS=1.36 PD=0.725
M$13111 \$8360 RESET_B|X VGND VGND sky130_fd_pr__nfet_01v8 L=0.15 W=0.42
+ AS=0.06405 AD=0.12495 PS=0.725 PD=1.015
M$13112 VGND \$8349 \$8359 VGND sky130_fd_pr__nfet_01v8 L=0.15 W=0.42
+ AS=0.12495 AD=0.0669 PS=1.015 PD=0.75
M$13113 \$8359 \$8350 \$8309 VGND sky130_fd_pr__nfet_01v8 L=0.15 W=0.36
+ AS=0.0669 AD=0.0711 PS=0.75 PD=0.755
M$13114 \$8311 \$8310 \$8309 VGND sky130_fd_pr__nfet_01v8 L=0.15 W=0.36
+ AS=0.0999 AD=0.0711 PS=0.985 PD=0.755
M$13115 \$8311 \$8313 VGND VGND sky130_fd_pr__nfet_01v8 L=0.15 W=0.64 AS=0.0999
+ AD=0.1346 PS=0.985 PD=1.15
M$13116 VGND RESET_B|X \$8358 VGND sky130_fd_pr__nfet_01v8 L=0.15 W=0.42
+ AS=0.1346 AD=0.0441 PS=1.15 PD=0.63
M$13117 \$8358 \$8311 \$8357 VGND sky130_fd_pr__nfet_01v8 L=0.15 W=0.42
+ AS=0.0441 AD=0.1401 PS=0.63 PD=1.1
M$13118 \$8357 \$8310 \$8313 VGND sky130_fd_pr__nfet_01v8 L=0.15 W=0.36
+ AS=0.1401 AD=0.0594 PS=1.1 PD=0.69
M$13119 \$8314 \$8350 \$8313 VGND sky130_fd_pr__nfet_01v8 L=0.15 W=0.36
+ AS=0.066 AD=0.0594 PS=0.745 PD=0.69
M$13120 \$8314 D|X VGND VGND sky130_fd_pr__nfet_01v8 L=0.15 W=0.42 AS=0.066
+ AD=0.2205 PS=0.745 PD=1.89
M$13121 VGND \$8416 A|Q VGND sky130_fd_pr__nfet_01v8 L=0.15 W=0.65 AS=0.2087
+ AD=0.169 PS=2.02 PD=1.82
M$13124 \$8310 \$8350 VGND VGND sky130_fd_pr__nfet_01v8 L=0.15 W=0.42 AS=0.1092
+ AD=0.0567 PS=1.36 PD=0.69
M$13125 VGND CLK|TICK \$8350 VGND sky130_fd_pr__nfet_01v8 L=0.15 W=0.42
+ AS=0.0567 AD=0.1092 PS=0.69 PD=1.36
M$13139 VGND B|Y \$8639 VGND sky130_fd_pr__nfet_01v8 L=0.15 W=0.65 AS=0.169
+ AD=0.08775 PS=1.82 PD=0.92
M$13140 \$8639 A|B1|X A|A1|Y VGND sky130_fd_pr__nfet_01v8 L=0.15 W=0.65
+ AS=0.08775 AD=0.169 PS=0.92 PD=1.82
M$13142 \$8612 A1|Y VGND VGND sky130_fd_pr__nfet_01v8 L=0.15 W=0.42 AS=0.1113
+ AD=0.0588 PS=1.37 PD=0.7
M$13143 VGND A2|B|C|X \$8612 VGND sky130_fd_pr__nfet_01v8 L=0.15 W=0.42
+ AS=0.0588 AD=0.0588 PS=0.7 PD=0.7
M$13144 \$8612 A|B1|X A|B|C|Y VGND sky130_fd_pr__nfet_01v8 L=0.15 W=0.42
+ AS=0.0588 AD=0.1113 PS=0.7 PD=1.37
M$13145 \$8567 A|A1|B|Y \$8638 VGND sky130_fd_pr__nfet_01v8 L=0.15 W=0.65
+ AS=0.169 AD=0.06825 PS=1.82 PD=0.86
M$13146 \$8638 A|B1|X VGND VGND sky130_fd_pr__nfet_01v8 L=0.15 W=0.65
+ AS=0.06825 AD=0.08775 PS=0.86 PD=0.92
M$13147 VGND A|B1|X \$8613 VGND sky130_fd_pr__nfet_01v8 L=0.15 W=0.65
+ AS=0.08775 AD=0.169 PS=0.92 PD=1.82
M$13148 VGND A|A1|B|Y \$8613 VGND sky130_fd_pr__nfet_01v8 L=0.15 W=0.65
+ AS=0.169 AD=0.08775 PS=1.82 PD=0.92
M$13149 \$8613 \$8567 A|B|Y VGND sky130_fd_pr__nfet_01v8 L=0.15 W=0.65
+ AS=0.08775 AD=0.195 PS=0.92 PD=1.9
M$13151 \$8569 A|B|Y \$8637 VGND sky130_fd_pr__nfet_01v8 L=0.15 W=0.42
+ AS=0.1092 AD=0.0441 PS=1.36 PD=0.63
M$13152 \$8637 A2|B|C|X \$8636 VGND sky130_fd_pr__nfet_01v8 L=0.15 W=0.42
+ AS=0.0441 AD=0.0441 PS=0.63 PD=0.63
M$13153 VGND A2|C|D|X \$8636 VGND sky130_fd_pr__nfet_01v8 L=0.15 W=0.42
+ AS=0.13165 AD=0.0441 PS=1.14 PD=0.63
M$13154 VGND \$8569 A1|X VGND sky130_fd_pr__nfet_01v8 L=0.15 W=0.65 AS=0.13165
+ AD=0.169 PS=1.14 PD=1.82
M$13155 VGND A2|C|D|X \$8635 VGND sky130_fd_pr__nfet_01v8 L=0.15 W=0.65
+ AS=0.169 AD=0.08775 PS=1.82 PD=0.92
M$13156 \$8635 A2|B|C|X \$8634 VGND sky130_fd_pr__nfet_01v8 L=0.15 W=0.65
+ AS=0.08775 AD=0.08775 PS=0.92 PD=0.92
M$13157 \$8634 A|B|Y \$8633 VGND sky130_fd_pr__nfet_01v8 L=0.15 W=0.65
+ AS=0.08775 AD=0.10725 PS=0.92 PD=0.98
M$13158 \$8633 A|X B1|Y VGND sky130_fd_pr__nfet_01v8 L=0.15 W=0.65 AS=0.10725
+ AD=0.195 PS=0.98 PD=1.9
M$13160 A|B1|Y B1|Y \$8614 VGND sky130_fd_pr__nfet_01v8 L=0.15 W=0.42 AS=0.1113
+ AD=0.0588 PS=1.37 PD=0.7
M$13161 \$8614 A|A2|B|C|SLEEP|Y VGND VGND sky130_fd_pr__nfet_01v8 L=0.15 W=0.42
+ AS=0.0588 AD=0.0588 PS=0.7 PD=0.7
M$13162 VGND A|A1|X \$8614 VGND sky130_fd_pr__nfet_01v8 L=0.15 W=0.42 AS=0.0588
+ AD=0.1113 PS=0.7 PD=1.37
M$13165 VGND A|A2|B|C|SLEEP|Y C|Y VGND sky130_fd_pr__nfet_01v8 L=0.15 W=0.65
+ AS=0.169 AD=0.08775 PS=1.82 PD=0.92
M$13166 C|Y A|B|B1|Y VGND VGND sky130_fd_pr__nfet_01v8 L=0.15 W=0.65 AS=0.08775
+ AD=0.169 PS=0.92 PD=1.82
M$13168 \$8392 \$8393 \$8394 VGND sky130_fd_pr__nfet_01v8 L=0.15 W=0.64
+ AS=0.224 AD=0.0928 PS=1.98 PD=0.93
M$13169 \$8394 C|Y \$8391 VGND sky130_fd_pr__nfet_01v8 L=0.15 W=0.64 AS=0.0928
+ AD=0.1728 PS=0.93 PD=1.82
M$13170 VGND A1|B|Y \$8632 VGND sky130_fd_pr__nfet_01v8 L=0.15 W=0.65 AS=0.169
+ AD=0.08775 PS=1.82 PD=0.92
M$13171 \$8632 A|Y A|Y VGND sky130_fd_pr__nfet_01v8 L=0.15 W=0.65 AS=0.08775
+ AD=0.169 PS=0.92 PD=1.82
M$13173 VGND A2|A_N|B|X \$8573 VGND sky130_fd_pr__nfet_01v8 L=0.15 W=0.42
+ AS=0.10025 AD=0.1092 PS=0.985 PD=1.36
M$13174 A2|Y \$8573 \$8631 VGND sky130_fd_pr__nfet_01v8 L=0.15 W=0.65 AS=0.169
+ AD=0.08775 PS=1.82 PD=0.92
M$13175 \$8631 A1|B|Y VGND VGND sky130_fd_pr__nfet_01v8 L=0.15 W=0.65
+ AS=0.08775 AD=0.10025 PS=0.92 PD=0.985
M$13177 A|A1|B|Y A|B1|X \$8630 VGND sky130_fd_pr__nfet_01v8 L=0.15 W=0.65
+ AS=0.169 AD=0.08775 PS=1.82 PD=0.92
M$13178 \$8630 A|B|Y VGND VGND sky130_fd_pr__nfet_01v8 L=0.15 W=0.65 AS=0.08775
+ AD=0.169 PS=0.92 PD=1.82
M$13180 VGND A|B|Y \$8575 VGND sky130_fd_pr__nfet_01v8 L=0.15 W=0.65 AS=0.169
+ AD=0.08775 PS=1.82 PD=0.92
M$13181 \$8575 A|X VGND VGND sky130_fd_pr__nfet_01v8 L=0.15 W=0.65 AS=0.08775
+ AD=0.08775 PS=0.92 PD=0.92
M$13182 VGND A|X \$8629 VGND sky130_fd_pr__nfet_01v8 L=0.15 W=0.65 AS=0.08775
+ AD=0.08775 PS=0.92 PD=0.92
M$13183 \$8629 A|B|Y A|B|X VGND sky130_fd_pr__nfet_01v8 L=0.15 W=0.65
+ AS=0.08775 AD=0.25025 PS=0.92 PD=1.42
M$13184 A|B|X \$8575 VGND VGND sky130_fd_pr__nfet_01v8 L=0.15 W=0.65 AS=0.25025
+ AD=0.208 PS=1.42 PD=1.94
M$13185 VGND B|Y \$8628 VGND sky130_fd_pr__nfet_01v8 L=0.15 W=0.65 AS=0.169
+ AD=0.08775 PS=1.82 PD=0.92
M$13186 \$8628 A|B|Y B|Y VGND sky130_fd_pr__nfet_01v8 L=0.15 W=0.65 AS=0.08775
+ AD=0.169 PS=0.92 PD=1.82
M$13188 VGND A|B|X \$8578 VGND sky130_fd_pr__nfet_01v8 L=0.15 W=0.65 AS=0.169
+ AD=0.08775 PS=1.82 PD=0.92
M$13189 \$8578 A|X VGND VGND sky130_fd_pr__nfet_01v8 L=0.15 W=0.65 AS=0.08775
+ AD=0.08775 PS=0.92 PD=0.92
M$13190 VGND A|X \$8627 VGND sky130_fd_pr__nfet_01v8 L=0.15 W=0.65 AS=0.08775
+ AD=0.08775 PS=0.92 PD=0.92
M$13191 \$8627 A|B|X A|A1|B|X VGND sky130_fd_pr__nfet_01v8 L=0.15 W=0.65
+ AS=0.08775 AD=0.25025 PS=0.92 PD=1.42
M$13192 A|A1|B|X \$8578 VGND VGND sky130_fd_pr__nfet_01v8 L=0.15 W=0.65
+ AS=0.25025 AD=0.208 PS=1.42 PD=1.94
M$13196 A|B1|Y A2|B|X VGND VGND sky130_fd_pr__nfet_01v8 L=0.15 W=0.65
+ AS=0.08775 AD=0.08775 PS=0.92 PD=0.92
M$13197 VGND A3|B1|C|SLEEP|Y A|B1|Y VGND sky130_fd_pr__nfet_01v8 L=0.15 W=0.65
+ AS=0.08775 AD=0.169 PS=0.92 PD=1.82
M$13199 A|Y A|A1|Y \$8626 VGND sky130_fd_pr__nfet_01v8 L=0.15 W=0.65 AS=0.091
+ AD=0.095875 PS=0.93 PD=0.945
M$13200 \$8626 A2|B|Y VGND VGND sky130_fd_pr__nfet_01v8 L=0.15 W=0.65
+ AS=0.095875 AD=0.17225 PS=0.945 PD=1.83
M$13205 D|Y \$8584 \$8615 VGND sky130_fd_pr__nfet_01v8 L=0.15 W=0.65 AS=0.195
+ AD=0.08775 PS=1.9 PD=0.92
M$13206 \$8615 B|Y VGND VGND sky130_fd_pr__nfet_01v8 L=0.15 W=0.65 AS=0.08775
+ AD=0.169 PS=0.92 PD=1.82
M$13207 \$8615 A|B|Y VGND VGND sky130_fd_pr__nfet_01v8 L=0.15 W=0.65 AS=0.169
+ AD=0.08775 PS=1.82 PD=0.92
M$13208 VGND A|B|Y \$8625 VGND sky130_fd_pr__nfet_01v8 L=0.15 W=0.65 AS=0.08775
+ AD=0.06825 PS=0.92 PD=0.86
M$13209 \$8625 B|Y \$8584 VGND sky130_fd_pr__nfet_01v8 L=0.15 W=0.65 AS=0.06825
+ AD=0.169 PS=0.86 PD=1.82
M$13211 \$8585 A2|B|X \$8624 VGND sky130_fd_pr__nfet_01v8 L=0.15 W=0.65
+ AS=0.169 AD=0.06825 PS=1.82 PD=0.86
M$13212 \$8624 A|Q VGND VGND sky130_fd_pr__nfet_01v8 L=0.15 W=0.65 AS=0.06825
+ AD=0.08775 PS=0.86 PD=0.92
M$13213 VGND A|Q \$8616 VGND sky130_fd_pr__nfet_01v8 L=0.15 W=0.65 AS=0.08775
+ AD=0.169 PS=0.92 PD=1.82
M$13214 VGND A2|B|X \$8616 VGND sky130_fd_pr__nfet_01v8 L=0.15 W=0.65 AS=0.169
+ AD=0.08775 PS=1.82 PD=0.92
M$13215 \$8616 \$8585 B|Y VGND sky130_fd_pr__nfet_01v8 L=0.15 W=0.65 AS=0.08775
+ AD=0.195 PS=0.92 PD=1.9
M$13216 A|X \$8586 VGND VGND sky130_fd_pr__nfet_01v8 L=0.15 W=0.42 AS=0.1113
+ AD=0.0966 PS=1.37 PD=0.88
M$13217 VGND B|Y \$8623 VGND sky130_fd_pr__nfet_01v8 L=0.15 W=0.42 AS=0.0966
+ AD=0.0441 PS=0.88 PD=0.63
M$13218 \$8623 A|Q \$8586 VGND sky130_fd_pr__nfet_01v8 L=0.15 W=0.42 AS=0.0441
+ AD=0.1113 PS=0.63 PD=1.37
M$13220 B|Y A|Q VGND VGND sky130_fd_pr__nfet_01v8 L=0.15 W=0.65 AS=0.08775
+ AD=0.169 PS=0.92 PD=1.82
M$13238 \$8641 A1|Y VGND VGND sky130_fd_pr__nfet_01v8 L=0.15 W=0.42 AS=0.1113
+ AD=0.0588 PS=1.37 PD=0.7
M$13239 VGND A2|C|D|X \$8641 VGND sky130_fd_pr__nfet_01v8 L=0.15 W=0.42
+ AS=0.0588 AD=0.0588 PS=0.7 PD=0.7
M$13240 \$8641 B1|Y A|A2|B|C|SLEEP|Y VGND sky130_fd_pr__nfet_01v8 L=0.15 W=0.42
+ AS=0.0588 AD=0.1113 PS=0.7 PD=1.37
M$13241 A3|Y A|A2|B|C|SLEEP|Y VGND VGND sky130_fd_pr__nfet_01v8 L=0.15 W=0.65
+ AS=0.169 AD=0.08775 PS=1.82 PD=0.92
M$13242 VGND A|B|C|Y A3|Y VGND sky130_fd_pr__nfet_01v8 L=0.15 W=0.65 AS=0.08775
+ AD=0.08775 PS=0.92 PD=0.92
M$13243 A3|Y A|A2|B|Y VGND VGND sky130_fd_pr__nfet_01v8 L=0.15 W=0.65
+ AS=0.08775 AD=0.169 PS=0.92 PD=1.82
M$13245 B|Y A|A1|X \$8746 VGND sky130_fd_pr__nfet_01v8 L=0.15 W=0.65 AS=0.169
+ AD=0.08775 PS=1.82 PD=0.92
M$13246 \$8746 A|B|B1|Y VGND VGND sky130_fd_pr__nfet_01v8 L=0.15 W=0.65
+ AS=0.08775 AD=0.169 PS=0.92 PD=1.82
M$13247 \$8646 B|Y \$8750 VGND sky130_fd_pr__nfet_01v8 L=0.15 W=0.65 AS=0.169
+ AD=0.06825 PS=1.82 PD=0.86
M$13248 \$8750 A|A2|B|C|SLEEP|Y VGND VGND sky130_fd_pr__nfet_01v8 L=0.15 W=0.65
+ AS=0.06825 AD=0.08775 PS=0.86 PD=0.92
M$13249 VGND A|A2|B|C|SLEEP|Y \$8647 VGND sky130_fd_pr__nfet_01v8 L=0.15 W=0.65
+ AS=0.08775 AD=0.169 PS=0.92 PD=1.82
M$13250 VGND B|Y \$8647 VGND sky130_fd_pr__nfet_01v8 L=0.15 W=0.65 AS=0.169
+ AD=0.08775 PS=1.82 PD=0.92
M$13251 \$8647 \$8646 A1|B|Y VGND sky130_fd_pr__nfet_01v8 L=0.15 W=0.65
+ AS=0.08775 AD=0.195 PS=0.92 PD=1.9
M$13254 \$8648 A1|B|Y \$8763 VGND sky130_fd_pr__nfet_01v8 L=0.15 W=0.65
+ AS=0.169 AD=0.06825 PS=1.82 PD=0.86
M$13255 \$8763 A|Y VGND VGND sky130_fd_pr__nfet_01v8 L=0.15 W=0.65 AS=0.06825
+ AD=0.08775 PS=0.86 PD=0.92
M$13256 VGND A|Y \$8649 VGND sky130_fd_pr__nfet_01v8 L=0.15 W=0.65 AS=0.08775
+ AD=0.169 PS=0.92 PD=1.82
M$13257 VGND A1|B|Y \$8649 VGND sky130_fd_pr__nfet_01v8 L=0.15 W=0.65 AS=0.169
+ AD=0.08775 PS=1.82 PD=0.92
M$13258 \$8649 \$8648 A|C|Y VGND sky130_fd_pr__nfet_01v8 L=0.15 W=0.65
+ AS=0.08775 AD=0.195 PS=0.92 PD=1.9
M$13260 \$8651 A3|B|X \$8774 VGND sky130_fd_pr__nfet_01v8 L=0.15 W=0.65
+ AS=0.169 AD=0.06825 PS=1.82 PD=0.86
M$13261 \$8774 A|Y VGND VGND sky130_fd_pr__nfet_01v8 L=0.15 W=0.65 AS=0.06825
+ AD=0.08775 PS=0.86 PD=0.92
M$13262 VGND A|Y \$8653 VGND sky130_fd_pr__nfet_01v8 L=0.15 W=0.65 AS=0.08775
+ AD=0.169 PS=0.92 PD=1.82
M$13263 VGND A3|B|X \$8653 VGND sky130_fd_pr__nfet_01v8 L=0.15 W=0.65 AS=0.169
+ AD=0.08775 PS=1.82 PD=0.92
M$13264 \$8653 \$8651 B|D|Y VGND sky130_fd_pr__nfet_01v8 L=0.15 W=0.65
+ AS=0.08775 AD=0.195 PS=0.92 PD=1.9
M$13268 B|Y A|C|Y VGND VGND sky130_fd_pr__nfet_01v8 L=0.15 W=0.65 AS=0.169
+ AD=0.08775 PS=1.82 PD=0.92
M$13269 VGND A|B|B1|X B|Y VGND sky130_fd_pr__nfet_01v8 L=0.15 W=0.65 AS=0.08775
+ AD=0.08775 PS=0.92 PD=0.92
M$13273 \$8658 A|A1|B|X VGND VGND sky130_fd_pr__nfet_01v8 L=0.15 W=0.65
+ AS=0.182 AD=0.11375 PS=1.86 PD=1
M$13274 VGND A2|B|X \$8658 VGND sky130_fd_pr__nfet_01v8 L=0.15 W=0.65
+ AS=0.11375 AD=0.08775 PS=1 PD=0.92
M$13275 \$8658 A3|B1|C|SLEEP|Y VGND VGND sky130_fd_pr__nfet_01v8 L=0.15 W=0.65
+ AS=0.08775 AD=0.08775 PS=0.92 PD=0.92
M$13276 VGND A4|B|X \$8658 VGND sky130_fd_pr__nfet_01v8 L=0.15 W=0.65
+ AS=0.08775 AD=0.203125 PS=0.92 PD=1.275
M$13277 \$8658 A|B1|X B|Y VGND sky130_fd_pr__nfet_01v8 L=0.15 W=0.65
+ AS=0.203125 AD=0.169 PS=1.275 PD=1.82
M$13279 VGND B|Y \$8806 VGND sky130_fd_pr__nfet_01v8 L=0.15 W=0.65 AS=0.169
+ AD=0.08775 PS=1.82 PD=0.92
M$13280 \$8806 A|B1|X A|A1|Y VGND sky130_fd_pr__nfet_01v8 L=0.15 W=0.65
+ AS=0.08775 AD=0.169 PS=0.92 PD=1.82
M$13282 \$8664 A|A1|Y VGND VGND sky130_fd_pr__nfet_01v8 L=0.15 W=0.65 AS=0.169
+ AD=0.08775 PS=1.82 PD=0.92
M$13283 VGND A2|B|X \$8664 VGND sky130_fd_pr__nfet_01v8 L=0.15 W=0.65
+ AS=0.08775 AD=0.10075 PS=0.92 PD=0.96
M$13284 \$8664 A3|B1|C|SLEEP|Y \$8665 VGND sky130_fd_pr__nfet_01v8 L=0.15
+ W=0.65 AS=0.10075 AD=0.169 PS=0.96 PD=1.82
M$13285 VGND \$8665 B|X VGND sky130_fd_pr__nfet_01v8 L=0.15 W=0.65 AS=0.169
+ AD=0.169 PS=1.82 PD=1.82
M$13286 \$8667 A4|B|X \$8817 VGND sky130_fd_pr__nfet_01v8 L=0.15 W=0.65
+ AS=0.169 AD=0.06825 PS=1.82 PD=0.86
M$13287 \$8817 A|Y VGND VGND sky130_fd_pr__nfet_01v8 L=0.15 W=0.65 AS=0.06825
+ AD=0.08775 PS=0.86 PD=0.92
M$13288 VGND A|Y \$8668 VGND sky130_fd_pr__nfet_01v8 L=0.15 W=0.65 AS=0.08775
+ AD=0.169 PS=0.92 PD=1.82
M$13289 VGND A4|B|X \$8668 VGND sky130_fd_pr__nfet_01v8 L=0.15 W=0.65 AS=0.169
+ AD=0.08775 PS=1.82 PD=0.92
M$13290 \$8668 \$8667 A3|B|Y VGND sky130_fd_pr__nfet_01v8 L=0.15 W=0.65
+ AS=0.08775 AD=0.195 PS=0.92 PD=1.9
M$13291 VGND A2|B|Y \$8669 VGND sky130_fd_pr__nfet_01v8 L=0.15 W=0.65 AS=0.169
+ AD=0.08775 PS=1.82 PD=0.92
M$13292 \$8669 A|A1|Y VGND VGND sky130_fd_pr__nfet_01v8 L=0.15 W=0.65
+ AS=0.08775 AD=0.08775 PS=0.92 PD=0.92
M$13293 VGND A|A1|Y \$8810 VGND sky130_fd_pr__nfet_01v8 L=0.15 W=0.65
+ AS=0.08775 AD=0.08775 PS=0.92 PD=0.92
M$13294 \$8810 A2|B|Y A2|X VGND sky130_fd_pr__nfet_01v8 L=0.15 W=0.65
+ AS=0.08775 AD=0.25025 PS=0.92 PD=1.42
M$13295 A2|X \$8669 VGND VGND sky130_fd_pr__nfet_01v8 L=0.15 W=0.65 AS=0.25025
+ AD=0.208 PS=1.42 PD=1.94
M$13297 VGND A|A1|B|X \$8671 VGND sky130_fd_pr__nfet_01v8 L=0.15 W=0.65
+ AS=0.169 AD=0.08775 PS=1.82 PD=0.92
M$13298 \$8671 A2|X VGND VGND sky130_fd_pr__nfet_01v8 L=0.15 W=0.65 AS=0.08775
+ AD=0.08775 PS=0.92 PD=0.92
M$13299 VGND A2|A3|Y \$8671 VGND sky130_fd_pr__nfet_01v8 L=0.15 W=0.65
+ AS=0.08775 AD=0.19825 PS=0.92 PD=1.26
M$13300 \$8671 A|B1|X B|SLEEP|Y VGND sky130_fd_pr__nfet_01v8 L=0.15 W=0.65
+ AS=0.19825 AD=0.221 PS=1.26 PD=1.98
M$13302 VGND A3|B|Y \$8783 VGND sky130_fd_pr__nfet_01v8 L=0.15 W=0.65 AS=0.169
+ AD=0.08775 PS=1.82 PD=0.92
M$13303 \$8783 A|A1|Y B1|Y VGND sky130_fd_pr__nfet_01v8 L=0.15 W=0.65
+ AS=0.08775 AD=0.169 PS=0.92 PD=1.82
M$13304 B|C|Y B1|Y \$8676 VGND sky130_fd_pr__nfet_01v8 L=0.15 W=0.42 AS=0.1113
+ AD=0.0588 PS=1.37 PD=0.7
M$13305 \$8676 A2|A3|Y VGND VGND sky130_fd_pr__nfet_01v8 L=0.15 W=0.42
+ AS=0.0588 AD=0.0588 PS=0.7 PD=0.7
M$13306 VGND A|A1|Y \$8676 VGND sky130_fd_pr__nfet_01v8 L=0.15 W=0.42 AS=0.0588
+ AD=0.1113 PS=0.7 PD=1.37
M$13308 \$8677 A|A1|B|X \$8760 VGND sky130_fd_pr__nfet_01v8 L=0.15 W=0.65
+ AS=0.169 AD=0.06825 PS=1.82 PD=0.86
M$13309 \$8760 A|B1|X VGND VGND sky130_fd_pr__nfet_01v8 L=0.15 W=0.65
+ AS=0.06825 AD=0.08775 PS=0.86 PD=0.92
M$13310 VGND A|B1|X \$8679 VGND sky130_fd_pr__nfet_01v8 L=0.15 W=0.65
+ AS=0.08775 AD=0.169 PS=0.92 PD=1.82
M$13311 VGND A|A1|B|X \$8679 VGND sky130_fd_pr__nfet_01v8 L=0.15 W=0.65
+ AS=0.169 AD=0.08775 PS=1.82 PD=0.92
M$13312 \$8679 \$8677 B|Y VGND sky130_fd_pr__nfet_01v8 L=0.15 W=0.65 AS=0.08775
+ AD=0.195 PS=0.92 PD=1.9
M$13314 VGND B|Y \$8734 VGND sky130_fd_pr__nfet_01v8 L=0.15 W=0.65 AS=0.169
+ AD=0.08775 PS=1.82 PD=0.92
M$13315 \$8734 A|X B1|Y VGND sky130_fd_pr__nfet_01v8 L=0.15 W=0.65 AS=0.08775
+ AD=0.169 PS=0.92 PD=1.82
M$13333 VGND A|B|C|Y A1|Y VGND sky130_fd_pr__nfet_01v8 L=0.15 W=0.65 AS=0.169
+ AD=0.08775 PS=1.82 PD=0.92
M$13334 A1|Y A|B1|Y VGND VGND sky130_fd_pr__nfet_01v8 L=0.15 W=0.65 AS=0.08775
+ AD=0.169 PS=0.92 PD=1.82
M$13335 B|Y A|B1|Y \$8913 VGND sky130_fd_pr__nfet_01v8 L=0.15 W=0.42 AS=0.1113
+ AD=0.0588 PS=1.37 PD=0.7
M$13336 \$8913 A|A2|B|Y VGND VGND sky130_fd_pr__nfet_01v8 L=0.15 W=0.42
+ AS=0.0588 AD=0.0588 PS=0.7 PD=0.7
M$13337 VGND A|A1|B1|Y \$8913 VGND sky130_fd_pr__nfet_01v8 L=0.15 W=0.42
+ AS=0.0588 AD=0.1113 PS=0.7 PD=1.37
M$13338 \$8644 A|B|C|Y VGND VGND sky130_fd_pr__nfet_01v8 L=0.15 W=0.42
+ AS=0.1092 AD=0.0567 PS=1.36 PD=0.69
M$13339 VGND A|A2|B|Y \$8644 VGND sky130_fd_pr__nfet_01v8 L=0.15 W=0.42
+ AS=0.0567 AD=0.0567 PS=0.69 PD=0.69
M$13340 VGND A|A1|B1|Y \$8644 VGND sky130_fd_pr__nfet_01v8 L=0.15 W=0.42
+ AS=0.101875 AD=0.0567 PS=0.99 PD=0.69
M$13341 VGND \$8644 A|A1|X VGND sky130_fd_pr__nfet_01v8 L=0.15 W=0.65
+ AS=0.101875 AD=0.182 PS=0.99 PD=1.86
M$13343 \$8856 A|A2|B|C|SLEEP|Y VGND VGND sky130_fd_pr__nfet_01v8 L=0.15 W=0.42
+ AS=0.1092 AD=0.0567 PS=1.36 PD=0.69
M$13344 VGND A|B|B1|C|X \$8856 VGND sky130_fd_pr__nfet_01v8 L=0.15 W=0.42
+ AS=0.0567 AD=0.0567 PS=0.69 PD=0.69
M$13345 VGND A|B_N|SLEEP|Y \$8856 VGND sky130_fd_pr__nfet_01v8 L=0.15 W=0.42
+ AS=0.101875 AD=0.0567 PS=0.99 PD=0.69
M$13346 VGND \$8856 A2|A3|X VGND sky130_fd_pr__nfet_01v8 L=0.15 W=0.65
+ AS=0.101875 AD=0.182 PS=0.99 PD=1.86
M$13348 VGND B|Y \$8933 VGND sky130_fd_pr__nfet_01v8 L=0.15 W=0.65 AS=0.169
+ AD=0.08775 PS=1.82 PD=0.92
M$13349 \$8933 A|A1|X A|B|B1|Y VGND sky130_fd_pr__nfet_01v8 L=0.15 W=0.65
+ AS=0.08775 AD=0.169 PS=0.92 PD=1.82
M$13351 \$8914 A|A1|X VGND VGND sky130_fd_pr__nfet_01v8 L=0.15 W=0.42 AS=0.1113
+ AD=0.0588 PS=1.37 PD=0.7
M$13352 VGND A2|Y \$8914 VGND sky130_fd_pr__nfet_01v8 L=0.15 W=0.42 AS=0.0588
+ AD=0.0588 PS=0.7 PD=0.7
M$13353 \$8914 A|B|B1|Y SLEEP|Y VGND sky130_fd_pr__nfet_01v8 L=0.15 W=0.42
+ AS=0.0588 AD=0.1113 PS=0.7 PD=1.37
M$13354 A2|Y A|B|B1|C|X \$8915 VGND sky130_fd_pr__nfet_01v8 L=0.15 W=0.42
+ AS=0.1113 AD=0.0588 PS=1.37 PD=0.7
M$13355 \$8915 A2|B|X VGND VGND sky130_fd_pr__nfet_01v8 L=0.15 W=0.42 AS=0.0588
+ AD=0.0588 PS=0.7 PD=0.7
M$13356 VGND A|A1|Y \$8915 VGND sky130_fd_pr__nfet_01v8 L=0.15 W=0.42 AS=0.0588
+ AD=0.1113 PS=0.7 PD=1.37
M$13358 VGND A2|B|Y \$8932 VGND sky130_fd_pr__nfet_01v8 L=0.15 W=0.65
+ AS=0.17225 AD=0.095875 PS=1.83 PD=0.945
M$13359 \$8932 A1|B|Y A|Y VGND sky130_fd_pr__nfet_01v8 L=0.15 W=0.65
+ AS=0.095875 AD=0.091 PS=0.945 PD=0.93
M$13361 VGND A2|B|Y \$8863 VGND sky130_fd_pr__nfet_01v8 L=0.15 W=0.65 AS=0.169
+ AD=0.08775 PS=1.82 PD=0.92
M$13362 \$8863 A|C|Y VGND VGND sky130_fd_pr__nfet_01v8 L=0.15 W=0.65 AS=0.08775
+ AD=0.08775 PS=0.92 PD=0.92
M$13363 VGND A|C|Y \$8931 VGND sky130_fd_pr__nfet_01v8 L=0.15 W=0.65 AS=0.08775
+ AD=0.08775 PS=0.92 PD=0.92
M$13364 \$8931 A2|B|Y A|C|X VGND sky130_fd_pr__nfet_01v8 L=0.15 W=0.65
+ AS=0.08775 AD=0.25025 PS=0.92 PD=1.42
M$13365 A|C|X \$8863 VGND VGND sky130_fd_pr__nfet_01v8 L=0.15 W=0.65 AS=0.25025
+ AD=0.208 PS=1.42 PD=1.94
M$13367 VGND A2|A_N|B|X B1|Y VGND sky130_fd_pr__nfet_01v8 L=0.15 W=0.65
+ AS=0.08775 AD=0.08775 PS=0.92 PD=0.92
M$13368 B1|Y A|A1|B|Y VGND VGND sky130_fd_pr__nfet_01v8 L=0.15 W=0.65
+ AS=0.08775 AD=0.169 PS=0.92 PD=1.82
M$13370 VGND B|D|Y \$8655 VGND sky130_fd_pr__nfet_01v8 L=0.15 W=0.42 AS=0.1092
+ AD=0.0693 PS=1.36 PD=0.75
M$13371 \$8655 A|C|X VGND VGND sky130_fd_pr__nfet_01v8 L=0.15 W=0.42 AS=0.0693
+ AD=0.0567 PS=0.75 PD=0.69
M$13372 VGND A|B|B1|X \$8655 VGND sky130_fd_pr__nfet_01v8 L=0.15 W=0.42
+ AS=0.0567 AD=0.0567 PS=0.69 PD=0.69
M$13373 VGND A|B|Y \$8655 VGND sky130_fd_pr__nfet_01v8 L=0.15 W=0.42
+ AS=0.101875 AD=0.0567 PS=0.99 PD=0.69
M$13374 VGND \$8655 B|C|X VGND sky130_fd_pr__nfet_01v8 L=0.15 W=0.65
+ AS=0.101875 AD=0.1755 PS=0.99 PD=1.84
M$13377 A|Y A|B2|Y VGND VGND sky130_fd_pr__nfet_01v8 L=0.15 W=0.65 AS=0.08775
+ AD=0.169 PS=0.92 PD=1.82
M$13378 \$8867 B|D|Y \$8930 VGND sky130_fd_pr__nfet_01v8 L=0.15 W=0.65 AS=0.169
+ AD=0.06825 PS=1.82 PD=0.86
M$13379 \$8930 A|Y VGND VGND sky130_fd_pr__nfet_01v8 L=0.15 W=0.65 AS=0.06825
+ AD=0.08775 PS=0.86 PD=0.92
M$13380 VGND A|Y \$8916 VGND sky130_fd_pr__nfet_01v8 L=0.15 W=0.65 AS=0.08775
+ AD=0.169 PS=0.92 PD=1.82
M$13381 VGND B|D|Y \$8916 VGND sky130_fd_pr__nfet_01v8 L=0.15 W=0.65 AS=0.169
+ AD=0.08775 PS=1.82 PD=0.92
M$13382 \$8916 \$8867 A|B|Y VGND sky130_fd_pr__nfet_01v8 L=0.15 W=0.65
+ AS=0.08775 AD=0.195 PS=0.92 PD=1.9
M$13383 VGND B|Y \$8929 VGND sky130_fd_pr__nfet_01v8 L=0.15 W=0.65 AS=0.169
+ AD=0.08775 PS=1.82 PD=0.92
M$13384 \$8929 A|X A|B2|Y VGND sky130_fd_pr__nfet_01v8 L=0.15 W=0.65 AS=0.08775
+ AD=0.169 PS=0.92 PD=1.82
M$13388 VGND A|A1|B|X \$8869 VGND sky130_fd_pr__nfet_01v8 L=0.15 W=0.65
+ AS=0.169 AD=0.08775 PS=1.82 PD=0.92
M$13389 \$8869 A|B1|X VGND VGND sky130_fd_pr__nfet_01v8 L=0.15 W=0.65
+ AS=0.08775 AD=0.08775 PS=0.92 PD=0.92
M$13390 VGND A|B1|X \$8928 VGND sky130_fd_pr__nfet_01v8 L=0.15 W=0.65
+ AS=0.08775 AD=0.08775 PS=0.92 PD=0.92
M$13391 \$8928 A|A1|B|X A|A1|B|X VGND sky130_fd_pr__nfet_01v8 L=0.15 W=0.65
+ AS=0.08775 AD=0.25025 PS=0.92 PD=1.42
M$13392 A|A1|B|X \$8869 VGND VGND sky130_fd_pr__nfet_01v8 L=0.15 W=0.65
+ AS=0.25025 AD=0.208 PS=1.42 PD=1.94
M$13395 A|A1|Y A2|B|X VGND VGND sky130_fd_pr__nfet_01v8 L=0.15 W=0.65
+ AS=0.08775 AD=0.169 PS=0.92 PD=1.82
M$13396 VGND B|X A2|B|Y VGND sky130_fd_pr__nfet_01v8 L=0.15 W=0.65 AS=0.169
+ AD=0.08775 PS=1.82 PD=0.92
M$13400 B|SLEEP|Y A|B1|X \$8917 VGND sky130_fd_pr__nfet_01v8 L=0.15 W=0.65
+ AS=0.221 AD=0.19825 PS=1.98 PD=1.26
M$13401 \$8917 A3|B|Y VGND VGND sky130_fd_pr__nfet_01v8 L=0.15 W=0.65
+ AS=0.19825 AD=0.08775 PS=1.26 PD=0.92
M$13402 VGND A2|X \$8917 VGND sky130_fd_pr__nfet_01v8 L=0.15 W=0.65 AS=0.08775
+ AD=0.08775 PS=0.92 PD=0.92
M$13403 \$8917 A|A1|B|X VGND VGND sky130_fd_pr__nfet_01v8 L=0.15 W=0.65
+ AS=0.08775 AD=0.169 PS=0.92 PD=1.82
M$13404 \$8918 A1|Y VGND VGND sky130_fd_pr__nfet_01v8 L=0.15 W=0.42 AS=0.1113
+ AD=0.0588 PS=1.37 PD=0.7
M$13405 VGND A2|X \$8918 VGND sky130_fd_pr__nfet_01v8 L=0.15 W=0.42 AS=0.0588
+ AD=0.0588 PS=0.7 PD=0.7
M$13406 \$8918 A|B1|X B|Y VGND sky130_fd_pr__nfet_01v8 L=0.15 W=0.42 AS=0.0588
+ AD=0.1113 PS=0.7 PD=1.37
M$13407 \$8875 A3|B|Y \$8927 VGND sky130_fd_pr__nfet_01v8 L=0.15 W=0.65
+ AS=0.169 AD=0.06825 PS=1.82 PD=0.86
M$13408 \$8927 A|B1|X VGND VGND sky130_fd_pr__nfet_01v8 L=0.15 W=0.65
+ AS=0.06825 AD=0.08775 PS=0.86 PD=0.92
M$13409 VGND A|B1|X \$8919 VGND sky130_fd_pr__nfet_01v8 L=0.15 W=0.65
+ AS=0.08775 AD=0.169 PS=0.92 PD=1.82
M$13410 VGND A3|B|Y \$8919 VGND sky130_fd_pr__nfet_01v8 L=0.15 W=0.65 AS=0.169
+ AD=0.08775 PS=1.82 PD=0.92
M$13411 \$8919 \$8875 A2|A3|Y VGND sky130_fd_pr__nfet_01v8 L=0.15 W=0.65
+ AS=0.08775 AD=0.195 PS=0.92 PD=1.9
M$13415 VGND B|Y \$8877 VGND sky130_fd_pr__nfet_01v8 L=0.15 W=0.65 AS=0.169
+ AD=0.08775 PS=1.82 PD=0.92
M$13416 \$8877 A|X VGND VGND sky130_fd_pr__nfet_01v8 L=0.15 W=0.65 AS=0.08775
+ AD=0.08775 PS=0.92 PD=0.92
M$13417 VGND A|X \$8926 VGND sky130_fd_pr__nfet_01v8 L=0.15 W=0.65 AS=0.08775
+ AD=0.08775 PS=0.92 PD=0.92
M$13418 \$8926 B|Y B|C|X VGND sky130_fd_pr__nfet_01v8 L=0.15 W=0.65 AS=0.08775
+ AD=0.25025 PS=0.92 PD=1.42
M$13419 B|C|X \$8877 VGND VGND sky130_fd_pr__nfet_01v8 L=0.15 W=0.65 AS=0.25025
+ AD=0.208 PS=1.42 PD=1.94
M$13439 VGND A|B|Y \$9008 VGND sky130_fd_pr__nfet_01v8 L=0.15 W=0.65 AS=0.169
+ AD=0.08775 PS=1.82 PD=0.92
M$13440 \$9008 A|X A|B1|Y VGND sky130_fd_pr__nfet_01v8 L=0.15 W=0.65 AS=0.08775
+ AD=0.169 PS=0.92 PD=1.82
M$13441 \$8934 A|B|Y \$9014 VGND sky130_fd_pr__nfet_01v8 L=0.15 W=0.65 AS=0.169
+ AD=0.06825 PS=1.82 PD=0.86
M$13442 \$9014 A|X VGND VGND sky130_fd_pr__nfet_01v8 L=0.15 W=0.65 AS=0.06825
+ AD=0.08775 PS=0.86 PD=0.92
M$13443 VGND A|X \$8935 VGND sky130_fd_pr__nfet_01v8 L=0.15 W=0.65 AS=0.08775
+ AD=0.169 PS=0.92 PD=1.82
M$13444 VGND A|B|Y \$8935 VGND sky130_fd_pr__nfet_01v8 L=0.15 W=0.65 AS=0.169
+ AD=0.08775 PS=1.82 PD=0.92
M$13445 \$8935 \$8934 A|A2|B|Y VGND sky130_fd_pr__nfet_01v8 L=0.15 W=0.65
+ AS=0.08775 AD=0.195 PS=0.92 PD=1.9
M$13446 VGND B|Y \$8936 VGND sky130_fd_pr__nfet_01v8 L=0.15 W=0.65 AS=0.169
+ AD=0.08775 PS=1.82 PD=0.92
M$13447 \$8936 A|B|C|Y VGND VGND sky130_fd_pr__nfet_01v8 L=0.15 W=0.65
+ AS=0.08775 AD=0.08775 PS=0.92 PD=0.92
M$13448 VGND A|B|C|Y \$9022 VGND sky130_fd_pr__nfet_01v8 L=0.15 W=0.65
+ AS=0.08775 AD=0.08775 PS=0.92 PD=0.92
M$13449 \$9022 B|Y A|B|B1|C|X VGND sky130_fd_pr__nfet_01v8 L=0.15 W=0.65
+ AS=0.08775 AD=0.25025 PS=0.92 PD=1.42
M$13450 A|B|B1|C|X \$8936 VGND VGND sky130_fd_pr__nfet_01v8 L=0.15 W=0.65
+ AS=0.25025 AD=0.208 PS=1.42 PD=1.94
M$13452 B|Y A|B|B1|C|X VGND VGND sky130_fd_pr__nfet_01v8 L=0.15 W=0.42
+ AS=0.1092 AD=0.1197 PS=1.36 PD=1.41
M$13453 \$8937 A|B_N|SLEEP|Y VGND VGND sky130_fd_pr__nfet_01v8 L=0.15 W=0.42
+ AS=0.1092 AD=0.10025 PS=1.36 PD=0.985
M$13454 VGND A|B1|C1|X A2|SLEEP|Y VGND sky130_fd_pr__nfet_01v8 L=0.15 W=0.65
+ AS=0.10025 AD=0.08775 PS=0.985 PD=0.92
M$13455 A2|SLEEP|Y \$8937 VGND VGND sky130_fd_pr__nfet_01v8 L=0.15 W=0.65
+ AS=0.08775 AD=0.169 PS=0.92 PD=1.82
M$13456 VGND A|B|B1|C|X \$8939 VGND sky130_fd_pr__nfet_01v8 L=0.15 W=0.42
+ AS=0.1092 AD=0.0567 PS=1.36 PD=0.69
M$13457 \$8939 A|A2|B|C|SLEEP|Y VGND VGND sky130_fd_pr__nfet_01v8 L=0.15 W=0.42
+ AS=0.0567 AD=0.10025 PS=0.69 PD=0.985
M$13458 VGND \$8939 A4|X VGND sky130_fd_pr__nfet_01v8 L=0.15 W=0.65 AS=0.10025
+ AD=0.169 PS=0.985 PD=1.82
M$13459 \$8942 A|A1|X VGND VGND sky130_fd_pr__nfet_01v8 L=0.15 W=0.65 AS=0.182
+ AD=0.11375 PS=1.86 PD=1
M$13460 VGND A2|SLEEP|Y \$8942 VGND sky130_fd_pr__nfet_01v8 L=0.15 W=0.65
+ AS=0.11375 AD=0.08775 PS=1 PD=0.92
M$13461 \$8942 A1|A3|B|X VGND VGND sky130_fd_pr__nfet_01v8 L=0.15 W=0.65
+ AS=0.08775 AD=0.08775 PS=0.92 PD=0.92
M$13462 VGND A4|X \$8942 VGND sky130_fd_pr__nfet_01v8 L=0.15 W=0.65 AS=0.08775
+ AD=0.203125 PS=0.92 PD=1.275
M$13463 \$8942 A|B1|X B|SLEEP|Y VGND sky130_fd_pr__nfet_01v8 L=0.15 W=0.65
+ AS=0.203125 AD=0.169 PS=1.275 PD=1.82
M$13464 VGND A|A1|X \$8944 VGND sky130_fd_pr__nfet_01v8 L=0.15 W=0.42 AS=0.1092
+ AD=0.0567 PS=1.36 PD=0.69
M$13465 \$8944 A2|SLEEP|Y VGND VGND sky130_fd_pr__nfet_01v8 L=0.15 W=0.42
+ AS=0.0567 AD=0.10025 PS=0.69 PD=0.985
M$13466 VGND \$8944 A2|B|X VGND sky130_fd_pr__nfet_01v8 L=0.15 W=0.65
+ AS=0.10025 AD=0.169 PS=0.985 PD=1.82
M$13467 A|Y A|B|B1|C|X VGND VGND sky130_fd_pr__nfet_01v8 L=0.15 W=0.65 AS=0.169
+ AD=0.08775 PS=1.82 PD=0.92
M$13468 VGND A2|B|X A|Y VGND sky130_fd_pr__nfet_01v8 L=0.15 W=0.65 AS=0.08775
+ AD=0.08775 PS=0.92 PD=0.92
M$13470 VGND A|Y \$8946 VGND sky130_fd_pr__nfet_01v8 L=0.15 W=0.42 AS=0.1092
+ AD=0.0567 PS=1.36 PD=0.69
M$13471 \$8946 SLEEP|Y VGND VGND sky130_fd_pr__nfet_01v8 L=0.15 W=0.42
+ AS=0.0567 AD=0.10025 PS=0.69 PD=0.985
M$13472 VGND \$8946 A2|A_N|B|X VGND sky130_fd_pr__nfet_01v8 L=0.15 W=0.65
+ AS=0.10025 AD=0.169 PS=0.985 PD=1.82
M$13475 VGND A|Y A2|B|Y VGND sky130_fd_pr__nfet_01v8 L=0.15 W=0.65 AS=0.169
+ AD=0.08775 PS=1.82 PD=0.92
M$13476 A2|B|Y A2|A_N|B|X VGND VGND sky130_fd_pr__nfet_01v8 L=0.15 W=0.65
+ AS=0.08775 AD=0.169 PS=0.92 PD=1.82
M$13478 VGND B|X \$8949 VGND sky130_fd_pr__nfet_01v8 L=0.15 W=0.65 AS=0.169
+ AD=0.08775 PS=1.82 PD=0.92
M$13479 \$8949 A|C|X VGND VGND sky130_fd_pr__nfet_01v8 L=0.15 W=0.65 AS=0.08775
+ AD=0.08775 PS=0.92 PD=0.92
M$13480 VGND A|C|X \$9069 VGND sky130_fd_pr__nfet_01v8 L=0.15 W=0.65 AS=0.08775
+ AD=0.08775 PS=0.92 PD=0.92
M$13481 \$9069 B|X B|X VGND sky130_fd_pr__nfet_01v8 L=0.15 W=0.65 AS=0.08775
+ AD=0.25025 PS=0.92 PD=1.42
M$13482 B|X \$8949 VGND VGND sky130_fd_pr__nfet_01v8 L=0.15 W=0.65 AS=0.25025
+ AD=0.208 PS=1.42 PD=1.94
M$13485 A|B|Y A|X \$9079 VGND sky130_fd_pr__nfet_01v8 L=0.15 W=0.65 AS=0.169
+ AD=0.08775 PS=1.82 PD=0.92
M$13486 \$9079 B|Y VGND VGND sky130_fd_pr__nfet_01v8 L=0.15 W=0.65 AS=0.08775
+ AD=0.169 PS=0.92 PD=1.82
M$13487 VGND A|B|Y \$8952 VGND sky130_fd_pr__nfet_01v8 L=0.15 W=0.65 AS=0.169
+ AD=0.08775 PS=1.82 PD=0.92
M$13488 \$8952 A|Y VGND VGND sky130_fd_pr__nfet_01v8 L=0.15 W=0.65 AS=0.08775
+ AD=0.08775 PS=0.92 PD=0.92
M$13489 VGND A|Y \$9086 VGND sky130_fd_pr__nfet_01v8 L=0.15 W=0.65 AS=0.08775
+ AD=0.08775 PS=0.92 PD=0.92
M$13490 \$9086 A|B|Y A4|B|X VGND sky130_fd_pr__nfet_01v8 L=0.15 W=0.65
+ AS=0.08775 AD=0.25025 PS=0.92 PD=1.42
M$13491 A4|B|X \$8952 VGND VGND sky130_fd_pr__nfet_01v8 L=0.15 W=0.65
+ AS=0.25025 AD=0.208 PS=1.42 PD=1.94
M$13493 B|C|Y A|B1|X \$8955 VGND sky130_fd_pr__nfet_01v8 L=0.15 W=0.65 AS=0.169
+ AD=0.203125 PS=1.82 PD=1.275
M$13494 \$8955 A4|B|X VGND VGND sky130_fd_pr__nfet_01v8 L=0.15 W=0.65
+ AS=0.203125 AD=0.08775 PS=1.275 PD=0.92
M$13495 VGND A3|B1|C|SLEEP|Y \$8955 VGND sky130_fd_pr__nfet_01v8 L=0.15 W=0.65
+ AS=0.08775 AD=0.08775 PS=0.92 PD=0.92
M$13496 \$8955 A2|B|X VGND VGND sky130_fd_pr__nfet_01v8 L=0.15 W=0.65
+ AS=0.08775 AD=0.11375 PS=0.92 PD=1
M$13497 VGND A|A1|B|X \$8955 VGND sky130_fd_pr__nfet_01v8 L=0.15 W=0.65
+ AS=0.11375 AD=0.182 PS=1 PD=1.86
M$13499 VGND B|Y \$9102 VGND sky130_fd_pr__nfet_01v8 L=0.15 W=0.65 AS=0.169
+ AD=0.08775 PS=1.82 PD=0.92
M$13500 \$9102 A|B1|X A|B|Y VGND sky130_fd_pr__nfet_01v8 L=0.15 W=0.65
+ AS=0.08775 AD=0.169 PS=0.92 PD=1.82
M$13501 VGND A|B|Y \$9098 VGND sky130_fd_pr__nfet_01v8 L=0.15 W=0.65 AS=0.169
+ AD=0.08775 PS=1.82 PD=0.92
M$13502 \$9098 A|A1|Y A|Y VGND sky130_fd_pr__nfet_01v8 L=0.15 W=0.65 AS=0.08775
+ AD=0.169 PS=0.92 PD=1.82
M$13505 VGND A|B|SLEEP|X \$8958 VGND sky130_fd_pr__nfet_01v8 L=0.15 W=0.42
+ AS=0.1092 AD=0.0567 PS=1.36 PD=0.69
M$13506 \$8958 A3|B1|C|SLEEP|Y VGND VGND sky130_fd_pr__nfet_01v8 L=0.15 W=0.42
+ AS=0.0567 AD=0.10025 PS=0.69 PD=0.985
M$13507 VGND \$8958 A2|X VGND sky130_fd_pr__nfet_01v8 L=0.15 W=0.65 AS=0.10025
+ AD=0.169 PS=0.985 PD=1.82
M$13508 VGND A|B|SLEEP|X A1|Y VGND sky130_fd_pr__nfet_01v8 L=0.15 W=0.65
+ AS=0.169 AD=0.08775 PS=1.82 PD=0.92
M$13511 VGND A|B|Y \$8963 VGND sky130_fd_pr__nfet_01v8 L=0.15 W=0.42 AS=0.1092
+ AD=0.0567 PS=1.36 PD=0.69
M$13512 \$8963 A|B|SLEEP|X VGND VGND sky130_fd_pr__nfet_01v8 L=0.15 W=0.42
+ AS=0.0567 AD=0.10025 PS=0.69 PD=0.985
M$13513 VGND \$8963 A|X VGND sky130_fd_pr__nfet_01v8 L=0.15 W=0.65 AS=0.10025
+ AD=0.169 PS=0.985 PD=1.82
M$13514 VGND B|Y \$8965 VGND sky130_fd_pr__nfet_01v8 L=0.15 W=0.65 AS=0.169
+ AD=0.08775 PS=1.82 PD=0.92
M$13515 \$8965 A|B|SLEEP|X VGND VGND sky130_fd_pr__nfet_01v8 L=0.15 W=0.65
+ AS=0.08775 AD=0.08775 PS=0.92 PD=0.92
M$13516 VGND A|B|SLEEP|X \$9028 VGND sky130_fd_pr__nfet_01v8 L=0.15 W=0.65
+ AS=0.08775 AD=0.08775 PS=0.92 PD=0.92
M$13517 \$9028 B|Y A2|B|X VGND sky130_fd_pr__nfet_01v8 L=0.15 W=0.65 AS=0.08775
+ AD=0.25025 PS=0.92 PD=1.42
M$13518 A2|B|X \$8965 VGND VGND sky130_fd_pr__nfet_01v8 L=0.15 W=0.65
+ AS=0.25025 AD=0.208 PS=1.42 PD=1.94
M$13538 \$9139 A|A2|B|Y \$9198 VGND sky130_fd_pr__nfet_01v8 L=0.15 W=0.65
+ AS=0.169 AD=0.06825 PS=1.82 PD=0.86
M$13539 \$9198 A|A1|B1|Y VGND VGND sky130_fd_pr__nfet_01v8 L=0.15 W=0.65
+ AS=0.06825 AD=0.08775 PS=0.86 PD=0.92
M$13540 VGND A|A1|B1|Y \$9183 VGND sky130_fd_pr__nfet_01v8 L=0.15 W=0.65
+ AS=0.08775 AD=0.169 PS=0.92 PD=1.82
M$13541 VGND A|A2|B|Y \$9183 VGND sky130_fd_pr__nfet_01v8 L=0.15 W=0.65
+ AS=0.169 AD=0.08775 PS=1.82 PD=0.92
M$13542 \$9183 \$9139 A|B_N|SLEEP|Y VGND sky130_fd_pr__nfet_01v8 L=0.15 W=0.65
+ AS=0.08775 AD=0.195 PS=0.92 PD=1.9
M$13543 VGND A|X A|A1|B1|Y VGND sky130_fd_pr__nfet_01v8 L=0.15 W=0.42 AS=0.1197
+ AD=0.1092 PS=1.41 PD=1.36
M$13545 VGND A|B1|C1|X \$9140 VGND sky130_fd_pr__nfet_01v8 L=0.15 W=0.42
+ AS=0.10025 AD=0.1092 PS=0.985 PD=1.36
M$13546 VGND A|B_N|SLEEP|Y A|A1|X VGND sky130_fd_pr__nfet_01v8 L=0.15 W=0.65
+ AS=0.10025 AD=0.08775 PS=0.985 PD=0.92
M$13547 A|A1|X \$9140 VGND VGND sky130_fd_pr__nfet_01v8 L=0.15 W=0.65
+ AS=0.08775 AD=0.169 PS=0.92 PD=1.82
M$13549 \$9141 A2|B|X \$9201 VGND sky130_fd_pr__nfet_01v8 L=0.15 W=0.65
+ AS=0.169 AD=0.06825 PS=1.82 PD=0.86
M$13550 \$9201 A|A1|Y VGND VGND sky130_fd_pr__nfet_01v8 L=0.15 W=0.65
+ AS=0.06825 AD=0.08775 PS=0.86 PD=0.92
M$13551 VGND A|A1|Y \$9185 VGND sky130_fd_pr__nfet_01v8 L=0.15 W=0.65
+ AS=0.08775 AD=0.169 PS=0.92 PD=1.82
M$13552 VGND A2|B|X \$9185 VGND sky130_fd_pr__nfet_01v8 L=0.15 W=0.65 AS=0.169
+ AD=0.08775 PS=1.82 PD=0.92
M$13553 \$9185 \$9141 A|A1|B|Y VGND sky130_fd_pr__nfet_01v8 L=0.15 W=0.65
+ AS=0.08775 AD=0.195 PS=0.92 PD=1.9
M$13554 VGND \$9142 A|B1|C1|X VGND sky130_fd_pr__nfet_01v8 L=0.15 W=0.42
+ AS=0.097 AD=0.1491 PS=0.975 PD=1.55
M$13555 VGND \$9143 \$9142 VGND sky130_fd_pr__nfet_01v8 L=0.5 W=0.65 AS=0.097
+ AD=0.17225 PS=0.975 PD=1.83
M$13556 \$9143 \$9144 VGND VGND sky130_fd_pr__nfet_01v8 L=0.5 W=0.65 AS=0.169
+ AD=0.10435 PS=1.82 PD=1.01
M$13557 VGND A|FINE_MUX[21] \$9144 VGND sky130_fd_pr__nfet_01v8 L=0.15 W=0.42
+ AS=0.10435 AD=0.1134 PS=1.01 PD=1.38
M$13560 VGND B|Y \$9203 VGND sky130_fd_pr__nfet_01v8 L=0.15 W=0.65 AS=0.169
+ AD=0.08775 PS=1.82 PD=0.92
M$13561 \$9203 A|B1|C1|X A|Y VGND sky130_fd_pr__nfet_01v8 L=0.15 W=0.65
+ AS=0.08775 AD=0.169 PS=0.92 PD=1.82
M$13563 A|Y A|Y \$9205 VGND sky130_fd_pr__nfet_01v8 L=0.15 W=0.65 AS=0.169
+ AD=0.08775 PS=1.82 PD=0.92
M$13564 \$9205 A|A1|B|Y VGND VGND sky130_fd_pr__nfet_01v8 L=0.15 W=0.65
+ AS=0.08775 AD=0.169 PS=0.92 PD=1.82
M$13565 VGND A2|A_N|B|X \$9148 VGND sky130_fd_pr__nfet_01v8 L=0.15 W=0.65
+ AS=0.169 AD=0.08775 PS=1.82 PD=0.92
M$13566 \$9148 A|Y VGND VGND sky130_fd_pr__nfet_01v8 L=0.15 W=0.65 AS=0.08775
+ AD=0.08775 PS=0.92 PD=0.92
M$13567 VGND A|Y \$9207 VGND sky130_fd_pr__nfet_01v8 L=0.15 W=0.65 AS=0.08775
+ AD=0.08775 PS=0.92 PD=0.92
M$13568 \$9207 A2|A_N|B|X A|B|B1|X VGND sky130_fd_pr__nfet_01v8 L=0.15 W=0.65
+ AS=0.08775 AD=0.25025 PS=0.92 PD=1.42
M$13569 A|B|B1|X \$9148 VGND VGND sky130_fd_pr__nfet_01v8 L=0.15 W=0.65
+ AS=0.25025 AD=0.208 PS=1.42 PD=1.94
M$13570 \$9186 A|A1|B|Y VGND VGND sky130_fd_pr__nfet_01v8 L=0.15 W=0.65
+ AS=0.169 AD=0.08775 PS=1.82 PD=0.92
M$13571 VGND A2|A_N|B|X \$9186 VGND sky130_fd_pr__nfet_01v8 L=0.15 W=0.65
+ AS=0.08775 AD=0.11375 PS=0.92 PD=1
M$13572 \$9186 A|B2|Y \$9150 VGND sky130_fd_pr__nfet_01v8 L=0.15 W=0.65
+ AS=0.11375 AD=0.08775 PS=1 PD=0.92
M$13573 \$9150 A|B|B1|X \$9186 VGND sky130_fd_pr__nfet_01v8 L=0.15 W=0.65
+ AS=0.08775 AD=0.169 PS=0.92 PD=1.82
M$13574 VGND \$9150 B|X VGND sky130_fd_pr__nfet_01v8 L=0.15 W=0.65 AS=0.169
+ AD=0.169 PS=1.82 PD=1.82
M$13578 B|Y A|B2|Y \$9206 VGND sky130_fd_pr__nfet_01v8 L=0.15 W=0.65 AS=0.169
+ AD=0.08775 PS=1.82 PD=0.92
M$13579 \$9206 A|B|Y VGND VGND sky130_fd_pr__nfet_01v8 L=0.15 W=0.65 AS=0.08775
+ AD=0.169 PS=0.92 PD=1.82
M$13580 VGND B|Y \$9153 VGND sky130_fd_pr__nfet_01v8 L=0.15 W=0.65 AS=0.169
+ AD=0.08775 PS=1.82 PD=0.92
M$13581 \$9153 A|B|B1|X VGND VGND sky130_fd_pr__nfet_01v8 L=0.15 W=0.65
+ AS=0.08775 AD=0.08775 PS=0.92 PD=0.92
M$13582 VGND A|B|B1|X \$9202 VGND sky130_fd_pr__nfet_01v8 L=0.15 W=0.65
+ AS=0.08775 AD=0.08775 PS=0.92 PD=0.92
M$13583 \$9202 B|Y A2|B|X VGND sky130_fd_pr__nfet_01v8 L=0.15 W=0.65 AS=0.08775
+ AD=0.25025 PS=0.92 PD=1.42
M$13584 A2|B|X \$9153 VGND VGND sky130_fd_pr__nfet_01v8 L=0.15 W=0.65
+ AS=0.25025 AD=0.208 PS=1.42 PD=1.94
M$13585 \$9155 B|X \$9200 VGND sky130_fd_pr__nfet_01v8 L=0.15 W=0.65 AS=0.169
+ AD=0.06825 PS=1.82 PD=0.86
M$13586 \$9200 A|Y VGND VGND sky130_fd_pr__nfet_01v8 L=0.15 W=0.65 AS=0.06825
+ AD=0.08775 PS=0.86 PD=0.92
M$13587 VGND A|Y \$9187 VGND sky130_fd_pr__nfet_01v8 L=0.15 W=0.65 AS=0.08775
+ AD=0.169 PS=0.92 PD=1.82
M$13588 VGND B|X \$9187 VGND sky130_fd_pr__nfet_01v8 L=0.15 W=0.65 AS=0.169
+ AD=0.08775 PS=1.82 PD=0.92
M$13589 \$9187 \$9155 A3|B1|C|SLEEP|Y VGND sky130_fd_pr__nfet_01v8 L=0.15
+ W=0.65 AS=0.08775 AD=0.195 PS=0.92 PD=1.9
M$13592 VGND A|A1|B|X \$9156 VGND sky130_fd_pr__nfet_01v8 L=0.15 W=0.65
+ AS=0.169 AD=0.08775 PS=1.82 PD=0.92
M$13593 \$9156 A|B1|X VGND VGND sky130_fd_pr__nfet_01v8 L=0.15 W=0.65
+ AS=0.08775 AD=0.08775 PS=0.92 PD=0.92
M$13594 VGND A|B1|X \$9197 VGND sky130_fd_pr__nfet_01v8 L=0.15 W=0.65
+ AS=0.08775 AD=0.08775 PS=0.92 PD=0.92
M$13595 \$9197 A|A1|B|X A|A1|B|X VGND sky130_fd_pr__nfet_01v8 L=0.15 W=0.65
+ AS=0.08775 AD=0.25025 PS=0.92 PD=1.42
M$13596 A|A1|B|X \$9156 VGND VGND sky130_fd_pr__nfet_01v8 L=0.15 W=0.65
+ AS=0.25025 AD=0.208 PS=1.42 PD=1.94
M$13597 VGND A2|B|X \$9159 VGND sky130_fd_pr__nfet_01v8 L=0.15 W=0.65 AS=0.169
+ AD=0.08775 PS=1.82 PD=0.92
M$13598 \$9159 A|Y VGND VGND sky130_fd_pr__nfet_01v8 L=0.15 W=0.65 AS=0.08775
+ AD=0.08775 PS=0.92 PD=0.92
M$13599 VGND A|Y \$9196 VGND sky130_fd_pr__nfet_01v8 L=0.15 W=0.65 AS=0.08775
+ AD=0.08775 PS=0.92 PD=0.92
M$13600 \$9196 A2|B|X A|B|SLEEP|X VGND sky130_fd_pr__nfet_01v8 L=0.15 W=0.65
+ AS=0.08775 AD=0.25025 PS=0.92 PD=1.42
M$13601 A|B|SLEEP|X \$9159 VGND VGND sky130_fd_pr__nfet_01v8 L=0.15 W=0.65
+ AS=0.25025 AD=0.208 PS=1.42 PD=1.94
M$13604 VGND A|A1|B|X \$9162 VGND sky130_fd_pr__nfet_01v8 L=0.15 W=0.65
+ AS=0.169 AD=0.08775 PS=1.82 PD=0.92
M$13605 \$9162 A|B1|X VGND VGND sky130_fd_pr__nfet_01v8 L=0.15 W=0.65
+ AS=0.08775 AD=0.08775 PS=0.92 PD=0.92
M$13606 VGND A|B1|X \$9195 VGND sky130_fd_pr__nfet_01v8 L=0.15 W=0.65
+ AS=0.08775 AD=0.08775 PS=0.92 PD=0.92
M$13607 \$9195 A|A1|B|X A|A1|B|X VGND sky130_fd_pr__nfet_01v8 L=0.15 W=0.65
+ AS=0.08775 AD=0.25025 PS=0.92 PD=1.42
M$13608 A|A1|B|X \$9162 VGND VGND sky130_fd_pr__nfet_01v8 L=0.15 W=0.65
+ AS=0.25025 AD=0.208 PS=1.42 PD=1.94
M$13609 \$8959 A3|B1|C|SLEEP|Y VGND VGND sky130_fd_pr__nfet_01v8 L=0.15 W=0.42
+ AS=0.1092 AD=0.0567 PS=1.36 PD=0.69
M$13610 VGND A|B|SLEEP|X \$8959 VGND sky130_fd_pr__nfet_01v8 L=0.15 W=0.42
+ AS=0.0567 AD=0.0567 PS=0.69 PD=0.69
M$13611 VGND A|Y \$8959 VGND sky130_fd_pr__nfet_01v8 L=0.15 W=0.42 AS=0.101875
+ AD=0.0567 PS=0.99 PD=0.69
M$13612 VGND \$8959 A|B1|X VGND sky130_fd_pr__nfet_01v8 L=0.15 W=0.65
+ AS=0.101875 AD=0.182 PS=0.99 PD=1.86
M$13613 VGND B|Y \$9194 VGND sky130_fd_pr__nfet_01v8 L=0.15 W=0.65 AS=0.169
+ AD=0.08775 PS=1.82 PD=0.92
M$13614 \$9194 A|B1|X A|Y VGND sky130_fd_pr__nfet_01v8 L=0.15 W=0.65 AS=0.08775
+ AD=0.169 PS=0.92 PD=1.82
M$13617 VGND B|Y \$9192 VGND sky130_fd_pr__nfet_01v8 L=0.15 W=0.65 AS=0.169
+ AD=0.08775 PS=1.82 PD=0.92
M$13618 \$9192 A|B1|X A|B|Y VGND sky130_fd_pr__nfet_01v8 L=0.15 W=0.65
+ AS=0.08775 AD=0.169 PS=0.92 PD=1.82
M$13619 VGND A|B|Y \$9191 VGND sky130_fd_pr__nfet_01v8 L=0.15 W=0.65 AS=0.169
+ AD=0.08775 PS=1.82 PD=0.92
M$13620 \$9191 A|Y B|Y VGND sky130_fd_pr__nfet_01v8 L=0.15 W=0.65 AS=0.08775
+ AD=0.169 PS=0.92 PD=1.82
M$13628 \$9208 A|FINE_MUX[15] VGND VGND sky130_fd_pr__nfet_01v8 L=0.15 W=0.42
+ AS=0.1134 AD=0.10435 PS=1.38 PD=1.01
M$13629 VGND \$9208 \$9209 VGND sky130_fd_pr__nfet_01v8 L=0.5 W=0.65 AS=0.10435
+ AD=0.169 PS=1.01 PD=1.82
M$13630 VGND \$9210 A|B1|X VGND sky130_fd_pr__nfet_01v8 L=0.15 W=0.42 AS=0.097
+ AD=0.1491 PS=0.975 PD=1.55
M$13631 \$9210 \$9209 VGND VGND sky130_fd_pr__nfet_01v8 L=0.5 W=0.65 AS=0.17225
+ AD=0.097 PS=1.83 PD=0.975
M$13640 A|B1|X \$9211 VGND VGND sky130_fd_pr__nfet_01v8 L=0.15 W=0.42 AS=0.1491
+ AD=0.097 PS=1.55 PD=0.975
M$13641 VGND \$9212 \$9211 VGND sky130_fd_pr__nfet_01v8 L=0.5 W=0.65 AS=0.097
+ AD=0.17225 PS=0.975 PD=1.83
M$13642 VGND A|FINE_MUX[16] \$9213 VGND sky130_fd_pr__nfet_01v8 L=0.15 W=0.42
+ AS=0.10435 AD=0.1134 PS=1.01 PD=1.38
M$13643 \$9212 \$9213 VGND VGND sky130_fd_pr__nfet_01v8 L=0.5 W=0.65 AS=0.169
+ AD=0.10435 PS=1.82 PD=1.01
M$13645 A|X \$9214 VGND VGND sky130_fd_pr__nfet_01v8 L=0.15 W=0.42 AS=0.1491
+ AD=0.097 PS=1.55 PD=0.975
M$13646 VGND \$9215 \$9214 VGND sky130_fd_pr__nfet_01v8 L=0.5 W=0.65 AS=0.097
+ AD=0.17225 PS=0.975 PD=1.83
M$13647 VGND A|FINE_MUX[17] \$9216 VGND sky130_fd_pr__nfet_01v8 L=0.15 W=0.42
+ AS=0.10435 AD=0.1134 PS=1.01 PD=1.38
M$13648 \$9215 \$9216 VGND VGND sky130_fd_pr__nfet_01v8 L=0.5 W=0.65 AS=0.169
+ AD=0.10435 PS=1.82 PD=1.01
M$13651 A|B1|X \$9217 VGND VGND sky130_fd_pr__nfet_01v8 L=0.15 W=0.42 AS=0.1491
+ AD=0.097 PS=1.55 PD=0.975
M$13652 VGND \$9218 \$9217 VGND sky130_fd_pr__nfet_01v8 L=0.5 W=0.65 AS=0.097
+ AD=0.17225 PS=0.975 PD=1.83
M$13653 VGND A|FINE_MUX[18] \$9219 VGND sky130_fd_pr__nfet_01v8 L=0.15 W=0.42
+ AS=0.10435 AD=0.1134 PS=1.01 PD=1.38
M$13654 \$9218 \$9219 VGND VGND sky130_fd_pr__nfet_01v8 L=0.5 W=0.65 AS=0.169
+ AD=0.10435 PS=1.82 PD=1.01
M$13655 A|X \$9220 VGND VGND sky130_fd_pr__nfet_01v8 L=0.15 W=0.42 AS=0.1491
+ AD=0.097 PS=1.55 PD=0.975
M$13656 VGND \$9221 \$9220 VGND sky130_fd_pr__nfet_01v8 L=0.5 W=0.65 AS=0.097
+ AD=0.17225 PS=0.975 PD=1.83
M$13657 VGND A|FINE_MUX[19] \$9222 VGND sky130_fd_pr__nfet_01v8 L=0.15 W=0.42
+ AS=0.10435 AD=0.1134 PS=1.01 PD=1.38
M$13658 \$9221 \$9222 VGND VGND sky130_fd_pr__nfet_01v8 L=0.5 W=0.65 AS=0.169
+ AD=0.10435 PS=1.82 PD=1.01
M$13660 A|X \$9223 VGND VGND sky130_fd_pr__nfet_01v8 L=0.15 W=0.42 AS=0.1491
+ AD=0.097 PS=1.55 PD=0.975
M$13661 VGND \$9224 \$9223 VGND sky130_fd_pr__nfet_01v8 L=0.5 W=0.65 AS=0.097
+ AD=0.17225 PS=0.975 PD=1.83
M$13662 VGND A|FINE_MUX[20] \$9225 VGND sky130_fd_pr__nfet_01v8 L=0.15 W=0.42
+ AS=0.10435 AD=0.1134 PS=1.01 PD=1.38
M$13663 \$9224 \$9225 VGND VGND sky130_fd_pr__nfet_01v8 L=0.5 W=0.65 AS=0.169
+ AD=0.10435 PS=1.82 PD=1.01
M$13665 VGND A|B1|X A|A1|Y VGND sky130_fd_pr__nfet_01v8 L=0.15 W=0.42 AS=0.1197
+ AD=0.1092 PS=1.41 PD=1.36
M$13666 A|B1|X \$9226 VGND VGND sky130_fd_pr__nfet_01v8 L=0.15 W=0.42 AS=0.1491
+ AD=0.097 PS=1.55 PD=0.975
M$13667 VGND \$9227 \$9226 VGND sky130_fd_pr__nfet_01v8 L=0.5 W=0.65 AS=0.097
+ AD=0.17225 PS=0.975 PD=1.83
M$13668 VGND A|FINE_MUX[22] \$9228 VGND sky130_fd_pr__nfet_01v8 L=0.15 W=0.42
+ AS=0.10435 AD=0.1134 PS=1.01 PD=1.38
M$13669 \$9227 \$9228 VGND VGND sky130_fd_pr__nfet_01v8 L=0.5 W=0.65 AS=0.169
+ AD=0.10435 PS=1.82 PD=1.01
M$13672 A|B1|C1|X \$9229 VGND VGND sky130_fd_pr__nfet_01v8 L=0.15 W=0.42
+ AS=0.1491 AD=0.097 PS=1.55 PD=0.975
M$13673 VGND \$9230 \$9229 VGND sky130_fd_pr__nfet_01v8 L=0.5 W=0.65 AS=0.097
+ AD=0.17225 PS=0.975 PD=1.83
M$13674 VGND A|FINE_MUX[23] \$9231 VGND sky130_fd_pr__nfet_01v8 L=0.15 W=0.42
+ AS=0.10435 AD=0.1134 PS=1.01 PD=1.38
M$13675 \$9230 \$9231 VGND VGND sky130_fd_pr__nfet_01v8 L=0.5 W=0.65 AS=0.169
+ AD=0.10435 PS=1.82 PD=1.01
M$13676 A|B1|X \$9232 VGND VGND sky130_fd_pr__nfet_01v8 L=0.15 W=0.42 AS=0.1491
+ AD=0.097 PS=1.55 PD=0.975
M$13677 VGND \$9233 \$9232 VGND sky130_fd_pr__nfet_01v8 L=0.5 W=0.65 AS=0.097
+ AD=0.17225 PS=0.975 PD=1.83
M$13678 VGND A|FINE_MUX[24] \$9234 VGND sky130_fd_pr__nfet_01v8 L=0.15 W=0.42
+ AS=0.10435 AD=0.1134 PS=1.01 PD=1.38
M$13679 \$9233 \$9234 VGND VGND sky130_fd_pr__nfet_01v8 L=0.5 W=0.65 AS=0.169
+ AD=0.10435 PS=1.82 PD=1.01
M$13681 VGND B|X \$9357 VGND sky130_fd_pr__nfet_01v8 L=0.15 W=0.65 AS=0.169
+ AD=0.08775 PS=1.82 PD=0.92
M$13682 \$9357 A|Y A|Y VGND sky130_fd_pr__nfet_01v8 L=0.15 W=0.65 AS=0.08775
+ AD=0.169 PS=0.92 PD=1.82
M$13683 A|X \$9235 VGND VGND sky130_fd_pr__nfet_01v8 L=0.15 W=0.42 AS=0.1491
+ AD=0.097 PS=1.55 PD=0.975
M$13684 VGND \$9236 \$9235 VGND sky130_fd_pr__nfet_01v8 L=0.5 W=0.65 AS=0.097
+ AD=0.17225 PS=0.975 PD=1.83
M$13685 VGND A|FINE_MUX[25] \$9237 VGND sky130_fd_pr__nfet_01v8 L=0.15 W=0.42
+ AS=0.10435 AD=0.1134 PS=1.01 PD=1.38
M$13686 \$9236 \$9237 VGND VGND sky130_fd_pr__nfet_01v8 L=0.5 W=0.65 AS=0.169
+ AD=0.10435 PS=1.82 PD=1.01
M$13687 A|X \$9239 VGND VGND sky130_fd_pr__nfet_01v8 L=0.15 W=0.42 AS=0.1491
+ AD=0.097 PS=1.55 PD=0.975
M$13688 VGND \$9240 \$9239 VGND sky130_fd_pr__nfet_01v8 L=0.5 W=0.65 AS=0.097
+ AD=0.17225 PS=0.975 PD=1.83
M$13689 VGND A|FINE_MUX[26] \$9241 VGND sky130_fd_pr__nfet_01v8 L=0.15 W=0.42
+ AS=0.10435 AD=0.1134 PS=1.01 PD=1.38
M$13690 \$9240 \$9241 VGND VGND sky130_fd_pr__nfet_01v8 L=0.5 W=0.65 AS=0.169
+ AD=0.10435 PS=1.82 PD=1.01
M$13692 \$9242 A|FINE_MUX[27] VGND VGND sky130_fd_pr__nfet_01v8 L=0.15 W=0.42
+ AS=0.1134 AD=0.10435 PS=1.38 PD=1.01
M$13693 VGND \$9242 \$9243 VGND sky130_fd_pr__nfet_01v8 L=0.5 W=0.65 AS=0.10435
+ AD=0.169 PS=1.01 PD=1.82
M$13694 VGND \$9244 A|B1|X VGND sky130_fd_pr__nfet_01v8 L=0.15 W=0.42 AS=0.097
+ AD=0.1491 PS=0.975 PD=1.55
M$13695 \$9244 \$9243 VGND VGND sky130_fd_pr__nfet_01v8 L=0.5 W=0.65 AS=0.17225
+ AD=0.097 PS=1.83 PD=0.975
M$13697 A|B1|X \$9245 VGND VGND sky130_fd_pr__nfet_01v8 L=0.15 W=0.42 AS=0.1491
+ AD=0.097 PS=1.55 PD=0.975
M$13698 VGND \$9246 \$9245 VGND sky130_fd_pr__nfet_01v8 L=0.5 W=0.65 AS=0.097
+ AD=0.17225 PS=0.975 PD=1.83
M$13699 VGND A|FINE_MUX[28] \$9247 VGND sky130_fd_pr__nfet_01v8 L=0.15 W=0.42
+ AS=0.10435 AD=0.1134 PS=1.01 PD=1.38
M$13700 \$9246 \$9247 VGND VGND sky130_fd_pr__nfet_01v8 L=0.5 W=0.65 AS=0.169
+ AD=0.10435 PS=1.82 PD=1.01
M$13702 \$9248 A|FINE_MUX[29] VGND VGND sky130_fd_pr__nfet_01v8 L=0.15 W=0.42
+ AS=0.1134 AD=0.10435 PS=1.38 PD=1.01
M$13703 VGND \$9248 \$9249 VGND sky130_fd_pr__nfet_01v8 L=0.5 W=0.65 AS=0.10435
+ AD=0.169 PS=1.01 PD=1.82
M$13704 VGND \$9250 A|B1|X VGND sky130_fd_pr__nfet_01v8 L=0.15 W=0.42 AS=0.097
+ AD=0.1491 PS=0.975 PD=1.55
M$13705 \$9250 \$9249 VGND VGND sky130_fd_pr__nfet_01v8 L=0.5 W=0.65 AS=0.17225
+ AD=0.097 PS=1.83 PD=0.975
M$13707 \$9251 A|FINE_MUX[30] VGND VGND sky130_fd_pr__nfet_01v8 L=0.15 W=0.42
+ AS=0.1134 AD=0.10435 PS=1.38 PD=1.01
M$13708 VGND \$9251 \$9252 VGND sky130_fd_pr__nfet_01v8 L=0.5 W=0.65 AS=0.10435
+ AD=0.169 PS=1.01 PD=1.82
M$13709 VGND \$9253 A|B1|X VGND sky130_fd_pr__nfet_01v8 L=0.15 W=0.42 AS=0.097
+ AD=0.1491 PS=0.975 PD=1.55
M$13710 \$9253 \$9252 VGND VGND sky130_fd_pr__nfet_01v8 L=0.5 W=0.65 AS=0.17225
+ AD=0.097 PS=1.83 PD=0.975
.ENDS PLL_COUNTER_DCO_PHYS
