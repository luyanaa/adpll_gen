* CDL Netlist generated by OpenROAD

*.BUSDELIMITER [

.SUBCKT PLL_RING_DCO_PHYS COARSE_MUX[0] COARSE_MUX[10] COARSE_MUX[11]
+ COARSE_MUX[12] COARSE_MUX[13] COARSE_MUX[14] COARSE_MUX[1]
+ COARSE_MUX[2] COARSE_MUX[3] COARSE_MUX[4] COARSE_MUX[5] COARSE_MUX[6]
+ COARSE_MUX[7] COARSE_MUX[8] COARSE_MUX[9] DCO_EN FINE_MUX[0]
+ FINE_MUX[10] FINE_MUX[11] FINE_MUX[12] FINE_MUX[13] FINE_MUX[14]
+ FINE_MUX[15] FINE_MUX[16] FINE_MUX[17] FINE_MUX[18] FINE_MUX[19]
+ FINE_MUX[1] FINE_MUX[20] FINE_MUX[21] FINE_MUX[22] FINE_MUX[23]
+ FINE_MUX[24] FINE_MUX[25] FINE_MUX[26] FINE_MUX[27] FINE_MUX[28]
+ FINE_MUX[29] FINE_MUX[2] FINE_MUX[30] FINE_MUX[3] FINE_MUX[4]
+ FINE_MUX[5] FINE_MUX[6] FINE_MUX[7] FINE_MUX[8] FINE_MUX[9]
+ INJ_EN MID_MUX[0] MID_MUX[10] MID_MUX[11] MID_MUX[12] MID_MUX[13]
+ MID_MUX[14] MID_MUX[1] MID_MUX[2] MID_MUX[3] MID_MUX[4] MID_MUX[5]
+ MID_MUX[6] MID_MUX[7] MID_MUX[8] MID_MUX[9] MID_OUT OUT INJ_EDGE
+ REF SS_BBPD[0] SS_BBPD[1] VSS VDD
XFILLER_15_148 VDD VSS FILLER2H7R
XFILLER_7_64 VDD VSS FILLER64H7R
XFILLER_1_128 VDD VSS FILLCAP16H7R
XFILLER_1_144 VDD VSS FILLCAP4H7R
XFILLER_1_148 VDD VSS FILLER2H7R
Xring/mid/rebuffer8 ring/mid/net3 VDD VSS ring/mid/net8 BUFX1P4H7R
Xring/mid/rebuffer9 ring/mid/net3 VDD VSS ring/mid/net9 BUFX1P4H7R
Xring/base_delay_stage_106_delay_cell_impl ring/base_delay_BASE_CHAIN_63_
+ VDD VSS ring/base_delay_BASE_CHAIN_107_ BUFX20H7R
XFILLER_8_221 VDD VSS FILLCAP4H7R
XFILLER_8_227 VDD VSS FILLER64H7R
XFILLER_8_291 VDD VSS FILLER64H7R
XFILLER_16_20 VDD VSS FILLCAP32H7R
XFILLER_8_355 VDD VSS FILLCAP16H7R
XFILLER_8_371 VDD VSS FILLCAP4H7R
XFILLER_8_377 VDD VSS FILLER1H7R
XFILLER_9_0 VDD VSS FILLER64H7R
XFILLER_9_64 VDD VSS FILLER64H7R
XFILLER_9_128 VDD VSS FILLCAP16H7R
XFILLER_9_144 VDD VSS FILLCAP4H7R
XFILLER_9_148 VDD VSS FILLER2H7R
XFILLER_9_152 VDD VSS FILLER64H7R
XFILLER_9_216 VDD VSS FILLER64H7R
XFILLER_16_52 VDD VSS FILLCAP16H7R
XFILLER_9_280 VDD VSS FILLCAP16H7R
XFILLER_9_296 VDD VSS FILLCAP4H7R
XFILLER_9_302 VDD VSS FILLER64H7R
XFILLER_9_366 VDD VSS FILLCAP8H7R
XFILLER_9_374 VDD VSS FILLCAP4H7R
XFILLER_10_0 VDD VSS FILLER64H7R
XFILLER_10_64 VDD VSS FILLCAP8H7R
XFILLER_10_72 VDD VSS FILLER2H7R
XFILLER_10_74 VDD VSS FILLER1H7R
XFILLER_10_77 VDD VSS FILLER64H7R
XFILLER_16_68 VDD VSS FILLCAP4H7R
XFILLER_10_141 VDD VSS FILLER64H7R
XFILLER_10_205 VDD VSS FILLCAP16H7R
XFILLER_10_221 VDD VSS FILLCAP4H7R
XFILLER_10_227 VDD VSS FILLER64H7R
XFILLER_10_291 VDD VSS FILLER64H7R
XFILLER_10_355 VDD VSS FILLCAP16H7R
XFILLER_10_371 VDD VSS FILLCAP4H7R
XFILLER_10_377 VDD VSS FILLER1H7R
XFILLER_11_0 VDD VSS FILLER64H7R
XFILLER_11_64 VDD VSS FILLER64H7R
XFILLER_16_72 VDD VSS FILLER2H7R
XFILLER_11_128 VDD VSS FILLCAP16H7R
XFILLER_11_144 VDD VSS FILLCAP4H7R
XFILLER_11_148 VDD VSS FILLER2H7R
XFILLER_11_152 VDD VSS FILLER64H7R
XFILLER_11_216 VDD VSS FILLER64H7R
XFILLER_11_280 VDD VSS FILLCAP16H7R
XFILLER_11_296 VDD VSS FILLCAP4H7R
XFILLER_11_302 VDD VSS FILLER64H7R
XFILLER_11_366 VDD VSS FILLCAP8H7R
XFILLER_11_374 VDD VSS FILLCAP4H7R
XFILLER_16_74 VDD VSS FILLER1H7R
XFILLER_12_0 VDD VSS FILLER64H7R
XFILLER_12_64 VDD VSS FILLCAP8H7R
XFILLER_12_72 VDD VSS FILLER2H7R
XFILLER_12_74 VDD VSS FILLER1H7R
XFILLER_12_77 VDD VSS FILLER64H7R
Xring/mid/rebuffer10 ring/mid/net3 VDD VSS ring/mid/net10
+ BUFX1P4H7R
Xring/mid/rebuffer11 ring/mid/net3 VDD VSS ring/mid/net11
+ BUFX1P4H7R
Xring/mid/rebuffer12 ring/mid/net3 VDD VSS ring/mid/net12
+ BUFX1P4H7R
Xring/mid/rebuffer13 ring/mid/net3 VDD VSS ring/mid/net13
+ BUFX1P4H7R
XFILLER_1_152 VDD VSS FILLER64H7R
XFILLER_16_77 VDD VSS FILLER64H7R
XFILLER_1_216 VDD VSS FILLER64H7R
XFILLER_1_280 VDD VSS FILLCAP16H7R
XFILLER_1_296 VDD VSS FILLCAP4H7R
XFILLER_1_302 VDD VSS FILLER64H7R
XFILLER_1_366 VDD VSS FILLCAP8H7R
XFILLER_1_374 VDD VSS FILLCAP4H7R
XFILLER_2_0 VDD VSS FILLER64H7R
XFILLER_2_64 VDD VSS FILLCAP8H7R
XFILLER_2_72 VDD VSS FILLER2H7R
XFILLER_2_74 VDD VSS FILLER1H7R
XFILLER_16_141 VDD VSS FILLER64H7R
XFILLER_2_77 VDD VSS FILLER64H7R
XFILLER_2_141 VDD VSS FILLER64H7R
XFILLER_2_205 VDD VSS FILLCAP16H7R
XFILLER_2_221 VDD VSS FILLCAP4H7R
XFILLER_2_227 VDD VSS FILLER64H7R
XFILLER_2_291 VDD VSS FILLER64H7R
XFILLER_2_355 VDD VSS FILLCAP16H7R
XFILLER_2_371 VDD VSS FILLCAP4H7R
XFILLER_2_377 VDD VSS FILLER1H7R
XFILLER_3_0 VDD VSS FILLER64H7R
XFILLER_16_205 VDD VSS FILLCAP16H7R
XFILLER_3_64 VDD VSS FILLER64H7R
XFILLER_3_128 VDD VSS FILLCAP16H7R
XFILLER_3_144 VDD VSS FILLCAP4H7R
XFILLER_3_148 VDD VSS FILLER2H7R
XFILLER_3_152 VDD VSS FILLER64H7R
XFILLER_3_216 VDD VSS FILLER64H7R
XFILLER_3_280 VDD VSS FILLCAP16H7R
XFILLER_3_296 VDD VSS FILLCAP4H7R
XFILLER_3_302 VDD VSS FILLER64H7R
XFILLER_3_366 VDD VSS FILLCAP8H7R
XFILLER_16_221 VDD VSS FILLCAP4H7R
XFILLER_3_374 VDD VSS FILLCAP4H7R
XFILLER_4_0 VDD VSS FILLER64H7R
XFILLER_4_64 VDD VSS FILLCAP8H7R
Xring/base_delay_stage_193_delay_cell_impl ring/base_delay_BASE_CHAIN_107_
+ VDD VSS ring/base_delay_BASE_CHAIN_194_ BUFX7H7R
XFILLER_17_112 VDD VSS FILLCAP32H7R
XFILLER_17_144 VDD VSS FILLCAP4H7R
XFILLER_17_148 VDD VSS FILLER2H7R
XFILLER_17_152 VDD VSS FILLER64H7R
XFILLER_17_216 VDD VSS FILLER64H7R
XFILLER_17_280 VDD VSS FILLCAP16H7R
XFILLER_16_227 VDD VSS FILLER64H7R
XFILLER_15_152 VDD VSS FILLER64H7R
XFILLER_17_296 VDD VSS FILLCAP4H7R
XFILLER_17_302 VDD VSS FILLER64H7R
XFILLER_17_366 VDD VSS FILLCAP8H7R
XFILLER_17_374 VDD VSS FILLCAP4H7R
XFILLER_18_0 VDD VSS FILLCAP8H7R
XFILLER_18_8 VDD VSS FILLER2H7R
XFILLER_18_13 VDD VSS FILLCAP16H7R
XFILLER_18_29 VDD VSS FILLER1H7R
XFILLER_18_50 VDD VSS FILLCAP16H7R
XFILLER_18_66 VDD VSS FILLCAP8H7R
XFILLER_16_291 VDD VSS FILLER64H7R
XFILLER_18_74 VDD VSS FILLER1H7R
XFILLER_18_77 VDD VSS FILLER64H7R
XFILLER_18_141 VDD VSS FILLER64H7R
XFILLER_18_205 VDD VSS FILLCAP16H7R
XFILLER_18_221 VDD VSS FILLCAP4H7R
XFILLER_18_227 VDD VSS FILLER64H7R
XFILLER_18_291 VDD VSS FILLER64H7R
XFILLER_18_355 VDD VSS FILLCAP16H7R
XFILLER_18_371 VDD VSS FILLCAP4H7R
XFILLER_18_377 VDD VSS FILLER1H7R
XFILLER_16_355 VDD VSS FILLCAP16H7R
XFILLER_14_141 VDD VSS FILLER64H7R
XFILLER_14_205 VDD VSS FILLCAP16H7R
XFILLER_14_221 VDD VSS FILLCAP4H7R
XFILLER_14_227 VDD VSS FILLER64H7R
XFILLER_14_291 VDD VSS FILLER64H7R
XFILLER_14_355 VDD VSS FILLCAP16H7R
XFILLER_14_371 VDD VSS FILLCAP4H7R
XFILLER_14_377 VDD VSS FILLER1H7R
XFILLER_15_0 VDD VSS FILLER64H7R
XFILLER_15_64 VDD VSS FILLER64H7R
XFILLER_16_371 VDD VSS FILLCAP4H7R
XFILLER_15_128 VDD VSS FILLCAP16H7R
XFILLER_12_141 VDD VSS FILLER64H7R
XFILLER_12_205 VDD VSS FILLCAP16H7R
XFILLER_12_221 VDD VSS FILLCAP4H7R
XFILLER_12_227 VDD VSS FILLER64H7R
XFILLER_12_291 VDD VSS FILLER64H7R
XFILLER_12_355 VDD VSS FILLCAP16H7R
XFILLER_12_371 VDD VSS FILLCAP4H7R
XFILLER_12_377 VDD VSS FILLER1H7R
XFILLER_13_0 VDD VSS FILLER64H7R
XFILLER_16_377 VDD VSS FILLER1H7R
XFILLER_13_64 VDD VSS FILLER64H7R
XFILLER_13_128 VDD VSS FILLCAP16H7R
XFILLER_13_144 VDD VSS FILLCAP4H7R
XFILLER_13_148 VDD VSS FILLER2H7R
XFILLER_13_152 VDD VSS FILLER64H7R
XFILLER_13_216 VDD VSS FILLER64H7R
XFILLER_13_280 VDD VSS FILLCAP16H7R
XFILLER_13_296 VDD VSS FILLCAP4H7R
XFILLER_13_302 VDD VSS FILLER64H7R
XFILLER_13_366 VDD VSS FILLCAP8H7R
XFILLER_17_0 VDD VSS FILLER2H7R
XFILLER_13_374 VDD VSS FILLCAP4H7R
XFILLER_14_0 VDD VSS FILLER64H7R
XFILLER_14_64 VDD VSS FILLCAP8H7R
XFILLER_14_72 VDD VSS FILLER2H7R
XFILLER_14_74 VDD VSS FILLER1H7R
XFILLER_14_77 VDD VSS FILLER64H7R
XFILLER_17_22 VDD VSS FILLCAP8H7R
XFILLER_17_30 VDD VSS FILLER2H7R
XFILLER_17_32 VDD VSS FILLER1H7R
XFILLER_17_48 VDD VSS FILLER64H7R
XFILLER_8_77 VDD VSS FILLER64H7R
XFILLER_15_216 VDD VSS FILLER64H7R
XFILLER_8_141 VDD VSS FILLER64H7R
XFILLER_8_205 VDD VSS FILLCAP16H7R
XFILLER_7_128 VDD VSS FILLCAP16H7R
XFILLER_7_144 VDD VSS FILLCAP4H7R
XFILLER_7_148 VDD VSS FILLER2H7R
XFILLER_7_152 VDD VSS FILLER64H7R
XFILLER_7_216 VDD VSS FILLER64H7R
XFILLER_7_280 VDD VSS FILLCAP16H7R
XFILLER_7_296 VDD VSS FILLCAP4H7R
XFILLER_7_302 VDD VSS FILLER64H7R
XFILLER_15_280 VDD VSS FILLCAP16H7R
XFILLER_7_366 VDD VSS FILLCAP8H7R
XFILLER_7_374 VDD VSS FILLCAP4H7R
XFILLER_8_0 VDD VSS FILLER64H7R
XFILLER_8_64 VDD VSS FILLCAP8H7R
XFILLER_8_72 VDD VSS FILLER2H7R
XFILLER_8_74 VDD VSS FILLER1H7R
Xrebuffer14 net5 VDD VSS net14 BUFX1P4H7R
Xclone15 net16 VDD VSS net15 INVX10H7R
XFILLER_0_0 VDD VSS FILLER64H7R
XFILLER_0_64 VDD VSS FILLCAP8H7R
XFILLER_15_296 VDD VSS FILLCAP4H7R
XFILLER_0_72 VDD VSS FILLER2H7R
XFILLER_0_76 VDD VSS FILLER64H7R
XFILLER_0_140 VDD VSS FILLCAP8H7R
XFILLER_0_150 VDD VSS FILLER64H7R
XFILLER_0_214 VDD VSS FILLCAP8H7R
XFILLER_0_224 VDD VSS FILLER64H7R
XFILLER_0_288 VDD VSS FILLCAP8H7R
XFILLER_0_298 VDD VSS FILLER64H7R
XFILLER_0_362 VDD VSS FILLCAP8H7R
XFILLER_0_372 VDD VSS FILLCAP4H7R
XFILLER_15_302 VDD VSS FILLER64H7R
XFILLER_0_376 VDD VSS FILLER2H7R
XFILLER_1_0 VDD VSS FILLER64H7R
Xring/base_delay_stage_62_delay_cell_impl net5 VDD VSS ring/base_delay_BASE_CHAIN_63_
+ BUFX7H7R
XFILLER_4_72 VDD VSS FILLER2H7R
XFILLER_4_74 VDD VSS FILLER1H7R
XFILLER_4_77 VDD VSS FILLER64H7R
XFILLER_4_141 VDD VSS FILLER64H7R
XFILLER_4_205 VDD VSS FILLCAP16H7R
XFILLER_4_221 VDD VSS FILLCAP4H7R
XFILLER_4_227 VDD VSS FILLER64H7R
XFILLER_15_366 VDD VSS FILLCAP8H7R
XFILLER_4_291 VDD VSS FILLER64H7R
XFILLER_4_355 VDD VSS FILLCAP16H7R
XFILLER_4_371 VDD VSS FILLCAP4H7R
XFILLER_4_377 VDD VSS FILLER1H7R
XFILLER_5_0 VDD VSS FILLER64H7R
XFILLER_5_64 VDD VSS FILLER64H7R
XFILLER_5_128 VDD VSS FILLCAP16H7R
XFILLER_5_144 VDD VSS FILLCAP4H7R
XFILLER_5_148 VDD VSS FILLER2H7R
XFILLER_5_152 VDD VSS FILLER64H7R
XFILLER_15_374 VDD VSS FILLCAP4H7R
XFILLER_5_216 VDD VSS FILLER64H7R
XFILLER_5_280 VDD VSS FILLCAP16H7R
XFILLER_5_296 VDD VSS FILLCAP4H7R
XFILLER_5_302 VDD VSS FILLER64H7R
XFILLER_5_366 VDD VSS FILLCAP8H7R
XFILLER_5_374 VDD VSS FILLCAP4H7R
XFILLER_6_0 VDD VSS FILLER64H7R
XFILLER_6_64 VDD VSS FILLCAP8H7R
XFILLER_6_72 VDD VSS FILLER2H7R
XFILLER_6_74 VDD VSS FILLER1H7R
XFILLER_16_0 VDD VSS FILLCAP4H7R
XFILLER_6_77 VDD VSS FILLER64H7R
XFILLER_6_141 VDD VSS FILLER64H7R
XFILLER_6_205 VDD VSS FILLCAP16H7R
XFILLER_6_221 VDD VSS FILLCAP4H7R
XFILLER_6_227 VDD VSS FILLER64H7R
XFILLER_6_291 VDD VSS FILLER64H7R
XFILLER_6_355 VDD VSS FILLCAP16H7R
XFILLER_6_371 VDD VSS FILLCAP4H7R
XFILLER_6_377 VDD VSS FILLER1H7R
XFILLER_7_0 VDD VSS FILLER64H7R
XFILLER_16_4 VDD VSS FILLER1H7R
XFILLER_1_64 VDD VSS FILLER64H7R
Xring/coarse/stage_0_impl/dwn_impl ring/coarse/stage_0_impl/PATH_0
+ ring/coarse/RCHAIN_1_ VDD VSS ring/COARSE_OUT NAND2X6H7R
Xring/coarse/stage_0_impl/mid_impl COARSE_MUX[0] ring/base_delay_BASE_CHAIN_194_
+ VDD VSS ring/coarse/stage_0_impl/PATH_0 NAND2BX1H7R
Xring/coarse/stage_0_impl/upp_impl COARSE_MUX[0] ring/base_delay_BASE_CHAIN_194_
+ VDD VSS ring/coarse/FCHAIN_1_ NAND2X6H7R
Xring/coarse/stage_10_impl/dwn_impl ring/coarse/stage_10_impl/PATH_0
+ ring/coarse/RCHAIN_11_ VDD VSS ring/coarse/RCHAIN_10_ NAND2X6H7R
Xring/coarse/stage_10_impl/mid_impl COARSE_MUX[10] ring/coarse/FCHAIN_10_
+ VDD VSS ring/coarse/stage_10_impl/PATH_0 NAND2BX1H7R
Xring/coarse/stage_10_impl/upp_impl COARSE_MUX[10] ring/coarse/FCHAIN_10_
+ VDD VSS ring/coarse/FCHAIN_11_ NAND2X8H7R
Xring/coarse/stage_11_impl/dwn_impl ring/coarse/stage_11_impl/PATH_0
+ ring/coarse/RCHAIN_12_ VDD VSS ring/coarse/RCHAIN_11_ NAND2X8H7R
Xring/coarse/stage_11_impl/mid_impl COARSE_MUX[11] ring/coarse/FCHAIN_11_
+ VDD VSS ring/coarse/stage_11_impl/PATH_0 NAND2BX1H7R
Xring/coarse/stage_11_impl/upp_impl COARSE_MUX[11] ring/coarse/FCHAIN_11_
+ VDD VSS ring/coarse/FCHAIN_12_ NAND2X6H7R
Xring/coarse/stage_12_impl/dwn_impl ring/coarse/stage_12_impl/PATH_0
+ ring/coarse/RCHAIN_13_ VDD VSS ring/coarse/RCHAIN_12_ NAND2X6H7R
Xring/coarse/stage_12_impl/mid_impl COARSE_MUX[12] ring/coarse/FCHAIN_12_
+ VDD VSS ring/coarse/stage_12_impl/PATH_0 NAND2BX1H7R
Xring/coarse/stage_12_impl/upp_impl COARSE_MUX[12] ring/coarse/FCHAIN_12_
+ VDD VSS ring/coarse/FCHAIN_13_ NAND2X8H7R
Xring/coarse/stage_13_impl/dwn_impl ring/coarse/stage_13_impl/PATH_0
+ ring/coarse/RCHAIN_14_ VDD VSS ring/coarse/RCHAIN_13_ NAND2X3H7R
Xring/coarse/stage_13_impl/mid_impl COARSE_MUX[13] ring/coarse/FCHAIN_13_
+ VDD VSS ring/coarse/stage_13_impl/PATH_0 NAND2BX1H7R
Xring/coarse/stage_13_impl/upp_impl COARSE_MUX[13] ring/coarse/FCHAIN_13_
+ VDD VSS ring/coarse/FCHAIN_14_ NAND2X8H7R
Xring/coarse/stage_14_impl/dwn_impl ring/coarse/stage_14_impl/PATH_0
+ ring/coarse/FCHAIN_15_ VDD VSS ring/coarse/RCHAIN_14_ NAND2X6H7R
Xring/coarse/stage_14_impl/mid_impl COARSE_MUX[14] ring/coarse/FCHAIN_14_
+ VDD VSS ring/coarse/stage_14_impl/PATH_0 NAND2BX6H7R
Xring/coarse/stage_14_impl/upp_impl COARSE_MUX[14] ring/coarse/FCHAIN_14_
+ VDD VSS ring/coarse/FCHAIN_15_ NAND2X6H7R
Xring/coarse/stage_1_impl/dwn_impl ring/coarse/stage_1_impl/PATH_0
+ ring/coarse/RCHAIN_2_ VDD VSS ring/coarse/RCHAIN_1_ NAND2X6H7R
Xring/coarse/stage_1_impl/mid_impl COARSE_MUX[1] ring/coarse/FCHAIN_1_
+ VDD VSS ring/coarse/stage_1_impl/PATH_0 NAND2BX1H7R
Xring/coarse/stage_1_impl/upp_impl COARSE_MUX[1] ring/coarse/FCHAIN_1_
+ VDD VSS ring/coarse/FCHAIN_2_ NAND2X6H7R
Xring/coarse/stage_2_impl/dwn_impl ring/coarse/stage_2_impl/PATH_0
+ ring/coarse/RCHAIN_3_ VDD VSS ring/coarse/RCHAIN_2_ NAND2X6H7R
Xring/coarse/stage_2_impl/mid_impl COARSE_MUX[2] ring/coarse/FCHAIN_2_
+ VDD VSS ring/coarse/stage_2_impl/PATH_0 NAND2BX1H7R
Xring/coarse/stage_2_impl/upp_impl COARSE_MUX[2] ring/coarse/FCHAIN_2_
+ VDD VSS ring/coarse/FCHAIN_3_ NAND2X6H7R
Xring/coarse/stage_3_impl/dwn_impl ring/coarse/stage_3_impl/PATH_0
+ ring/coarse/RCHAIN_4_ VDD VSS ring/coarse/RCHAIN_3_ NAND2X6H7R
Xring/coarse/stage_3_impl/mid_impl COARSE_MUX[3] ring/coarse/FCHAIN_3_
+ VDD VSS ring/coarse/stage_3_impl/PATH_0 NAND2BX1H7R
Xring/coarse/stage_3_impl/upp_impl COARSE_MUX[3] ring/coarse/FCHAIN_3_
+ VDD VSS ring/coarse/FCHAIN_4_ NAND2X6H7R
Xring/coarse/stage_4_impl/dwn_impl ring/coarse/stage_4_impl/PATH_0
+ ring/coarse/RCHAIN_5_ VDD VSS ring/coarse/RCHAIN_4_ NAND2X3H7R
Xring/coarse/stage_4_impl/mid_impl COARSE_MUX[4] ring/coarse/FCHAIN_4_
+ VDD VSS ring/coarse/stage_4_impl/PATH_0 NAND2BX1H7R
Xring/coarse/stage_4_impl/upp_impl COARSE_MUX[4] ring/coarse/FCHAIN_4_
+ VDD VSS ring/coarse/FCHAIN_5_ NAND2X8H7R
Xring/coarse/stage_5_impl/dwn_impl ring/coarse/stage_5_impl/PATH_0
+ ring/coarse/RCHAIN_6_ VDD VSS ring/coarse/RCHAIN_5_ NAND2X3H7R
Xring/coarse/stage_5_impl/mid_impl COARSE_MUX[5] ring/coarse/FCHAIN_5_
+ VDD VSS ring/coarse/stage_5_impl/PATH_0 NAND2BX1H7R
Xring/coarse/stage_5_impl/upp_impl COARSE_MUX[5] ring/coarse/FCHAIN_5_
+ VDD VSS ring/coarse/FCHAIN_6_ NAND2X4H7R
Xring/coarse/stage_6_impl/dwn_impl ring/coarse/stage_6_impl/PATH_0
+ ring/coarse/RCHAIN_7_ VDD VSS ring/coarse/RCHAIN_6_ NAND2X3H7R
Xring/coarse/stage_6_impl/mid_impl COARSE_MUX[6] ring/coarse/FCHAIN_6_
+ VDD VSS ring/coarse/stage_6_impl/PATH_0 NAND2BX1H7R
Xring/coarse/stage_6_impl/upp_impl COARSE_MUX[6] ring/coarse/FCHAIN_6_
+ VDD VSS ring/coarse/FCHAIN_7_ NAND2X6H7R
Xring/coarse/stage_7_impl/dwn_impl ring/coarse/stage_7_impl/PATH_0
+ ring/coarse/RCHAIN_8_ VDD VSS ring/coarse/RCHAIN_7_ NAND2X3H7R
Xring/coarse/stage_7_impl/mid_impl COARSE_MUX[7] ring/coarse/FCHAIN_7_
+ VDD VSS ring/coarse/stage_7_impl/PATH_0 NAND2BX1H7R
Xring/coarse/stage_7_impl/upp_impl COARSE_MUX[7] ring/coarse/FCHAIN_7_
+ VDD VSS ring/coarse/FCHAIN_8_ NAND2X6H7R
Xring/coarse/stage_8_impl/dwn_impl ring/coarse/stage_8_impl/PATH_0
+ ring/coarse/RCHAIN_9_ VDD VSS ring/coarse/RCHAIN_8_ NAND2X6H7R
Xring/coarse/stage_8_impl/mid_impl COARSE_MUX[8] ring/coarse/FCHAIN_8_
+ VDD VSS ring/coarse/stage_8_impl/PATH_0 NAND2BX1H7R
Xring/coarse/stage_8_impl/upp_impl COARSE_MUX[8] ring/coarse/FCHAIN_8_
+ VDD VSS ring/coarse/FCHAIN_9_ NAND2X6H7R
Xring/coarse/stage_9_impl/dwn_impl ring/coarse/stage_9_impl/PATH_0
+ ring/coarse/RCHAIN_10_ VDD VSS ring/coarse/RCHAIN_9_ NAND2X6H7R
Xring/coarse/stage_9_impl/mid_impl COARSE_MUX[9] ring/coarse/FCHAIN_9_
+ VDD VSS ring/coarse/stage_9_impl/PATH_0 NAND2BX1H7R
Xring/coarse/stage_9_impl/upp_impl COARSE_MUX[9] ring/coarse/FCHAIN_9_
+ VDD VSS ring/coarse/FCHAIN_10_ NAND2X6H7R
Xring/dff_x_impl REF ring/SS_BBPD_WIRE_1_ SS_BBPD[1] VDD VSS
+ DFFNQX2H7R
Xring/dff_y_impl REF ring/SS_BBPD_WIRE_0_ SS_BBPD[0] VDD VSS
+ DFFNQX2H7R
Xring/fine/inv_0_impl net2 VDD VSS ring/fine/LOAD INVX20H7R
Xring/fine/inv_1_impl ring/fine/LOAD VDD VSS ring/FINE_OUT
+ INVX5H7R
Xring/fine/stage_0_dyn_impl FINE_MUX[0] net15 ring/fine/MUXB_0_
+ VDD VSS ring/fine/UNCONNECTED_0_ NAND3X1H7R
Xring/fine/stage_0_inv_b_impl FINE_MUX[0] VDD VSS ring/fine/MUXB_0_
+ INVX1H7R
Xring/fine/stage_10_dyn_impl FINE_MUX[10] net15 ring/fine/MUXB_10_
+ VDD VSS ring/fine/UNCONNECTED_10_ NAND3X1H7R
Xring/fine/stage_10_inv_b_impl FINE_MUX[10] VDD VSS ring/fine/MUXB_10_
+ INVX1H7R
Xring/fine/stage_11_dyn_impl FINE_MUX[11] net15 ring/fine/MUXB_11_
+ VDD VSS ring/fine/UNCONNECTED_11_ NAND3X1H7R
Xring/fine/stage_11_inv_b_impl FINE_MUX[11] VDD VSS ring/fine/MUXB_11_
+ INVX1H7R
Xring/fine/stage_12_dyn_impl FINE_MUX[12] net15 ring/fine/MUXB_12_
+ VDD VSS ring/fine/UNCONNECTED_12_ NAND3X1H7R
Xring/fine/stage_12_inv_b_impl FINE_MUX[12] VDD VSS ring/fine/MUXB_12_
+ INVX1H7R
Xring/fine/stage_13_dyn_impl FINE_MUX[13] net15 ring/fine/MUXB_13_
+ VDD VSS ring/fine/UNCONNECTED_13_ NAND3X1H7R
Xring/fine/stage_13_inv_b_impl FINE_MUX[13] VDD VSS ring/fine/MUXB_13_
+ INVX1H7R
Xring/fine/stage_14_dyn_impl FINE_MUX[14] net15 ring/fine/MUXB_14_
+ VDD VSS ring/fine/UNCONNECTED_14_ NAND3X1H7R
Xring/fine/stage_14_inv_b_impl FINE_MUX[14] VDD VSS ring/fine/MUXB_14_
+ INVX1H7R
Xring/fine/stage_15_dyn_impl FINE_MUX[15] net15 ring/fine/MUXB_15_
+ VDD VSS ring/fine/UNCONNECTED_15_ NAND3X1H7R
Xring/fine/stage_15_inv_b_impl FINE_MUX[15] VDD VSS ring/fine/MUXB_15_
+ INVX1H7R
Xring/fine/stage_16_dyn_impl FINE_MUX[16] net15 ring/fine/MUXB_16_
+ VDD VSS ring/fine/UNCONNECTED_16_ NAND3X1H7R
Xring/fine/stage_16_inv_b_impl FINE_MUX[16] VDD VSS ring/fine/MUXB_16_
+ INVX1H7R
Xring/fine/stage_17_dyn_impl FINE_MUX[17] net15 ring/fine/MUXB_17_
+ VDD VSS ring/fine/UNCONNECTED_17_ NAND3X1H7R
Xring/fine/stage_17_inv_b_impl FINE_MUX[17] VDD VSS ring/fine/MUXB_17_
+ INVX1H7R
Xring/fine/stage_18_dyn_impl FINE_MUX[18] net15 ring/fine/MUXB_18_
+ VDD VSS ring/fine/UNCONNECTED_18_ NAND3X1H7R
Xring/fine/stage_18_inv_b_impl FINE_MUX[18] VDD VSS ring/fine/MUXB_18_
+ INVX1H7R
Xring/fine/stage_19_dyn_impl FINE_MUX[19] net15 ring/fine/MUXB_19_
+ VDD VSS ring/fine/UNCONNECTED_19_ NAND3X1H7R
Xring/fine/stage_19_inv_b_impl FINE_MUX[19] VDD VSS ring/fine/MUXB_19_
+ INVX1H7R
Xring/fine/stage_1_dyn_impl FINE_MUX[1] net15 ring/fine/MUXB_1_
+ VDD VSS ring/fine/UNCONNECTED_1_ NAND3X1H7R
Xring/fine/stage_1_inv_b_impl FINE_MUX[1] VDD VSS ring/fine/MUXB_1_
+ INVX1H7R
Xring/fine/stage_20_dyn_impl FINE_MUX[20] net15 ring/fine/MUXB_20_
+ VDD VSS ring/fine/UNCONNECTED_20_ NAND3X1H7R
Xring/fine/stage_20_inv_b_impl FINE_MUX[20] VDD VSS ring/fine/MUXB_20_
+ INVX1H7R
Xring/fine/stage_21_dyn_impl FINE_MUX[21] net15 ring/fine/MUXB_21_
+ VDD VSS ring/fine/UNCONNECTED_21_ NAND3X1H7R
Xring/fine/stage_21_inv_b_impl FINE_MUX[21] VDD VSS ring/fine/MUXB_21_
+ INVX1H7R
Xring/fine/stage_22_dyn_impl FINE_MUX[22] net15 ring/fine/MUXB_22_
+ VDD VSS ring/fine/UNCONNECTED_22_ NAND3X1H7R
Xring/fine/stage_22_inv_b_impl FINE_MUX[22] VDD VSS ring/fine/MUXB_22_
+ INVX1H7R
Xring/fine/stage_23_dyn_impl FINE_MUX[23] net15 ring/fine/MUXB_23_
+ VDD VSS ring/fine/UNCONNECTED_23_ NAND3X1H7R
Xring/fine/stage_23_inv_b_impl FINE_MUX[23] VDD VSS ring/fine/MUXB_23_
+ INVX1H7R
Xring/fine/stage_24_dyn_impl FINE_MUX[24] ring/fine/LOAD ring/fine/MUXB_24_
+ VDD VSS ring/fine/UNCONNECTED_24_ NAND3X1H7R
Xring/fine/stage_24_inv_b_impl FINE_MUX[24] VDD VSS ring/fine/MUXB_24_
+ INVX1H7R
Xring/fine/stage_25_dyn_impl FINE_MUX[25] ring/fine/LOAD ring/fine/MUXB_25_
+ VDD VSS ring/fine/UNCONNECTED_25_ NAND3X1H7R
Xring/fine/stage_25_inv_b_impl FINE_MUX[25] VDD VSS ring/fine/MUXB_25_
+ INVX1H7R
Xring/fine/stage_26_dyn_impl FINE_MUX[26] ring/fine/LOAD ring/fine/MUXB_26_
+ VDD VSS ring/fine/UNCONNECTED_26_ NAND3X1H7R
Xring/fine/stage_26_inv_b_impl FINE_MUX[26] VDD VSS ring/fine/MUXB_26_
+ INVX1H7R
Xring/fine/stage_27_dyn_impl FINE_MUX[27] ring/fine/LOAD ring/fine/MUXB_27_
+ VDD VSS ring/fine/UNCONNECTED_27_ NAND3X1H7R
Xring/fine/stage_27_inv_b_impl FINE_MUX[27] VDD VSS ring/fine/MUXB_27_
+ INVX1H7R
Xring/fine/stage_28_dyn_impl FINE_MUX[28] ring/fine/LOAD ring/fine/MUXB_28_
+ VDD VSS ring/fine/UNCONNECTED_28_ NAND3X1H7R
Xring/fine/stage_28_inv_b_impl FINE_MUX[28] VDD VSS ring/fine/MUXB_28_
+ INVX1H7R
Xring/fine/stage_29_dyn_impl FINE_MUX[29] ring/fine/LOAD ring/fine/MUXB_29_
+ VDD VSS ring/fine/UNCONNECTED_29_ NAND3X1H7R
Xring/fine/stage_29_inv_b_impl FINE_MUX[29] VDD VSS ring/fine/MUXB_29_
+ INVX1H7R
Xring/fine/stage_2_dyn_impl FINE_MUX[2] ring/fine/LOAD ring/fine/MUXB_2_
+ VDD VSS ring/fine/UNCONNECTED_2_ NAND3X1H7R
Xring/fine/stage_2_inv_b_impl FINE_MUX[2] VDD VSS ring/fine/MUXB_2_
+ INVX1H7R
Xring/fine/stage_30_dyn_impl FINE_MUX[30] ring/fine/LOAD ring/fine/MUXB_30_
+ VDD VSS ring/fine/UNCONNECTED_30_ NAND3X1H7R
Xring/fine/stage_30_inv_b_impl FINE_MUX[30] VDD VSS ring/fine/MUXB_30_
+ INVX1H7R
Xring/fine/stage_3_dyn_impl FINE_MUX[3] ring/fine/LOAD ring/fine/MUXB_3_
+ VDD VSS ring/fine/UNCONNECTED_3_ NAND3X1H7R
Xring/fine/stage_3_inv_b_impl FINE_MUX[3] VDD VSS ring/fine/MUXB_3_
+ INVX1H7R
Xring/fine/stage_4_dyn_impl FINE_MUX[4] ring/fine/LOAD ring/fine/MUXB_4_
+ VDD VSS ring/fine/UNCONNECTED_4_ NAND3X1H7R
Xring/fine/stage_4_inv_b_impl FINE_MUX[4] VDD VSS ring/fine/MUXB_4_
+ INVX1H7R
Xring/fine/stage_5_dyn_impl FINE_MUX[5] ring/fine/LOAD ring/fine/MUXB_5_
+ VDD VSS ring/fine/UNCONNECTED_5_ NAND3X1H7R
Xring/fine/stage_5_inv_b_impl FINE_MUX[5] VDD VSS ring/fine/MUXB_5_
+ INVX1H7R
Xring/fine/stage_6_dyn_impl FINE_MUX[6] ring/fine/LOAD ring/fine/MUXB_6_
+ VDD VSS ring/fine/UNCONNECTED_6_ NAND3X1H7R
Xring/fine/stage_6_inv_b_impl FINE_MUX[6] VDD VSS ring/fine/MUXB_6_
+ INVX1H7R
Xring/fine/stage_7_dyn_impl FINE_MUX[7] ring/fine/LOAD ring/fine/MUXB_7_
+ VDD VSS ring/fine/UNCONNECTED_7_ NAND3X1H7R
Xring/fine/stage_7_inv_b_impl FINE_MUX[7] VDD VSS ring/fine/MUXB_7_
+ INVX1H7R
Xring/fine/stage_8_dyn_impl FINE_MUX[8] ring/fine/LOAD ring/fine/MUXB_8_
+ VDD VSS ring/fine/UNCONNECTED_8_ NAND3X1H7R
Xring/fine/stage_8_inv_b_impl FINE_MUX[8] VDD VSS ring/fine/MUXB_8_
+ INVX1H7R
Xring/fine/stage_9_dyn_impl FINE_MUX[9] ring/fine/LOAD ring/fine/MUXB_9_
+ VDD VSS ring/fine/UNCONNECTED_9_ NAND3X1H7R
Xring/fine/stage_9_inv_b_impl FINE_MUX[9] VDD VSS ring/fine/MUXB_9_
+ INVX1H7R
Xring/mid/inv_0_impl ring/COARSE_OUT VDD VSS ring/mid/LOAD
+ INVX10H7R
Xring/mid/inv_1_impl ring/mid/net3 VDD VSS net2 INVX20H7R
Xring/mid/stage_0_dyn_impl_1 MID_MUX[0] ring/mid/net13 ring/mid/MUXB_0_
+ VDD VSS ring/mid/UNCONNECTED_0_ NAND3X8H7R
Xring/mid/stage_0_dyn_impl_2 MID_MUX[0] ring/mid/net3 ring/mid/MUXB_0_
+ VDD VSS ring/mid/UNCONNECTED_0_ NAND3X6H7R
Xring/mid/stage_0_inv_b_impl MID_MUX[0] VDD VSS ring/mid/MUXB_0_
+ INVX1H7R
Xring/mid/stage_10_dyn_impl_1 MID_MUX[10] ring/mid/net7 ring/mid/MUXB_10_
+ VDD VSS ring/mid/UNCONNECTED_10_ NAND3X8H7R
Xring/mid/stage_10_dyn_impl_2 MID_MUX[10] ring/mid/net7 ring/mid/MUXB_10_
+ VDD VSS ring/mid/UNCONNECTED_10_ NAND3X6H7R
Xring/mid/stage_10_inv_b_impl MID_MUX[10] VDD VSS ring/mid/MUXB_10_
+ INVX1H7R
Xring/mid/stage_11_dyn_impl_1 MID_MUX[11] ring/mid/net6 ring/mid/MUXB_11_
+ VDD VSS ring/mid/UNCONNECTED_11_ NAND3X8H7R
Xring/mid/stage_11_dyn_impl_2 MID_MUX[11] ring/mid/net6 ring/mid/MUXB_11_
+ VDD VSS ring/mid/UNCONNECTED_11_ NAND3X6H7R
Xring/mid/stage_11_inv_b_impl MID_MUX[11] VDD VSS ring/mid/MUXB_11_
+ INVX1H7R
Xring/mid/stage_12_dyn_impl_1 MID_MUX[12] ring/mid/net11 ring/mid/MUXB_12_
+ VDD VSS ring/mid/UNCONNECTED_12_ NAND3X8H7R
Xring/mid/stage_12_dyn_impl_2 MID_MUX[12] ring/mid/net6 ring/mid/MUXB_12_
+ VDD VSS ring/mid/UNCONNECTED_12_ NAND3X6H7R
Xring/mid/stage_12_inv_b_impl MID_MUX[12] VDD VSS ring/mid/MUXB_12_
+ INVX1H7R
Xring/mid/stage_13_dyn_impl_1 MID_MUX[13] ring/mid/net10 ring/mid/MUXB_13_
+ VDD VSS ring/mid/UNCONNECTED_13_ NAND3X8H7R
Xring/mid/stage_13_dyn_impl_2 MID_MUX[13] ring/mid/net12 ring/mid/MUXB_13_
+ VDD VSS ring/mid/UNCONNECTED_13_ NAND3X6H7R
Xring/mid/stage_13_inv_b_impl MID_MUX[13] VDD VSS ring/mid/MUXB_13_
+ INVX1H7R
Xring/mid/stage_14_dyn_impl_1 MID_MUX[14] ring/mid/net8 ring/mid/MUXB_14_
+ VDD VSS ring/mid/UNCONNECTED_14_ NAND3X8H7R
Xring/mid/stage_14_dyn_impl_2 MID_MUX[14] ring/mid/net8 ring/mid/MUXB_14_
+ VDD VSS ring/mid/UNCONNECTED_14_ NAND3X6H7R
Xring/mid/stage_14_inv_b_impl MID_MUX[14] VDD VSS ring/mid/MUXB_14_
+ INVX1H7R
Xring/mid/stage_1_dyn_impl_1 MID_MUX[1] ring/mid/net6 ring/mid/MUXB_1_
+ VDD VSS ring/mid/UNCONNECTED_1_ NAND3X8H7R
Xring/mid/stage_1_dyn_impl_2 MID_MUX[1] ring/mid/net6 ring/mid/MUXB_1_
+ VDD VSS ring/mid/UNCONNECTED_1_ NAND3X6H7R
Xring/mid/stage_1_inv_b_impl MID_MUX[1] VDD VSS ring/mid/MUXB_1_
+ INVX1H7R
Xring/mid/stage_2_dyn_impl_1 MID_MUX[2] ring/mid/net6 ring/mid/MUXB_2_
+ VDD VSS ring/mid/UNCONNECTED_2_ NAND3X8H7R
Xring/mid/stage_2_dyn_impl_2 MID_MUX[2] ring/mid/net6 ring/mid/MUXB_2_
+ VDD VSS ring/mid/UNCONNECTED_2_ NAND3X6H7R
Xring/mid/stage_2_inv_b_impl MID_MUX[2] VDD VSS ring/mid/MUXB_2_
+ INVX1H7R
Xring/mid/stage_3_dyn_impl_1 MID_MUX[3] ring/mid/net7 ring/mid/MUXB_3_
+ VDD VSS ring/mid/UNCONNECTED_3_ NAND3X8H7R
Xring/mid/stage_3_dyn_impl_2 MID_MUX[3] ring/mid/net8 ring/mid/MUXB_3_
+ VDD VSS ring/mid/UNCONNECTED_3_ NAND3X6H7R
Xring/mid/stage_3_inv_b_impl MID_MUX[3] VDD VSS ring/mid/MUXB_3_
+ INVX1H7R
Xring/mid/stage_4_dyn_impl_1 MID_MUX[4] ring/mid/net8 ring/mid/MUXB_4_
+ VDD VSS ring/mid/UNCONNECTED_4_ NAND3X8H7R
Xring/mid/stage_4_dyn_impl_2 MID_MUX[4] ring/mid/net8 ring/mid/MUXB_4_
+ VDD VSS ring/mid/UNCONNECTED_4_ NAND3X6H7R
Xring/mid/stage_4_inv_b_impl MID_MUX[4] VDD VSS ring/mid/MUXB_4_
+ INVX1H7R
Xring/mid/stage_5_dyn_impl_1 MID_MUX[5] ring/mid/net9 ring/mid/MUXB_5_
+ VDD VSS ring/mid/UNCONNECTED_5_ NAND3X8H7R
Xring/mid/stage_5_dyn_impl_2 MID_MUX[5] ring/mid/net3 ring/mid/MUXB_5_
+ VDD VSS ring/mid/UNCONNECTED_5_ NAND3X6H7R
Xring/mid/stage_5_inv_b_impl MID_MUX[5] VDD VSS ring/mid/MUXB_5_
+ INVX1H7R
Xring/mid/stage_6_dyn_impl_1 MID_MUX[6] ring/mid/net6 ring/mid/MUXB_6_
+ VDD VSS ring/mid/UNCONNECTED_6_ NAND3X8H7R
Xring/mid/stage_6_dyn_impl_2 MID_MUX[6] ring/mid/net6 ring/mid/MUXB_6_
+ VDD VSS ring/mid/UNCONNECTED_6_ NAND3X6H7R
Xring/mid/stage_6_inv_b_impl MID_MUX[6] VDD VSS ring/mid/MUXB_6_
+ INVX1H7R
Xring/mid/stage_7_dyn_impl_1 MID_MUX[7] ring/mid/net3 ring/mid/MUXB_7_
+ VDD VSS ring/mid/UNCONNECTED_7_ NAND3X8H7R
Xring/mid/stage_7_dyn_impl_2 MID_MUX[7] ring/mid/net3 ring/mid/MUXB_7_
+ VDD VSS ring/mid/UNCONNECTED_7_ NAND3X6H7R
Xring/mid/stage_7_inv_b_impl MID_MUX[7] VDD VSS ring/mid/MUXB_7_
+ INVX1H7R
Xring/mid/stage_8_dyn_impl_1 MID_MUX[8] ring/mid/net6 ring/mid/MUXB_8_
+ VDD VSS ring/mid/UNCONNECTED_8_ NAND3X8H7R
Xring/mid/stage_8_dyn_impl_2 MID_MUX[8] ring/mid/net6 ring/mid/MUXB_8_
+ VDD VSS ring/mid/UNCONNECTED_8_ NAND3X6H7R
Xring/mid/stage_8_inv_b_impl MID_MUX[8] VDD VSS ring/mid/MUXB_8_
+ INVX1H7R
Xring/mid/stage_9_dyn_impl_1 MID_MUX[9] ring/mid/net6 ring/mid/MUXB_9_
+ VDD VSS ring/mid/UNCONNECTED_9_ NAND3X8H7R
Xring/mid/stage_9_dyn_impl_2 MID_MUX[9] ring/mid/net6 ring/mid/MUXB_9_
+ VDD VSS ring/mid/UNCONNECTED_9_ NAND3X6H7R
Xring/mid/stage_9_inv_b_impl MID_MUX[9] VDD VSS ring/mid/MUXB_9_
+ INVX1H7R
Xring/sym/inj_dummy_inv_impl ring/sym/INJ_EDGE_BALANCED VDD
+ VSS ring/sym/INJ_DUMMY INVX1H7R
Xring/sym/inj_slope_balancer_impl REF VDD VSS ring/sym/INJ_EDGE_BALANCED
+ INVX1H7R
Xring/sym/osc_dummy_inv_impl ring/sym/OSC_BALANCED VDD VSS
+ ring/sym/OSC_DUMMY INVX1H7R
Xring/sym/osc_slope_balancer_impl ring/FINE_OUT VDD VSS ring/sym/OSC_BALANCED
+ INVX7H7R
Xrebuffer16 net2 VDD VSS net16 BUFX1P4H7R
Xring/sym/ssbbpd_impl/buf_nand_y_impl ring/sym/ssbbpd_impl/OUT_NANDY
+ VDD VSS ring/SS_BBPD_WIRE_0_ BUFX0P5H7R
Xring/sym/ssbbpd_impl/nand_x_impl ring/sym/OSC_BALANCED ring/sym/ssbbpd_impl/OUT_NANDY
+ VDD VSS ring/SS_BBPD_WIRE_1_ NAND2X6H7R
Xring/sym/ssbbpd_impl/nand_y_impl ring/sym/INJ_EDGE_BALANCED
+ ring/SS_BBPD_WIRE_1_ VDD VSS ring/sym/ssbbpd_impl/OUT_NANDY
+ NAND2X1H7R
Xring/sym/sym_mux/nand_inj_impl ring/sym/sym_mux/DCO_EN_INJ_WIN
+ ring/sym/OSC_BALANCED VDD VSS ring/sym/sym_mux/OSC_INJ NAND2X6H7R
Xring/sym/sym_mux/nand_pll_impl ring/sym/sym_mux/OSC_INJ ring/sym/sym_mux/REF_INJ
+ VDD VSS net5 NAND2X16H7R
Xring/sym/sym_mux/nand_ref_impl ring/sym/INJ_EDGE_BALANCED
+ zero_ VDD VSS ring/sym/sym_mux/REF_INJ NAND2BX1H7R
Xring/sym/sym_mux/norb_en_inj_impl DCO_EN zero_ VDD VSS ring/sym/sym_mux/DCO_EN_INJ_WIN
+ NOR2BX3H7R
XTIE_ZERO_zero_ VDD VSS zero_ TIELOH7R
XTAP_TAPCELL_ROW_0_0 VDD VSS FILLTAPH7R
XTAP_TAPCELL_ROW_0_1 VDD VSS FILLTAPH7R
XTAP_TAPCELL_ROW_0_2 VDD VSS FILLTAPH7R
XTAP_TAPCELL_ROW_0_3 VDD VSS FILLTAPH7R
XTAP_TAPCELL_ROW_0_4 VDD VSS FILLTAPH7R
XTAP_TAPCELL_ROW_1_5 VDD VSS FILLTAPH7R
XTAP_TAPCELL_ROW_1_6 VDD VSS FILLTAPH7R
XTAP_TAPCELL_ROW_2_7 VDD VSS FILLTAPH7R
XTAP_TAPCELL_ROW_2_8 VDD VSS FILLTAPH7R
XTAP_TAPCELL_ROW_2_9 VDD VSS FILLTAPH7R
XTAP_TAPCELL_ROW_3_10 VDD VSS FILLTAPH7R
XTAP_TAPCELL_ROW_3_11 VDD VSS FILLTAPH7R
XTAP_TAPCELL_ROW_4_12 VDD VSS FILLTAPH7R
XTAP_TAPCELL_ROW_4_13 VDD VSS FILLTAPH7R
XTAP_TAPCELL_ROW_4_14 VDD VSS FILLTAPH7R
XTAP_TAPCELL_ROW_5_15 VDD VSS FILLTAPH7R
XTAP_TAPCELL_ROW_5_16 VDD VSS FILLTAPH7R
XTAP_TAPCELL_ROW_6_17 VDD VSS FILLTAPH7R
XTAP_TAPCELL_ROW_6_18 VDD VSS FILLTAPH7R
XTAP_TAPCELL_ROW_6_19 VDD VSS FILLTAPH7R
XTAP_TAPCELL_ROW_7_20 VDD VSS FILLTAPH7R
XTAP_TAPCELL_ROW_7_21 VDD VSS FILLTAPH7R
XTAP_TAPCELL_ROW_8_22 VDD VSS FILLTAPH7R
XTAP_TAPCELL_ROW_8_23 VDD VSS FILLTAPH7R
XTAP_TAPCELL_ROW_8_24 VDD VSS FILLTAPH7R
XTAP_TAPCELL_ROW_9_25 VDD VSS FILLTAPH7R
XTAP_TAPCELL_ROW_9_26 VDD VSS FILLTAPH7R
XTAP_TAPCELL_ROW_10_27 VDD VSS FILLTAPH7R
XTAP_TAPCELL_ROW_10_28 VDD VSS FILLTAPH7R
XTAP_TAPCELL_ROW_10_29 VDD VSS FILLTAPH7R
XTAP_TAPCELL_ROW_11_30 VDD VSS FILLTAPH7R
XTAP_TAPCELL_ROW_11_31 VDD VSS FILLTAPH7R
XTAP_TAPCELL_ROW_12_32 VDD VSS FILLTAPH7R
XTAP_TAPCELL_ROW_12_33 VDD VSS FILLTAPH7R
XTAP_TAPCELL_ROW_12_34 VDD VSS FILLTAPH7R
XTAP_TAPCELL_ROW_13_35 VDD VSS FILLTAPH7R
XTAP_TAPCELL_ROW_13_36 VDD VSS FILLTAPH7R
XTAP_TAPCELL_ROW_14_37 VDD VSS FILLTAPH7R
XTAP_TAPCELL_ROW_14_38 VDD VSS FILLTAPH7R
XTAP_TAPCELL_ROW_14_39 VDD VSS FILLTAPH7R
XTAP_TAPCELL_ROW_15_40 VDD VSS FILLTAPH7R
XTAP_TAPCELL_ROW_15_41 VDD VSS FILLTAPH7R
XTAP_TAPCELL_ROW_16_42 VDD VSS FILLTAPH7R
XTAP_TAPCELL_ROW_16_43 VDD VSS FILLTAPH7R
XTAP_TAPCELL_ROW_16_44 VDD VSS FILLTAPH7R
XTAP_TAPCELL_ROW_17_45 VDD VSS FILLTAPH7R
XTAP_TAPCELL_ROW_17_46 VDD VSS FILLTAPH7R
XTAP_TAPCELL_ROW_18_47 VDD VSS FILLTAPH7R
XTAP_TAPCELL_ROW_18_48 VDD VSS FILLTAPH7R
XTAP_TAPCELL_ROW_18_49 VDD VSS FILLTAPH7R
XTAP_TAPCELL_ROW_19_50 VDD VSS FILLTAPH7R
XTAP_TAPCELL_ROW_19_51 VDD VSS FILLTAPH7R
XTAP_TAPCELL_ROW_20_52 VDD VSS FILLTAPH7R
XTAP_TAPCELL_ROW_20_53 VDD VSS FILLTAPH7R
XTAP_TAPCELL_ROW_20_54 VDD VSS FILLTAPH7R
XTAP_TAPCELL_ROW_21_55 VDD VSS FILLTAPH7R
XTAP_TAPCELL_ROW_21_56 VDD VSS FILLTAPH7R
XTAP_TAPCELL_ROW_22_57 VDD VSS FILLTAPH7R
XTAP_TAPCELL_ROW_22_58 VDD VSS FILLTAPH7R
XTAP_TAPCELL_ROW_22_59 VDD VSS FILLTAPH7R
XTAP_TAPCELL_ROW_23_60 VDD VSS FILLTAPH7R
XTAP_TAPCELL_ROW_23_61 VDD VSS FILLTAPH7R
XTAP_TAPCELL_ROW_24_62 VDD VSS FILLTAPH7R
XTAP_TAPCELL_ROW_24_63 VDD VSS FILLTAPH7R
XTAP_TAPCELL_ROW_24_64 VDD VSS FILLTAPH7R
XTAP_TAPCELL_ROW_25_65 VDD VSS FILLTAPH7R
XTAP_TAPCELL_ROW_25_66 VDD VSS FILLTAPH7R
XTAP_TAPCELL_ROW_26_67 VDD VSS FILLTAPH7R
XTAP_TAPCELL_ROW_26_68 VDD VSS FILLTAPH7R
XTAP_TAPCELL_ROW_26_69 VDD VSS FILLTAPH7R
XTAP_TAPCELL_ROW_27_70 VDD VSS FILLTAPH7R
XTAP_TAPCELL_ROW_27_71 VDD VSS FILLTAPH7R
XTAP_TAPCELL_ROW_28_72 VDD VSS FILLTAPH7R
XTAP_TAPCELL_ROW_28_73 VDD VSS FILLTAPH7R
XTAP_TAPCELL_ROW_28_74 VDD VSS FILLTAPH7R
XTAP_TAPCELL_ROW_29_75 VDD VSS FILLTAPH7R
XTAP_TAPCELL_ROW_29_76 VDD VSS FILLTAPH7R
XTAP_TAPCELL_ROW_30_77 VDD VSS FILLTAPH7R
XTAP_TAPCELL_ROW_30_78 VDD VSS FILLTAPH7R
XTAP_TAPCELL_ROW_30_79 VDD VSS FILLTAPH7R
XTAP_TAPCELL_ROW_31_80 VDD VSS FILLTAPH7R
XTAP_TAPCELL_ROW_31_81 VDD VSS FILLTAPH7R
XTAP_TAPCELL_ROW_32_82 VDD VSS FILLTAPH7R
XTAP_TAPCELL_ROW_32_83 VDD VSS FILLTAPH7R
XTAP_TAPCELL_ROW_32_84 VDD VSS FILLTAPH7R
XTAP_TAPCELL_ROW_33_85 VDD VSS FILLTAPH7R
XTAP_TAPCELL_ROW_33_86 VDD VSS FILLTAPH7R
XTAP_TAPCELL_ROW_34_87 VDD VSS FILLTAPH7R
XTAP_TAPCELL_ROW_34_88 VDD VSS FILLTAPH7R
XTAP_TAPCELL_ROW_34_89 VDD VSS FILLTAPH7R
XTAP_TAPCELL_ROW_35_90 VDD VSS FILLTAPH7R
XTAP_TAPCELL_ROW_35_91 VDD VSS FILLTAPH7R
XTAP_TAPCELL_ROW_36_92 VDD VSS FILLTAPH7R
XTAP_TAPCELL_ROW_36_93 VDD VSS FILLTAPH7R
XTAP_TAPCELL_ROW_36_94 VDD VSS FILLTAPH7R
XTAP_TAPCELL_ROW_37_95 VDD VSS FILLTAPH7R
XTAP_TAPCELL_ROW_37_96 VDD VSS FILLTAPH7R
XTAP_TAPCELL_ROW_38_97 VDD VSS FILLTAPH7R
XTAP_TAPCELL_ROW_38_98 VDD VSS FILLTAPH7R
XTAP_TAPCELL_ROW_38_99 VDD VSS FILLTAPH7R
XTAP_TAPCELL_ROW_39_100 VDD VSS FILLTAPH7R
XTAP_TAPCELL_ROW_39_101 VDD VSS FILLTAPH7R
XTAP_TAPCELL_ROW_40_102 VDD VSS FILLTAPH7R
XTAP_TAPCELL_ROW_40_103 VDD VSS FILLTAPH7R
XTAP_TAPCELL_ROW_40_104 VDD VSS FILLTAPH7R
XTAP_TAPCELL_ROW_41_105 VDD VSS FILLTAPH7R
XTAP_TAPCELL_ROW_41_106 VDD VSS FILLTAPH7R
XTAP_TAPCELL_ROW_42_107 VDD VSS FILLTAPH7R
XTAP_TAPCELL_ROW_42_108 VDD VSS FILLTAPH7R
XTAP_TAPCELL_ROW_42_109 VDD VSS FILLTAPH7R
XTAP_TAPCELL_ROW_43_110 VDD VSS FILLTAPH7R
XTAP_TAPCELL_ROW_43_111 VDD VSS FILLTAPH7R
XTAP_TAPCELL_ROW_44_112 VDD VSS FILLTAPH7R
XTAP_TAPCELL_ROW_44_113 VDD VSS FILLTAPH7R
XTAP_TAPCELL_ROW_44_114 VDD VSS FILLTAPH7R
XTAP_TAPCELL_ROW_45_115 VDD VSS FILLTAPH7R
XTAP_TAPCELL_ROW_45_116 VDD VSS FILLTAPH7R
XTAP_TAPCELL_ROW_46_117 VDD VSS FILLTAPH7R
XTAP_TAPCELL_ROW_46_118 VDD VSS FILLTAPH7R
XTAP_TAPCELL_ROW_46_119 VDD VSS FILLTAPH7R
XTAP_TAPCELL_ROW_47_120 VDD VSS FILLTAPH7R
XTAP_TAPCELL_ROW_47_121 VDD VSS FILLTAPH7R
XTAP_TAPCELL_ROW_48_122 VDD VSS FILLTAPH7R
XTAP_TAPCELL_ROW_48_123 VDD VSS FILLTAPH7R
XTAP_TAPCELL_ROW_48_124 VDD VSS FILLTAPH7R
XTAP_TAPCELL_ROW_49_125 VDD VSS FILLTAPH7R
XTAP_TAPCELL_ROW_49_126 VDD VSS FILLTAPH7R
XTAP_TAPCELL_ROW_50_127 VDD VSS FILLTAPH7R
XTAP_TAPCELL_ROW_50_128 VDD VSS FILLTAPH7R
XTAP_TAPCELL_ROW_50_129 VDD VSS FILLTAPH7R
XTAP_TAPCELL_ROW_51_130 VDD VSS FILLTAPH7R
XTAP_TAPCELL_ROW_51_131 VDD VSS FILLTAPH7R
XTAP_TAPCELL_ROW_52_132 VDD VSS FILLTAPH7R
XTAP_TAPCELL_ROW_52_133 VDD VSS FILLTAPH7R
XTAP_TAPCELL_ROW_52_134 VDD VSS FILLTAPH7R
XTAP_TAPCELL_ROW_52_135 VDD VSS FILLTAPH7R
XTAP_TAPCELL_ROW_52_136 VDD VSS FILLTAPH7R
XFILLER_19_0 VDD VSS FILLCAP4H7R
Xmax_cap2 net2 VDD VSS MID_OUT BUFX16H7R
Xring/mid/max_cap3 ring/mid/LOAD VDD VSS ring/mid/net3 BUFX20H7R
XFILLER_15_144 VDD VSS FILLCAP4H7R
Xmax_cap5 net14 VDD VSS OUT BUFX20H7R
Xring/mid/rebuffer6 ring/mid/LOAD VDD VSS ring/mid/net6 BUFX2P5H7R
Xring/mid/rebuffer7 ring/mid/LOAD VDD VSS ring/mid/net7 BUFX1P4H7R
XFILLER_19_4 VDD VSS FILLER1H7R
XFILLER_19_32 VDD VSS FILLCAP4H7R
XFILLER_19_36 VDD VSS FILLER2H7R
XFILLER_19_38 VDD VSS FILLER1H7R
XFILLER_19_42 VDD VSS FILLER64H7R
XFILLER_19_106 VDD VSS FILLCAP32H7R
XFILLER_19_138 VDD VSS FILLCAP8H7R
XFILLER_19_146 VDD VSS FILLCAP4H7R
XFILLER_19_152 VDD VSS FILLER64H7R
XFILLER_19_216 VDD VSS FILLER64H7R
XFILLER_19_280 VDD VSS FILLCAP16H7R
XFILLER_19_296 VDD VSS FILLCAP4H7R
XFILLER_19_302 VDD VSS FILLER64H7R
XFILLER_19_366 VDD VSS FILLCAP8H7R
XFILLER_19_374 VDD VSS FILLCAP4H7R
XFILLER_20_0 VDD VSS FILLER2H7R
XFILLER_20_29 VDD VSS FILLCAP4H7R
XFILLER_20_33 VDD VSS FILLER2H7R
XFILLER_20_35 VDD VSS FILLER1H7R
XFILLER_20_51 VDD VSS FILLCAP4H7R
XFILLER_20_55 VDD VSS FILLER2H7R
XFILLER_20_72 VDD VSS FILLER2H7R
XFILLER_20_74 VDD VSS FILLER1H7R
XFILLER_20_77 VDD VSS FILLER64H7R
XFILLER_20_141 VDD VSS FILLCAP32H7R
XFILLER_20_173 VDD VSS FILLCAP8H7R
XFILLER_20_184 VDD VSS FILLCAP8H7R
XFILLER_20_192 VDD VSS FILLER1H7R
XFILLER_20_204 VDD VSS FILLCAP16H7R
XFILLER_20_220 VDD VSS FILLCAP4H7R
XFILLER_20_224 VDD VSS FILLER1H7R
XFILLER_20_227 VDD VSS FILLER64H7R
XFILLER_20_291 VDD VSS FILLER64H7R
XFILLER_20_355 VDD VSS FILLCAP8H7R
XFILLER_20_363 VDD VSS FILLER2H7R
XFILLER_20_365 VDD VSS FILLER1H7R
XFILLER_20_369 VDD VSS FILLCAP4H7R
XFILLER_20_373 VDD VSS FILLER2H7R
XFILLER_20_377 VDD VSS FILLER1H7R
XFILLER_21_0 VDD VSS FILLCAP4H7R
XFILLER_21_4 VDD VSS FILLER2H7R
XFILLER_21_31 VDD VSS FILLER2H7R
XFILLER_21_53 VDD VSS FILLER2H7R
XFILLER_21_75 VDD VSS FILLER64H7R
XFILLER_21_139 VDD VSS FILLCAP8H7R
XFILLER_21_147 VDD VSS FILLER2H7R
XFILLER_21_149 VDD VSS FILLER1H7R
XFILLER_21_152 VDD VSS FILLCAP16H7R
XFILLER_21_168 VDD VSS FILLCAP8H7R
XFILLER_21_176 VDD VSS FILLER1H7R
XFILLER_21_181 VDD VSS FILLER1H7R
XFILLER_21_220 VDD VSS FILLER64H7R
XFILLER_21_284 VDD VSS FILLCAP16H7R
XFILLER_21_302 VDD VSS FILLCAP32H7R
XFILLER_21_334 VDD VSS FILLCAP16H7R
XFILLER_21_350 VDD VSS FILLCAP8H7R
XFILLER_21_358 VDD VSS FILLER1H7R
XFILLER_21_377 VDD VSS FILLER1H7R
XFILLER_22_0 VDD VSS FILLER2H7R
XFILLER_22_30 VDD VSS FILLCAP8H7R
XFILLER_22_38 VDD VSS FILLER2H7R
XFILLER_22_40 VDD VSS FILLER1H7R
XFILLER_22_44 VDD VSS FILLCAP16H7R
XFILLER_22_60 VDD VSS FILLER2H7R
XFILLER_22_62 VDD VSS FILLER1H7R
XFILLER_22_66 VDD VSS FILLCAP8H7R
XFILLER_22_74 VDD VSS FILLER1H7R
XFILLER_22_77 VDD VSS FILLER64H7R
XFILLER_22_141 VDD VSS FILLCAP16H7R
XFILLER_22_157 VDD VSS FILLER1H7R
XFILLER_22_180 VDD VSS FILLER1H7R
XFILLER_22_196 VDD VSS FILLCAP16H7R
XFILLER_22_212 VDD VSS FILLCAP8H7R
XFILLER_22_220 VDD VSS FILLCAP4H7R
XFILLER_22_224 VDD VSS FILLER1H7R
XFILLER_22_227 VDD VSS FILLCAP32H7R
XFILLER_22_259 VDD VSS FILLCAP8H7R
XFILLER_22_267 VDD VSS FILLER1H7R
XFILLER_22_294 VDD VSS FILLCAP16H7R
XFILLER_22_310 VDD VSS FILLCAP4H7R
XFILLER_22_330 VDD VSS FILLCAP8H7R
XFILLER_22_354 VDD VSS FILLCAP8H7R
XFILLER_22_362 VDD VSS FILLCAP4H7R
XFILLER_22_369 VDD VSS FILLCAP4H7R
XFILLER_22_373 VDD VSS FILLER2H7R
XFILLER_22_377 VDD VSS FILLER1H7R
XFILLER_23_0 VDD VSS FILLER2H7R
XFILLER_23_2 VDD VSS FILLER1H7R
XFILLER_23_14 VDD VSS FILLCAP4H7R
XFILLER_23_32 VDD VSS FILLCAP8H7R
XFILLER_23_40 VDD VSS FILLER2H7R
XFILLER_23_42 VDD VSS FILLER1H7R
XFILLER_23_58 VDD VSS FILLCAP4H7R
XFILLER_23_62 VDD VSS FILLER1H7R
XFILLER_23_83 VDD VSS FILLER64H7R
XFILLER_23_147 VDD VSS FILLER2H7R
XFILLER_23_149 VDD VSS FILLER1H7R
XFILLER_23_152 VDD VSS FILLCAP16H7R
XFILLER_23_168 VDD VSS FILLCAP8H7R
XFILLER_23_176 VDD VSS FILLCAP4H7R
XFILLER_23_184 VDD VSS FILLER1H7R
XFILLER_23_188 VDD VSS FILLER64H7R
XFILLER_23_252 VDD VSS FILLCAP32H7R
XFILLER_23_284 VDD VSS FILLCAP16H7R
XFILLER_23_302 VDD VSS FILLCAP32H7R
XFILLER_23_334 VDD VSS FILLCAP4H7R
XFILLER_23_338 VDD VSS FILLER2H7R
XFILLER_23_348 VDD VSS FILLCAP8H7R
XFILLER_23_356 VDD VSS FILLCAP4H7R
XFILLER_23_360 VDD VSS FILLER1H7R
XFILLER_23_377 VDD VSS FILLER1H7R
XFILLER_24_0 VDD VSS FILLCAP4H7R
XFILLER_24_18 VDD VSS FILLER2H7R
XFILLER_24_36 VDD VSS FILLCAP4H7R
XFILLER_24_80 VDD VSS FILLER64H7R
XFILLER_24_144 VDD VSS FILLCAP32H7R
XFILLER_24_176 VDD VSS FILLCAP4H7R
XFILLER_24_180 VDD VSS FILLER1H7R
XFILLER_24_204 VDD VSS FILLCAP16H7R
XFILLER_24_220 VDD VSS FILLCAP4H7R
XFILLER_24_224 VDD VSS FILLER1H7R
XFILLER_24_227 VDD VSS FILLER64H7R
XFILLER_24_291 VDD VSS FILLCAP32H7R
XFILLER_24_323 VDD VSS FILLCAP8H7R
XFILLER_24_336 VDD VSS FILLCAP8H7R
XFILLER_24_344 VDD VSS FILLCAP4H7R
XFILLER_24_348 VDD VSS FILLER2H7R
XFILLER_24_350 VDD VSS FILLER1H7R
XFILLER_24_359 VDD VSS FILLCAP16H7R
XFILLER_24_377 VDD VSS FILLER1H7R
XFILLER_25_0 VDD VSS FILLCAP4H7R
XFILLER_25_4 VDD VSS FILLER2H7R
XFILLER_25_44 VDD VSS FILLCAP4H7R
XFILLER_25_51 VDD VSS FILLCAP16H7R
XFILLER_25_67 VDD VSS FILLER2H7R
XFILLER_25_84 VDD VSS FILLER64H7R
XFILLER_25_148 VDD VSS FILLER2H7R
XFILLER_25_152 VDD VSS FILLCAP16H7R
XFILLER_25_168 VDD VSS FILLCAP8H7R
XFILLER_25_176 VDD VSS FILLER1H7R
XFILLER_25_200 VDD VSS FILLCAP16H7R
XFILLER_25_216 VDD VSS FILLCAP8H7R
XFILLER_25_224 VDD VSS FILLCAP4H7R
XFILLER_25_228 VDD VSS FILLER2H7R
XFILLER_25_230 VDD VSS FILLER1H7R
XFILLER_25_240 VDD VSS FILLCAP32H7R
XFILLER_25_272 VDD VSS FILLCAP16H7R
XFILLER_25_288 VDD VSS FILLCAP8H7R
XFILLER_25_296 VDD VSS FILLCAP4H7R
XFILLER_25_302 VDD VSS FILLCAP16H7R
XFILLER_25_318 VDD VSS FILLCAP8H7R
XFILLER_25_326 VDD VSS FILLER2H7R
XFILLER_25_328 VDD VSS FILLER1H7R
XFILLER_25_340 VDD VSS FILLCAP4H7R
XFILLER_25_344 VDD VSS FILLER2H7R
XFILLER_25_354 VDD VSS FILLCAP8H7R
XFILLER_25_362 VDD VSS FILLER2H7R
XFILLER_25_372 VDD VSS FILLCAP4H7R
XFILLER_25_376 VDD VSS FILLER2H7R
XFILLER_26_0 VDD VSS FILLCAP4H7R
XFILLER_26_4 VDD VSS FILLER2H7R
XFILLER_26_28 VDD VSS FILLER2H7R
XFILLER_26_42 VDD VSS FILLCAP4H7R
XFILLER_26_61 VDD VSS FILLCAP8H7R
XFILLER_26_69 VDD VSS FILLER2H7R
XFILLER_26_71 VDD VSS FILLER1H7R
XFILLER_26_85 VDD VSS FILLCAP4H7R
XFILLER_26_104 VDD VSS FILLER64H7R
XFILLER_26_168 VDD VSS FILLCAP32H7R
XFILLER_26_200 VDD VSS FILLCAP16H7R
XFILLER_26_216 VDD VSS FILLCAP8H7R
XFILLER_26_224 VDD VSS FILLER1H7R
XFILLER_26_227 VDD VSS FILLER64H7R
XFILLER_26_291 VDD VSS FILLCAP16H7R
XFILLER_26_307 VDD VSS FILLCAP4H7R
XFILLER_26_311 VDD VSS FILLER2H7R
XFILLER_26_335 VDD VSS FILLCAP16H7R
XFILLER_26_351 VDD VSS FILLCAP8H7R
XFILLER_26_377 VDD VSS FILLER1H7R
XFILLER_27_0 VDD VSS FILLER2H7R
XFILLER_27_14 VDD VSS FILLER1H7R
XFILLER_27_37 VDD VSS FILLCAP4H7R
XFILLER_27_41 VDD VSS FILLER2H7R
XFILLER_27_63 VDD VSS FILLCAP4H7R
XFILLER_27_87 VDD VSS FILLCAP32H7R
XFILLER_27_119 VDD VSS FILLCAP16H7R
XFILLER_27_135 VDD VSS FILLCAP8H7R
XFILLER_27_143 VDD VSS FILLCAP4H7R
XFILLER_27_147 VDD VSS FILLER2H7R
XFILLER_27_149 VDD VSS FILLER1H7R
XFILLER_27_152 VDD VSS FILLER64H7R
XFILLER_27_216 VDD VSS FILLER64H7R
XFILLER_27_280 VDD VSS FILLCAP16H7R
XFILLER_27_296 VDD VSS FILLCAP4H7R
XFILLER_27_302 VDD VSS FILLCAP16H7R
XFILLER_27_318 VDD VSS FILLER2H7R
XFILLER_27_346 VDD VSS FILLER2H7R
XFILLER_27_348 VDD VSS FILLER1H7R
XFILLER_27_357 VDD VSS FILLCAP16H7R
XFILLER_27_373 VDD VSS FILLCAP4H7R
XFILLER_27_377 VDD VSS FILLER1H7R
XFILLER_28_0 VDD VSS FILLCAP4H7R
XFILLER_28_4 VDD VSS FILLER2H7R
XFILLER_28_11 VDD VSS FILLER2H7R
XFILLER_28_13 VDD VSS FILLER1H7R
XFILLER_28_21 VDD VSS FILLCAP16H7R
XFILLER_28_37 VDD VSS FILLCAP8H7R
XFILLER_28_45 VDD VSS FILLCAP4H7R
XFILLER_28_49 VDD VSS FILLER2H7R
XFILLER_28_51 VDD VSS FILLER1H7R
XFILLER_28_55 VDD VSS FILLCAP16H7R
XFILLER_28_71 VDD VSS FILLCAP4H7R
XFILLER_28_84 VDD VSS FILLER64H7R
XFILLER_28_148 VDD VSS FILLER64H7R
XFILLER_28_212 VDD VSS FILLCAP8H7R
XFILLER_28_220 VDD VSS FILLCAP4H7R
XFILLER_28_224 VDD VSS FILLER1H7R
XFILLER_28_227 VDD VSS FILLER64H7R
XFILLER_28_291 VDD VSS FILLCAP32H7R
XFILLER_28_323 VDD VSS FILLER2H7R
XFILLER_28_330 VDD VSS FILLER2H7R
XFILLER_28_340 VDD VSS FILLCAP4H7R
XFILLER_28_361 VDD VSS FILLCAP4H7R
XFILLER_28_365 VDD VSS FILLER1H7R
XFILLER_28_374 VDD VSS FILLER1H7R
XFILLER_28_377 VDD VSS FILLER1H7R
XFILLER_29_0 VDD VSS FILLER2H7R
XFILLER_29_16 VDD VSS FILLER2H7R
XFILLER_29_25 VDD VSS FILLER1H7R
XFILLER_29_31 VDD VSS FILLCAP16H7R
XFILLER_29_47 VDD VSS FILLER2H7R
XFILLER_29_64 VDD VSS FILLCAP8H7R
XFILLER_29_72 VDD VSS FILLER2H7R
XFILLER_29_74 VDD VSS FILLER1H7R
XFILLER_29_90 VDD VSS FILLCAP32H7R
XFILLER_29_122 VDD VSS FILLCAP16H7R
XFILLER_29_138 VDD VSS FILLCAP8H7R
XFILLER_29_146 VDD VSS FILLCAP4H7R
XFILLER_29_152 VDD VSS FILLER64H7R
XFILLER_29_216 VDD VSS FILLER64H7R
XFILLER_29_280 VDD VSS FILLCAP16H7R
XFILLER_29_296 VDD VSS FILLCAP4H7R
XFILLER_29_302 VDD VSS FILLCAP32H7R
XFILLER_29_334 VDD VSS FILLCAP8H7R
XFILLER_29_342 VDD VSS FILLCAP4H7R
XFILLER_29_354 VDD VSS FILLCAP8H7R
XFILLER_29_362 VDD VSS FILLER1H7R
XFILLER_29_376 VDD VSS FILLER2H7R
XFILLER_30_0 VDD VSS FILLCAP4H7R
XFILLER_30_42 VDD VSS FILLCAP4H7R
XFILLER_30_46 VDD VSS FILLER1H7R
XFILLER_30_70 VDD VSS FILLER1H7R
XFILLER_30_97 VDD VSS FILLER64H7R
XFILLER_30_161 VDD VSS FILLER64H7R
XFILLER_30_227 VDD VSS FILLER64H7R
XFILLER_30_291 VDD VSS FILLCAP32H7R
XFILLER_30_323 VDD VSS FILLCAP4H7R
XFILLER_30_327 VDD VSS FILLER2H7R
XFILLER_30_329 VDD VSS FILLER1H7R
XFILLER_30_338 VDD VSS FILLCAP4H7R
XFILLER_30_342 VDD VSS FILLER2H7R
XFILLER_30_344 VDD VSS FILLER1H7R
XFILLER_30_353 VDD VSS FILLCAP8H7R
XFILLER_30_361 VDD VSS FILLCAP4H7R
XFILLER_30_365 VDD VSS FILLER2H7R
XFILLER_30_367 VDD VSS FILLER1H7R
XFILLER_30_371 VDD VSS FILLCAP4H7R
XFILLER_30_377 VDD VSS FILLER1H7R
XFILLER_31_0 VDD VSS FILLCAP4H7R
XFILLER_31_4 VDD VSS FILLER1H7R
XFILLER_31_16 VDD VSS FILLCAP4H7R
XFILLER_31_20 VDD VSS FILLER1H7R
XFILLER_31_75 VDD VSS FILLER64H7R
XFILLER_31_139 VDD VSS FILLCAP8H7R
XFILLER_31_147 VDD VSS FILLER2H7R
XFILLER_31_149 VDD VSS FILLER1H7R
XFILLER_31_152 VDD VSS FILLER64H7R
XFILLER_31_216 VDD VSS FILLER64H7R
XFILLER_31_280 VDD VSS FILLCAP16H7R
XFILLER_31_296 VDD VSS FILLCAP4H7R
XFILLER_31_302 VDD VSS FILLCAP32H7R
XFILLER_31_334 VDD VSS FILLCAP8H7R
XFILLER_31_342 VDD VSS FILLER2H7R
XFILLER_31_360 VDD VSS FILLCAP4H7R
XFILLER_31_370 VDD VSS FILLCAP8H7R
XFILLER_32_0 VDD VSS FILLCAP4H7R
XFILLER_32_19 VDD VSS FILLCAP8H7R
XFILLER_32_27 VDD VSS FILLER1H7R
XFILLER_32_44 VDD VSS FILLER2H7R
XFILLER_32_46 VDD VSS FILLER1H7R
XFILLER_32_73 VDD VSS FILLER2H7R
XFILLER_32_77 VDD VSS FILLER64H7R
XFILLER_32_141 VDD VSS FILLER64H7R
XFILLER_32_205 VDD VSS FILLCAP16H7R
XFILLER_32_221 VDD VSS FILLCAP4H7R
XFILLER_32_227 VDD VSS FILLER64H7R
XFILLER_32_291 VDD VSS FILLER64H7R
XFILLER_32_355 VDD VSS FILLCAP4H7R
XFILLER_32_359 VDD VSS FILLER1H7R
XFILLER_32_377 VDD VSS FILLER1H7R
XFILLER_33_0 VDD VSS FILLER1H7R
XFILLER_33_21 VDD VSS FILLCAP8H7R
XFILLER_33_40 VDD VSS FILLER2H7R
XFILLER_33_55 VDD VSS FILLER2H7R
XFILLER_33_57 VDD VSS FILLER1H7R
XFILLER_33_78 VDD VSS FILLCAP16H7R
XFILLER_33_103 VDD VSS FILLCAP32H7R
XFILLER_33_135 VDD VSS FILLCAP8H7R
XFILLER_33_143 VDD VSS FILLCAP4H7R
XFILLER_33_147 VDD VSS FILLER2H7R
XFILLER_33_149 VDD VSS FILLER1H7R
XFILLER_33_152 VDD VSS FILLER64H7R
XFILLER_33_216 VDD VSS FILLER64H7R
XFILLER_33_280 VDD VSS FILLCAP16H7R
XFILLER_33_296 VDD VSS FILLCAP4H7R
XFILLER_33_302 VDD VSS FILLER64H7R
XFILLER_33_366 VDD VSS FILLER1H7R
XFILLER_33_370 VDD VSS FILLCAP8H7R
XFILLER_34_0 VDD VSS FILLCAP8H7R
XFILLER_34_8 VDD VSS FILLER1H7R
XFILLER_34_12 VDD VSS FILLCAP8H7R
XFILLER_34_20 VDD VSS FILLER2H7R
XFILLER_34_37 VDD VSS FILLCAP32H7R
XFILLER_34_69 VDD VSS FILLCAP4H7R
XFILLER_34_73 VDD VSS FILLER2H7R
XFILLER_34_77 VDD VSS FILLER64H7R
XFILLER_34_141 VDD VSS FILLER64H7R
XFILLER_34_205 VDD VSS FILLCAP16H7R
XFILLER_34_221 VDD VSS FILLCAP4H7R
XFILLER_34_227 VDD VSS FILLER64H7R
XFILLER_34_291 VDD VSS FILLER64H7R
XFILLER_34_355 VDD VSS FILLCAP16H7R
XFILLER_34_371 VDD VSS FILLCAP4H7R
XFILLER_34_377 VDD VSS FILLER1H7R
XFILLER_35_0 VDD VSS FILLCAP4H7R
XFILLER_35_39 VDD VSS FILLER1H7R
XFILLER_35_55 VDD VSS FILLER64H7R
XFILLER_35_119 VDD VSS FILLCAP16H7R
XFILLER_35_135 VDD VSS FILLCAP8H7R
XFILLER_35_143 VDD VSS FILLCAP4H7R
XFILLER_35_147 VDD VSS FILLER2H7R
XFILLER_35_149 VDD VSS FILLER1H7R
XFILLER_35_152 VDD VSS FILLER64H7R
XFILLER_35_216 VDD VSS FILLER64H7R
XFILLER_35_280 VDD VSS FILLCAP16H7R
XFILLER_35_296 VDD VSS FILLCAP4H7R
XFILLER_35_302 VDD VSS FILLER64H7R
XFILLER_35_366 VDD VSS FILLCAP8H7R
XFILLER_35_374 VDD VSS FILLCAP4H7R
XFILLER_36_0 VDD VSS FILLER1H7R
XFILLER_36_21 VDD VSS FILLCAP4H7R
XFILLER_36_25 VDD VSS FILLER2H7R
XFILLER_36_27 VDD VSS FILLER1H7R
XFILLER_36_31 VDD VSS FILLCAP4H7R
XFILLER_36_35 VDD VSS FILLER2H7R
XFILLER_36_37 VDD VSS FILLER1H7R
XFILLER_36_58 VDD VSS FILLCAP16H7R
XFILLER_36_74 VDD VSS FILLER1H7R
XFILLER_36_77 VDD VSS FILLER64H7R
XFILLER_36_141 VDD VSS FILLER64H7R
XFILLER_36_205 VDD VSS FILLCAP16H7R
XFILLER_36_221 VDD VSS FILLCAP4H7R
XFILLER_36_227 VDD VSS FILLER64H7R
XFILLER_36_291 VDD VSS FILLER64H7R
XFILLER_36_355 VDD VSS FILLCAP16H7R
XFILLER_36_371 VDD VSS FILLCAP4H7R
XFILLER_36_377 VDD VSS FILLER1H7R
XFILLER_37_0 VDD VSS FILLCAP8H7R
XFILLER_37_8 VDD VSS FILLER1H7R
XFILLER_37_12 VDD VSS FILLCAP32H7R
XFILLER_37_44 VDD VSS FILLER2H7R
XFILLER_37_49 VDD VSS FILLER64H7R
XFILLER_37_113 VDD VSS FILLCAP32H7R
XFILLER_37_145 VDD VSS FILLCAP4H7R
XFILLER_37_149 VDD VSS FILLER1H7R
XFILLER_37_152 VDD VSS FILLER64H7R
XFILLER_37_216 VDD VSS FILLER64H7R
XFILLER_37_280 VDD VSS FILLCAP16H7R
XFILLER_37_296 VDD VSS FILLCAP4H7R
XFILLER_37_302 VDD VSS FILLER64H7R
XFILLER_37_366 VDD VSS FILLCAP8H7R
XFILLER_37_374 VDD VSS FILLCAP4H7R
XFILLER_38_0 VDD VSS FILLER64H7R
XFILLER_38_64 VDD VSS FILLCAP8H7R
XFILLER_38_72 VDD VSS FILLER2H7R
XFILLER_38_74 VDD VSS FILLER1H7R
XFILLER_38_77 VDD VSS FILLER64H7R
XFILLER_38_141 VDD VSS FILLER64H7R
XFILLER_38_205 VDD VSS FILLCAP16H7R
XFILLER_38_221 VDD VSS FILLCAP4H7R
XFILLER_38_227 VDD VSS FILLER64H7R
XFILLER_38_291 VDD VSS FILLER64H7R
XFILLER_38_355 VDD VSS FILLCAP16H7R
XFILLER_38_371 VDD VSS FILLCAP4H7R
XFILLER_38_377 VDD VSS FILLER1H7R
XFILLER_39_0 VDD VSS FILLER64H7R
XFILLER_39_64 VDD VSS FILLER64H7R
XFILLER_39_128 VDD VSS FILLCAP16H7R
XFILLER_39_144 VDD VSS FILLCAP4H7R
XFILLER_39_148 VDD VSS FILLER2H7R
XFILLER_39_152 VDD VSS FILLER64H7R
XFILLER_39_216 VDD VSS FILLER64H7R
XFILLER_39_280 VDD VSS FILLCAP16H7R
XFILLER_39_296 VDD VSS FILLCAP4H7R
XFILLER_39_302 VDD VSS FILLER64H7R
XFILLER_39_366 VDD VSS FILLCAP8H7R
XFILLER_39_374 VDD VSS FILLCAP4H7R
XFILLER_40_0 VDD VSS FILLER64H7R
XFILLER_40_64 VDD VSS FILLCAP8H7R
XFILLER_40_72 VDD VSS FILLER2H7R
XFILLER_40_74 VDD VSS FILLER1H7R
XFILLER_40_77 VDD VSS FILLER64H7R
XFILLER_40_141 VDD VSS FILLER64H7R
XFILLER_40_205 VDD VSS FILLCAP16H7R
XFILLER_40_221 VDD VSS FILLCAP4H7R
XFILLER_40_227 VDD VSS FILLER64H7R
XFILLER_40_291 VDD VSS FILLER64H7R
XFILLER_40_355 VDD VSS FILLCAP16H7R
XFILLER_40_371 VDD VSS FILLCAP4H7R
XFILLER_40_377 VDD VSS FILLER1H7R
XFILLER_41_0 VDD VSS FILLER64H7R
XFILLER_41_64 VDD VSS FILLER64H7R
XFILLER_41_128 VDD VSS FILLCAP16H7R
XFILLER_41_144 VDD VSS FILLCAP4H7R
XFILLER_41_148 VDD VSS FILLER2H7R
XFILLER_41_152 VDD VSS FILLER64H7R
XFILLER_41_216 VDD VSS FILLER64H7R
XFILLER_41_280 VDD VSS FILLCAP16H7R
XFILLER_41_296 VDD VSS FILLCAP4H7R
XFILLER_41_302 VDD VSS FILLER64H7R
XFILLER_41_366 VDD VSS FILLCAP8H7R
XFILLER_41_374 VDD VSS FILLCAP4H7R
XFILLER_42_0 VDD VSS FILLER64H7R
XFILLER_42_64 VDD VSS FILLCAP8H7R
XFILLER_42_72 VDD VSS FILLER2H7R
XFILLER_42_74 VDD VSS FILLER1H7R
XFILLER_42_77 VDD VSS FILLER64H7R
XFILLER_42_141 VDD VSS FILLER64H7R
XFILLER_42_205 VDD VSS FILLCAP16H7R
XFILLER_42_221 VDD VSS FILLCAP4H7R
XFILLER_42_227 VDD VSS FILLER64H7R
XFILLER_42_291 VDD VSS FILLER64H7R
XFILLER_42_355 VDD VSS FILLCAP16H7R
XFILLER_42_371 VDD VSS FILLCAP4H7R
XFILLER_42_377 VDD VSS FILLER1H7R
XFILLER_43_0 VDD VSS FILLER64H7R
XFILLER_43_64 VDD VSS FILLER64H7R
XFILLER_43_128 VDD VSS FILLCAP16H7R
XFILLER_43_144 VDD VSS FILLCAP4H7R
XFILLER_43_148 VDD VSS FILLER2H7R
XFILLER_43_152 VDD VSS FILLER64H7R
XFILLER_43_216 VDD VSS FILLER64H7R
XFILLER_43_280 VDD VSS FILLCAP16H7R
XFILLER_43_296 VDD VSS FILLCAP4H7R
XFILLER_43_302 VDD VSS FILLER64H7R
XFILLER_43_366 VDD VSS FILLCAP8H7R
XFILLER_43_374 VDD VSS FILLCAP4H7R
XFILLER_44_0 VDD VSS FILLER64H7R
XFILLER_44_64 VDD VSS FILLCAP8H7R
XFILLER_44_72 VDD VSS FILLER2H7R
XFILLER_44_74 VDD VSS FILLER1H7R
XFILLER_44_77 VDD VSS FILLER64H7R
XFILLER_44_141 VDD VSS FILLER64H7R
XFILLER_44_205 VDD VSS FILLCAP16H7R
XFILLER_44_221 VDD VSS FILLCAP4H7R
XFILLER_44_227 VDD VSS FILLER64H7R
XFILLER_44_291 VDD VSS FILLER64H7R
XFILLER_44_355 VDD VSS FILLCAP16H7R
XFILLER_44_371 VDD VSS FILLCAP4H7R
XFILLER_44_377 VDD VSS FILLER1H7R
XFILLER_45_0 VDD VSS FILLER64H7R
XFILLER_45_64 VDD VSS FILLER64H7R
XFILLER_45_128 VDD VSS FILLCAP16H7R
XFILLER_45_144 VDD VSS FILLCAP4H7R
XFILLER_45_148 VDD VSS FILLER2H7R
XFILLER_45_152 VDD VSS FILLER64H7R
XFILLER_45_216 VDD VSS FILLER64H7R
XFILLER_45_280 VDD VSS FILLCAP16H7R
XFILLER_45_296 VDD VSS FILLCAP4H7R
XFILLER_45_302 VDD VSS FILLER64H7R
XFILLER_45_366 VDD VSS FILLCAP8H7R
XFILLER_45_374 VDD VSS FILLCAP4H7R
XFILLER_46_0 VDD VSS FILLER64H7R
XFILLER_46_64 VDD VSS FILLCAP8H7R
XFILLER_46_72 VDD VSS FILLER2H7R
XFILLER_46_74 VDD VSS FILLER1H7R
XFILLER_46_77 VDD VSS FILLER64H7R
XFILLER_46_141 VDD VSS FILLER64H7R
XFILLER_46_205 VDD VSS FILLCAP16H7R
XFILLER_46_221 VDD VSS FILLCAP4H7R
XFILLER_46_227 VDD VSS FILLER64H7R
XFILLER_46_291 VDD VSS FILLER64H7R
XFILLER_46_355 VDD VSS FILLCAP16H7R
XFILLER_46_371 VDD VSS FILLCAP4H7R
XFILLER_46_377 VDD VSS FILLER1H7R
XFILLER_47_0 VDD VSS FILLER64H7R
XFILLER_47_64 VDD VSS FILLER64H7R
XFILLER_47_128 VDD VSS FILLCAP16H7R
XFILLER_47_144 VDD VSS FILLCAP4H7R
XFILLER_47_148 VDD VSS FILLER2H7R
XFILLER_47_152 VDD VSS FILLER64H7R
XFILLER_47_216 VDD VSS FILLER64H7R
XFILLER_47_280 VDD VSS FILLCAP16H7R
XFILLER_47_296 VDD VSS FILLCAP4H7R
XFILLER_47_302 VDD VSS FILLER64H7R
XFILLER_47_366 VDD VSS FILLCAP8H7R
XFILLER_47_374 VDD VSS FILLCAP4H7R
XFILLER_48_0 VDD VSS FILLER64H7R
XFILLER_48_64 VDD VSS FILLCAP8H7R
XFILLER_48_72 VDD VSS FILLER2H7R
XFILLER_48_74 VDD VSS FILLER1H7R
XFILLER_48_77 VDD VSS FILLER64H7R
XFILLER_48_141 VDD VSS FILLER64H7R
XFILLER_48_205 VDD VSS FILLCAP16H7R
XFILLER_48_221 VDD VSS FILLCAP4H7R
XFILLER_48_227 VDD VSS FILLER64H7R
XFILLER_48_291 VDD VSS FILLER64H7R
XFILLER_48_355 VDD VSS FILLCAP16H7R
XFILLER_48_371 VDD VSS FILLCAP4H7R
XFILLER_48_377 VDD VSS FILLER1H7R
XFILLER_49_0 VDD VSS FILLER64H7R
XFILLER_49_64 VDD VSS FILLER64H7R
XFILLER_49_128 VDD VSS FILLCAP16H7R
XFILLER_49_144 VDD VSS FILLCAP4H7R
XFILLER_49_148 VDD VSS FILLER2H7R
XFILLER_49_152 VDD VSS FILLER64H7R
XFILLER_49_216 VDD VSS FILLER64H7R
XFILLER_49_280 VDD VSS FILLCAP16H7R
XFILLER_49_296 VDD VSS FILLCAP4H7R
XFILLER_49_302 VDD VSS FILLER64H7R
XFILLER_49_366 VDD VSS FILLCAP8H7R
XFILLER_49_374 VDD VSS FILLCAP4H7R
XFILLER_50_0 VDD VSS FILLER64H7R
XFILLER_50_64 VDD VSS FILLCAP8H7R
XFILLER_50_72 VDD VSS FILLER2H7R
XFILLER_50_74 VDD VSS FILLER1H7R
XFILLER_50_77 VDD VSS FILLER64H7R
XFILLER_50_141 VDD VSS FILLER64H7R
XFILLER_50_205 VDD VSS FILLCAP16H7R
XFILLER_50_221 VDD VSS FILLCAP4H7R
XFILLER_50_227 VDD VSS FILLER64H7R
XFILLER_50_291 VDD VSS FILLER64H7R
XFILLER_50_355 VDD VSS FILLCAP16H7R
XFILLER_50_371 VDD VSS FILLCAP4H7R
XFILLER_50_377 VDD VSS FILLER1H7R
XFILLER_51_0 VDD VSS FILLER64H7R
XFILLER_51_64 VDD VSS FILLER64H7R
XFILLER_51_128 VDD VSS FILLCAP16H7R
XFILLER_51_144 VDD VSS FILLCAP4H7R
XFILLER_51_148 VDD VSS FILLER2H7R
XFILLER_51_152 VDD VSS FILLER64H7R
XFILLER_51_216 VDD VSS FILLER64H7R
XFILLER_51_280 VDD VSS FILLCAP16H7R
XFILLER_51_296 VDD VSS FILLCAP4H7R
XFILLER_51_302 VDD VSS FILLER64H7R
XFILLER_51_366 VDD VSS FILLCAP8H7R
XFILLER_51_374 VDD VSS FILLCAP4H7R
XFILLER_52_0 VDD VSS FILLER64H7R
XFILLER_52_64 VDD VSS FILLCAP8H7R
XFILLER_52_72 VDD VSS FILLER2H7R
XFILLER_52_76 VDD VSS FILLER64H7R
XFILLER_52_140 VDD VSS FILLCAP8H7R
XFILLER_52_150 VDD VSS FILLER64H7R
XFILLER_52_214 VDD VSS FILLCAP8H7R
XFILLER_52_224 VDD VSS FILLER64H7R
XFILLER_52_288 VDD VSS FILLCAP8H7R
XFILLER_52_298 VDD VSS FILLER64H7R
XFILLER_52_362 VDD VSS FILLCAP8H7R
XFILLER_52_372 VDD VSS FILLCAP4H7R
XFILLER_52_376 VDD VSS FILLER2H7R
.ENDS PLL_RING_DCO_PHYS
