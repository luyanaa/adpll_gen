************************************************************************
*
* Copyright 2023 IHP PDK Authors
*
* Licensed under the Apache License, Version 2.0 (the "License");
* you may not use this file except in compliance with the License.
* You may obtain a copy of the License at
*
*    https://www.apache.org/licenses/LICENSE-2.0
*
* Unless required by applicable law or agreed to in writing, software
* distributed under the License is distributed on an "AS IS" BASIS,
* WITHOUT WARRANTIES OR CONDITIONS OF ANY KIND, either express or implied.
* See the License for the specific language governing permissions and
* limitations under the License.
*
************************************************************************

************************************************************************
* Library Name: sg13g2_stdcell
* Cell Name:    sg13g2_a21o_1
* View Name:    schematic
************************************************************************

.SUBCKT sg13g2_a21o_1 X A1 A2 B1 VDD VSS
*.PININFO A1:I A2:I B1:I X:O VDD:B VSS:B
MN0 net1 A1 net2 VSS sg13_lv_nmos m=1 w=640.00n l=130.00n ng=1
MN1 net2 A2 VSS VSS sg13_lv_nmos m=1 w=640.00n l=130.00n ng=1
MN2 net1 B1 VSS VSS sg13_lv_nmos m=1 w=640.00n l=130.00n ng=1
MN3 X net1 VSS VSS sg13_lv_nmos m=1 w=740.00n l=130.00n ng=1
MP2 net1 B1 net3 VDD sg13_lv_pmos m=1 w=1.000u l=130.00n ng=1
MP0 net3 A1 VDD VDD sg13_lv_pmos m=1 w=1.000u l=130.00n ng=1
MP1 net3 A2 VDD VDD sg13_lv_pmos m=1 w=1.000u l=130.00n ng=1
MP3 X net1 VDD VDD sg13_lv_pmos m=1 w=1.12u l=130.00n ng=1
.ENDS

************************************************************************
* Library Name: sg13g2_stdcell
* Cell Name:    sg13g2_a21o_2
* View Name:    schematic
************************************************************************

.SUBCKT sg13g2_a21o_2 X A1 A2 B1 VDD VSS
*.PININFO A1:I A2:I B1:I X:O VDD:B VSS:B
MN0 net1 A1 net2 VSS sg13_lv_nmos m=1 w=740.00n l=130.00n ng=1
MN1 net2 A2 VSS VSS sg13_lv_nmos m=1 w=740.00n l=130.00n ng=1
MN2 net1 B1 VSS VSS sg13_lv_nmos m=1 w=740.00n l=130.00n ng=1
MN3 X net1 VSS VSS sg13_lv_nmos m=1 w=1.48u l=130.00n ng=2
MP2 net1 B1 net3 VDD sg13_lv_pmos m=1 w=1.000u l=130.00n ng=1
MP0 net3 A1 VDD VDD sg13_lv_pmos m=1 w=1.000u l=130.00n ng=1
MP1 net3 A2 VDD VDD sg13_lv_pmos m=1 w=1.000u l=130.00n ng=1
MP3 X net1 VDD VDD sg13_lv_pmos m=1 w=2.24u l=130.00n ng=2
.ENDS

************************************************************************
* Library Name: sg13g2_stdcell
* Cell Name:    sg13g2_a21oi_1
* View Name:    schematic
************************************************************************

.SUBCKT sg13g2_a21oi_1 Y A1 A2 B1 VDD VSS
*.PININFO A1:I A2:I B1:I Y:O VDD:B VSS:B
MN0 Y B1 VSS VSS sg13_lv_nmos m=1 w=740.00n l=130.00n ng=1
MN2 net1 A2 VSS VSS sg13_lv_nmos m=1 w=740.00n l=130.00n ng=1
MN1 Y A1 net1 VSS sg13_lv_nmos m=1 w=740.00n l=130.00n ng=1
MP2 Y B1 net2 VDD sg13_lv_pmos m=1 w=1.12u l=130.00n ng=1
MP1 net2 A2 VDD VDD sg13_lv_pmos m=1 w=1.12u l=130.00n ng=1
MP0 net2 A1 VDD VDD sg13_lv_pmos m=1 w=1.12u l=130.00n ng=1
.ENDS

************************************************************************
* Library Name: sg13g2_stdcell
* Cell Name:    sg13g2_a21oi_2
* View Name:    schematic
************************************************************************

.SUBCKT sg13g2_a21oi_2 Y A1 A2 B1 VDD VSS
*.PININFO A1:I A2:I B1:I Y:O VDD:B VSS:B
MN0 Y B1 VSS VSS sg13_lv_nmos m=1 w=1.48u l=130.00n ng=2
MN2 net2 A2 VSS VSS sg13_lv_nmos m=1 w=1.48u l=130.00n ng=2
MN1 Y A1 net2 VSS sg13_lv_nmos m=1 w=1.48u l=130.00n ng=2
MP2 Y B1 net1 VDD sg13_lv_pmos m=1 w=2.24u l=130.00n ng=2
MP1 net1 A2 VDD VDD sg13_lv_pmos m=1 w=2.24u l=130.00n ng=2
MP0 net1 A1 VDD VDD sg13_lv_pmos m=1 w=2.24u l=130.00n ng=2
.ENDS

************************************************************************
* Library Name: sg13g2_stdcell
* Cell Name:    sg13g2_a221oi_1
* View Name:    schematic
************************************************************************

.SUBCKT sg13g2_a221oi_1 Y A1 A2 B1 B2 C1 VDD VSS
*.PININFO A1:I A2:I B1:I B2:I C1:I Y:O VDD:B VSS:B
MP2 Y C1 net3 VDD sg13_lv_pmos m=1 w=1.12u l=130.00n ng=1
MP4 net3 B2 net1 VDD sg13_lv_pmos m=1 w=1.12u l=130.00n ng=1
MP1 net3 B1 net1 VDD sg13_lv_pmos m=1 w=1.12u l=130.00n ng=1
MP3 net1 A2 VDD VDD sg13_lv_pmos m=1 w=1.12u l=130.00n ng=1
MP0 net1 A1 VDD VDD sg13_lv_pmos m=1 w=1.12u l=130.00n ng=1
MN4 Y C1 VSS VSS sg13_lv_nmos m=1 w=740.00n l=130.00n ng=1
MN3 net4 B2 VSS VSS sg13_lv_nmos m=1 w=740.00n l=130.00n ng=1
MN2 Y B1 net4 VSS sg13_lv_nmos m=1 w=740.00n l=130.00n ng=1
MN1 net2 A2 VSS VSS sg13_lv_nmos m=1 w=740.00n l=130.00n ng=1
MN0 Y A1 net2 VSS sg13_lv_nmos m=1 w=740.00n l=130.00n ng=1
.ENDS

************************************************************************
* Library Name: sg13g2_stdcell
* Cell Name:    sg13g2_and2_1
* View Name:    schematic
************************************************************************

.SUBCKT sg13g2_and2_1 X A B VDD VSS
*.PININFO A:I B:I X:O VDD:B VSS:B
MN0 net4 A net2 VSS sg13_lv_nmos m=1 w=640.00n l=130.00n ng=1
MN2 X net4 VSS VSS sg13_lv_nmos m=1 w=740.00n l=130.00n ng=1
MN1 net2 B VSS VSS sg13_lv_nmos m=1 w=640.00n l=130.00n ng=1
MP0 net4 B VDD VDD sg13_lv_pmos m=1 w=840.00n l=130.00n ng=1
MP2 X net4 VDD VDD sg13_lv_pmos m=1 w=1.12u l=130.00n ng=1
MP1 net4 A VDD VDD sg13_lv_pmos m=1 w=840.00n l=130.00n ng=1
.ENDS

************************************************************************
* Library Name: sg13g2_stdcell
* Cell Name:    sg13g2_and2_2
* View Name:    schematic
************************************************************************

.SUBCKT sg13g2_and2_2 X A B VDD VSS
*.PININFO A:I B:I X:O VDD:B VSS:B
MN0 net1 A net2 VSS sg13_lv_nmos m=1 w=640.00n l=130.00n ng=1
MN2 X net1 VSS VSS sg13_lv_nmos m=1 w=1.48u l=130.00n ng=2
MN1 net2 B VSS VSS sg13_lv_nmos m=1 w=640.00n l=130.00n ng=1
MP0 net1 B VDD VDD sg13_lv_pmos m=1 w=840.00n l=130.00n ng=1
MP2 X net1 VDD VDD sg13_lv_pmos m=1 w=2.24u l=130.00n ng=2
MP1 net1 A VDD VDD sg13_lv_pmos m=1 w=840.00n l=130.00n ng=1
.ENDS

************************************************************************
* Library Name: sg13g2_stdcell
* Cell Name:    sg13g2_and3_1
* View Name:    schematic
************************************************************************

.SUBCKT sg13g2_and3_1 X A B C VDD VSS
*.PININFO A:I B:I C:I X:O VDD:B VSS:B
MN2 net3 C VSS VSS sg13_lv_nmos m=1 w=640.00n l=130.00n ng=1
MN3 X net2 VSS VSS sg13_lv_nmos m=1 w=740.00n l=130.00n ng=1
MN0 net2 A net1 VSS sg13_lv_nmos m=1 w=640.00n l=130.00n ng=1
MN1 net1 B net3 VSS sg13_lv_nmos m=1 w=640.00n l=130.00n ng=1
MP3 X net2 VDD VDD sg13_lv_pmos m=1 w=1.12u l=130.00n ng=1
MP1 net2 B VDD VDD sg13_lv_pmos m=1 w=840.00n l=130.00n ng=1
MP2 net2 A VDD VDD sg13_lv_pmos m=1 w=840.00n l=130.00n ng=1
MP0 net2 C VDD VDD sg13_lv_pmos m=1 w=840.00n l=130.00n ng=1
.ENDS

************************************************************************
* Library Name: sg13g2_stdcell
* Cell Name:    sg13g2_and3_2
* View Name:    schematic
************************************************************************

.SUBCKT sg13g2_and3_2 X A B C VDD VSS
*.PININFO A:I B:I C:I X:O VDD:B VSS:B
MN2 net3 C VSS VSS sg13_lv_nmos m=1 w=640.00n l=130.00n ng=1
MN3 X net2 VSS VSS sg13_lv_nmos m=1 w=1.48u l=130.00n ng=2
MN0 net2 A net1 VSS sg13_lv_nmos m=1 w=640.00n l=130.00n ng=1
MN1 net1 B net3 VSS sg13_lv_nmos m=1 w=640.00n l=130.00n ng=1
MP3 X net2 VDD VDD sg13_lv_pmos m=1 w=2.24u l=130.00n ng=2
MP1 net2 B VDD VDD sg13_lv_pmos m=1 w=840.00n l=130.00n ng=1
MP2 net2 A VDD VDD sg13_lv_pmos m=1 w=840.00n l=130.00n ng=1
MP0 net2 C VDD VDD sg13_lv_pmos m=1 w=840.00n l=130.00n ng=1
.ENDS

************************************************************************
* Library Name: sg13g2_stdcell
* Cell Name:    sg13g2_and4_1
* View Name:    schematic
************************************************************************

.SUBCKT sg13g2_and4_1 X A B C D VDD VSS
*.PININFO A:I B:I C:I D:I X:O VDD:B VSS:B
MN3 net17 D VSS VSS sg13_lv_nmos m=1 w=640.00n l=130.00n ng=1
MN2 net16 C net17 VSS sg13_lv_nmos m=1 w=640.00n l=130.00n ng=1
MN1 net15 B net16 VSS sg13_lv_nmos m=1 w=640.00n l=130.00n ng=1
MN0 net1 A net15 VSS sg13_lv_nmos m=1 w=640.00n l=130.00n ng=1
MN4 X net1 VSS VSS sg13_lv_nmos m=1 w=740.00n l=130.00n ng=1
MP3 net1 A VDD VDD sg13_lv_pmos m=1 w=840.00n l=130.00n ng=1
MP4 X net1 VDD VDD sg13_lv_pmos m=1 w=1.12u l=130.00n ng=1
MP0 net1 D VDD VDD sg13_lv_pmos m=1 w=840.00n l=130.00n ng=1
MP1 net1 C VDD VDD sg13_lv_pmos m=1 w=840.00n l=130.00n ng=1
MP2 net1 B VDD VDD sg13_lv_pmos m=1 w=840.00n l=130.00n ng=1
.ENDS

************************************************************************
* Library Name: sg13g2_stdcell
* Cell Name:    sg13g2_and4_2
* View Name:    schematic
************************************************************************

.SUBCKT sg13g2_and4_2 X A B C D VDD VSS
*.PININFO A:I B:I C:I D:I X:O VDD:B VSS:B
MN3 net17 D VSS VSS sg13_lv_nmos m=1 w=640.00n l=130.00n ng=1
MN2 net16 C net17 VSS sg13_lv_nmos m=1 w=640.00n l=130.00n ng=1
MN1 net15 B net16 VSS sg13_lv_nmos m=1 w=640.00n l=130.00n ng=1
MN0 net1 A net15 VSS sg13_lv_nmos m=1 w=640.00n l=130.00n ng=1
MN4 X net1 VSS VSS sg13_lv_nmos m=1 w=1.48u l=130.00n ng=2
MP3 net1 A VDD VDD sg13_lv_pmos m=1 w=840.00n l=130.00n ng=1
MP4 X net1 VDD VDD sg13_lv_pmos m=1 w=2.24u l=130.00n ng=2
MP0 net1 D VDD VDD sg13_lv_pmos m=1 w=840.00n l=130.00n ng=1
MP1 net1 C VDD VDD sg13_lv_pmos m=1 w=840.00n l=130.00n ng=1
MP2 net1 B VDD VDD sg13_lv_pmos m=1 w=840.00n l=130.00n ng=1
.ENDS

************************************************************************
* Library Name: sg13g2_stdcell
* Cell Name:    sg13g2_antennanp
* View Name:    schematic
************************************************************************

.SUBCKT sg13g2_antennanp A VDD VSS
*.PININFO A:I VDD:B VSS:B
DD1 VSS A dantenna m=1 w=780n l=780n a=608.4f p=3.12u
DD0 A VDD dpantenna m=1 w=1.05u l=1.34u a=1.407p p=4.78u
.ENDS

************************************************************************
* Library Name: sg13g2_stdcell
* Cell Name:    sg13g2_buf_1
* View Name:    schematic
************************************************************************

.SUBCKT sg13g2_buf_1 X A VDD VSS
*.PININFO A:I X:O VDD:B VSS:B
MN0 net1 A VSS VSS sg13_lv_nmos m=1 w=550.00n l=130.00n ng=1
MN1 X net1 VSS VSS sg13_lv_nmos m=1 w=740.00n l=130.00n ng=1
MP1 X net1 VDD VDD sg13_lv_pmos m=1 w=1.12u l=130.00n ng=1
MP0 net1 A VDD VDD sg13_lv_pmos m=1 w=840.00n l=130.00n ng=1
.ENDS

************************************************************************
* Library Name: sg13g2_stdcell
* Cell Name:    sg13g2_buf_16
* View Name:    schematic
************************************************************************

.SUBCKT sg13g2_buf_16 X A VDD VSS
*.PININFO A:I X:O VDD:B VSS:B
MN0 net1 A VSS VSS sg13_lv_nmos m=1 w=4.44u l=130.00n ng=6
MN1 X net1 VSS VSS sg13_lv_nmos m=1 w=11.84u l=130.00n ng=16
MP1 X net1 VDD VDD sg13_lv_pmos m=1 w=17.92u l=130.00n ng=16
MP0 net1 A VDD VDD sg13_lv_pmos m=1 w=6.72u l=130.00n ng=6
.ENDS

************************************************************************
* Library Name: sg13g2_stdcell
* Cell Name:    sg13g2_buf_2
* View Name:    schematic
************************************************************************

.SUBCKT sg13g2_buf_2 X A VDD VSS
*.PININFO A:I X:O VDD:B VSS:B
MN0 net1 A VSS VSS sg13_lv_nmos m=1 w=640.00n l=130.00n ng=1
MN1 X net1 VSS VSS sg13_lv_nmos m=1 w=1.48u l=130.00n ng=2
MP1 X net1 VDD VDD sg13_lv_pmos m=1 w=2.24u l=130.00n ng=2
MP0 net1 A VDD VDD sg13_lv_pmos m=1 w=1.000u l=130.00n ng=1
.ENDS

************************************************************************
* Library Name: sg13g2_stdcell
* Cell Name:    sg13g2_buf_4
* View Name:    schematic
************************************************************************

.SUBCKT sg13g2_buf_4 X A VDD VSS
*.PININFO A:I X:O VDD:B VSS:B
MN0 net1 A VSS VSS sg13_lv_nmos m=1 w=740.00n l=130.00n ng=1
MN1 X net1 VSS VSS sg13_lv_nmos m=1 w=2.96u l=130.00n ng=4
MP1 X net1 VDD VDD sg13_lv_pmos m=1 w=4.48u l=130.00n ng=4
MP0 net1 A VDD VDD sg13_lv_pmos m=1 w=1.68u l=130.00n ng=2
.ENDS

************************************************************************
* Library Name: sg13g2_stdcell
* Cell Name:    sg13g2_buf_8
* View Name:    schematic
************************************************************************

.SUBCKT sg13g2_buf_8 X A VDD VSS
*.PININFO A:I X:O VDD:B VSS:B
MN0 net1 A VSS VSS sg13_lv_nmos m=1 w=2.22u l=130.00n ng=3
MN1 X net1 VSS VSS sg13_lv_nmos m=1 w=5.92u l=130.00n ng=8
MP1 X net1 VDD VDD sg13_lv_pmos m=1 w=8.96u l=130.00n ng=8
MP0 net1 A VDD VDD sg13_lv_pmos m=1 w=3.36u l=130.00n ng=3
.ENDS

************************************************************************
* Library Name: sg13g2_stdcell
* Cell Name:    sg13g2_decap_4
* View Name:    schematic
************************************************************************

.SUBCKT sg13g2_decap_4 VDD VSS
*.PININFO VDD:B VSS:B
MN0 VSS VDD VSS VSS sg13_lv_nmos m=1 w=420.00n l=1.000u ng=1
MP0 VDD VSS VDD VDD sg13_lv_pmos m=1 w=1.000u l=1.000u ng=1
.ENDS

************************************************************************
* Library Name: sg13g2_stdcell
* Cell Name:    sg13g2_decap_8
* View Name:    schematic
************************************************************************

.SUBCKT sg13g2_decap_8 VDD VSS
*.PININFO VDD:B VSS:B
MN0 VSS VDD VSS VSS sg13_lv_nmos m=1 w=840.00n l=1.000u ng=2
MP0 VDD VSS VDD VDD sg13_lv_pmos m=1 w=2.000u l=1.000u ng=2
.ENDS

************************************************************************
* Library Name: sg13g2_stdcell
* Cell Name:    sg13g2_dfrbp_1
* View Name:    schematic
************************************************************************

.SUBCKT sg13g2_dfrbp_1 Q Q_N CLK D RESET_B VDD VSS
*.PININFO CLK:I D:I RESET_B:I Q:O Q_N:O VDD:B VSS:B
MN11 net12 net2 VSS VSS sg13_lv_nmos m=1 w=420.00n l=130.00n ng=1
MN10 net5 clkneg net12 VSS sg13_lv_nmos m=1 w=420.00n l=130.00n ng=1
MN12 net2 net5 net11 VSS sg13_lv_nmos m=1 w=420.00n l=130.00n ng=1
MN13 net11 RESET_B VSS VSS sg13_lv_nmos m=1 w=420.00n l=130.00n ng=1
MN14 Q_N net5 VSS VSS sg13_lv_nmos m=1 w=740.00n l=130.00n ng=1
MN0 Db D net10 VSS sg13_lv_nmos m=1 w=420.00n l=130.00n ng=1
MN1 net10 RESET_B VSS VSS sg13_lv_nmos m=1 w=420.00n l=130.00n ng=1
MN4 Db clkneg net6 VSS sg13_lv_nmos m=1 w=420.00n l=130.00n ng=1
MN5 net6 clkpos net9 VSS sg13_lv_nmos m=1 w=420.00n l=130.00n ng=1
MN6 net9 net4 net8 VSS sg13_lv_nmos m=1 w=420.00n l=130.00n ng=1
MN7 net8 RESET_B VSS VSS sg13_lv_nmos m=1 w=420.00n l=130.00n ng=1
MN8 net4 net6 VSS VSS sg13_lv_nmos m=1 w=740.00n l=130.00n ng=1
MN2 clkneg CLK VSS VSS sg13_lv_nmos m=1 w=740.00n l=130.00n ng=1
MN9 net4 clkpos net5 VSS sg13_lv_nmos m=1 w=740.00n l=130.00n ng=1
MN3 clkpos clkneg VSS VSS sg13_lv_nmos m=1 w=740.00n l=130.00n ng=1
MN16 Q net1 VSS VSS sg13_lv_nmos m=1 w=740.00n l=130.00n ng=1
MN15 net1 net5 VSS VSS sg13_lv_nmos m=1 w=740.00n l=130.00n ng=1
MP11 net5 clkpos net3 VDD sg13_lv_pmos m=1 w=420.00n l=130.00n ng=1
MP12 net2 net5 VDD VDD sg13_lv_pmos m=1 w=420.00n l=130.00n ng=1
MP13 net2 RESET_B VDD VDD sg13_lv_pmos m=1 w=420.00n l=130.00n ng=1
MP14 Q_N net5 VDD VDD sg13_lv_pmos m=1 w=1.12u l=130.00n ng=1
MP4 Db clkpos net6 VDD sg13_lv_pmos m=1 w=420.00n l=130.00n ng=1
MP0 Db RESET_B VDD VDD sg13_lv_pmos m=1 w=420.00n l=130.00n ng=1
MP1 Db D VDD VDD sg13_lv_pmos m=1 w=420.00n l=130.00n ng=1
MP5 net7 net4 VDD VDD sg13_lv_pmos m=1 w=420.00n l=130.00n ng=1
MP6 net6 clkneg net7 VDD sg13_lv_pmos m=1 w=420.00n l=130.00n ng=1
MP7 net6 RESET_B VDD VDD sg13_lv_pmos m=1 w=420.00n l=130.00n ng=1
MP2 clkneg CLK VDD VDD sg13_lv_pmos m=1 w=1.12u l=130.00n ng=1
MP3 clkpos clkneg VDD VDD sg13_lv_pmos m=1 w=1.12u l=130.00n ng=1
MP8 net4 net6 VDD VDD sg13_lv_pmos m=1 w=1.000u l=130.00n ng=1
MP9 net4 clkneg net5 VDD sg13_lv_pmos m=1 w=1.000u l=130.00n ng=1
MP16 Q net1 VDD VDD sg13_lv_pmos m=1 w=1.12u l=130.00n ng=1
MP10 net3 net2 VDD VDD sg13_lv_pmos m=1 w=420.00n l=130.00n ng=1
MP15 net1 net5 VDD VDD sg13_lv_pmos m=1 w=1.12u l=130.00n ng=1
.ENDS

************************************************************************
* Library Name: sg13g2_stdcell
* Cell Name:    sg13g2_dfrbp_2
* View Name:    schematic
************************************************************************

.SUBCKT sg13g2_dfrbp_2 Q Q_N CLK D RESET_B VDD VSS
*.PININFO CLK:I D:I RESET_B:I Q:O Q_N:O VDD:B VSS:B
MN11 net12 net2 VSS VSS sg13_lv_nmos m=1 w=420.00n l=130.00n ng=1
MN10 net5 clkneg net12 VSS sg13_lv_nmos m=1 w=420.00n l=130.00n ng=1
MN12 net2 net5 net11 VSS sg13_lv_nmos m=1 w=420.00n l=130.00n ng=1
MN13 net11 RESET_B VSS VSS sg13_lv_nmos m=1 w=420.00n l=130.00n ng=1
MN14 Q_N net5 VSS VSS sg13_lv_nmos m=1 w=1.48u l=130.00n ng=2
MN0 Db D net10 VSS sg13_lv_nmos m=1 w=420.00n l=130.00n ng=1
MN1 net10 RESET_B VSS VSS sg13_lv_nmos m=1 w=420.00n l=130.00n ng=1
MN4 Db clkneg net6 VSS sg13_lv_nmos m=1 w=420.00n l=130.00n ng=1
MN5 net6 clkpos net9 VSS sg13_lv_nmos m=1 w=420.00n l=130.00n ng=1
MN6 net9 net4 net8 VSS sg13_lv_nmos m=1 w=420.00n l=130.00n ng=1
MN7 net8 RESET_B VSS VSS sg13_lv_nmos m=1 w=420.00n l=130.00n ng=1
MN8 net4 net6 VSS VSS sg13_lv_nmos m=1 w=740.00n l=130.00n ng=1
MN2 clkneg CLK VSS VSS sg13_lv_nmos m=1 w=740.00n l=130.00n ng=1
MN9 net4 clkpos net5 VSS sg13_lv_nmos m=1 w=740.00n l=130.00n ng=1
MN3 clkpos clkneg VSS VSS sg13_lv_nmos m=1 w=740.00n l=130.00n ng=1
MN16 Q net1 VSS VSS sg13_lv_nmos m=1 w=1.48u l=130.00n ng=2
MN15 net1 net5 VSS VSS sg13_lv_nmos m=1 w=640.00n l=130.00n ng=1
MP11 net5 clkpos net3 VDD sg13_lv_pmos m=1 w=420.00n l=130.00n ng=1
MP12 net2 net5 VDD VDD sg13_lv_pmos m=1 w=420.00n l=130.00n ng=1
MP13 net2 RESET_B VDD VDD sg13_lv_pmos m=1 w=420.00n l=130.00n ng=1
MP14 Q_N net5 VDD VDD sg13_lv_pmos m=1 w=2.24u l=130.00n ng=2
MP4 Db clkpos net6 VDD sg13_lv_pmos m=1 w=420.00n l=130.00n ng=1
MP0 Db RESET_B VDD VDD sg13_lv_pmos m=1 w=420.00n l=130.00n ng=1
MP1 Db D VDD VDD sg13_lv_pmos m=1 w=420.00n l=130.00n ng=1
MP5 net7 net4 VDD VDD sg13_lv_pmos m=1 w=420.00n l=130.00n ng=1
MP6 net6 clkneg net7 VDD sg13_lv_pmos m=1 w=420.00n l=130.00n ng=1
MP7 net6 RESET_B VDD VDD sg13_lv_pmos m=1 w=420.00n l=130.00n ng=1
MP2 clkneg CLK VDD VDD sg13_lv_pmos m=1 w=1.12u l=130.00n ng=1
MP3 clkpos clkneg VDD VDD sg13_lv_pmos m=1 w=1.12u l=130.00n ng=1
MP8 net4 net6 VDD VDD sg13_lv_pmos m=1 w=1.000u l=130.00n ng=1
MP9 net4 clkneg net5 VDD sg13_lv_pmos m=1 w=1.000u l=130.00n ng=1
MP16 Q net1 VDD VDD sg13_lv_pmos m=1 w=2.24u l=130.00n ng=2
MP10 net3 net2 VDD VDD sg13_lv_pmos m=1 w=420.00n l=130.00n ng=1
MP15 net1 net5 VDD VDD sg13_lv_pmos m=1 w=1.000u l=130.00n ng=1
.ENDS

************************************************************************
* Library Name: sg13g2_stdcell
* Cell Name:    sg13g2_dlhq_1
* View Name:    schematic
************************************************************************

.SUBCKT sg13g2_dlhq_1 Q D GATE VDD VSS
*.PININFO D:I GATE:I Q:O VDD:B VSS:B
MP8 Q qint_b VDD VDD sg13_lv_pmos m=1 w=1.12u l=130.00n ng=1
MP6 qint GATE_BB net8 VDD sg13_lv_pmos m=1 w=420.00n l=130.00n ng=1
MP7 qint_b qint VDD VDD sg13_lv_pmos m=1 w=1.12u l=130.00n ng=1
MP2 Db D VDD VDD sg13_lv_pmos m=1 w=840.00n l=130.00n ng=1
MP0 GATE_B GATE VDD VDD sg13_lv_pmos m=1 w=840.00n l=130.00n ng=1
MP1 GATE_BB GATE_B VDD VDD sg13_lv_pmos m=1 w=840.00n l=130.00n ng=1
MP5 net8 qint_b VDD VDD sg13_lv_pmos m=1 w=420.00n l=130.00n ng=1
MP4 net4 GATE_B qint VDD sg13_lv_pmos m=1 w=1.000u l=130.00n ng=1
MP3 net4 Db VDD VDD sg13_lv_pmos m=1 w=1.000u l=130.00n ng=1
MN0 GATE_B GATE VSS VSS sg13_lv_nmos m=1 w=740.00n l=130.00n ng=1
MN1 GATE_BB GATE_B VSS VSS sg13_lv_nmos m=1 w=740.00n l=130.00n ng=1
MN5 qint GATE_B net9 VSS sg13_lv_nmos m=1 w=420.00n l=130.00n ng=1
MN8 Q qint_b VSS VSS sg13_lv_nmos m=1 w=740.00n l=130.00n ng=1
MN4 net7 Db VSS VSS sg13_lv_nmos m=1 w=740.00n l=130.00n ng=1
MN6 net9 qint_b VSS VSS sg13_lv_nmos m=1 w=420.00n l=130.00n ng=1
MN7 qint_b qint VSS VSS sg13_lv_nmos m=1 w=740.00n l=130.00n ng=1
MN3 qint GATE_BB net7 VSS sg13_lv_nmos m=1 w=740.00n l=130.00n ng=1
MN2 Db D VSS VSS sg13_lv_nmos m=1 w=550.00n l=130.00n ng=1
.ENDS

************************************************************************
* Library Name: sg13g2_stdcell
* Cell Name:    sg13g2_dlhr_1
* View Name:    schematic
************************************************************************

.SUBCKT sg13g2_dlhr_1 Q Q_N D GATE RESET_B VDD VSS
*.PININFO D:I GATE:I RESET_B:I Q:O Q_N:O VDD:B VSS:B
MP8 qint_b RESET_B VDD VDD sg13_lv_pmos m=1 w=1.12u l=130.00n ng=1
MP9 Q qint_b VDD VDD sg13_lv_pmos m=1 w=1.12u l=130.00n ng=1
MP6 qint GATE_BB net11 VDD sg13_lv_pmos m=1 w=420.00n l=130.00n ng=1
MP5 net11 qint_b VDD VDD sg13_lv_pmos m=1 w=420.00n l=130.00n ng=1
MP4 qint GATE_B net2 VDD sg13_lv_pmos m=1 w=1.000u l=130.00n ng=1
MP3 net2 Db VDD VDD sg13_lv_pmos m=1 w=1.000u l=130.00n ng=1
MP2 Db D VDD VDD sg13_lv_pmos m=1 w=840.00n l=130.00n ng=1
MP0 GATE_B GATE VDD VDD sg13_lv_pmos m=1 w=840.00n l=130.00n ng=1
MP11 Q_N qintn_b VDD VDD sg13_lv_pmos m=1 w=1.12u l=130.00n ng=1
MP7 qint_b qint VDD VDD sg13_lv_pmos m=1 w=1.12u l=130.00n ng=1
MP1 GATE_BB GATE_B VDD VDD sg13_lv_pmos m=1 w=840.00n l=130.00n ng=1
MP10 qintn_b qint_b VDD VDD sg13_lv_pmos m=1 w=840.00n l=130.00n ng=1
MN7 qint_b qint net9 VSS sg13_lv_nmos m=1 w=740.00n l=130.00n ng=1
MN8 net9 RESET_B VSS VSS sg13_lv_nmos m=1 w=740.00n l=130.00n ng=1
MN5 qint GATE_B net7 VSS sg13_lv_nmos m=1 w=420.00n l=130.00n ng=1
MN6 net7 qint_b VSS VSS sg13_lv_nmos m=1 w=420.00n l=130.00n ng=1
MN9 Q qint_b VSS VSS sg13_lv_nmos m=1 w=740.00n l=130.00n ng=1
MN3 qint GATE_BB net1 VSS sg13_lv_nmos m=1 w=640.00n l=130.00n ng=1
MN4 net1 Db VSS VSS sg13_lv_nmos m=1 w=640.00n l=130.00n ng=1
MN2 Db D VSS VSS sg13_lv_nmos m=1 w=550.00n l=130.00n ng=1
MN0 GATE_B GATE VSS VSS sg13_lv_nmos m=1 w=740.00n l=130.00n ng=1
MN11 Q_N qintn_b VSS VSS sg13_lv_nmos m=1 w=740.00n l=130.00n ng=1
MN1 GATE_BB GATE_B VSS VSS sg13_lv_nmos m=1 w=740.00n l=130.00n ng=1
MN10 qintn_b qint_b VSS VSS sg13_lv_nmos m=1 w=550.00n l=130.00n ng=1
.ENDS

************************************************************************
* Library Name: sg13g2_stdcell
* Cell Name:    sg13g2_dlhrq_1
* View Name:    schematic
************************************************************************

.SUBCKT sg13g2_dlhrq_1 Q D GATE RESET_B VDD VSS
*.PININFO D:I GATE:I RESET_B:I Q:O VDD:B VSS:B
MN8 net116 RESET_B VSS VSS sg13_lv_nmos m=1 w=740.00n l=130.00n ng=1
MN9 Q qint_b VSS VSS sg13_lv_nmos m=1 w=740.00n l=130.00n ng=1
MN1 GATE_BB GATE_B VSS VSS sg13_lv_nmos m=1 w=740.00n l=130.00n ng=1
MN5 qint GATE_B net89 VSS sg13_lv_nmos m=1 w=420.00n l=130.00n ng=1
MN7 qint_b qint net116 VSS sg13_lv_nmos m=1 w=740.00n l=130.00n ng=1
MN2 Db D VSS VSS sg13_lv_nmos m=1 w=550.00n l=130.00n ng=1
MN4 net61 Db VSS VSS sg13_lv_nmos m=1 w=640.00n l=130.00n ng=1
MN3 qint GATE_BB net61 VSS sg13_lv_nmos m=1 w=640.00n l=130.00n ng=1
MN6 net89 qint_b VSS VSS sg13_lv_nmos m=1 w=420.00n l=130.00n ng=1
MN0 GATE_B GATE VSS VSS sg13_lv_nmos m=1 w=740.00n l=130.00n ng=1
MP3 net60 Db VDD VDD sg13_lv_pmos m=1 w=1.000u l=130.00n ng=1
MP8 qint_b RESET_B VDD VDD sg13_lv_pmos m=1 w=1.000u l=130.00n ng=1
MP6 qint GATE_BB net92 VDD sg13_lv_pmos m=1 w=420.00n l=130.00n ng=1
MP9 Q qint_b VDD VDD sg13_lv_pmos m=1 w=1.12u l=130.00n ng=1
MP5 net92 qint_b VDD VDD sg13_lv_pmos m=1 w=420.00n l=130.00n ng=1
MP0 GATE_B GATE VDD VDD sg13_lv_pmos m=1 w=840.00n l=130.00n ng=1
MP2 Db D VDD VDD sg13_lv_pmos m=1 w=840.00n l=130.00n ng=1
MP4 qint GATE_B net60 VDD sg13_lv_pmos m=1 w=1.000u l=130.00n ng=1
MP1 GATE_BB GATE_B VDD VDD sg13_lv_pmos m=1 w=840.00n l=130.00n ng=1
MP7 qint_b qint VDD VDD sg13_lv_pmos m=1 w=1.000u l=130.00n ng=1
.ENDS

************************************************************************
* Library Name: sg13g2_stdcell
* Cell Name:    sg13g2_dllr_1
* View Name:    schematic
************************************************************************

.SUBCKT sg13g2_dllr_1 Q Q_N D GATE_N RESET_B VDD VSS
*.PININFO D:I GATE_N:I RESET_B:I Q:O Q_N:O VDD:B VSS:B
MN2 Db D VSS VSS sg13_lv_nmos m=1 w=550.00n l=130.00n ng=1
MN0 gnb GATE_N VSS VSS sg13_lv_nmos m=1 w=740.00n l=130.00n ng=1
MN1 gnbb gnb VSS VSS sg13_lv_nmos m=1 w=740.00n l=130.00n ng=1
MN6 net89 qint_b VSS VSS sg13_lv_nmos m=1 w=420.00n l=130.00n ng=1
MN7 qint_b qint net116 VSS sg13_lv_nmos m=1 w=740.00n l=130.00n ng=1
MN8 net116 RESET_B VSS VSS sg13_lv_nmos m=1 w=740.00n l=130.00n ng=1
MN5 qint gnbb net89 VSS sg13_lv_nmos m=1 w=420.00n l=130.00n ng=1
MN11 Q_N qintn_b VSS VSS sg13_lv_nmos m=1 w=740.00n l=130.00n ng=1
MN3 qint gnb net61 VSS sg13_lv_nmos m=1 w=640.00n l=130.00n ng=1
MN10 qintn_b qint_b VSS VSS sg13_lv_nmos m=1 w=550.00n l=130.00n ng=1
MN4 net61 Db VSS VSS sg13_lv_nmos m=1 w=640.00n l=130.00n ng=1
MN9 Q qint_b VSS VSS sg13_lv_nmos m=1 w=740.00n l=130.00n ng=1
MP1 gnbb gnb VDD VDD sg13_lv_pmos m=1 w=840.00n l=130.00n ng=1
MP4 qint gnbb net60 VDD sg13_lv_pmos m=1 w=1.000u l=130.00n ng=1
MP10 qintn_b qint_b VDD VDD sg13_lv_pmos m=1 w=840.00n l=130.00n ng=1
MP11 Q_N qintn_b VDD VDD sg13_lv_pmos m=1 w=1.12u l=130.00n ng=1
MP3 net60 Db VDD VDD sg13_lv_pmos m=1 w=1.000u l=130.00n ng=1
MP5 net92 qint_b VDD VDD sg13_lv_pmos m=1 w=420.00n l=130.00n ng=1
MP8 qint_b RESET_B VDD VDD sg13_lv_pmos m=1 w=1.12u l=130.00n ng=1
MP2 Db D VDD VDD sg13_lv_pmos m=1 w=840.00n l=130.00n ng=1
MP0 gnb GATE_N VDD VDD sg13_lv_pmos m=1 w=840.00n l=130.00n ng=1
MP9 Q qint_b VDD VDD sg13_lv_pmos m=1 w=1.12u l=130.00n ng=1
MP6 qint gnb net92 VDD sg13_lv_pmos m=1 w=420.00n l=130.00n ng=1
MP7 qint_b qint VDD VDD sg13_lv_pmos m=1 w=1.12u l=130.00n ng=1
.ENDS

************************************************************************
* Library Name: sg13g2_stdcell
* Cell Name:    sg13g2_dllrq_1
* View Name:    schematic
************************************************************************

.SUBCKT sg13g2_dllrq_1 Q D GATE_N RESET_B VDD VSS
*.PININFO D:I GATE_N:I RESET_B:I Q:O VDD:B VSS:B
MN5 qint gnbb net89 VSS sg13_lv_nmos m=1 w=420.00n l=130.00n ng=1
MN3 qint gnb net61 VSS sg13_lv_nmos m=1 w=640.00n l=130.00n ng=1
MN8 net116 RESET_B VSS VSS sg13_lv_nmos m=1 w=740.00n l=130.00n ng=1
MN9 Q qint_b VSS VSS sg13_lv_nmos m=1 w=740.00n l=130.00n ng=1
MN4 net61 Db VSS VSS sg13_lv_nmos m=1 w=640.00n l=130.00n ng=1
MN6 net89 qint_b VSS VSS sg13_lv_nmos m=1 w=420.00n l=130.00n ng=1
MN7 qint_b qint net116 VSS sg13_lv_nmos m=1 w=740.00n l=130.00n ng=1
MN2 Db D VSS VSS sg13_lv_nmos m=1 w=550.00n l=130.00n ng=1
MN0 gnb GATE_N VSS VSS sg13_lv_nmos m=1 w=740.00n l=130.00n ng=1
MN1 gnbb gnb VSS VSS sg13_lv_nmos m=1 w=740.00n l=130.00n ng=1
MP3 net59 Db VDD VDD sg13_lv_pmos m=1 w=1.000u l=130.00n ng=1
MP8 qint_b RESET_B VDD VDD sg13_lv_pmos m=1 w=1.000u l=130.00n ng=1
MP0 gnb GATE_N VDD VDD sg13_lv_pmos m=1 w=840.00n l=130.00n ng=1
MP5 net92 qint_b VDD VDD sg13_lv_pmos m=1 w=420.00n l=130.00n ng=1
MP7 qint_b qint VDD VDD sg13_lv_pmos m=1 w=1.000u l=130.00n ng=1
MP9 Q qint_b VDD VDD sg13_lv_pmos m=1 w=1.12u l=130.00n ng=1
MP4 qint gnbb net59 VDD sg13_lv_pmos m=1 w=1.000u l=130.00n ng=1
MP2 Db D VDD VDD sg13_lv_pmos m=1 w=840.00n l=130.00n ng=1
MP1 gnbb gnb VDD VDD sg13_lv_pmos m=1 w=840.00n l=130.00n ng=1
MP6 qint gnb net92 VDD sg13_lv_pmos m=1 w=420.00n l=130.00n ng=1
.ENDS

************************************************************************
* Library Name: sg13g2_stdcell
* Cell Name:    sg13g2_dlygate4sd1_1
* View Name:    schematic
************************************************************************

.SUBCKT sg13g2_dlygate4sd1_1 X A VDD VSS
*.PININFO A:I X:O VDD:B VSS:B
MP3 X net3 VDD VDD sg13_lv_pmos m=1 w=1.12u l=130.00n ng=1
MP2 net3 net2 VDD VDD sg13_lv_pmos m=1 w=1.000u l=130.00n ng=1
MP1 net2 net1 VDD VDD sg13_lv_pmos m=1 w=1.000u l=130.00n ng=1
MP0 net1 A VDD VDD sg13_lv_pmos m=1 w=420.00n l=130.00n ng=1
MN3 X net3 VSS VSS sg13_lv_nmos m=1 w=740.00n l=130.00n ng=1
MN2 net3 net2 VSS VSS sg13_lv_nmos m=1 w=420.00n l=130.00n ng=1
MN1 net2 net1 VSS VSS sg13_lv_nmos m=1 w=420.00n l=130.00n ng=1
MN0 net1 A VSS VSS sg13_lv_nmos m=1 w=420.00n l=130.00n ng=1
.ENDS

************************************************************************
* Library Name: sg13g2_stdcell
* Cell Name:    sg13g2_dlygate4sd2_1
* View Name:    schematic
************************************************************************

.SUBCKT sg13g2_dlygate4sd2_1 X A VDD VSS
*.PININFO A:I X:O VDD:B VSS:B
MP3 X net3 VDD VDD sg13_lv_pmos m=1 w=1.12u l=130.00n ng=1
MP2 net3 net2 VDD VDD sg13_lv_pmos m=1 w=1.000u l=250.00n ng=1
MP1 net2 net1 VDD VDD sg13_lv_pmos m=1 w=1.000u l=250.00n ng=1
MP0 net1 A VDD VDD sg13_lv_pmos m=1 w=420.00n l=130.00n ng=1
MN3 X net3 VSS VSS sg13_lv_nmos m=1 w=740.00n l=130.00n ng=1
MN2 net3 net2 VSS VSS sg13_lv_nmos m=1 w=420.00n l=180.00n ng=1
MN1 net2 net1 VSS VSS sg13_lv_nmos m=1 w=420.00n l=180.00n ng=1
MN0 net1 A VSS VSS sg13_lv_nmos m=1 w=420.00n l=130.00n ng=1
.ENDS

************************************************************************
* Library Name: sg13g2_stdcell
* Cell Name:    sg13g2_dlygate4sd3_1
* View Name:    schematic
************************************************************************

.SUBCKT sg13g2_dlygate4sd3_1 X A VDD VSS
*.PININFO A:I X:O VDD:B VSS:B
MP3 X net3 VDD VDD sg13_lv_pmos m=1 w=1.12u l=130.00n ng=1
MP2 net3 net2 VDD VDD sg13_lv_pmos m=1 w=1.000u l=500.0n ng=1
MP1 net2 net1 VDD VDD sg13_lv_pmos m=1 w=1.000u l=500.0n ng=1
MP0 net1 A VDD VDD sg13_lv_pmos m=1 w=420.00n l=130.00n ng=1
MN3 X net3 VSS VSS sg13_lv_nmos m=1 w=740.00n l=130.00n ng=1
MN2 net3 net2 VSS VSS sg13_lv_nmos m=1 w=420.00n l=500.0n ng=1
MN1 net2 net1 VSS VSS sg13_lv_nmos m=1 w=420.00n l=500.0n ng=1
MN0 net1 A VSS VSS sg13_lv_nmos m=1 w=420.00n l=130.00n ng=1
.ENDS

************************************************************************
* Library Name: sg13g2_stdcell
* Cell Name:    sg13g2_ebufn_2
* View Name:    schematic
************************************************************************

.SUBCKT sg13g2_ebufn_2 Z A TE_B VDD VSS
*.PININFO A:I TE_B:I Z:O VDD:B VSS:B
MN3 net4 net3 VSS VSS sg13_lv_nmos m=1 w=1.48u l=130.00n ng=2
MN2 Z net1 net4 VSS sg13_lv_nmos m=1 w=1.48u l=130.00n ng=2
MN1 net3 TE_B VSS VSS sg13_lv_nmos m=1 w=640.00n l=130.00n ng=1
MN0 net1 A VSS VSS sg13_lv_nmos m=1 w=640.00n l=130.00n ng=1
MP2 net2 TE_B VDD VDD sg13_lv_pmos m=1 w=2.24u l=130.00n ng=2
MP3 Z net1 net2 VDD sg13_lv_pmos m=1 w=2.24u l=130.00n ng=2
MP1 net3 TE_B VDD VDD sg13_lv_pmos m=1 w=1.000u l=130.00n ng=1
MP0 net1 A VDD VDD sg13_lv_pmos m=1 w=1.000u l=130.00n ng=1
.ENDS

************************************************************************
* Library Name: sg13g2_stdcell
* Cell Name:    sg13g2_ebufn_4
* View Name:    schematic
************************************************************************

.SUBCKT sg13g2_ebufn_4 Z A TE_B VDD VSS
*.PININFO A:I TE_B:I Z:O VDD:B VSS:B
MN0 net23 A VSS VSS sg13_lv_nmos m=1 w=740.00n l=130.00n ng=1
MN1 net21 TE_B VSS VSS sg13_lv_nmos m=1 w=740.00n l=130.00n ng=1
MN2 Z net23 net22 VSS sg13_lv_nmos m=1 w=2.96u l=130.00n ng=4
MN3 net22 net21 VSS VSS sg13_lv_nmos m=1 w=2.96u l=130.00n ng=4
MP0 net23 A VDD VDD sg13_lv_pmos m=1 w=1.12u l=130.00n ng=1
MP1 net21 TE_B VDD VDD sg13_lv_pmos m=1 w=1.12u l=130.00n ng=1
MP3 Z net23 net24 VDD sg13_lv_pmos m=1 w=4.48u l=130.00n ng=4
MP2 net24 TE_B VDD VDD sg13_lv_pmos m=1 w=4.48u l=130.00n ng=4
.ENDS

************************************************************************
* Library Name: sg13g2_stdcell
* Cell Name:    sg13g2_ebufn_8
* View Name:    schematic
************************************************************************

.SUBCKT sg13g2_ebufn_8 Z A TE_B VDD VSS
*.PININFO A:I TE_B:I Z:O VDD:B VSS:B
MN3 net23 net22 VSS VSS sg13_lv_nmos m=1 w=5.92u l=130.00n ng=8
MN2 Z net21 net23 VSS sg13_lv_nmos m=1 w=5.92u l=130.00n ng=8
MN1 net22 TE_B VSS VSS sg13_lv_nmos m=1 w=740.00n l=130.00n ng=1
MN0 net21 A VSS VSS sg13_lv_nmos m=1 w=1.48u l=130.00n ng=2
MP2 net24 TE_B VDD VDD sg13_lv_pmos m=1 w=8.96u l=130.00n ng=8
MP3 Z net21 net24 VDD sg13_lv_pmos m=1 w=8.96u l=130.00n ng=8
MP1 net22 TE_B VDD VDD sg13_lv_pmos m=1 w=1.12u l=130.00n ng=1
MP0 net21 A VDD VDD sg13_lv_pmos m=1 w=2.24u l=130.00n ng=2
.ENDS

************************************************************************
* Library Name: sg13g2_stdcell
* Cell Name:    sg13g2_einvn_2
* View Name:    schematic
************************************************************************

.SUBCKT sg13g2_einvn_2 Z A TE_B VDD VSS
*.PININFO A:I TE_B:I Z:O VDD:B VSS:B
MN0 TE TE_B VSS VSS sg13_lv_nmos m=1 w=420.00n l=130.00n ng=1
MN2 net1 TE VSS VSS sg13_lv_nmos m=1 w=1.48u l=130.00n ng=2
MN1 Z A net1 VSS sg13_lv_nmos m=1 w=1.48u l=130.00n ng=2
MP0 TE TE_B VDD VDD sg13_lv_pmos m=1 w=640.00n l=130.00n ng=1
MP1 net2 TE_B VDD VDD sg13_lv_pmos m=1 w=2.24u l=130.00n ng=2
MP2 Z A net2 VDD sg13_lv_pmos m=1 w=2.24u l=130.00n ng=2
.ENDS

************************************************************************
* Library Name: sg13g2_stdcell
* Cell Name:    sg13g2_einvn_4
* View Name:    schematic
************************************************************************

.SUBCKT sg13g2_einvn_4 Z A TE_B VDD VSS
*.PININFO A:I TE_B:I Z:O VDD:B VSS:B
MN2 net16 TE VSS VSS sg13_lv_nmos m=1 w=2.96u l=130.00n ng=4
MN0 TE TE_B VSS VSS sg13_lv_nmos m=1 w=740.00n l=130.00n ng=1
MN1 Z A net16 VSS sg13_lv_nmos m=1 w=2.96u l=130.00n ng=4
MP0 TE TE_B VDD VDD sg13_lv_pmos m=1 w=1.12u l=130.00n ng=1
MP1 net17 TE_B VDD VDD sg13_lv_pmos m=1 w=4.48u l=130.00n ng=4
MP2 Z A net17 VDD sg13_lv_pmos m=1 w=4.48u l=130.00n ng=4
.ENDS

************************************************************************
* Library Name: sg13g2_stdcell
* Cell Name:    sg13g2_einvn_8
* View Name:    schematic
************************************************************************

.SUBCKT sg13g2_einvn_8 Z A TE_B VDD VSS
*.PININFO A:I TE_B:I Z:O VDD:B VSS:B
MN1 Z A net29 VSS sg13_lv_nmos m=1 w=5.92u l=130.00n ng=8
MN0 TE TE_B VSS VSS sg13_lv_nmos m=1 w=740.00n l=130.00n ng=1
MN2 net29 TE VSS VSS sg13_lv_nmos m=1 w=5.92u l=130.00n ng=8
MP1 net28 TE_B VDD VDD sg13_lv_pmos m=1 w=8.96u l=130.00n ng=8
MP2 Z A net28 VDD sg13_lv_pmos m=1 w=8.96u l=130.00n ng=8
MP0 TE TE_B VDD VDD sg13_lv_pmos m=1 w=1.12u l=130.00n ng=1
.ENDS

************************************************************************
* Library Name: sg13g2_stdcell
* Cell Name:    sg13g2_inv_1
* View Name:    schematic
************************************************************************

.SUBCKT sg13g2_inv_1 Y A VDD VSS
*.PININFO A:I Y:O VDD:B VSS:B
MN0 Y A VSS VSS sg13_lv_nmos m=1 w=740.00n l=130.00n ng=1
MP0 Y A VDD VDD sg13_lv_pmos m=1 w=1.12u l=130.00n ng=1
.ENDS

************************************************************************
* Library Name: sg13g2_stdcell
* Cell Name:    sg13g2_inv_16
* View Name:    schematic
************************************************************************

.SUBCKT sg13g2_inv_16 Y A VDD VSS
*.PININFO A:I Y:O VDD:B VSS:B
MN0 Y A VSS VSS sg13_lv_nmos m=1 w=11.84u l=130.00n ng=16
MP0 Y A VDD VDD sg13_lv_pmos m=1 w=17.92u l=130.00n ng=16
.ENDS

************************************************************************
* Library Name: sg13g2_stdcell
* Cell Name:    sg13g2_inv_2
* View Name:    schematic
************************************************************************

.SUBCKT sg13g2_inv_2 Y A VDD VSS
*.PININFO A:I Y:O VDD:B VSS:B
MN0 Y A VSS VSS sg13_lv_nmos m=1 w=1.48u l=130.00n ng=2
MP0 Y A VDD VDD sg13_lv_pmos m=1 w=2.24u l=130.00n ng=2
.ENDS

************************************************************************
* Library Name: sg13g2_stdcell
* Cell Name:    sg13g2_inv_4
* View Name:    schematic
************************************************************************

.SUBCKT sg13g2_inv_4 Y A VDD VSS
*.PININFO A:I Y:O VDD:B VSS:B
MP0 Y A VDD VDD sg13_lv_pmos m=1 w=4.48u l=130.00n ng=4
MN0 Y A VSS VSS sg13_lv_nmos m=1 w=2.96u l=130.00n ng=4
.ENDS

************************************************************************
* Library Name: sg13g2_stdcell
* Cell Name:    sg13g2_inv_8
* View Name:    schematic
************************************************************************

.SUBCKT sg13g2_inv_8 Y A VDD VSS
*.PININFO A:I Y:O VDD:B VSS:B
MN0 Y A VSS VSS sg13_lv_nmos m=1 w=5.92u l=130.00n ng=8
MP0 Y A VDD VDD sg13_lv_pmos m=1 w=8.96u l=130.00n ng=8
.ENDS

************************************************************************
* Library Name: sg13g2_stdcell
* Cell Name:    sg13g2_lgcp_1
* View Name:    schematic
************************************************************************

.SUBCKT sg13g2_lgcp_1 GCLK CLK GATE VDD VSS
*.PININFO CLK:I GATE:I GCLK:O VDD:B VSS:B
MP1 CLKBB CLKB VDD VDD sg13_lv_pmos m=1 w=840.00n l=130.00n ng=1
MP3 net1 CLKBB net4 VDD sg13_lv_pmos m=1 w=1.000u l=130.00n ng=1
MP4 int_GATE net1 VDD VDD sg13_lv_pmos m=1 w=1.12u l=130.00n ng=1
MP2 net4 GATE VDD VDD sg13_lv_pmos m=1 w=1.000u l=130.00n ng=1
MP8 net3 int_GATE VDD VDD sg13_lv_pmos m=1 w=840.00n l=130.00n ng=1
MP9 GCLK net3 VDD VDD sg13_lv_pmos m=1 w=1.12u l=130.00n ng=1
MP6 net1 CLKB net6 VDD sg13_lv_pmos m=1 w=420.00n l=130.00n ng=1
MP0 CLKB CLK VDD VDD sg13_lv_pmos m=1 w=840.00n l=130.00n ng=1
MP7 net3 CLK VDD VDD sg13_lv_pmos m=1 w=840.00n l=130.00n ng=1
MP5 net6 int_GATE VDD VDD sg13_lv_pmos m=1 w=420.00n l=130.00n ng=1
MN9 GCLK net3 VSS VSS sg13_lv_nmos m=1 w=740.00n l=130.00n ng=1
MN7 net3 int_GATE net5 VSS sg13_lv_nmos m=1 w=640.00n l=130.00n ng=1
MN4 int_GATE net1 VSS VSS sg13_lv_nmos m=1 w=740.00n l=130.00n ng=1
MN1 CLKBB CLKB VSS VSS sg13_lv_nmos m=1 w=740.00n l=130.00n ng=1
MN6 net7 int_GATE VSS VSS sg13_lv_nmos m=1 w=420.00n l=130.00n ng=1
MN3 net2 GATE VSS VSS sg13_lv_nmos m=1 w=640.00n l=130.00n ng=1
MN5 net1 CLKBB net7 VSS sg13_lv_nmos m=1 w=420.00n l=130.00n ng=1
MN0 CLKB CLK VSS VSS sg13_lv_nmos m=1 w=740.00n l=130.00n ng=1
MN8 net5 CLK VSS VSS sg13_lv_nmos m=1 w=640.00n l=130.00n ng=1
MN2 net1 CLKB net2 VSS sg13_lv_nmos m=1 w=640.00n l=130.00n ng=1
.ENDS

************************************************************************
* Library Name: sg13g2_stdcell
* Cell Name:    sg13g2_mux2_1
* View Name:    schematic
************************************************************************

.SUBCKT sg13g2_mux2_1 X A0 A1 S VDD VSS
*.PININFO A0:I A1:I S:I X:O VDD:B VSS:B
MP1 net4 S VDD VDD sg13_lv_pmos m=1 w=1.000u l=130.00n ng=1
MP5 X net6 VDD VDD sg13_lv_pmos m=1 w=1.12u l=130.00n ng=1
MP4 net6 A1 net5 VDD sg13_lv_pmos m=1 w=1.000u l=130.00n ng=1
MP0 Sb S VDD VDD sg13_lv_pmos m=1 w=840.00n l=130.00n ng=1
MP3 net5 Sb VDD VDD sg13_lv_pmos m=1 w=1.000u l=130.00n ng=1
MP2 net6 A0 net4 VDD sg13_lv_pmos m=1 w=1.000u l=130.00n ng=1
MN4 net3 S VSS VSS sg13_lv_nmos m=1 w=740.00n l=130.00n ng=1
MN2 net1 Sb VSS VSS sg13_lv_nmos m=1 w=740.00n l=130.00n ng=1
MN5 X net6 VSS VSS sg13_lv_nmos m=1 w=740.00n l=130.00n ng=1
MN0 Sb S VSS VSS sg13_lv_nmos m=1 w=550.00n l=130.00n ng=1
MN3 net6 A1 net3 VSS sg13_lv_nmos m=1 w=740.00n l=130.00n ng=1
MN1 net6 A0 net1 VSS sg13_lv_nmos m=1 w=740.00n l=130.00n ng=1
.ENDS

************************************************************************
* Library Name: sg13g2_stdcell
* Cell Name:    sg13g2_mux2_2
* View Name:    schematic
************************************************************************

.SUBCKT sg13g2_mux2_2 X A0 A1 S VDD VSS
*.PININFO A0:I A1:I S:I X:O VDD:B VSS:B
MP1 net4 S VDD VDD sg13_lv_pmos m=1 w=1.000u l=130.00n ng=1
MP5 X net6 VDD VDD sg13_lv_pmos m=1 w=2.24u l=130.00n ng=2
MP4 net6 A1 net5 VDD sg13_lv_pmos m=1 w=1.000u l=130.00n ng=1
MP0 Sb S VDD VDD sg13_lv_pmos m=1 w=840.00n l=130.00n ng=1
MP3 net5 Sb VDD VDD sg13_lv_pmos m=1 w=1.000u l=130.00n ng=1
MP2 net6 A0 net4 VDD sg13_lv_pmos m=1 w=1.000u l=130.00n ng=1
MN4 net3 S VSS VSS sg13_lv_nmos m=1 w=740.00n l=130.00n ng=1
MN2 net1 Sb VSS VSS sg13_lv_nmos m=1 w=740.00n l=130.00n ng=1
MN5 X net6 VSS VSS sg13_lv_nmos m=1 w=1.48u l=130.00n ng=2
MN0 Sb S VSS VSS sg13_lv_nmos m=1 w=550.00n l=130.00n ng=1
MN3 net6 A1 net3 VSS sg13_lv_nmos m=1 w=740.00n l=130.00n ng=1
MN1 net6 A0 net1 VSS sg13_lv_nmos m=1 w=740.00n l=130.00n ng=1
.ENDS

************************************************************************
* Library Name: sg13g2_stdcell
* Cell Name:    sg13g2_mux4_1
* View Name:    schematic
************************************************************************

.SUBCKT sg13g2_mux4_1 X A0 A1 A2 A3 S0 S1 VDD VSS
*.PININFO A0:I A1:I A2:I A3:I S0:I S1:I X:O VDD:B VSS:B
MN12 X Xb VSS VSS sg13_lv_nmos m=1 w=740.00n l=130.00n ng=1
MN2 low S0b net7 VSS sg13_lv_nmos m=1 w=640.00n l=130.00n ng=1
MN3 net7 A0 VSS VSS sg13_lv_nmos m=1 w=640.00n l=130.00n ng=1
MN6 low S1b Xb VSS sg13_lv_nmos m=1 w=640.00n l=130.00n ng=1
MN11 high S1 Xb VSS sg13_lv_nmos m=1 w=640.00n l=130.00n ng=1
MN10 net4 A3 VSS VSS sg13_lv_nmos m=1 w=640.00n l=130.00n ng=1
MN9 high S0 net4 VSS sg13_lv_nmos m=1 w=640.00n l=130.00n ng=1
MN8 net6 A2 VSS VSS sg13_lv_nmos m=1 w=640.00n l=130.00n ng=1
MN7 high S0b net6 VSS sg13_lv_nmos m=1 w=640.00n l=130.00n ng=1
MN5 net2 A1 VSS VSS sg13_lv_nmos m=1 w=640.00n l=130.00n ng=1
MN4 low S0 net2 VSS sg13_lv_nmos m=1 w=640.00n l=130.00n ng=1
MN1 S1b S1 VSS VSS sg13_lv_nmos m=1 w=640.00n l=130.00n ng=1
MN0 S0b S0 VSS VSS sg13_lv_nmos m=1 w=640.00n l=130.00n ng=1
MP6 low S1 Xb VDD sg13_lv_pmos m=1 w=1.000u l=130.00n ng=1
MP11 high S1b Xb VDD sg13_lv_pmos m=1 w=1.000u l=130.00n ng=1
MP12 X Xb VDD VDD sg13_lv_pmos m=1 w=1.12u l=130.00n ng=1
MP10 high S0b net3 VDD sg13_lv_pmos m=1 w=1.000u l=130.00n ng=1
MP9 net3 A3 VDD VDD sg13_lv_pmos m=1 w=1.000u l=130.00n ng=1
MP8 high S0 net5 VDD sg13_lv_pmos m=1 w=1.000u l=130.00n ng=1
MP7 net5 A2 VDD VDD sg13_lv_pmos m=1 w=1.000u l=130.00n ng=1
MP2 net8 A0 VDD VDD sg13_lv_pmos m=1 w=1.000u l=130.00n ng=1
MP3 low S0 net8 VDD sg13_lv_pmos m=1 w=1.000u l=130.00n ng=1
MP1 S1b S1 VDD VDD sg13_lv_pmos m=1 w=1.000u l=130.00n ng=1
MP0 S0b S0 VDD VDD sg13_lv_pmos m=1 w=1.000u l=130.00n ng=1
MP5 low S0b net1 VDD sg13_lv_pmos m=1 w=1.000u l=130.00n ng=1
MP4 net1 A1 VDD VDD sg13_lv_pmos m=1 w=1.000u l=130.00n ng=1
.ENDS

************************************************************************
* Library Name: sg13g2_stdcell
* Cell Name:    sg13g2_nand2_1
* View Name:    schematic
************************************************************************

.SUBCKT sg13g2_nand2_1 Y A B VDD VSS
*.PININFO A:I B:I Y:O VDD:B VSS:B
MP1 Y B VDD VDD sg13_lv_pmos m=1 w=1.12u l=130.00n ng=1
MP0 Y A VDD VDD sg13_lv_pmos m=1 w=1.12u l=130.00n ng=1
MN1 net1 B VSS VSS sg13_lv_nmos m=1 w=740.00n l=130.00n ng=1
MN0 Y A net1 VSS sg13_lv_nmos m=1 w=740.00n l=130.00n ng=1
.ENDS

************************************************************************
* Library Name: sg13g2_stdcell
* Cell Name:    sg13g2_nand2_2
* View Name:    schematic
************************************************************************

.SUBCKT sg13g2_nand2_2 Y A B VDD VSS
*.PININFO A:I B:I Y:O VDD:B VSS:B
MP1 Y B VDD VDD sg13_lv_pmos m=1 w=2.24u l=130.00n ng=2
MP0 Y A VDD VDD sg13_lv_pmos m=1 w=2.24u l=130.00n ng=2
MN1 net1 B VSS VSS sg13_lv_nmos m=1 w=1.44u l=130.00n ng=2
MN0 Y A net1 VSS sg13_lv_nmos m=1 w=1.44u l=130.00n ng=2
.ENDS

************************************************************************
* Library Name: sg13g2_stdcell
* Cell Name:    sg13g2_nand2b_1
* View Name:    schematic
************************************************************************

.SUBCKT sg13g2_nand2b_1 Y A_N B VDD VSS
*.PININFO A_N:I B:I Y:O VDD:B VSS:B
MP2 Y net2 VDD VDD sg13_lv_pmos m=1 w=1.12u l=130.00n ng=1
MP1 net2 A_N VDD VDD sg13_lv_pmos m=1 w=840.00n l=130.00n ng=1
MP0 Y B VDD VDD sg13_lv_pmos m=1 w=1.12u l=130.00n ng=1
MN1 Y net2 net1 VSS sg13_lv_nmos m=1 w=740.00n l=130.00n ng=1
MN0 net2 A_N VSS VSS sg13_lv_nmos m=1 w=550.00n l=130.00n ng=1
MN2 net1 B VSS VSS sg13_lv_nmos m=1 w=740.00n l=130.00n ng=1
.ENDS

************************************************************************
* Library Name: sg13g2_stdcell
* Cell Name:    sg13g2_nand2b_2
* View Name:    schematic
************************************************************************

.SUBCKT sg13g2_nand2b_2 Y A_N B VDD VSS
*.PININFO A_N:I B:I Y:O VDD:B VSS:B
MP2 Y A VDD VDD sg13_lv_pmos m=1 w=2.24u l=130.00n ng=2
MP0 A A_N VDD VDD sg13_lv_pmos m=1 w=840.00n l=130.00n ng=1
MP1 Y B VDD VDD sg13_lv_pmos m=1 w=2.24u l=130.00n ng=2
MN1 Y B net1 VSS sg13_lv_nmos m=1 w=1.44u l=130.00n ng=2
MN0 A A_N VSS VSS sg13_lv_nmos m=1 w=550.00n l=130.00n ng=1
MN2 net1 A VSS VSS sg13_lv_nmos m=1 w=1.44u l=130.00n ng=2
.ENDS

************************************************************************
* Library Name: sg13g2_stdcell
* Cell Name:    sg13g2_nand3_1
* View Name:    schematic
************************************************************************

.SUBCKT sg13g2_nand3_1 Y A B C VDD VSS
*.PININFO A:I B:I C:I Y:O VDD:B VSS:B
MP0 Y A VDD VDD sg13_lv_pmos m=1 w=1.12u l=130.00n ng=1
MP1 Y B VDD VDD sg13_lv_pmos m=1 w=1.12u l=130.00n ng=1
MP2 Y C VDD VDD sg13_lv_pmos m=1 w=1.12u l=130.00n ng=1
MN1 net2 B net3 VSS sg13_lv_nmos m=1 w=740.00n l=130.00n ng=1
MN2 net3 C VSS VSS sg13_lv_nmos m=1 w=740.00n l=130.00n ng=1
MN0 Y A net2 VSS sg13_lv_nmos m=1 w=740.00n l=130.00n ng=1
.ENDS

************************************************************************
* Library Name: sg13g2_stdcell
* Cell Name:    sg13g2_nand3b_1
* View Name:    schematic
************************************************************************

.SUBCKT sg13g2_nand3b_1 Y A_N B C VDD VSS
*.PININFO A_N:I B:I C:I Y:O VDD:B VSS:B
MP0 net1 A_N VDD VDD sg13_lv_pmos m=1 w=840.00n l=130.00n ng=1
MP1 Y net1 VDD VDD sg13_lv_pmos m=1 w=1.12u l=130.00n ng=1
MP2 Y B VDD VDD sg13_lv_pmos m=1 w=1.12u l=130.00n ng=1
MP3 Y C VDD VDD sg13_lv_pmos m=1 w=1.12u l=130.00n ng=1
MN2 net2 B net3 VSS sg13_lv_nmos m=1 w=740.00n l=130.00n ng=1
MN3 net3 C VSS VSS sg13_lv_nmos m=1 w=740.00n l=130.00n ng=1
MN0 net1 A_N VSS VSS sg13_lv_nmos m=1 w=550.00n l=130.00n ng=1
MN1 Y net1 net2 VSS sg13_lv_nmos m=1 w=740.00n l=130.00n ng=1
.ENDS

************************************************************************
* Library Name: sg13g2_stdcell
* Cell Name:    sg13g2_nand4_1
* View Name:    schematic
************************************************************************

.SUBCKT sg13g2_nand4_1 Y A B C D VDD VSS
*.PININFO A:I B:I C:I D:I Y:O VDD:B VSS:B
MP3 Y D VDD VDD sg13_lv_pmos m=1 w=1.12u l=130.00n ng=1
MP0 Y A VDD VDD sg13_lv_pmos m=1 w=1.12u l=130.00n ng=1
MP1 Y B VDD VDD sg13_lv_pmos m=1 w=1.12u l=130.00n ng=1
MP2 Y C VDD VDD sg13_lv_pmos m=1 w=1.12u l=130.00n ng=1
MN1 net2 B net3 VSS sg13_lv_nmos m=1 w=740.00n l=130.00n ng=1
MN2 net3 C net5 VSS sg13_lv_nmos m=1 w=740.00n l=130.00n ng=1
MN0 Y A net2 VSS sg13_lv_nmos m=1 w=740.00n l=130.00n ng=1
MN3 net5 D VSS VSS sg13_lv_nmos m=1 w=740.00n l=130.00n ng=1
.ENDS

************************************************************************
* Library Name: sg13g2_stdcell
* Cell Name:    sg13g2_nor2_1
* View Name:    schematic
************************************************************************

.SUBCKT sg13g2_nor2_1 Y A B VDD VSS
*.PININFO A:I B:I Y:O VDD:B VSS:B
MN0 Y A VSS VSS sg13_lv_nmos m=1 w=740.00n l=130.00n ng=1
MN1 Y B VSS VSS sg13_lv_nmos m=1 w=740.00n l=130.00n ng=1
MP0 net1 A VDD VDD sg13_lv_pmos m=1 w=1.12u l=130.00n ng=1
MP1 Y B net1 VDD sg13_lv_pmos m=1 w=1.12u l=130.00n ng=1
.ENDS

************************************************************************
* Library Name: sg13g2_stdcell
* Cell Name:    sg13g2_nor2_2
* View Name:    schematic
************************************************************************

.SUBCKT sg13g2_nor2_2 Y A B VDD VSS
*.PININFO A:I B:I Y:O VDD:B VSS:B
MN0 Y A VSS VSS sg13_lv_nmos m=1 w=1.48u l=130.00n ng=2
MN1 Y B VSS VSS sg13_lv_nmos m=1 w=1.48u l=130.00n ng=2
MP0 net1 A VDD VDD sg13_lv_pmos m=1 w=2.24u l=130.00n ng=2
MP1 Y B net1 VDD sg13_lv_pmos m=1 w=2.24u l=130.00n ng=2
.ENDS

************************************************************************
* Library Name: sg13g2_stdcell
* Cell Name:    sg13g2_nor2b_1
* View Name:    schematic
************************************************************************

.SUBCKT sg13g2_nor2b_1 Y A B_N VDD VSS
*.PININFO A:I B_N:I Y:O VDD:B VSS:B
MN0 B B_N VSS VSS sg13_lv_nmos m=1 w=550.00n l=130.00n ng=1
MN1 Y A VSS VSS sg13_lv_nmos m=1 w=740.00n l=130.00n ng=1
MN2 Y B VSS VSS sg13_lv_nmos m=1 w=740.00n l=130.00n ng=1
MP0 B B_N VDD VDD sg13_lv_pmos m=1 w=840.00n l=130.00n ng=1
MP1 net1 B VDD VDD sg13_lv_pmos m=1 w=1.12u l=130.00n ng=1
MP2 Y A net1 VDD sg13_lv_pmos m=1 w=1.12u l=130.00n ng=1
.ENDS

************************************************************************
* Library Name: sg13g2_stdcell
* Cell Name:    sg13g2_nor2b_2
* View Name:    schematic
************************************************************************

.SUBCKT sg13g2_nor2b_2 Y A B_N VDD VSS
*.PININFO A:I B_N:I Y:O VDD:B VSS:B
MN0 B B_N VSS VSS sg13_lv_nmos m=1 w=640.00n l=130.00n ng=1
MN1 Y A VSS VSS sg13_lv_nmos m=1 w=1.44u l=130.00n ng=2
MN2 Y B VSS VSS sg13_lv_nmos m=1 w=1.44u l=130.00n ng=2
MP0 B B_N VDD VDD sg13_lv_pmos m=1 w=1.000u l=130.00n ng=1
MP1 net1 B VDD VDD sg13_lv_pmos m=1 w=2.24u l=130.00n ng=2
MP2 Y A net1 VDD sg13_lv_pmos m=1 w=2.24u l=130.00n ng=2
.ENDS

************************************************************************
* Library Name: sg13g2_stdcell
* Cell Name:    sg13g2_nor3_1
* View Name:    schematic
************************************************************************

.SUBCKT sg13g2_nor3_1 Y A B C VDD VSS
*.PININFO A:I B:I C:I Y:O VDD:B VSS:B
MP2 Y C net2 VDD sg13_lv_pmos m=1 w=1.12u l=130.00n ng=1
MP1 net2 B net3 VDD sg13_lv_pmos m=1 w=1.12u l=130.00n ng=1
MP0 net3 A VDD VDD sg13_lv_pmos m=1 w=1.12u l=130.00n ng=1
MN0 Y A VSS VSS sg13_lv_nmos m=1 w=770.00n l=130.00n ng=1
MN1 Y B VSS VSS sg13_lv_nmos m=1 w=770.00n l=130.00n ng=1
MN2 Y C VSS VSS sg13_lv_nmos m=1 w=770.00n l=130.00n ng=1
.ENDS

************************************************************************
* Library Name: sg13g2_stdcell
* Cell Name:    sg13g2_nor3_2
* View Name:    schematic
************************************************************************

.SUBCKT sg13g2_nor3_2 Y A B C VDD VSS
*.PININFO A:I B:I C:I Y:O VDD:B VSS:B
MP2 Y C net2 VDD sg13_lv_pmos m=1 w=2.24u l=130.00n ng=2
MP1 net2 B net3 VDD sg13_lv_pmos m=1 w=2.24u l=130.00n ng=2
MP0 net3 A VDD VDD sg13_lv_pmos m=1 w=2.24u l=130.00n ng=2
MN0 Y A VSS VSS sg13_lv_nmos m=1 w=1.48u l=130.00n ng=2
MN1 Y B VSS VSS sg13_lv_nmos m=1 w=1.48u l=130.00n ng=2
MN2 Y C VSS VSS sg13_lv_nmos m=1 w=1.48u l=130.00n ng=2
.ENDS

************************************************************************
* Library Name: sg13g2_stdcell
* Cell Name:    sg13g2_nor4_1
* View Name:    schematic
************************************************************************

.SUBCKT sg13g2_nor4_1 Y A B C D VDD VSS
*.PININFO A:I B:I C:I D:I Y:O VDD:B VSS:B
MP0 net3 A VDD VDD sg13_lv_pmos m=1 w=1.12u l=130.00n ng=1
MP1 net2 B net3 VDD sg13_lv_pmos m=1 w=1.12u l=130.00n ng=1
MP2 net1 C net2 VDD sg13_lv_pmos m=1 w=1.12u l=130.00n ng=1
MP3 Y D net1 VDD sg13_lv_pmos m=1 w=1.12u l=130.00n ng=1
MN0 Y A VSS VSS sg13_lv_nmos m=1 w=740.00n l=130.00n ng=1
MN3 Y D VSS VSS sg13_lv_nmos m=1 w=740.00n l=130.00n ng=1
MN1 Y B VSS VSS sg13_lv_nmos m=1 w=740.00n l=130.00n ng=1
MN2 Y C VSS VSS sg13_lv_nmos m=1 w=740.00n l=130.00n ng=1
.ENDS

************************************************************************
* Library Name: sg13g2_stdcell
* Cell Name:    sg13g2_nor4_2
* View Name:    schematic
************************************************************************

.SUBCKT sg13g2_nor4_2 Y A B C D VDD VSS
*.PININFO A:I B:I C:I D:I Y:O VDD:B VSS:B
MP0 net3 A VDD VDD sg13_lv_pmos m=1 w=2.24u l=130.00n ng=2
MP1 net2 B net3 VDD sg13_lv_pmos m=1 w=2.24u l=130.00n ng=2
MP2 net1 C net2 VDD sg13_lv_pmos m=1 w=2.24u l=130.00n ng=2
MP3 Y D net1 VDD sg13_lv_pmos m=1 w=2.24u l=130.00n ng=2
MN0 Y A VSS VSS sg13_lv_nmos m=1 w=1.48u l=130.00n ng=2
MN3 Y D VSS VSS sg13_lv_nmos m=1 w=1.48u l=130.00n ng=2
MN1 Y B VSS VSS sg13_lv_nmos m=1 w=1.48u l=130.00n ng=2
MN2 Y C VSS VSS sg13_lv_nmos m=1 w=1.48u l=130.00n ng=2
.ENDS

************************************************************************
* Library Name: sg13g2_stdcell
* Cell Name:    sg13g2_o21ai_1
* View Name:    schematic
************************************************************************

.SUBCKT sg13g2_o21ai_1 Y A1 A2 B1 VDD VSS
*.PININFO A1:I A2:I B1:I Y:O VDD:B VSS:B
MP0 net14 A1 VDD VDD sg13_lv_pmos m=1 w=1.12u l=150.00n ng=1
MP1 Y A2 net14 VDD sg13_lv_pmos m=1 w=1.12u l=150.00n ng=1
MP2 Y B1 VDD VDD sg13_lv_pmos m=1 w=1.12u l=150.00n ng=1
MN0 net1 A2 VSS VSS sg13_lv_nmos m=1 w=740.00n l=150.00n ng=1
MN2 net1 A1 VSS VSS sg13_lv_nmos m=1 w=740.00n l=150.00n ng=1
MN1 Y B1 net1 VSS sg13_lv_nmos m=1 w=740.00n l=150.00n ng=1
.ENDS

************************************************************************
* Library Name: sg13g2_stdcell
* Cell Name:    sg13g2_or2_1
* View Name:    schematic
************************************************************************

.SUBCKT sg13g2_or2_1 X A B VDD VSS
*.PININFO A:I B:I X:O VDD:B VSS:B
MP1 net2 B net3 VDD sg13_lv_pmos m=1 w=840.00n l=130.00n ng=1
MP0 net3 A VDD VDD sg13_lv_pmos m=1 w=840.00n l=130.00n ng=1
MP2 X net2 VDD VDD sg13_lv_pmos m=1 w=1.12u l=130.00n ng=1
MN1 net2 A VSS VSS sg13_lv_nmos m=1 w=550.00n l=130.00n ng=1
MN0 net2 B VSS VSS sg13_lv_nmos m=1 w=550.00n l=130.00n ng=1
MN2 X net2 VSS VSS sg13_lv_nmos m=1 w=740.00n l=130.00n ng=1
.ENDS

************************************************************************
* Library Name: sg13g2_stdcell
* Cell Name:    sg13g2_or2_2
* View Name:    schematic
************************************************************************

.SUBCKT sg13g2_or2_2 X A B VDD VSS
*.PININFO A:I B:I X:O VDD:B VSS:B
MP1 net2 B net3 VDD sg13_lv_pmos m=1 w=840.00n l=130.00n ng=1
MP0 net3 A VDD VDD sg13_lv_pmos m=1 w=840.00n l=130.00n ng=1
MP2 X net2 VDD VDD sg13_lv_pmos m=1 w=2.24u l=130.00n ng=2
MN1 net2 A VSS VSS sg13_lv_nmos m=1 w=550.00n l=130.00n ng=1
MN0 net2 B VSS VSS sg13_lv_nmos m=1 w=550.00n l=130.00n ng=1
MN2 X net2 VSS VSS sg13_lv_nmos m=1 w=1.48u l=130.00n ng=2
.ENDS

************************************************************************
* Library Name: sg13g2_stdcell
* Cell Name:    sg13g2_or3_1
* View Name:    schematic
************************************************************************

.SUBCKT sg13g2_or3_1 X A B C VDD VSS
*.PININFO A:I B:I C:I X:O VDD:B VSS:B
MN2 net1 C VSS VSS sg13_lv_nmos m=1 w=550.00n l=130.00n ng=1
MN3 X net1 VSS VSS sg13_lv_nmos m=1 w=740.00n l=130.00n ng=1
MN1 net1 B VSS VSS sg13_lv_nmos m=1 w=550.00n l=130.00n ng=1
MN0 net1 A VSS VSS sg13_lv_nmos m=1 w=550.00n l=130.00n ng=1
MP3 X net1 VDD VDD sg13_lv_pmos m=1 w=1.12u l=130.00n ng=1
MP1 net9 B net12 VDD sg13_lv_pmos m=1 w=1.000u l=130.00n ng=1
MP0 net12 A VDD VDD sg13_lv_pmos m=1 w=1.000u l=130.00n ng=1
MP2 net1 C net9 VDD sg13_lv_pmos m=1 w=1.000u l=130.00n ng=1
.ENDS

************************************************************************
* Library Name: sg13g2_stdcell
* Cell Name:    sg13g2_or3_2
* View Name:    schematic
************************************************************************

.SUBCKT sg13g2_or3_2 X A B C VDD VSS
*.PININFO A:I B:I C:I X:O VDD:B VSS:B
MN2 net1 C VSS VSS sg13_lv_nmos m=1 w=550.00n l=130.00n ng=1
MN3 X net1 VSS VSS sg13_lv_nmos m=1 w=1.48u l=130.00n ng=2
MN1 net1 B VSS VSS sg13_lv_nmos m=1 w=550.00n l=130.00n ng=1
MN0 net1 A VSS VSS sg13_lv_nmos m=1 w=550.00n l=130.00n ng=1
MP3 X net1 VDD VDD sg13_lv_pmos m=1 w=2.24u l=130.00n ng=2
MP1 net9 B net12 VDD sg13_lv_pmos m=1 w=1.000u l=130.00n ng=1
MP0 net12 A VDD VDD sg13_lv_pmos m=1 w=1.000u l=130.00n ng=1
MP2 net1 C net9 VDD sg13_lv_pmos m=1 w=1.000u l=130.00n ng=1
.ENDS

************************************************************************
* Library Name: sg13g2_stdcell
* Cell Name:    sg13g2_or4_1
* View Name:    schematic
************************************************************************

.SUBCKT sg13g2_or4_1 X A B C D VDD VSS
*.PININFO A:I B:I C:I D:I X:O VDD:B VSS:B
MN4 X net1 VSS VSS sg13_lv_nmos m=1 w=740.00n l=130.00n ng=1
MN3 net1 D VSS VSS sg13_lv_nmos m=1 w=550.00n l=130.00n ng=1
MN2 net1 C VSS VSS sg13_lv_nmos m=1 w=550.00n l=130.00n ng=1
MN1 net1 B VSS VSS sg13_lv_nmos m=1 w=550.00n l=130.00n ng=1
MN0 net1 A VSS VSS sg13_lv_nmos m=1 w=550.00n l=130.00n ng=1
MP0 net4 A VDD VDD sg13_lv_pmos m=1 w=1.000u l=130.00n ng=1
MP1 net3 B net4 VDD sg13_lv_pmos m=1 w=1.000u l=130.00n ng=1
MP2 net2 C net3 VDD sg13_lv_pmos m=1 w=1.000u l=130.00n ng=1
MP3 net1 D net2 VDD sg13_lv_pmos m=1 w=1.000u l=130.00n ng=1
MP4 X net1 VDD VDD sg13_lv_pmos m=1 w=1.12u l=130.00n ng=1
.ENDS

************************************************************************
* Library Name: sg13g2_stdcell
* Cell Name:    sg13g2_or4_2
* View Name:    schematic
************************************************************************

.SUBCKT sg13g2_or4_2 X A B C D VDD VSS
*.PININFO A:I B:I C:I D:I X:O VDD:B VSS:B
MN4 X net1 VSS VSS sg13_lv_nmos m=1 w=1.48u l=130.00n ng=2
MN3 net1 D VSS VSS sg13_lv_nmos m=1 w=550.00n l=130.00n ng=1
MN2 net1 C VSS VSS sg13_lv_nmos m=1 w=550.00n l=130.00n ng=1
MN1 net1 B VSS VSS sg13_lv_nmos m=1 w=550.00n l=130.00n ng=1
MN0 net1 A VSS VSS sg13_lv_nmos m=1 w=550.00n l=130.00n ng=1
MP0 net4 A VDD VDD sg13_lv_pmos m=1 w=1.000u l=130.00n ng=1
MP1 net3 B net4 VDD sg13_lv_pmos m=1 w=1.000u l=130.00n ng=1
MP2 net2 C net3 VDD sg13_lv_pmos m=1 w=1.000u l=130.00n ng=1
MP3 net1 D net2 VDD sg13_lv_pmos m=1 w=1.000u l=130.00n ng=1
MP4 X net1 VDD VDD sg13_lv_pmos m=1 w=2.24u l=130.00n ng=2
.ENDS

************************************************************************
* Library Name: sg13g2_stdcell
* Cell Name:    sg13g2_sdfbbp_1
* View Name:    schematic
************************************************************************

.SUBCKT sg13g2_sdfbbp_1 Q Q_N CLK D RESET_B SCD SCE SET_B VDD VSS
*.PININFO CLK:I D:I RESET_B:I SCD:I SCE:I SET_B:I Q:O Q_N:O VDD:B VSS:B
MP1 resetbb RESET_B VDD VDD sg13_lv_pmos m=1 w=640.00n l=130.00n ng=1
MP19 pre_q DbbLatch2 net8 VDD sg13_lv_pmos m=1 w=1.000u l=130.00n ng=1
MP20 pre_q SET_B VDD VDD sg13_lv_pmos m=1 w=1.000u l=130.00n ng=1
MP3 CLKbb CLKb VDD VDD sg13_lv_pmos m=1 w=1.12u l=130.00n ng=1
MP0 SCEb SCE VDD VDD sg13_lv_pmos m=1 w=640.00n l=130.00n ng=1
MP7 Db D net3 VDD sg13_lv_pmos m=1 w=640.00n l=130.00n ng=1
MP13 DbbTG CLKb net10 VDD sg13_lv_pmos m=1 w=420.00n l=130.00n ng=1
MP12 net10 DbLatchM VDD VDD sg13_lv_pmos m=1 w=420.00n l=130.00n ng=1
MP6 net3 SCE VDD VDD sg13_lv_pmos m=1 w=640.00n l=130.00n ng=1
MP21 Q_N pre_q VDD VDD sg13_lv_pmos m=1 w=1.12u l=130.00n ng=1
MP14 net1 DbLatchM VDD VDD sg13_lv_pmos m=1 w=840.00n l=130.00n ng=1
MP18 net8 resetbb VDD VDD sg13_lv_pmos m=1 w=1.000u l=130.00n ng=1
MP11 DbLatchM SET_B VDD VDD sg13_lv_pmos m=1 w=840.00n l=130.00n ng=1
MP4 net2 SCD VDD VDD sg13_lv_pmos m=1 w=640.00n l=130.00n ng=1
MP2 CLKb CLK VDD VDD sg13_lv_pmos m=1 w=1.12u l=130.00n ng=1
MP10 DbLatchM DbbTG net7 VDD sg13_lv_pmos m=1 w=840.00n l=130.00n ng=1
MP8 Db CLKbb DbbTG VDD sg13_lv_pmos m=1 w=640.00n l=130.00n ng=1
MP5 Db SCEb net2 VDD sg13_lv_pmos m=1 w=640.00n l=130.00n ng=1
MP22 pre_qb pre_q VDD VDD sg13_lv_pmos m=1 w=840.00n l=130.00n ng=1
MP9 net7 resetbb VDD VDD sg13_lv_pmos m=1 w=840.00n l=130.00n ng=1
MP16 net6 pre_q VDD VDD sg13_lv_pmos m=1 w=420.00n l=130.00n ng=1
MP17 DbbLatch2 CLKbb net6 VDD sg13_lv_pmos m=1 w=420.00n l=130.00n ng=1
MP15 DbbLatch2 CLKb net1 VDD sg13_lv_pmos m=1 w=840.00n l=130.00n ng=1
MP23 Q pre_qb VDD VDD sg13_lv_pmos m=1 w=1.12u l=130.00n ng=1
MN4 Db SCE net5 VSS sg13_lv_nmos m=1 w=420.00n l=130.00n ng=1
MN5 net5 SCD VSS VSS sg13_lv_nmos m=1 w=420.00n l=130.00n ng=1
MN18 pre_q DbbLatch2 net11 VSS sg13_lv_nmos m=1 w=740.00n l=130.00n ng=1
MN8 Db CLKb DbbTG VSS sg13_lv_nmos m=1 w=420.00n l=130.00n ng=1
MN7 net4 SCEb VSS VSS sg13_lv_nmos m=1 w=420.00n l=130.00n ng=1
MN3 CLKbb CLKb VSS VSS sg13_lv_nmos m=1 w=740.00n l=130.00n ng=1
MN1 resetbb RESET_B VSS VSS sg13_lv_nmos m=1 w=420.00n l=130.00n ng=1
MN17 net14 pre_q VSS VSS sg13_lv_nmos m=1 w=420.00n l=130.00n ng=1
MN9 DbLatchM DbbTG net12 VSS sg13_lv_nmos m=1 w=550.00n l=130.00n ng=1
MN0 SCEb SCE VSS VSS sg13_lv_nmos m=1 w=420.00n l=130.00n ng=1
MN10 net12 SET_B VSS VSS sg13_lv_nmos m=1 w=550.00n l=130.00n ng=1
MN13 net15 DbLatchM VSS VSS sg13_lv_nmos m=1 w=420.00n l=130.00n ng=1
MN19 net11 SET_B VSS VSS sg13_lv_nmos m=1 w=740.00n l=130.00n ng=1
MN12 DbbTG CLKbb net15 VSS sg13_lv_nmos m=1 w=420.00n l=130.00n ng=1
MN6 Db D net4 VSS sg13_lv_nmos m=1 w=420.00n l=130.00n ng=1
MN22 pre_qb pre_q VSS VSS sg13_lv_nmos m=1 w=550.00n l=130.00n ng=1
MN16 DbbLatch2 CLKb net14 VSS sg13_lv_nmos m=1 w=420.00n l=130.00n ng=1
MN23 Q pre_qb VSS VSS sg13_lv_nmos m=1 w=740.00n l=130.00n ng=1
MN15 net13 DbLatchM VSS VSS sg13_lv_nmos m=1 w=550.00n l=130.00n ng=1
MN2 CLKb CLK VSS VSS sg13_lv_nmos m=1 w=740.00n l=130.00n ng=1
MN14 DbbLatch2 CLKbb net13 VSS sg13_lv_nmos m=1 w=550.00n l=130.00n ng=1
MN11 DbLatchM resetbb net12 VSS sg13_lv_nmos m=1 w=550.00n l=130.00n ng=1
MN21 Q_N pre_q VSS VSS sg13_lv_nmos m=1 w=740.00n l=130.00n ng=1
MN20 pre_q resetbb net11 VSS sg13_lv_nmos m=1 w=740.00n l=130.00n ng=1
.ENDS

************************************************************************
* Library Name: sg13g2_stdcell
* Cell Name:    sg13g2_sighold
* View Name:    schematic
************************************************************************

.SUBCKT sg13g2_sighold SH VDD VSS
*.PININFO SH:B VDD:B VSS:B
MN1 net1 SH VSS VSS sg13_lv_nmos m=1 w=300.0n l=130.00n ng=1
MN0 SH net1 VSS VSS sg13_lv_nmos m=1 w=300.0n l=700.0n ng=1
MP1 net1 SH VDD VDD sg13_lv_pmos m=1 w=450.00n l=130.00n ng=1
MP0 SH net1 VDD VDD sg13_lv_pmos m=1 w=300.0n l=700.0n ng=1
.ENDS

************************************************************************
* Library Name: sg13g2_stdcell
* Cell Name:    sg13g2_slgcp_1
* View Name:    schematic
************************************************************************

.SUBCKT sg13g2_slgcp_1 GCLK CLK GATE SCE VDD VSS
*.PININFO CLK:I GATE:I SCE:I GCLK:O VDD:B VSS:B
MP10 GCLK net5 VDD VDD sg13_lv_pmos m=1 w=1.12u l=130.00n ng=1
MP4 net1 CLKbb net6 VDD sg13_lv_pmos m=1 w=840.00n l=130.00n ng=1
MP1 CLKbb CLKb VDD VDD sg13_lv_pmos m=1 w=840.00n l=130.00n ng=1
MP8 net5 int_GATE VDD VDD sg13_lv_pmos m=1 w=840.00n l=130.00n ng=1
MP2 net3 SCE VDD VDD sg13_lv_pmos m=1 w=840.00n l=130.00n ng=1
MP7 net6 CLKb net4 VDD sg13_lv_pmos m=1 w=420.00n l=130.00n ng=1
MP5 int_GATE net6 VDD VDD sg13_lv_pmos m=1 w=1.12u l=130.00n ng=1
MP0 CLKb CLK VDD VDD sg13_lv_pmos m=1 w=840.00n l=130.00n ng=1
MP9 net5 CLK VDD VDD sg13_lv_pmos m=1 w=840.00n l=130.00n ng=1
MP6 net4 int_GATE VDD VDD sg13_lv_pmos m=1 w=420.00n l=130.00n ng=1
MP3 net1 GATE net3 VDD sg13_lv_pmos m=1 w=840.00n l=130.00n ng=1
MN5 int_GATE net6 VSS VSS sg13_lv_nmos m=1 w=740.00n l=130.00n ng=1
MN9 net2 CLK VSS VSS sg13_lv_nmos m=1 w=640.00n l=130.00n ng=1
MN2 net1 SCE VSS VSS sg13_lv_nmos m=1 w=550.00n l=130.00n ng=1
MN4 net6 CLKb net1 VSS sg13_lv_nmos m=1 w=550.00n l=130.00n ng=1
MN7 net7 int_GATE VSS VSS sg13_lv_nmos m=1 w=420.00n l=130.00n ng=1
MN8 net5 int_GATE net2 VSS sg13_lv_nmos m=1 w=640.00n l=130.00n ng=1
MN10 GCLK net5 VSS VSS sg13_lv_nmos m=1 w=740.00n l=130.00n ng=1
MN1 CLKbb CLKb VSS VSS sg13_lv_nmos m=1 w=740.00n l=130.00n ng=1
MN3 net1 GATE VSS VSS sg13_lv_nmos m=1 w=550.00n l=130.00n ng=1
MN0 CLKb CLK VSS VSS sg13_lv_nmos m=1 w=740.00n l=130.00n ng=1
MN6 net6 CLKbb net7 VSS sg13_lv_nmos m=1 w=420.00n l=130.00n ng=1
.ENDS

************************************************************************
* Library Name: sg13g2_stdcell
* Cell Name:    sg13g2_tiehi
* View Name:    schematic
************************************************************************

.SUBCKT sg13g2_tiehi L_HI VDD VSS
*.PININFO L_HI:O VDD:B VSS:B
MN1 net3 net2 VSS VSS sg13_lv_nmos m=1 w=795.00n l=130.00n ng=1
MN0 net1 net1 VSS VSS sg13_lv_nmos m=1 w=300n l=130.00n ng=1
MP1 L_HI net3 VDD VDD sg13_lv_pmos m=1 w=1.155u l=130.00n ng=1
MP0 net2 net1 VDD VDD sg13_lv_pmos m=1 w=660.0n l=130.00n ng=1
.ENDS

************************************************************************
* Library Name: sg13g2_stdcell
* Cell Name:    sg13g2_tielo
* View Name:    schematic
************************************************************************

.SUBCKT sg13g2_tielo L_LO VDD VSS
*.PININFO L_LO:O VDD:B VSS:B
MN0 net3 net2 VSS VSS sg13_lv_nmos m=1 w=385.00n l=130.00n ng=1
MN1 L_LO net1 VSS VSS sg13_lv_nmos m=1 w=880.0n l=130.00n ng=1
MP0 net2 net2 VDD VDD sg13_lv_pmos m=1 w=300n l=130.00n ng=1
MP1 net1 net3 VDD VDD sg13_lv_pmos m=1 w=1.045u l=130.00n ng=1
.ENDS

************************************************************************
* Library Name: sg13g2_stdcell
* Cell Name:    sg13g2_xnor2_1
* View Name:    schematic
************************************************************************

.SUBCKT sg13g2_xnor2_1 Y A B VDD VSS
*.PININFO A:I B:I Y:O VDD:B VSS:B
MP4 Y net1 VDD VDD sg13_lv_pmos m=1 w=1.12u l=130.00n ng=1
MP3 Y B net4 VDD sg13_lv_pmos m=1 w=1.12u l=130.00n ng=1
MP2 net4 A VDD VDD sg13_lv_pmos m=1 w=1.12u l=130.00n ng=1
MP1 net1 B VDD VDD sg13_lv_pmos m=1 w=840.00n l=130.00n ng=1
MP0 net1 A VDD VDD sg13_lv_pmos m=1 w=840.00n l=130.00n ng=1
MN3 Y net1 net3 VSS sg13_lv_nmos m=1 w=740.00n l=130.00n ng=1
MN1 net2 A VSS VSS sg13_lv_nmos m=1 w=640.00n l=130.00n ng=1
MN0 net1 B net2 VSS sg13_lv_nmos m=1 w=640.00n l=130.00n ng=1
MN4 net3 B VSS VSS sg13_lv_nmos m=1 w=740.00n l=130.00n ng=1
MN2 net3 A VSS VSS sg13_lv_nmos m=1 w=740.00n l=130.00n ng=1
.ENDS

************************************************************************
* Library Name: sg13g2_stdcell
* Cell Name:    sg13g2_xor2_1
* View Name:    schematic
************************************************************************

.SUBCKT sg13g2_xor2_1 X A B VDD VSS
*.PININFO A:I B:I X:O VDD:B VSS:B
MN0 net1 A VSS VSS sg13_lv_nmos m=1 w=550.00n l=130.00n ng=1
MN3 X B net3 VSS sg13_lv_nmos m=1 w=740.00n l=130.00n ng=1
MN2 X net1 VSS VSS sg13_lv_nmos m=1 w=740.00n l=130.00n ng=1
MN4 net3 A VSS VSS sg13_lv_nmos m=1 w=740.00n l=130.00n ng=1
MN1 net1 B VSS VSS sg13_lv_nmos m=1 w=550.00n l=130.00n ng=1
MP0 net6 A VDD VDD sg13_lv_pmos m=1 w=1.000u l=130.00n ng=1
MP1 net1 B net6 VDD sg13_lv_pmos m=1 w=1.000u l=130.00n ng=1
MP2 net5 A VDD VDD sg13_lv_pmos m=1 w=1.12u l=130.00n ng=1
MP4 net5 B VDD VDD sg13_lv_pmos m=1 w=1.12u l=130.00n ng=1
MP3 X net1 net5 VDD sg13_lv_pmos m=1 w=1.12u l=130.00n ng=1
.ENDS

************************************************************************
* Library Name: sg13g2_stdcell
* Cell Name:    sg13g2_a22oi_1
* View Name:    schematic
************************************************************************

.SUBCKT sg13g2_a22oi_1 Y A1 A2 B1 B2 VDD VSS
*.PININFO A1:I A2:I B1:I B2:I Y:O VDD:B VSS:B
MN1 net1 B1 VSS VSS sg13_lv_nmos m=1 w=740.00n l=130.00n ng=1
MN0 Y B2 net1 VSS sg13_lv_nmos m=1 w=740.00n l=130.00n ng=1
MN3 net2 A2 VSS VSS sg13_lv_nmos m=1 w=740.00n l=130.00n ng=1
MN2 Y A1 net2 VSS sg13_lv_nmos m=1 w=740.00n l=130.00n ng=1
MP1 Y B1 net3 VDD sg13_lv_pmos m=1 w=1.12u l=130.00n ng=1
MP3 Y B2 net3 VDD sg13_lv_pmos m=1 w=1.12u l=130.00n ng=1
MP2 net3 A2 VDD VDD sg13_lv_pmos m=1 w=1.12u l=130.00n ng=1
MP0 net3 A1 VDD VDD sg13_lv_pmos m=1 w=1.12u l=130.00n ng=1
.ENDS

************************************************************************
* Library Name: sg13g2_stdcell
* Cell Name:    sg13g2_sdfrbpq_1
* View Name:    schematic
************************************************************************

.SUBCKT sg13g2_sdfrbpq_1 Q CLK D RESET_B SCD SCE VDD VSS
*.PININFO CLK:I D:I RESET_B:I SCD:I SCE:I Q:O VDD:B VSS:B
MN3 Db SCD net63 VSS sg13_lv_nmos m=1 w=740.00n l=130.00n ng=1
MN1 Db D net65 VSS sg13_lv_nmos m=1 w=740.00n l=130.00n ng=1
MN0 SCEb SCE VSS VSS sg13_lv_nmos m=1 w=550.00n l=130.00n ng=1
MN4 net63 SCE VSS VSS sg13_lv_nmos m=1 w=740.00n l=130.00n ng=1
MN2 net65 SCEb VSS VSS sg13_lv_nmos m=1 w=740.00n l=130.00n ng=1
MN17 net12 net2 VSS VSS sg13_lv_nmos m=1 w=420.00n l=130.00n ng=1
MN16 net5 clkneg net12 VSS sg13_lv_nmos m=1 w=420.00n l=130.00n ng=1
MN18 net2 net5 net11 VSS sg13_lv_nmos m=1 w=420.00n l=130.00n ng=1
MN19 net11 RESET_B VSS VSS sg13_lv_nmos m=1 w=420.00n l=130.00n ng=1
MN20 Q net2 VSS VSS sg13_lv_nmos m=1 w=740.00n l=130.00n ng=1
MN6 Dbbb Dbb net10 VSS sg13_lv_nmos m=1 w=420.00n l=130.00n ng=1
MN7 net10 RESET_B VSS VSS sg13_lv_nmos m=1 w=420.00n l=130.00n ng=1
MN10 Dbbb clkneg net6 VSS sg13_lv_nmos m=1 w=420.00n l=130.00n ng=1
MN11 net6 clkpos net9 VSS sg13_lv_nmos m=1 w=420.00n l=130.00n ng=1
MN12 net9 net4 net8 VSS sg13_lv_nmos m=1 w=420.00n l=130.00n ng=1
MN13 net8 RESET_B VSS VSS sg13_lv_nmos m=1 w=420.00n l=130.00n ng=1
MN14 net4 net6 VSS VSS sg13_lv_nmos m=1 w=740.00n l=130.00n ng=1
MN8 clkneg CLK VSS VSS sg13_lv_nmos m=1 w=740.00n l=130.00n ng=1
MN15 net4 clkpos net5 VSS sg13_lv_nmos m=1 w=740.00n l=130.00n ng=1
MN9 clkpos clkneg VSS VSS sg13_lv_nmos m=1 w=740.00n l=130.00n ng=1
MN5 Dbb Db VSS VSS sg13_lv_nmos m=1 w=740.00n l=130.00n ng=1
MP1 net64 SCE VDD VDD sg13_lv_pmos m=1 w=1.000u l=130.00n ng=1
MP3 net62 SCEb VDD VDD sg13_lv_pmos m=1 w=1.000u l=130.00n ng=1
MP0 SCEb SCE VDD VDD sg13_lv_pmos m=1 w=840.00n l=130.00n ng=1
MP4 Db SCD net62 VDD sg13_lv_pmos m=1 w=1.000u l=130.00n ng=1
MP2 Db D net64 VDD sg13_lv_pmos m=1 w=1.000u l=130.00n ng=1
MP17 net5 clkpos net3 VDD sg13_lv_pmos m=1 w=420.00n l=130.00n ng=1
MP18 net2 net5 VDD VDD sg13_lv_pmos m=1 w=420.00n l=130.00n ng=1
MP19 net2 RESET_B VDD VDD sg13_lv_pmos m=1 w=420.00n l=130.00n ng=1
MP20 Q net2 VDD VDD sg13_lv_pmos m=1 w=1.12u l=130.00n ng=1
MP10 Dbbb clkpos net6 VDD sg13_lv_pmos m=1 w=420.00n l=130.00n ng=1
MP6 Dbbb RESET_B VDD VDD sg13_lv_pmos m=1 w=420.00n l=130.00n ng=1
MP7 Dbbb Dbb VDD VDD sg13_lv_pmos m=1 w=420.00n l=130.00n ng=1
MP11 net7 net4 VDD VDD sg13_lv_pmos m=1 w=420.00n l=130.00n ng=1
MP12 net6 clkneg net7 VDD sg13_lv_pmos m=1 w=420.00n l=130.00n ng=1
MP13 net6 RESET_B VDD VDD sg13_lv_pmos m=1 w=420.00n l=130.00n ng=1
MP8 clkneg CLK VDD VDD sg13_lv_pmos m=1 w=1.12u l=130.00n ng=1
MP9 clkpos clkneg VDD VDD sg13_lv_pmos m=1 w=1.12u l=130.00n ng=1
MP14 net4 net6 VDD VDD sg13_lv_pmos m=1 w=1.000u l=130.00n ng=1
MP15 net4 clkneg net5 VDD sg13_lv_pmos m=1 w=1.000u l=130.00n ng=1
MP5 Dbb Db VDD VDD sg13_lv_pmos m=1 w=1.12u l=130.00n ng=1
MP16 net3 net2 VDD VDD sg13_lv_pmos m=1 w=420.00n l=130.00n ng=1
.ENDS

************************************************************************
* Library Name: sg13g2_stdcell
* Cell Name:    sg13g2_sdfrbpq_2
* View Name:    schematic
************************************************************************

.SUBCKT sg13g2_sdfrbpq_2 Q CLK D RESET_B SCD SCE VDD VSS
*.PININFO CLK:I D:I RESET_B:I SCD:I SCE:I Q:O VDD:B VSS:B
MN3 Db SCD net63 VSS sg13_lv_nmos m=1 w=740.00n l=130.00n ng=1
MN1 Db D net65 VSS sg13_lv_nmos m=1 w=740.00n l=130.00n ng=1
MN0 SCEb SCE VSS VSS sg13_lv_nmos m=1 w=550.00n l=130.00n ng=1
MN4 net63 SCE VSS VSS sg13_lv_nmos m=1 w=740.00n l=130.00n ng=1
MN2 net65 SCEb VSS VSS sg13_lv_nmos m=1 w=740.00n l=130.00n ng=1
MN5 Dbb Db VSS VSS sg13_lv_nmos m=1 w=740.00n l=130.00n ng=1
MN17 net12 net2 VSS VSS sg13_lv_nmos m=1 w=420.00n l=130.00n ng=1
MN16 net5 clkneg net12 VSS sg13_lv_nmos m=1 w=420.00n l=130.00n ng=1
MN18 net2 net5 net11 VSS sg13_lv_nmos m=1 w=420.00n l=130.00n ng=1
MN19 net11 RESET_B VSS VSS sg13_lv_nmos m=1 w=420.00n l=130.00n ng=1
MN20 Q net2 VSS VSS sg13_lv_nmos m=1 w=1.48u l=130.00n ng=2
MN6 Dbbb Dbb net10 VSS sg13_lv_nmos m=1 w=420.00n l=130.00n ng=1
MN7 net10 RESET_B VSS VSS sg13_lv_nmos m=1 w=420.00n l=130.00n ng=1
MN10 Dbbb clkneg net6 VSS sg13_lv_nmos m=1 w=420.00n l=130.00n ng=1
MN11 net6 clkpos net9 VSS sg13_lv_nmos m=1 w=420.00n l=130.00n ng=1
MN12 net9 net4 net8 VSS sg13_lv_nmos m=1 w=420.00n l=130.00n ng=1
MN13 net8 RESET_B VSS VSS sg13_lv_nmos m=1 w=420.00n l=130.00n ng=1
MN14 net4 net6 VSS VSS sg13_lv_nmos m=1 w=740.00n l=130.00n ng=1
MN8 clkneg CLK VSS VSS sg13_lv_nmos m=1 w=740.00n l=130.00n ng=1
MN15 net4 clkpos net5 VSS sg13_lv_nmos m=1 w=740.00n l=130.00n ng=1
MN9 clkpos clkneg VSS VSS sg13_lv_nmos m=1 w=740.00n l=130.00n ng=1
MP1 net64 SCE VDD VDD sg13_lv_pmos m=1 w=1.000u l=130.00n ng=1
MP3 net62 SCEb VDD VDD sg13_lv_pmos m=1 w=1.000u l=130.00n ng=1
MP0 SCEb SCE VDD VDD sg13_lv_pmos m=1 w=840.00n l=130.00n ng=1
MP4 Db SCD net62 VDD sg13_lv_pmos m=1 w=1.000u l=130.00n ng=1
MP2 Db D net64 VDD sg13_lv_pmos m=1 w=1.000u l=130.00n ng=1
MP5 Dbb Db VDD VDD sg13_lv_pmos m=1 w=1.12u l=130.00n ng=1
MP17 net5 clkpos net3 VDD sg13_lv_pmos m=1 w=420.00n l=130.00n ng=1
MP18 net2 net5 VDD VDD sg13_lv_pmos m=1 w=420.00n l=130.00n ng=1
MP19 net2 RESET_B VDD VDD sg13_lv_pmos m=1 w=420.00n l=130.00n ng=1
MP20 Q net2 VDD VDD sg13_lv_pmos m=1 w=2.24u l=130.00n ng=2
MP10 Dbbb clkpos net6 VDD sg13_lv_pmos m=1 w=420.00n l=130.00n ng=1
MP6 Dbbb RESET_B VDD VDD sg13_lv_pmos m=1 w=420.00n l=130.00n ng=1
MP7 Dbbb Dbb VDD VDD sg13_lv_pmos m=1 w=420.00n l=130.00n ng=1
MP11 net7 net4 VDD VDD sg13_lv_pmos m=1 w=420.00n l=130.00n ng=1
MP12 net6 clkneg net7 VDD sg13_lv_pmos m=1 w=420.00n l=130.00n ng=1
MP13 net6 RESET_B VDD VDD sg13_lv_pmos m=1 w=420.00n l=130.00n ng=1
MP8 clkneg CLK VDD VDD sg13_lv_pmos m=1 w=1.12u l=130.00n ng=1
MP9 clkpos clkneg VDD VDD sg13_lv_pmos m=1 w=1.12u l=130.00n ng=1
MP14 net4 net6 VDD VDD sg13_lv_pmos m=1 w=1.000u l=130.00n ng=1
MP15 net4 clkneg net5 VDD sg13_lv_pmos m=1 w=1.000u l=130.00n ng=1
MP16 net3 net2 VDD VDD sg13_lv_pmos m=1 w=420.00n l=130.00n ng=1
.ENDS

************************************************************************
* Library Name: sg13g2_stdcell
* Cell Name:    sg13g2_sdfrbp_2
* View Name:    schematic
************************************************************************

.SUBCKT sg13g2_sdfrbp_2 Q Q_N CLK D RESET_B SCD SCE VDD VSS
*.PININFO CLK:I D:I RESET_B:I SCD:I SCE:I Q:O Q_N:O VDD:B VSS:B
MN3 Db SCD net63 VSS sg13_lv_nmos m=1 w=740.00n l=130.00n ng=1
MN1 Db D net65 VSS sg13_lv_nmos m=1 w=740.00n l=130.00n ng=1
MN0 SCEb SCE VSS VSS sg13_lv_nmos m=1 w=550.00n l=130.00n ng=1
MN4 net63 SCE VSS VSS sg13_lv_nmos m=1 w=740.00n l=130.00n ng=1
MN2 net65 SCEb VSS VSS sg13_lv_nmos m=1 w=740.00n l=130.00n ng=1
MN5 Dbb Db VSS VSS sg13_lv_nmos m=1 w=740.00n l=130.00n ng=1
MN17 net12 net2 VSS VSS sg13_lv_nmos m=1 w=420.00n l=130.00n ng=1
MN16 net5 clkneg net12 VSS sg13_lv_nmos m=1 w=420.00n l=130.00n ng=1
MN18 net2 net5 net11 VSS sg13_lv_nmos m=1 w=420.00n l=130.00n ng=1
MN19 net11 RESET_B VSS VSS sg13_lv_nmos m=1 w=420.00n l=130.00n ng=1
MN20 Q_N net5 VSS VSS sg13_lv_nmos m=1 w=1.48u l=130.00n ng=2
MN6 Dbbb Dbb net10 VSS sg13_lv_nmos m=1 w=420.00n l=130.00n ng=1
MN7 net10 RESET_B VSS VSS sg13_lv_nmos m=1 w=420.00n l=130.00n ng=1
MN10 Dbbb clkneg net6 VSS sg13_lv_nmos m=1 w=420.00n l=130.00n ng=1
MN11 net6 clkpos net9 VSS sg13_lv_nmos m=1 w=420.00n l=130.00n ng=1
MN12 net9 net4 net8 VSS sg13_lv_nmos m=1 w=420.00n l=130.00n ng=1
MN13 net8 RESET_B VSS VSS sg13_lv_nmos m=1 w=420.00n l=130.00n ng=1
MN14 net4 net6 VSS VSS sg13_lv_nmos m=1 w=740.00n l=130.00n ng=1
MN8 clkneg CLK VSS VSS sg13_lv_nmos m=1 w=740.00n l=130.00n ng=1
MN15 net4 clkpos net5 VSS sg13_lv_nmos m=1 w=740.00n l=130.00n ng=1
MN9 clkpos clkneg VSS VSS sg13_lv_nmos m=1 w=740.00n l=130.00n ng=1
MN22 Q net1 VSS VSS sg13_lv_nmos m=1 w=1.48u l=130.00n ng=2
MN21 net1 net5 VSS VSS sg13_lv_nmos m=1 w=640.00n l=130.00n ng=1
MP1 net64 SCE VDD VDD sg13_lv_pmos m=1 w=1.000u l=130.00n ng=1
MP3 net62 SCEb VDD VDD sg13_lv_pmos m=1 w=1.000u l=130.00n ng=1
MP0 SCEb SCE VDD VDD sg13_lv_pmos m=1 w=840.00n l=130.00n ng=1
MP4 Db SCD net62 VDD sg13_lv_pmos m=1 w=1.000u l=130.00n ng=1
MP2 Db D net64 VDD sg13_lv_pmos m=1 w=1.000u l=130.00n ng=1
MP5 Dbb Db VDD VDD sg13_lv_pmos m=1 w=1.12u l=130.00n ng=1
MP17 net5 clkpos net3 VDD sg13_lv_pmos m=1 w=420.00n l=130.00n ng=1
MP18 net2 net5 VDD VDD sg13_lv_pmos m=1 w=420.00n l=130.00n ng=1
MP19 net2 RESET_B VDD VDD sg13_lv_pmos m=1 w=420.00n l=130.00n ng=1
MP20 Q_N net5 VDD VDD sg13_lv_pmos m=1 w=2.24u l=130.00n ng=2
MP10 Dbbb clkpos net6 VDD sg13_lv_pmos m=1 w=420.00n l=130.00n ng=1
MP6 Dbbb RESET_B VDD VDD sg13_lv_pmos m=1 w=420.00n l=130.00n ng=1
MP7 Dbbb Dbb VDD VDD sg13_lv_pmos m=1 w=420.00n l=130.00n ng=1
MP11 net7 net4 VDD VDD sg13_lv_pmos m=1 w=420.00n l=130.00n ng=1
MP12 net6 clkneg net7 VDD sg13_lv_pmos m=1 w=420.00n l=130.00n ng=1
MP13 net6 RESET_B VDD VDD sg13_lv_pmos m=1 w=420.00n l=130.00n ng=1
MP8 clkneg CLK VDD VDD sg13_lv_pmos m=1 w=1.12u l=130.00n ng=1
MP9 clkpos clkneg VDD VDD sg13_lv_pmos m=1 w=1.12u l=130.00n ng=1
MP14 net4 net6 VDD VDD sg13_lv_pmos m=1 w=1.000u l=130.00n ng=1
MP15 net4 clkneg net5 VDD sg13_lv_pmos m=1 w=1.000u l=130.00n ng=1
MP22 Q net1 VDD VDD sg13_lv_pmos m=1 w=2.24u l=130.00n ng=2
MP16 net3 net2 VDD VDD sg13_lv_pmos m=1 w=420.00n l=130.00n ng=1
MP21 net1 net5 VDD VDD sg13_lv_pmos m=1 w=1.000u l=130.00n ng=1
.ENDS

************************************************************************
* Library Name: sg13g2_stdcell
* Cell Name:    sg13g2_sdfrbp_1
* View Name:    schematic
************************************************************************

.SUBCKT sg13g2_sdfrbp_1 Q Q_N CLK D RESET_B SCD SCE VDD VSS
*.PININFO CLK:I D:I RESET_B:I SCD:I SCE:I Q:O Q_N:O VDD:B VSS:B
MN3 Db SCD net63 VSS sg13_lv_nmos m=1 w=740.00n l=130.00n ng=1
MN1 Db D net65 VSS sg13_lv_nmos m=1 w=740.00n l=130.00n ng=1
MN0 SCEb SCE VSS VSS sg13_lv_nmos m=1 w=550.00n l=130.00n ng=1
MN4 net63 SCE VSS VSS sg13_lv_nmos m=1 w=740.00n l=130.00n ng=1
MN2 net65 SCEb VSS VSS sg13_lv_nmos m=1 w=740.00n l=130.00n ng=1
MN5 net13 Db VSS VSS sg13_lv_nmos m=1 w=740.00n l=130.00n ng=1
MN17 net12 net2 VSS VSS sg13_lv_nmos m=1 w=420.00n l=130.00n ng=1
MN16 net5 clkneg net12 VSS sg13_lv_nmos m=1 w=420.00n l=130.00n ng=1
MN18 net2 net5 net11 VSS sg13_lv_nmos m=1 w=420.00n l=130.00n ng=1
MN19 net11 RESET_B VSS VSS sg13_lv_nmos m=1 w=420.00n l=130.00n ng=1
MN20 Q_N net5 VSS VSS sg13_lv_nmos m=1 w=740.00n l=130.00n ng=1
MN6 Dbb net13 net10 VSS sg13_lv_nmos m=1 w=420.00n l=130.00n ng=1
MN7 net10 RESET_B VSS VSS sg13_lv_nmos m=1 w=420.00n l=130.00n ng=1
MN10 Dbb clkneg net6 VSS sg13_lv_nmos m=1 w=420.00n l=130.00n ng=1
MN11 net6 clkpos net9 VSS sg13_lv_nmos m=1 w=420.00n l=130.00n ng=1
MN12 net9 net4 net8 VSS sg13_lv_nmos m=1 w=420.00n l=130.00n ng=1
MN13 net8 RESET_B VSS VSS sg13_lv_nmos m=1 w=420.00n l=130.00n ng=1
MN14 net4 net6 VSS VSS sg13_lv_nmos m=1 w=740.00n l=130.00n ng=1
MN8 clkneg CLK VSS VSS sg13_lv_nmos m=1 w=740.00n l=130.00n ng=1
MN15 net4 clkpos net5 VSS sg13_lv_nmos m=1 w=740.00n l=130.00n ng=1
MN9 clkpos clkneg VSS VSS sg13_lv_nmos m=1 w=740.00n l=130.00n ng=1
MN22 Q net1 VSS VSS sg13_lv_nmos m=1 w=740.00n l=130.00n ng=1
MN21 net1 net5 VSS VSS sg13_lv_nmos m=1 w=640.00n l=130.00n ng=1
MP1 net64 SCE VDD VDD sg13_lv_pmos m=1 w=1.000u l=130.00n ng=1
MP3 net62 SCEb VDD VDD sg13_lv_pmos m=1 w=1.000u l=130.00n ng=1
MP0 SCEb SCE VDD VDD sg13_lv_pmos m=1 w=840.00n l=130.00n ng=1
MP4 Db SCD net62 VDD sg13_lv_pmos m=1 w=1.000u l=130.00n ng=1
MP2 Db D net64 VDD sg13_lv_pmos m=1 w=1.000u l=130.00n ng=1
MP5 net13 Db VDD VDD sg13_lv_pmos m=1 w=1.12u l=130.00n ng=1
MP17 net5 clkpos net3 VDD sg13_lv_pmos m=1 w=420.00n l=130.00n ng=1
MP18 net2 net5 VDD VDD sg13_lv_pmos m=1 w=420.00n l=130.00n ng=1
MP19 net2 RESET_B VDD VDD sg13_lv_pmos m=1 w=420.00n l=130.00n ng=1
MP20 Q_N net5 VDD VDD sg13_lv_pmos m=1 w=1.12u l=130.00n ng=1
MP10 Dbb clkpos net6 VDD sg13_lv_pmos m=1 w=420.00n l=130.00n ng=1
MP6 Dbb RESET_B VDD VDD sg13_lv_pmos m=1 w=420.00n l=130.00n ng=1
MP7 Dbb net13 VDD VDD sg13_lv_pmos m=1 w=420.00n l=130.00n ng=1
MP11 net7 net4 VDD VDD sg13_lv_pmos m=1 w=420.00n l=130.00n ng=1
MP12 net6 clkneg net7 VDD sg13_lv_pmos m=1 w=420.00n l=130.00n ng=1
MP13 net6 RESET_B VDD VDD sg13_lv_pmos m=1 w=420.00n l=130.00n ng=1
MP8 clkneg CLK VDD VDD sg13_lv_pmos m=1 w=1.12u l=130.00n ng=1
MP9 clkpos clkneg VDD VDD sg13_lv_pmos m=1 w=1.12u l=130.00n ng=1
MP14 net4 net6 VDD VDD sg13_lv_pmos m=1 w=1.000u l=130.00n ng=1
MP15 net4 clkneg net5 VDD sg13_lv_pmos m=1 w=1.000u l=130.00n ng=1
MP22 Q net1 VDD VDD sg13_lv_pmos m=1 w=1.12u l=130.00n ng=1
MP16 net3 net2 VDD VDD sg13_lv_pmos m=1 w=420.00n l=130.00n ng=1
MP21 net1 net5 VDD VDD sg13_lv_pmos m=1 w=1.000u l=130.00n ng=1
.ENDS

************************************************************************
* Library Name: sg13g2_stdcell
* Cell Name:    sg13g2_dfrbpq_2
* View Name:    schematic
************************************************************************

.SUBCKT sg13g2_dfrbpq_2 Q CLK D RESET_B VDD VSS
*.PININFO CLK:I D:I RESET_B:I Q:O VDD:B VSS:B
MN11 net12 net2 VSS VSS sg13_lv_nmos m=1 w=420.00n l=130.00n ng=1
MN10 net5 clkneg net12 VSS sg13_lv_nmos m=1 w=420.00n l=130.00n ng=1
MN12 net2 net5 net11 VSS sg13_lv_nmos m=1 w=420.00n l=130.00n ng=1
MN13 net11 RESET_B VSS VSS sg13_lv_nmos m=1 w=420.00n l=130.00n ng=1
MN0 Db D net10 VSS sg13_lv_nmos m=1 w=420.00n l=130.00n ng=1
MN1 net10 RESET_B VSS VSS sg13_lv_nmos m=1 w=420.00n l=130.00n ng=1
MN4 Db clkneg net6 VSS sg13_lv_nmos m=1 w=420.00n l=130.00n ng=1
MN5 net6 clkpos net9 VSS sg13_lv_nmos m=1 w=420.00n l=130.00n ng=1
MN6 net9 net4 net8 VSS sg13_lv_nmos m=1 w=420.00n l=130.00n ng=1
MN7 net8 RESET_B VSS VSS sg13_lv_nmos m=1 w=420.00n l=130.00n ng=1
MN8 net4 net6 VSS VSS sg13_lv_nmos m=1 w=740.00n l=130.00n ng=1
MN2 clkneg CLK VSS VSS sg13_lv_nmos m=1 w=740.00n l=130.00n ng=1
MN9 net4 clkpos net5 VSS sg13_lv_nmos m=1 w=740.00n l=130.00n ng=1
MN3 clkpos clkneg VSS VSS sg13_lv_nmos m=1 w=740.00n l=130.00n ng=1
MN15 Q net1 VSS VSS sg13_lv_nmos m=1 w=1.48u l=130.00n ng=2
MN14 net1 net5 VSS VSS sg13_lv_nmos m=1 w=640.00n l=130.00n ng=1
MP11 net5 clkpos net3 VDD sg13_lv_pmos m=1 w=420.00n l=130.00n ng=1
MP12 net2 net5 VDD VDD sg13_lv_pmos m=1 w=420.00n l=130.00n ng=1
MP13 net2 RESET_B VDD VDD sg13_lv_pmos m=1 w=420.00n l=130.00n ng=1
MP4 Db clkpos net6 VDD sg13_lv_pmos m=1 w=420.00n l=130.00n ng=1
MP0 Db RESET_B VDD VDD sg13_lv_pmos m=1 w=420.00n l=130.00n ng=1
MP1 Db D VDD VDD sg13_lv_pmos m=1 w=420.00n l=130.00n ng=1
MP5 net7 net4 VDD VDD sg13_lv_pmos m=1 w=420.00n l=130.00n ng=1
MP6 net6 clkneg net7 VDD sg13_lv_pmos m=1 w=420.00n l=130.00n ng=1
MP7 net6 RESET_B VDD VDD sg13_lv_pmos m=1 w=420.00n l=130.00n ng=1
MP2 clkneg CLK VDD VDD sg13_lv_pmos m=1 w=1.12u l=130.00n ng=1
MP3 clkpos clkneg VDD VDD sg13_lv_pmos m=1 w=1.12u l=130.00n ng=1
MP8 net4 net6 VDD VDD sg13_lv_pmos m=1 w=1.000u l=130.00n ng=1
MP9 net4 clkneg net5 VDD sg13_lv_pmos m=1 w=1.000u l=130.00n ng=1
MP15 Q net1 VDD VDD sg13_lv_pmos m=1 w=2.24u l=130.00n ng=2
MP10 net3 net2 VDD VDD sg13_lv_pmos m=1 w=420.00n l=130.00n ng=1
MP14 net1 net5 VDD VDD sg13_lv_pmos m=1 w=1.000u l=130.00n ng=1
.ENDS

************************************************************************
* Library Name: sg13g2_stdcell
* Cell Name:    sg13g2_dfrbpq_1
* View Name:    schematic
************************************************************************

.SUBCKT sg13g2_dfrbpq_1 Q CLK D RESET_B VDD VSS
*.PININFO CLK:I D:I RESET_B:I Q:O VDD:B VSS:B
MN11 net12 net2 VSS VSS sg13_lv_nmos m=1 w=420.00n l=130.00n ng=1
MN10 net5 clkneg net12 VSS sg13_lv_nmos m=1 w=420.00n l=130.00n ng=1
MN12 net2 net5 net11 VSS sg13_lv_nmos m=1 w=420.00n l=130.00n ng=1
MN13 net11 RESET_B VSS VSS sg13_lv_nmos m=1 w=420.00n l=130.00n ng=1
MN0 Db D net10 VSS sg13_lv_nmos m=1 w=420.00n l=130.00n ng=1
MN1 net10 RESET_B VSS VSS sg13_lv_nmos m=1 w=420.00n l=130.00n ng=1
MN4 Db clkneg net6 VSS sg13_lv_nmos m=1 w=420.00n l=130.00n ng=1
MN5 net6 clkpos net9 VSS sg13_lv_nmos m=1 w=420.00n l=130.00n ng=1
MN6 net9 net4 net8 VSS sg13_lv_nmos m=1 w=420.00n l=130.00n ng=1
MN7 net8 RESET_B VSS VSS sg13_lv_nmos m=1 w=420.00n l=130.00n ng=1
MN8 net4 net6 VSS VSS sg13_lv_nmos m=1 w=740.00n l=130.00n ng=1
MN2 clkneg CLK VSS VSS sg13_lv_nmos m=1 w=740.00n l=130.00n ng=1
MN9 net4 clkpos net5 VSS sg13_lv_nmos m=1 w=740.00n l=130.00n ng=1
MN3 clkpos clkneg VSS VSS sg13_lv_nmos m=1 w=740.00n l=130.00n ng=1
MN15 Q net1 VSS VSS sg13_lv_nmos m=1 w=740.00n l=130.00n ng=1
MN14 net1 net5 VSS VSS sg13_lv_nmos m=1 w=740.00n l=130.00n ng=1
MP11 net5 clkpos net3 VDD sg13_lv_pmos m=1 w=420.00n l=130.00n ng=1
MP12 net2 net5 VDD VDD sg13_lv_pmos m=1 w=420.00n l=130.00n ng=1
MP13 net2 RESET_B VDD VDD sg13_lv_pmos m=1 w=420.00n l=130.00n ng=1
MP4 Db clkpos net6 VDD sg13_lv_pmos m=1 w=420.00n l=130.00n ng=1
MP0 Db RESET_B VDD VDD sg13_lv_pmos m=1 w=420.00n l=130.00n ng=1
MP1 Db D VDD VDD sg13_lv_pmos m=1 w=420.00n l=130.00n ng=1
MP5 net7 net4 VDD VDD sg13_lv_pmos m=1 w=420.00n l=130.00n ng=1
MP6 net6 clkneg net7 VDD sg13_lv_pmos m=1 w=420.00n l=130.00n ng=1
MP7 net6 RESET_B VDD VDD sg13_lv_pmos m=1 w=420.00n l=130.00n ng=1
MP2 clkneg CLK VDD VDD sg13_lv_pmos m=1 w=1.12u l=130.00n ng=1
MP3 clkpos clkneg VDD VDD sg13_lv_pmos m=1 w=1.12u l=130.00n ng=1
MP8 net4 net6 VDD VDD sg13_lv_pmos m=1 w=1.000u l=130.00n ng=1
MP9 net4 clkneg net5 VDD sg13_lv_pmos m=1 w=1.000u l=130.00n ng=1
MP15 Q net1 VDD VDD sg13_lv_pmos m=1 w=1.12u l=130.00n ng=1
MP10 net3 net2 VDD VDD sg13_lv_pmos m=1 w=420.00n l=130.00n ng=1
MP14 net1 net5 VDD VDD sg13_lv_pmos m=1 w=1.12u l=130.00n ng=1
.ENDS

************************************************************************
* Library Name: sg13g2_stdcell
* Cell Name:    sg13g2_fill_1
* View Name:    schematic
************************************************************************

.SUBCKT sg13g2_fill_1 VDD VSS
*.PININFO VDD:B VSS:B
.ENDS

************************************************************************
* Library Name: sg13g2_stdcell
* Cell Name:    sg13g2_fill_2
* View Name:    schematic
************************************************************************

.SUBCKT sg13g2_fill_2 VDD VSS
*.PININFO VDD:B VSS:B
.ENDS

************************************************************************
* Library Name: sg13g2_stdcell
* Cell Name:    sg13g2_fill_4
* View Name:    schematic
************************************************************************

.SUBCKT sg13g2_fill_4 VDD VSS
*.PININFO VDD:B VSS:B
.ENDS

************************************************************************
* Library Name: sg13g2_stdcell
* Cell Name:    sg13g2_fill_8
* View Name:    schematic
************************************************************************

.SUBCKT sg13g2_fill_8 VDD VSS
*.PININFO VDD:B VSS:B
.ENDS
* CDL Netlist generated by OpenROAD

*.BUSDELIMITER [

.SUBCKT PLL_RING_DCO_PHYS COARSE_MUX[0] COARSE_MUX[10] COARSE_MUX[11]
+ COARSE_MUX[12] COARSE_MUX[13] COARSE_MUX[14] COARSE_MUX[1]
+ COARSE_MUX[2] COARSE_MUX[3] COARSE_MUX[4] COARSE_MUX[5] COARSE_MUX[6]
+ COARSE_MUX[7] COARSE_MUX[8] COARSE_MUX[9] DCO_EN FINE_MUX[0]
+ FINE_MUX[10] FINE_MUX[11] FINE_MUX[12] FINE_MUX[13] FINE_MUX[14]
+ FINE_MUX[15] FINE_MUX[16] FINE_MUX[17] FINE_MUX[18] FINE_MUX[19]
+ FINE_MUX[1] FINE_MUX[20] FINE_MUX[21] FINE_MUX[22] FINE_MUX[23]
+ FINE_MUX[24] FINE_MUX[25] FINE_MUX[26] FINE_MUX[27] FINE_MUX[28]
+ FINE_MUX[29] FINE_MUX[2] FINE_MUX[30] FINE_MUX[3] FINE_MUX[4]
+ FINE_MUX[5] FINE_MUX[6] FINE_MUX[7] FINE_MUX[8] FINE_MUX[9]
+ INJ_EN MID_MUX[0] MID_MUX[10] MID_MUX[11] MID_MUX[12] MID_MUX[13]
+ MID_MUX[14] MID_MUX[1] MID_MUX[2] MID_MUX[3] MID_MUX[4] MID_MUX[5]
+ MID_MUX[6] MID_MUX[7] MID_MUX[8] MID_MUX[9] MID_OUT OUT INJ_EDGE
+ REF SS_BBPD[0] SS_BBPD[1] VSS VDD
Xring/base_delay_stage_0_delay_cell_impl ring/base_delay_BASE_CHAIN_1_
+ OUT VDD VSS sg13g2_buf_1
Xring/base_delay_stage_100_delay_cell_impl ring/base_delay_BASE_CHAIN_101_
+ ring/base_delay_BASE_CHAIN_100_ VDD VSS sg13g2_buf_1
Xring/base_delay_stage_101_delay_cell_impl ring/base_delay_BASE_CHAIN_102_
+ ring/base_delay_BASE_CHAIN_101_ VDD VSS sg13g2_buf_1
Xring/base_delay_stage_102_delay_cell_impl ring/base_delay_BASE_CHAIN_103_
+ ring/base_delay_BASE_CHAIN_102_ VDD VSS sg13g2_buf_1
Xring/base_delay_stage_103_delay_cell_impl ring/base_delay_BASE_CHAIN_104_
+ ring/base_delay_BASE_CHAIN_103_ VDD VSS sg13g2_buf_1
Xring/base_delay_stage_104_delay_cell_impl ring/base_delay_BASE_CHAIN_105_
+ ring/base_delay_BASE_CHAIN_104_ VDD VSS sg13g2_buf_1
Xring/base_delay_stage_105_delay_cell_impl ring/base_delay_BASE_CHAIN_106_
+ ring/base_delay_BASE_CHAIN_105_ VDD VSS sg13g2_buf_1
Xring/base_delay_stage_106_delay_cell_impl ring/base_delay_BASE_CHAIN_107_
+ ring/base_delay_BASE_CHAIN_106_ VDD VSS sg13g2_buf_1
Xring/base_delay_stage_107_delay_cell_impl ring/base_delay_BASE_CHAIN_108_
+ ring/base_delay_BASE_CHAIN_107_ VDD VSS sg13g2_buf_1
Xring/base_delay_stage_108_delay_cell_impl ring/base_delay_BASE_CHAIN_109_
+ ring/base_delay_BASE_CHAIN_108_ VDD VSS sg13g2_buf_1
Xring/base_delay_stage_109_delay_cell_impl ring/base_delay_BASE_CHAIN_110_
+ ring/base_delay_BASE_CHAIN_109_ VDD VSS sg13g2_buf_1
Xring/base_delay_stage_10_delay_cell_impl ring/base_delay_BASE_CHAIN_11_
+ ring/base_delay_BASE_CHAIN_10_ VDD VSS sg13g2_buf_1
Xring/base_delay_stage_110_delay_cell_impl ring/base_delay_BASE_CHAIN_111_
+ ring/base_delay_BASE_CHAIN_110_ VDD VSS sg13g2_buf_1
Xring/base_delay_stage_111_delay_cell_impl ring/base_delay_BASE_CHAIN_112_
+ ring/base_delay_BASE_CHAIN_111_ VDD VSS sg13g2_buf_1
Xring/base_delay_stage_112_delay_cell_impl ring/base_delay_BASE_CHAIN_113_
+ ring/base_delay_BASE_CHAIN_112_ VDD VSS sg13g2_buf_1
Xring/base_delay_stage_113_delay_cell_impl ring/base_delay_BASE_CHAIN_114_
+ ring/base_delay_BASE_CHAIN_113_ VDD VSS sg13g2_buf_1
Xring/base_delay_stage_114_delay_cell_impl ring/base_delay_BASE_CHAIN_115_
+ ring/base_delay_BASE_CHAIN_114_ VDD VSS sg13g2_buf_1
Xring/base_delay_stage_115_delay_cell_impl ring/base_delay_BASE_CHAIN_116_
+ ring/base_delay_BASE_CHAIN_115_ VDD VSS sg13g2_buf_1
Xring/base_delay_stage_116_delay_cell_impl ring/base_delay_BASE_CHAIN_117_
+ ring/base_delay_BASE_CHAIN_116_ VDD VSS sg13g2_buf_1
Xring/base_delay_stage_117_delay_cell_impl ring/base_delay_BASE_CHAIN_118_
+ ring/base_delay_BASE_CHAIN_117_ VDD VSS sg13g2_buf_1
Xring/base_delay_stage_118_delay_cell_impl ring/base_delay_BASE_CHAIN_119_
+ ring/base_delay_BASE_CHAIN_118_ VDD VSS sg13g2_buf_1
Xring/base_delay_stage_119_delay_cell_impl ring/base_delay_BASE_CHAIN_120_
+ ring/base_delay_BASE_CHAIN_119_ VDD VSS sg13g2_buf_1
Xring/base_delay_stage_11_delay_cell_impl ring/base_delay_BASE_CHAIN_12_
+ ring/base_delay_BASE_CHAIN_11_ VDD VSS sg13g2_buf_1
Xring/base_delay_stage_120_delay_cell_impl ring/base_delay_BASE_CHAIN_121_
+ ring/base_delay_BASE_CHAIN_120_ VDD VSS sg13g2_buf_1
Xring/base_delay_stage_121_delay_cell_impl ring/base_delay_BASE_CHAIN_122_
+ ring/base_delay_BASE_CHAIN_121_ VDD VSS sg13g2_buf_1
Xring/base_delay_stage_122_delay_cell_impl ring/base_delay_BASE_CHAIN_123_
+ ring/base_delay_BASE_CHAIN_122_ VDD VSS sg13g2_buf_1
Xring/base_delay_stage_123_delay_cell_impl ring/base_delay_BASE_CHAIN_124_
+ ring/base_delay_BASE_CHAIN_123_ VDD VSS sg13g2_buf_1
Xring/base_delay_stage_124_delay_cell_impl ring/base_delay_BASE_CHAIN_125_
+ ring/base_delay_BASE_CHAIN_124_ VDD VSS sg13g2_buf_1
Xring/base_delay_stage_125_delay_cell_impl ring/base_delay_BASE_CHAIN_126_
+ ring/base_delay_BASE_CHAIN_125_ VDD VSS sg13g2_buf_1
Xring/base_delay_stage_126_delay_cell_impl ring/base_delay_BASE_CHAIN_127_
+ ring/base_delay_BASE_CHAIN_126_ VDD VSS sg13g2_buf_1
Xring/base_delay_stage_127_delay_cell_impl ring/base_delay_BASE_CHAIN_128_
+ ring/base_delay_BASE_CHAIN_127_ VDD VSS sg13g2_buf_1
Xring/base_delay_stage_128_delay_cell_impl ring/base_delay_BASE_CHAIN_129_
+ ring/base_delay_BASE_CHAIN_128_ VDD VSS sg13g2_buf_1
Xring/base_delay_stage_129_delay_cell_impl ring/base_delay_BASE_CHAIN_130_
+ ring/base_delay_BASE_CHAIN_129_ VDD VSS sg13g2_buf_1
Xring/base_delay_stage_12_delay_cell_impl ring/base_delay_BASE_CHAIN_13_
+ ring/base_delay_BASE_CHAIN_12_ VDD VSS sg13g2_buf_1
Xring/base_delay_stage_130_delay_cell_impl ring/base_delay_BASE_CHAIN_131_
+ ring/base_delay_BASE_CHAIN_130_ VDD VSS sg13g2_buf_1
Xring/base_delay_stage_131_delay_cell_impl ring/base_delay_BASE_CHAIN_132_
+ ring/base_delay_BASE_CHAIN_131_ VDD VSS sg13g2_buf_1
Xring/base_delay_stage_132_delay_cell_impl ring/base_delay_BASE_CHAIN_133_
+ ring/base_delay_BASE_CHAIN_132_ VDD VSS sg13g2_buf_1
Xring/base_delay_stage_133_delay_cell_impl ring/base_delay_BASE_CHAIN_134_
+ ring/base_delay_BASE_CHAIN_133_ VDD VSS sg13g2_buf_1
Xring/base_delay_stage_134_delay_cell_impl ring/base_delay_BASE_CHAIN_135_
+ ring/base_delay_BASE_CHAIN_134_ VDD VSS sg13g2_buf_1
Xring/base_delay_stage_135_delay_cell_impl ring/base_delay_BASE_CHAIN_136_
+ ring/base_delay_BASE_CHAIN_135_ VDD VSS sg13g2_buf_1
Xring/base_delay_stage_136_delay_cell_impl ring/base_delay_BASE_CHAIN_137_
+ ring/base_delay_BASE_CHAIN_136_ VDD VSS sg13g2_buf_1
Xring/base_delay_stage_137_delay_cell_impl ring/base_delay_BASE_CHAIN_138_
+ ring/base_delay_BASE_CHAIN_137_ VDD VSS sg13g2_buf_1
Xring/base_delay_stage_138_delay_cell_impl ring/base_delay_BASE_CHAIN_139_
+ ring/base_delay_BASE_CHAIN_138_ VDD VSS sg13g2_buf_1
Xring/base_delay_stage_139_delay_cell_impl ring/base_delay_BASE_CHAIN_140_
+ ring/base_delay_BASE_CHAIN_139_ VDD VSS sg13g2_buf_1
Xring/base_delay_stage_13_delay_cell_impl ring/base_delay_BASE_CHAIN_14_
+ ring/base_delay_BASE_CHAIN_13_ VDD VSS sg13g2_buf_1
Xring/base_delay_stage_140_delay_cell_impl ring/base_delay_BASE_CHAIN_141_
+ ring/base_delay_BASE_CHAIN_140_ VDD VSS sg13g2_buf_1
Xring/base_delay_stage_141_delay_cell_impl ring/base_delay_BASE_CHAIN_142_
+ ring/base_delay_BASE_CHAIN_141_ VDD VSS sg13g2_buf_1
Xring/base_delay_stage_142_delay_cell_impl ring/base_delay_BASE_CHAIN_143_
+ ring/base_delay_BASE_CHAIN_142_ VDD VSS sg13g2_buf_1
Xring/base_delay_stage_143_delay_cell_impl ring/base_delay_BASE_CHAIN_144_
+ ring/base_delay_BASE_CHAIN_143_ VDD VSS sg13g2_buf_1
Xring/base_delay_stage_144_delay_cell_impl ring/base_delay_BASE_CHAIN_145_
+ ring/base_delay_BASE_CHAIN_144_ VDD VSS sg13g2_buf_1
Xring/base_delay_stage_145_delay_cell_impl ring/base_delay_BASE_CHAIN_146_
+ ring/base_delay_BASE_CHAIN_145_ VDD VSS sg13g2_buf_1
Xring/base_delay_stage_146_delay_cell_impl ring/base_delay_BASE_CHAIN_147_
+ ring/base_delay_BASE_CHAIN_146_ VDD VSS sg13g2_buf_1
Xring/base_delay_stage_147_delay_cell_impl ring/base_delay_BASE_CHAIN_148_
+ ring/base_delay_BASE_CHAIN_147_ VDD VSS sg13g2_buf_1
Xring/base_delay_stage_148_delay_cell_impl ring/base_delay_BASE_CHAIN_149_
+ ring/base_delay_BASE_CHAIN_148_ VDD VSS sg13g2_buf_1
Xring/base_delay_stage_149_delay_cell_impl ring/base_delay_BASE_CHAIN_150_
+ ring/base_delay_BASE_CHAIN_149_ VDD VSS sg13g2_buf_1
Xring/base_delay_stage_14_delay_cell_impl ring/base_delay_BASE_CHAIN_15_
+ ring/base_delay_BASE_CHAIN_14_ VDD VSS sg13g2_buf_1
Xring/base_delay_stage_150_delay_cell_impl ring/base_delay_BASE_CHAIN_151_
+ ring/base_delay_BASE_CHAIN_150_ VDD VSS sg13g2_buf_1
Xring/base_delay_stage_151_delay_cell_impl ring/base_delay_BASE_CHAIN_152_
+ ring/base_delay_BASE_CHAIN_151_ VDD VSS sg13g2_buf_1
Xring/base_delay_stage_152_delay_cell_impl ring/base_delay_BASE_CHAIN_153_
+ ring/base_delay_BASE_CHAIN_152_ VDD VSS sg13g2_buf_1
Xring/base_delay_stage_153_delay_cell_impl ring/base_delay_BASE_CHAIN_154_
+ ring/base_delay_BASE_CHAIN_153_ VDD VSS sg13g2_buf_1
Xring/base_delay_stage_154_delay_cell_impl ring/base_delay_BASE_CHAIN_155_
+ ring/base_delay_BASE_CHAIN_154_ VDD VSS sg13g2_buf_1
Xring/base_delay_stage_155_delay_cell_impl ring/base_delay_BASE_CHAIN_156_
+ ring/base_delay_BASE_CHAIN_155_ VDD VSS sg13g2_buf_1
Xring/base_delay_stage_156_delay_cell_impl ring/base_delay_BASE_CHAIN_157_
+ ring/base_delay_BASE_CHAIN_156_ VDD VSS sg13g2_buf_1
Xring/base_delay_stage_157_delay_cell_impl ring/base_delay_BASE_CHAIN_158_
+ ring/base_delay_BASE_CHAIN_157_ VDD VSS sg13g2_buf_1
Xring/base_delay_stage_158_delay_cell_impl ring/base_delay_BASE_CHAIN_159_
+ ring/base_delay_BASE_CHAIN_158_ VDD VSS sg13g2_buf_1
Xring/base_delay_stage_159_delay_cell_impl ring/base_delay_BASE_CHAIN_160_
+ ring/base_delay_BASE_CHAIN_159_ VDD VSS sg13g2_buf_1
Xring/base_delay_stage_15_delay_cell_impl ring/base_delay_BASE_CHAIN_16_
+ ring/base_delay_BASE_CHAIN_15_ VDD VSS sg13g2_buf_1
Xring/base_delay_stage_160_delay_cell_impl ring/base_delay_BASE_CHAIN_161_
+ ring/base_delay_BASE_CHAIN_160_ VDD VSS sg13g2_buf_1
Xring/base_delay_stage_161_delay_cell_impl ring/base_delay_BASE_CHAIN_162_
+ ring/base_delay_BASE_CHAIN_161_ VDD VSS sg13g2_buf_1
Xring/base_delay_stage_162_delay_cell_impl ring/base_delay_BASE_CHAIN_163_
+ ring/base_delay_BASE_CHAIN_162_ VDD VSS sg13g2_buf_1
Xring/base_delay_stage_163_delay_cell_impl ring/base_delay_BASE_CHAIN_164_
+ ring/base_delay_BASE_CHAIN_163_ VDD VSS sg13g2_buf_1
Xring/base_delay_stage_164_delay_cell_impl ring/base_delay_BASE_CHAIN_165_
+ ring/base_delay_BASE_CHAIN_164_ VDD VSS sg13g2_buf_1
Xring/base_delay_stage_165_delay_cell_impl ring/base_delay_BASE_CHAIN_166_
+ ring/base_delay_BASE_CHAIN_165_ VDD VSS sg13g2_buf_1
Xring/base_delay_stage_166_delay_cell_impl ring/base_delay_BASE_CHAIN_167_
+ ring/base_delay_BASE_CHAIN_166_ VDD VSS sg13g2_buf_1
Xring/base_delay_stage_167_delay_cell_impl ring/base_delay_BASE_CHAIN_168_
+ ring/base_delay_BASE_CHAIN_167_ VDD VSS sg13g2_buf_1
Xring/base_delay_stage_168_delay_cell_impl ring/base_delay_BASE_CHAIN_169_
+ ring/base_delay_BASE_CHAIN_168_ VDD VSS sg13g2_buf_1
Xring/base_delay_stage_169_delay_cell_impl ring/base_delay_BASE_CHAIN_170_
+ ring/base_delay_BASE_CHAIN_169_ VDD VSS sg13g2_buf_1
Xring/base_delay_stage_16_delay_cell_impl ring/base_delay_BASE_CHAIN_17_
+ ring/base_delay_BASE_CHAIN_16_ VDD VSS sg13g2_buf_1
Xring/base_delay_stage_170_delay_cell_impl ring/base_delay_BASE_CHAIN_171_
+ ring/base_delay_BASE_CHAIN_170_ VDD VSS sg13g2_buf_1
Xring/base_delay_stage_171_delay_cell_impl ring/base_delay_BASE_CHAIN_172_
+ ring/base_delay_BASE_CHAIN_171_ VDD VSS sg13g2_buf_1
Xring/base_delay_stage_172_delay_cell_impl ring/base_delay_BASE_CHAIN_173_
+ ring/base_delay_BASE_CHAIN_172_ VDD VSS sg13g2_buf_1
Xring/base_delay_stage_173_delay_cell_impl ring/base_delay_BASE_CHAIN_174_
+ ring/base_delay_BASE_CHAIN_173_ VDD VSS sg13g2_buf_1
Xring/base_delay_stage_174_delay_cell_impl ring/base_delay_BASE_CHAIN_175_
+ ring/base_delay_BASE_CHAIN_174_ VDD VSS sg13g2_buf_1
Xring/base_delay_stage_175_delay_cell_impl ring/base_delay_BASE_CHAIN_176_
+ ring/base_delay_BASE_CHAIN_175_ VDD VSS sg13g2_buf_1
Xring/base_delay_stage_176_delay_cell_impl ring/base_delay_BASE_CHAIN_177_
+ ring/base_delay_BASE_CHAIN_176_ VDD VSS sg13g2_buf_1
Xring/base_delay_stage_177_delay_cell_impl ring/base_delay_BASE_CHAIN_178_
+ ring/base_delay_BASE_CHAIN_177_ VDD VSS sg13g2_buf_1
Xring/base_delay_stage_178_delay_cell_impl ring/base_delay_BASE_CHAIN_179_
+ ring/base_delay_BASE_CHAIN_178_ VDD VSS sg13g2_buf_1
Xring/base_delay_stage_179_delay_cell_impl ring/base_delay_BASE_CHAIN_180_
+ ring/base_delay_BASE_CHAIN_179_ VDD VSS sg13g2_buf_1
Xring/base_delay_stage_17_delay_cell_impl ring/base_delay_BASE_CHAIN_18_
+ ring/base_delay_BASE_CHAIN_17_ VDD VSS sg13g2_buf_1
Xring/base_delay_stage_180_delay_cell_impl ring/base_delay_BASE_CHAIN_181_
+ ring/base_delay_BASE_CHAIN_180_ VDD VSS sg13g2_buf_1
Xring/base_delay_stage_181_delay_cell_impl ring/base_delay_BASE_CHAIN_182_
+ ring/base_delay_BASE_CHAIN_181_ VDD VSS sg13g2_buf_1
Xring/base_delay_stage_182_delay_cell_impl ring/base_delay_BASE_CHAIN_183_
+ ring/base_delay_BASE_CHAIN_182_ VDD VSS sg13g2_buf_1
Xring/base_delay_stage_183_delay_cell_impl ring/base_delay_BASE_CHAIN_184_
+ ring/base_delay_BASE_CHAIN_183_ VDD VSS sg13g2_buf_1
Xring/base_delay_stage_184_delay_cell_impl ring/base_delay_BASE_CHAIN_185_
+ ring/base_delay_BASE_CHAIN_184_ VDD VSS sg13g2_buf_1
Xring/base_delay_stage_185_delay_cell_impl ring/base_delay_BASE_CHAIN_186_
+ ring/base_delay_BASE_CHAIN_185_ VDD VSS sg13g2_buf_1
Xring/base_delay_stage_186_delay_cell_impl ring/base_delay_BASE_CHAIN_187_
+ ring/base_delay_BASE_CHAIN_186_ VDD VSS sg13g2_buf_1
Xring/base_delay_stage_187_delay_cell_impl ring/base_delay_BASE_CHAIN_188_
+ ring/base_delay_BASE_CHAIN_187_ VDD VSS sg13g2_buf_1
Xring/base_delay_stage_188_delay_cell_impl ring/base_delay_BASE_CHAIN_189_
+ ring/base_delay_BASE_CHAIN_188_ VDD VSS sg13g2_buf_1
Xring/base_delay_stage_189_delay_cell_impl ring/base_delay_BASE_CHAIN_190_
+ ring/base_delay_BASE_CHAIN_189_ VDD VSS sg13g2_buf_1
Xring/base_delay_stage_18_delay_cell_impl ring/base_delay_BASE_CHAIN_19_
+ ring/base_delay_BASE_CHAIN_18_ VDD VSS sg13g2_buf_1
Xring/base_delay_stage_190_delay_cell_impl ring/base_delay_BASE_CHAIN_191_
+ ring/base_delay_BASE_CHAIN_190_ VDD VSS sg13g2_buf_1
Xring/base_delay_stage_191_delay_cell_impl ring/base_delay_BASE_CHAIN_192_
+ ring/base_delay_BASE_CHAIN_191_ VDD VSS sg13g2_buf_1
Xring/base_delay_stage_192_delay_cell_impl ring/base_delay_BASE_CHAIN_193_
+ ring/base_delay_BASE_CHAIN_192_ VDD VSS sg13g2_buf_1
Xring/base_delay_stage_193_delay_cell_impl ring/base_delay_BASE_CHAIN_194_
+ ring/base_delay_BASE_CHAIN_193_ VDD VSS sg13g2_buf_1
Xring/base_delay_stage_194_delay_cell_impl ring/base_delay_BASE_CHAIN_195_
+ ring/base_delay_BASE_CHAIN_194_ VDD VSS sg13g2_buf_1
Xring/base_delay_stage_195_delay_cell_impl ring/base_delay_BASE_CHAIN_196_
+ ring/base_delay_BASE_CHAIN_195_ VDD VSS sg13g2_buf_1
Xring/base_delay_stage_196_delay_cell_impl ring/base_delay_BASE_CHAIN_197_
+ ring/base_delay_BASE_CHAIN_196_ VDD VSS sg13g2_buf_1
Xring/base_delay_stage_197_delay_cell_impl ring/base_delay_BASE_CHAIN_198_
+ ring/base_delay_BASE_CHAIN_197_ VDD VSS sg13g2_buf_1
Xring/base_delay_stage_198_delay_cell_impl ring/base_delay_BASE_CHAIN_199_
+ ring/base_delay_BASE_CHAIN_198_ VDD VSS sg13g2_buf_1
Xring/base_delay_stage_199_delay_cell_impl ring/base_delay_BASE_CHAIN_200_
+ ring/base_delay_BASE_CHAIN_199_ VDD VSS sg13g2_buf_1
Xring/base_delay_stage_19_delay_cell_impl ring/base_delay_BASE_CHAIN_20_
+ ring/base_delay_BASE_CHAIN_19_ VDD VSS sg13g2_buf_1
Xring/base_delay_stage_1_delay_cell_impl ring/base_delay_BASE_CHAIN_2_
+ ring/base_delay_BASE_CHAIN_1_ VDD VSS sg13g2_buf_1
Xring/base_delay_stage_200_delay_cell_impl ring/base_delay_BASE_CHAIN_201_
+ ring/base_delay_BASE_CHAIN_200_ VDD VSS sg13g2_buf_1
Xring/base_delay_stage_201_delay_cell_impl ring/base_delay_BASE_CHAIN_202_
+ ring/base_delay_BASE_CHAIN_201_ VDD VSS sg13g2_buf_1
Xring/base_delay_stage_202_delay_cell_impl ring/base_delay_BASE_CHAIN_203_
+ ring/base_delay_BASE_CHAIN_202_ VDD VSS sg13g2_buf_1
Xring/base_delay_stage_203_delay_cell_impl ring/base_delay_BASE_CHAIN_204_
+ ring/base_delay_BASE_CHAIN_203_ VDD VSS sg13g2_buf_1
Xring/base_delay_stage_204_delay_cell_impl ring/base_delay_BASE_CHAIN_205_
+ ring/base_delay_BASE_CHAIN_204_ VDD VSS sg13g2_buf_1
Xring/base_delay_stage_205_delay_cell_impl ring/base_delay_BASE_CHAIN_206_
+ ring/base_delay_BASE_CHAIN_205_ VDD VSS sg13g2_buf_1
Xring/base_delay_stage_206_delay_cell_impl ring/base_delay_BASE_CHAIN_207_
+ ring/base_delay_BASE_CHAIN_206_ VDD VSS sg13g2_buf_1
Xring/base_delay_stage_207_delay_cell_impl ring/base_delay_BASE_CHAIN_208_
+ ring/base_delay_BASE_CHAIN_207_ VDD VSS sg13g2_buf_1
Xring/base_delay_stage_208_delay_cell_impl ring/base_delay_BASE_CHAIN_209_
+ ring/base_delay_BASE_CHAIN_208_ VDD VSS sg13g2_buf_1
Xring/base_delay_stage_209_delay_cell_impl ring/base_delay_BASE_CHAIN_210_
+ ring/base_delay_BASE_CHAIN_209_ VDD VSS sg13g2_buf_1
Xring/base_delay_stage_20_delay_cell_impl ring/base_delay_BASE_CHAIN_21_
+ ring/base_delay_BASE_CHAIN_20_ VDD VSS sg13g2_buf_1
Xring/base_delay_stage_210_delay_cell_impl ring/base_delay_BASE_CHAIN_211_
+ ring/base_delay_BASE_CHAIN_210_ VDD VSS sg13g2_buf_1
Xring/base_delay_stage_211_delay_cell_impl ring/base_delay_BASE_CHAIN_212_
+ ring/base_delay_BASE_CHAIN_211_ VDD VSS sg13g2_buf_1
Xring/base_delay_stage_212_delay_cell_impl ring/base_delay_BASE_CHAIN_213_
+ ring/base_delay_BASE_CHAIN_212_ VDD VSS sg13g2_buf_1
Xring/base_delay_stage_213_delay_cell_impl ring/base_delay_BASE_CHAIN_214_
+ ring/base_delay_BASE_CHAIN_213_ VDD VSS sg13g2_buf_1
Xring/base_delay_stage_214_delay_cell_impl ring/base_delay_BASE_CHAIN_215_
+ ring/base_delay_BASE_CHAIN_214_ VDD VSS sg13g2_buf_1
Xring/base_delay_stage_215_delay_cell_impl ring/base_delay_BASE_CHAIN_216_
+ ring/base_delay_BASE_CHAIN_215_ VDD VSS sg13g2_buf_1
Xring/base_delay_stage_216_delay_cell_impl ring/base_delay_BASE_CHAIN_217_
+ ring/base_delay_BASE_CHAIN_216_ VDD VSS sg13g2_buf_1
Xring/base_delay_stage_217_delay_cell_impl ring/base_delay_BASE_CHAIN_218_
+ ring/base_delay_BASE_CHAIN_217_ VDD VSS sg13g2_buf_1
Xring/base_delay_stage_218_delay_cell_impl ring/base_delay_BASE_CHAIN_219_
+ ring/base_delay_BASE_CHAIN_218_ VDD VSS sg13g2_buf_1
Xring/base_delay_stage_219_delay_cell_impl ring/base_delay_BASE_CHAIN_220_
+ ring/base_delay_BASE_CHAIN_219_ VDD VSS sg13g2_buf_1
Xring/base_delay_stage_21_delay_cell_impl ring/base_delay_BASE_CHAIN_22_
+ ring/base_delay_BASE_CHAIN_21_ VDD VSS sg13g2_buf_1
Xring/base_delay_stage_220_delay_cell_impl ring/base_delay_BASE_CHAIN_221_
+ ring/base_delay_BASE_CHAIN_220_ VDD VSS sg13g2_buf_1
Xring/base_delay_stage_221_delay_cell_impl ring/base_delay_BASE_CHAIN_222_
+ ring/base_delay_BASE_CHAIN_221_ VDD VSS sg13g2_buf_1
Xring/base_delay_stage_222_delay_cell_impl ring/base_delay_BASE_CHAIN_223_
+ ring/base_delay_BASE_CHAIN_222_ VDD VSS sg13g2_buf_1
Xring/base_delay_stage_223_delay_cell_impl ring/base_delay_BASE_CHAIN_224_
+ ring/base_delay_BASE_CHAIN_223_ VDD VSS sg13g2_buf_1
Xring/base_delay_stage_224_delay_cell_impl ring/base_delay_BASE_CHAIN_225_
+ ring/base_delay_BASE_CHAIN_224_ VDD VSS sg13g2_buf_1
Xring/base_delay_stage_225_delay_cell_impl ring/base_delay_BASE_CHAIN_226_
+ ring/base_delay_BASE_CHAIN_225_ VDD VSS sg13g2_buf_1
Xring/base_delay_stage_226_delay_cell_impl ring/base_delay_BASE_CHAIN_227_
+ ring/base_delay_BASE_CHAIN_226_ VDD VSS sg13g2_buf_1
Xring/base_delay_stage_227_delay_cell_impl ring/base_delay_BASE_CHAIN_228_
+ ring/base_delay_BASE_CHAIN_227_ VDD VSS sg13g2_buf_1
Xring/base_delay_stage_228_delay_cell_impl ring/base_delay_BASE_CHAIN_229_
+ ring/base_delay_BASE_CHAIN_228_ VDD VSS sg13g2_buf_1
Xring/base_delay_stage_229_delay_cell_impl ring/base_delay_BASE_CHAIN_230_
+ ring/base_delay_BASE_CHAIN_229_ VDD VSS sg13g2_buf_1
Xring/base_delay_stage_22_delay_cell_impl ring/base_delay_BASE_CHAIN_23_
+ ring/base_delay_BASE_CHAIN_22_ VDD VSS sg13g2_buf_1
Xring/base_delay_stage_230_delay_cell_impl ring/base_delay_BASE_CHAIN_231_
+ ring/base_delay_BASE_CHAIN_230_ VDD VSS sg13g2_buf_1
Xring/base_delay_stage_231_delay_cell_impl ring/base_delay_BASE_CHAIN_232_
+ ring/base_delay_BASE_CHAIN_231_ VDD VSS sg13g2_buf_1
Xring/base_delay_stage_232_delay_cell_impl ring/base_delay_BASE_CHAIN_233_
+ ring/base_delay_BASE_CHAIN_232_ VDD VSS sg13g2_buf_1
Xring/base_delay_stage_233_delay_cell_impl ring/base_delay_BASE_CHAIN_234_
+ ring/base_delay_BASE_CHAIN_233_ VDD VSS sg13g2_buf_1
Xring/base_delay_stage_234_delay_cell_impl ring/base_delay_BASE_CHAIN_235_
+ ring/base_delay_BASE_CHAIN_234_ VDD VSS sg13g2_buf_1
Xring/base_delay_stage_235_delay_cell_impl ring/base_delay_BASE_CHAIN_236_
+ ring/base_delay_BASE_CHAIN_235_ VDD VSS sg13g2_buf_1
Xring/base_delay_stage_236_delay_cell_impl ring/base_delay_BASE_CHAIN_237_
+ ring/base_delay_BASE_CHAIN_236_ VDD VSS sg13g2_buf_1
Xring/base_delay_stage_237_delay_cell_impl ring/base_delay_BASE_CHAIN_238_
+ ring/base_delay_BASE_CHAIN_237_ VDD VSS sg13g2_buf_1
Xring/base_delay_stage_238_delay_cell_impl ring/base_delay_BASE_CHAIN_239_
+ ring/base_delay_BASE_CHAIN_238_ VDD VSS sg13g2_buf_1
Xring/base_delay_stage_239_delay_cell_impl ring/base_delay_BASE_CHAIN_240_
+ ring/base_delay_BASE_CHAIN_239_ VDD VSS sg13g2_buf_1
Xring/base_delay_stage_23_delay_cell_impl ring/base_delay_BASE_CHAIN_24_
+ ring/base_delay_BASE_CHAIN_23_ VDD VSS sg13g2_buf_1
Xring/base_delay_stage_240_delay_cell_impl ring/base_delay_BASE_CHAIN_241_
+ ring/base_delay_BASE_CHAIN_240_ VDD VSS sg13g2_buf_1
Xring/base_delay_stage_241_delay_cell_impl ring/base_delay_BASE_CHAIN_242_
+ ring/base_delay_BASE_CHAIN_241_ VDD VSS sg13g2_buf_1
Xring/base_delay_stage_242_delay_cell_impl ring/base_delay_BASE_CHAIN_243_
+ ring/base_delay_BASE_CHAIN_242_ VDD VSS sg13g2_buf_1
Xring/base_delay_stage_243_delay_cell_impl ring/base_delay_BASE_CHAIN_244_
+ ring/base_delay_BASE_CHAIN_243_ VDD VSS sg13g2_buf_1
Xring/base_delay_stage_244_delay_cell_impl ring/base_delay_BASE_CHAIN_245_
+ ring/base_delay_BASE_CHAIN_244_ VDD VSS sg13g2_buf_1
Xring/base_delay_stage_245_delay_cell_impl ring/base_delay_BASE_CHAIN_246_
+ ring/base_delay_BASE_CHAIN_245_ VDD VSS sg13g2_buf_1
Xring/base_delay_stage_246_delay_cell_impl ring/base_delay_BASE_CHAIN_247_
+ ring/base_delay_BASE_CHAIN_246_ VDD VSS sg13g2_buf_1
Xring/base_delay_stage_247_delay_cell_impl ring/base_delay_BASE_CHAIN_248_
+ ring/base_delay_BASE_CHAIN_247_ VDD VSS sg13g2_buf_1
Xring/base_delay_stage_248_delay_cell_impl ring/base_delay_BASE_CHAIN_249_
+ ring/base_delay_BASE_CHAIN_248_ VDD VSS sg13g2_buf_1
Xring/base_delay_stage_249_delay_cell_impl ring/base_delay_BASE_CHAIN_250_
+ ring/base_delay_BASE_CHAIN_249_ VDD VSS sg13g2_buf_1
Xring/base_delay_stage_24_delay_cell_impl ring/base_delay_BASE_CHAIN_25_
+ ring/base_delay_BASE_CHAIN_24_ VDD VSS sg13g2_buf_1
Xring/base_delay_stage_250_delay_cell_impl ring/base_delay_BASE_CHAIN_251_
+ ring/base_delay_BASE_CHAIN_250_ VDD VSS sg13g2_buf_1
Xring/base_delay_stage_251_delay_cell_impl ring/base_delay_BASE_CHAIN_252_
+ ring/base_delay_BASE_CHAIN_251_ VDD VSS sg13g2_buf_1
Xring/base_delay_stage_252_delay_cell_impl ring/base_delay_BASE_CHAIN_253_
+ ring/base_delay_BASE_CHAIN_252_ VDD VSS sg13g2_buf_1
Xring/base_delay_stage_253_delay_cell_impl ring/base_delay_BASE_CHAIN_254_
+ ring/base_delay_BASE_CHAIN_253_ VDD VSS sg13g2_buf_1
Xring/base_delay_stage_254_delay_cell_impl ring/base_delay_BASE_CHAIN_255_
+ ring/base_delay_BASE_CHAIN_254_ VDD VSS sg13g2_buf_1
Xring/base_delay_stage_255_delay_cell_impl ring/DCO_IN ring/base_delay_BASE_CHAIN_255_
+ VDD VSS sg13g2_buf_1
Xring/base_delay_stage_25_delay_cell_impl ring/base_delay_BASE_CHAIN_26_
+ ring/base_delay_BASE_CHAIN_25_ VDD VSS sg13g2_buf_1
Xring/base_delay_stage_26_delay_cell_impl ring/base_delay_BASE_CHAIN_27_
+ ring/base_delay_BASE_CHAIN_26_ VDD VSS sg13g2_buf_1
Xring/base_delay_stage_27_delay_cell_impl ring/base_delay_BASE_CHAIN_28_
+ ring/base_delay_BASE_CHAIN_27_ VDD VSS sg13g2_buf_1
Xring/base_delay_stage_28_delay_cell_impl ring/base_delay_BASE_CHAIN_29_
+ ring/base_delay_BASE_CHAIN_28_ VDD VSS sg13g2_buf_1
Xring/base_delay_stage_29_delay_cell_impl ring/base_delay_BASE_CHAIN_30_
+ ring/base_delay_BASE_CHAIN_29_ VDD VSS sg13g2_buf_1
Xring/base_delay_stage_2_delay_cell_impl ring/base_delay_BASE_CHAIN_3_
+ ring/base_delay_BASE_CHAIN_2_ VDD VSS sg13g2_buf_1
Xring/base_delay_stage_30_delay_cell_impl ring/base_delay_BASE_CHAIN_31_
+ ring/base_delay_BASE_CHAIN_30_ VDD VSS sg13g2_buf_1
Xring/base_delay_stage_31_delay_cell_impl ring/base_delay_BASE_CHAIN_32_
+ ring/base_delay_BASE_CHAIN_31_ VDD VSS sg13g2_buf_1
Xring/base_delay_stage_32_delay_cell_impl ring/base_delay_BASE_CHAIN_33_
+ ring/base_delay_BASE_CHAIN_32_ VDD VSS sg13g2_buf_1
Xring/base_delay_stage_33_delay_cell_impl ring/base_delay_BASE_CHAIN_34_
+ ring/base_delay_BASE_CHAIN_33_ VDD VSS sg13g2_buf_1
Xring/base_delay_stage_34_delay_cell_impl ring/base_delay_BASE_CHAIN_35_
+ ring/base_delay_BASE_CHAIN_34_ VDD VSS sg13g2_buf_1
Xring/base_delay_stage_35_delay_cell_impl ring/base_delay_BASE_CHAIN_36_
+ ring/base_delay_BASE_CHAIN_35_ VDD VSS sg13g2_buf_1
Xring/base_delay_stage_36_delay_cell_impl ring/base_delay_BASE_CHAIN_37_
+ ring/base_delay_BASE_CHAIN_36_ VDD VSS sg13g2_buf_1
Xring/base_delay_stage_37_delay_cell_impl ring/base_delay_BASE_CHAIN_38_
+ ring/base_delay_BASE_CHAIN_37_ VDD VSS sg13g2_buf_1
Xring/base_delay_stage_38_delay_cell_impl ring/base_delay_BASE_CHAIN_39_
+ ring/base_delay_BASE_CHAIN_38_ VDD VSS sg13g2_buf_1
Xring/base_delay_stage_39_delay_cell_impl ring/base_delay_BASE_CHAIN_40_
+ ring/base_delay_BASE_CHAIN_39_ VDD VSS sg13g2_buf_1
Xring/base_delay_stage_3_delay_cell_impl ring/base_delay_BASE_CHAIN_4_
+ ring/base_delay_BASE_CHAIN_3_ VDD VSS sg13g2_buf_1
Xring/base_delay_stage_40_delay_cell_impl ring/base_delay_BASE_CHAIN_41_
+ ring/base_delay_BASE_CHAIN_40_ VDD VSS sg13g2_buf_1
Xring/base_delay_stage_41_delay_cell_impl ring/base_delay_BASE_CHAIN_42_
+ ring/base_delay_BASE_CHAIN_41_ VDD VSS sg13g2_buf_1
Xring/base_delay_stage_42_delay_cell_impl ring/base_delay_BASE_CHAIN_43_
+ ring/base_delay_BASE_CHAIN_42_ VDD VSS sg13g2_buf_1
Xring/base_delay_stage_43_delay_cell_impl ring/base_delay_BASE_CHAIN_44_
+ ring/base_delay_BASE_CHAIN_43_ VDD VSS sg13g2_buf_1
Xring/base_delay_stage_44_delay_cell_impl ring/base_delay_BASE_CHAIN_45_
+ ring/base_delay_BASE_CHAIN_44_ VDD VSS sg13g2_buf_1
Xring/base_delay_stage_45_delay_cell_impl ring/base_delay_BASE_CHAIN_46_
+ ring/base_delay_BASE_CHAIN_45_ VDD VSS sg13g2_buf_1
Xring/base_delay_stage_46_delay_cell_impl ring/base_delay_BASE_CHAIN_47_
+ ring/base_delay_BASE_CHAIN_46_ VDD VSS sg13g2_buf_1
Xring/base_delay_stage_47_delay_cell_impl ring/base_delay_BASE_CHAIN_48_
+ ring/base_delay_BASE_CHAIN_47_ VDD VSS sg13g2_buf_1
Xring/base_delay_stage_48_delay_cell_impl ring/base_delay_BASE_CHAIN_49_
+ ring/base_delay_BASE_CHAIN_48_ VDD VSS sg13g2_buf_1
Xring/base_delay_stage_49_delay_cell_impl ring/base_delay_BASE_CHAIN_50_
+ ring/base_delay_BASE_CHAIN_49_ VDD VSS sg13g2_buf_1
Xring/base_delay_stage_4_delay_cell_impl ring/base_delay_BASE_CHAIN_5_
+ ring/base_delay_BASE_CHAIN_4_ VDD VSS sg13g2_buf_1
Xring/base_delay_stage_50_delay_cell_impl ring/base_delay_BASE_CHAIN_51_
+ ring/base_delay_BASE_CHAIN_50_ VDD VSS sg13g2_buf_1
Xring/base_delay_stage_51_delay_cell_impl ring/base_delay_BASE_CHAIN_52_
+ ring/base_delay_BASE_CHAIN_51_ VDD VSS sg13g2_buf_1
Xring/base_delay_stage_52_delay_cell_impl ring/base_delay_BASE_CHAIN_53_
+ ring/base_delay_BASE_CHAIN_52_ VDD VSS sg13g2_buf_1
Xring/base_delay_stage_53_delay_cell_impl ring/base_delay_BASE_CHAIN_54_
+ ring/base_delay_BASE_CHAIN_53_ VDD VSS sg13g2_buf_1
Xring/base_delay_stage_54_delay_cell_impl ring/base_delay_BASE_CHAIN_55_
+ ring/base_delay_BASE_CHAIN_54_ VDD VSS sg13g2_buf_1
Xring/base_delay_stage_55_delay_cell_impl ring/base_delay_BASE_CHAIN_56_
+ ring/base_delay_BASE_CHAIN_55_ VDD VSS sg13g2_buf_1
Xring/base_delay_stage_56_delay_cell_impl ring/base_delay_BASE_CHAIN_57_
+ ring/base_delay_BASE_CHAIN_56_ VDD VSS sg13g2_buf_1
Xring/base_delay_stage_57_delay_cell_impl ring/base_delay_BASE_CHAIN_58_
+ ring/base_delay_BASE_CHAIN_57_ VDD VSS sg13g2_buf_1
Xring/base_delay_stage_58_delay_cell_impl ring/base_delay_BASE_CHAIN_59_
+ ring/base_delay_BASE_CHAIN_58_ VDD VSS sg13g2_buf_1
Xring/base_delay_stage_59_delay_cell_impl ring/base_delay_BASE_CHAIN_60_
+ ring/base_delay_BASE_CHAIN_59_ VDD VSS sg13g2_buf_1
Xring/base_delay_stage_5_delay_cell_impl ring/base_delay_BASE_CHAIN_6_
+ ring/base_delay_BASE_CHAIN_5_ VDD VSS sg13g2_buf_1
Xring/base_delay_stage_60_delay_cell_impl ring/base_delay_BASE_CHAIN_61_
+ ring/base_delay_BASE_CHAIN_60_ VDD VSS sg13g2_buf_1
Xring/base_delay_stage_61_delay_cell_impl ring/base_delay_BASE_CHAIN_62_
+ ring/base_delay_BASE_CHAIN_61_ VDD VSS sg13g2_buf_1
Xring/base_delay_stage_62_delay_cell_impl ring/base_delay_BASE_CHAIN_63_
+ ring/base_delay_BASE_CHAIN_62_ VDD VSS sg13g2_buf_1
Xring/base_delay_stage_63_delay_cell_impl ring/base_delay_BASE_CHAIN_64_
+ ring/base_delay_BASE_CHAIN_63_ VDD VSS sg13g2_buf_1
Xring/base_delay_stage_64_delay_cell_impl ring/base_delay_BASE_CHAIN_65_
+ ring/base_delay_BASE_CHAIN_64_ VDD VSS sg13g2_buf_1
Xring/base_delay_stage_65_delay_cell_impl ring/base_delay_BASE_CHAIN_66_
+ ring/base_delay_BASE_CHAIN_65_ VDD VSS sg13g2_buf_1
Xring/base_delay_stage_66_delay_cell_impl ring/base_delay_BASE_CHAIN_67_
+ ring/base_delay_BASE_CHAIN_66_ VDD VSS sg13g2_buf_1
Xring/base_delay_stage_67_delay_cell_impl ring/base_delay_BASE_CHAIN_68_
+ ring/base_delay_BASE_CHAIN_67_ VDD VSS sg13g2_buf_1
Xring/base_delay_stage_68_delay_cell_impl ring/base_delay_BASE_CHAIN_69_
+ ring/base_delay_BASE_CHAIN_68_ VDD VSS sg13g2_buf_1
Xring/base_delay_stage_69_delay_cell_impl ring/base_delay_BASE_CHAIN_70_
+ ring/base_delay_BASE_CHAIN_69_ VDD VSS sg13g2_buf_1
Xring/base_delay_stage_6_delay_cell_impl ring/base_delay_BASE_CHAIN_7_
+ ring/base_delay_BASE_CHAIN_6_ VDD VSS sg13g2_buf_1
Xring/base_delay_stage_70_delay_cell_impl ring/base_delay_BASE_CHAIN_71_
+ ring/base_delay_BASE_CHAIN_70_ VDD VSS sg13g2_buf_1
Xring/base_delay_stage_71_delay_cell_impl ring/base_delay_BASE_CHAIN_72_
+ ring/base_delay_BASE_CHAIN_71_ VDD VSS sg13g2_buf_1
Xring/base_delay_stage_72_delay_cell_impl ring/base_delay_BASE_CHAIN_73_
+ ring/base_delay_BASE_CHAIN_72_ VDD VSS sg13g2_buf_1
Xring/base_delay_stage_73_delay_cell_impl ring/base_delay_BASE_CHAIN_74_
+ ring/base_delay_BASE_CHAIN_73_ VDD VSS sg13g2_buf_1
Xring/base_delay_stage_74_delay_cell_impl ring/base_delay_BASE_CHAIN_75_
+ ring/base_delay_BASE_CHAIN_74_ VDD VSS sg13g2_buf_1
Xring/base_delay_stage_75_delay_cell_impl ring/base_delay_BASE_CHAIN_76_
+ ring/base_delay_BASE_CHAIN_75_ VDD VSS sg13g2_buf_1
Xring/base_delay_stage_76_delay_cell_impl ring/base_delay_BASE_CHAIN_77_
+ ring/base_delay_BASE_CHAIN_76_ VDD VSS sg13g2_buf_1
Xring/base_delay_stage_77_delay_cell_impl ring/base_delay_BASE_CHAIN_78_
+ ring/base_delay_BASE_CHAIN_77_ VDD VSS sg13g2_buf_1
Xring/base_delay_stage_78_delay_cell_impl ring/base_delay_BASE_CHAIN_79_
+ ring/base_delay_BASE_CHAIN_78_ VDD VSS sg13g2_buf_1
Xring/base_delay_stage_79_delay_cell_impl ring/base_delay_BASE_CHAIN_80_
+ ring/base_delay_BASE_CHAIN_79_ VDD VSS sg13g2_buf_1
Xring/base_delay_stage_7_delay_cell_impl ring/base_delay_BASE_CHAIN_8_
+ ring/base_delay_BASE_CHAIN_7_ VDD VSS sg13g2_buf_1
Xring/base_delay_stage_80_delay_cell_impl ring/base_delay_BASE_CHAIN_81_
+ ring/base_delay_BASE_CHAIN_80_ VDD VSS sg13g2_buf_1
Xring/base_delay_stage_81_delay_cell_impl ring/base_delay_BASE_CHAIN_82_
+ ring/base_delay_BASE_CHAIN_81_ VDD VSS sg13g2_buf_1
Xring/base_delay_stage_82_delay_cell_impl ring/base_delay_BASE_CHAIN_83_
+ ring/base_delay_BASE_CHAIN_82_ VDD VSS sg13g2_buf_1
Xring/base_delay_stage_83_delay_cell_impl ring/base_delay_BASE_CHAIN_84_
+ ring/base_delay_BASE_CHAIN_83_ VDD VSS sg13g2_buf_1
Xring/base_delay_stage_84_delay_cell_impl ring/base_delay_BASE_CHAIN_85_
+ ring/base_delay_BASE_CHAIN_84_ VDD VSS sg13g2_buf_1
Xring/base_delay_stage_85_delay_cell_impl ring/base_delay_BASE_CHAIN_86_
+ ring/base_delay_BASE_CHAIN_85_ VDD VSS sg13g2_buf_1
Xring/base_delay_stage_86_delay_cell_impl ring/base_delay_BASE_CHAIN_87_
+ ring/base_delay_BASE_CHAIN_86_ VDD VSS sg13g2_buf_1
Xring/base_delay_stage_87_delay_cell_impl ring/base_delay_BASE_CHAIN_88_
+ ring/base_delay_BASE_CHAIN_87_ VDD VSS sg13g2_buf_1
Xring/base_delay_stage_88_delay_cell_impl ring/base_delay_BASE_CHAIN_89_
+ ring/base_delay_BASE_CHAIN_88_ VDD VSS sg13g2_buf_1
Xring/base_delay_stage_89_delay_cell_impl ring/base_delay_BASE_CHAIN_90_
+ ring/base_delay_BASE_CHAIN_89_ VDD VSS sg13g2_buf_1
Xring/base_delay_stage_8_delay_cell_impl ring/base_delay_BASE_CHAIN_9_
+ ring/base_delay_BASE_CHAIN_8_ VDD VSS sg13g2_buf_1
Xring/base_delay_stage_90_delay_cell_impl ring/base_delay_BASE_CHAIN_91_
+ ring/base_delay_BASE_CHAIN_90_ VDD VSS sg13g2_buf_1
Xring/base_delay_stage_91_delay_cell_impl ring/base_delay_BASE_CHAIN_92_
+ ring/base_delay_BASE_CHAIN_91_ VDD VSS sg13g2_buf_1
Xring/base_delay_stage_92_delay_cell_impl ring/base_delay_BASE_CHAIN_93_
+ ring/base_delay_BASE_CHAIN_92_ VDD VSS sg13g2_buf_1
Xring/base_delay_stage_93_delay_cell_impl ring/base_delay_BASE_CHAIN_94_
+ ring/base_delay_BASE_CHAIN_93_ VDD VSS sg13g2_buf_1
Xring/base_delay_stage_94_delay_cell_impl ring/base_delay_BASE_CHAIN_95_
+ ring/base_delay_BASE_CHAIN_94_ VDD VSS sg13g2_buf_1
Xring/base_delay_stage_95_delay_cell_impl ring/base_delay_BASE_CHAIN_96_
+ ring/base_delay_BASE_CHAIN_95_ VDD VSS sg13g2_buf_1
Xring/base_delay_stage_96_delay_cell_impl ring/base_delay_BASE_CHAIN_97_
+ ring/base_delay_BASE_CHAIN_96_ VDD VSS sg13g2_buf_1
Xring/base_delay_stage_97_delay_cell_impl ring/base_delay_BASE_CHAIN_98_
+ ring/base_delay_BASE_CHAIN_97_ VDD VSS sg13g2_buf_1
Xring/base_delay_stage_98_delay_cell_impl ring/base_delay_BASE_CHAIN_99_
+ ring/base_delay_BASE_CHAIN_98_ VDD VSS sg13g2_buf_1
Xring/base_delay_stage_99_delay_cell_impl ring/base_delay_BASE_CHAIN_100_
+ ring/base_delay_BASE_CHAIN_99_ VDD VSS sg13g2_buf_1
Xring/base_delay_stage_9_delay_cell_impl ring/base_delay_BASE_CHAIN_10_
+ ring/base_delay_BASE_CHAIN_9_ VDD VSS sg13g2_buf_1
Xring/coarse/impl_last_impl ring/coarse/RCHAIN_15_ ring/coarse/FCHAIN_15_
+ VDD VSS sg13g2_buf_1
Xring/coarse/stage_0_impl/dwn_impl ring/COARSE_OUT ring/coarse/stage_0_impl/PATH_0
+ ring/coarse/RCHAIN_1_ VDD VSS sg13g2_nand2_1
Xring/coarse/stage_0_impl/mid_impl ring/coarse/stage_0_impl/PATH_0
+ COARSE_MUX[0] ring/DCO_IN VDD VSS sg13g2_nand2b_1
Xring/coarse/stage_0_impl/upp_impl ring/coarse/FCHAIN_1_ COARSE_MUX[0]
+ ring/DCO_IN VDD VSS sg13g2_nand2_1
Xring/coarse/stage_10_impl/dwn_impl ring/coarse/RCHAIN_10_
+ ring/coarse/stage_10_impl/PATH_0 ring/coarse/RCHAIN_11_ VDD
+ VSS sg13g2_nand2_1
Xring/coarse/stage_10_impl/mid_impl ring/coarse/stage_10_impl/PATH_0
+ COARSE_MUX[10] ring/coarse/FCHAIN_10_ VDD VSS sg13g2_nand2b_1
Xring/coarse/stage_10_impl/upp_impl ring/coarse/FCHAIN_11_
+ COARSE_MUX[10] ring/coarse/FCHAIN_10_ VDD VSS sg13g2_nand2_1
Xring/coarse/stage_11_impl/dwn_impl ring/coarse/RCHAIN_11_
+ ring/coarse/stage_11_impl/PATH_0 ring/coarse/RCHAIN_12_ VDD
+ VSS sg13g2_nand2_1
Xring/coarse/stage_11_impl/mid_impl ring/coarse/stage_11_impl/PATH_0
+ COARSE_MUX[11] ring/coarse/FCHAIN_11_ VDD VSS sg13g2_nand2b_1
Xring/coarse/stage_11_impl/upp_impl ring/coarse/FCHAIN_12_
+ COARSE_MUX[11] ring/coarse/FCHAIN_11_ VDD VSS sg13g2_nand2_1
Xring/coarse/stage_12_impl/dwn_impl ring/coarse/RCHAIN_12_
+ ring/coarse/stage_12_impl/PATH_0 ring/coarse/RCHAIN_13_ VDD
+ VSS sg13g2_nand2_1
Xring/coarse/stage_12_impl/mid_impl ring/coarse/stage_12_impl/PATH_0
+ COARSE_MUX[12] ring/coarse/FCHAIN_12_ VDD VSS sg13g2_nand2b_1
Xring/coarse/stage_12_impl/upp_impl ring/coarse/FCHAIN_13_
+ COARSE_MUX[12] ring/coarse/FCHAIN_12_ VDD VSS sg13g2_nand2_1
Xring/coarse/stage_13_impl/dwn_impl ring/coarse/RCHAIN_13_
+ ring/coarse/stage_13_impl/PATH_0 ring/coarse/RCHAIN_14_ VDD
+ VSS sg13g2_nand2_1
Xring/coarse/stage_13_impl/mid_impl ring/coarse/stage_13_impl/PATH_0
+ COARSE_MUX[13] ring/coarse/FCHAIN_13_ VDD VSS sg13g2_nand2b_1
Xring/coarse/stage_13_impl/upp_impl ring/coarse/FCHAIN_14_
+ COARSE_MUX[13] ring/coarse/FCHAIN_13_ VDD VSS sg13g2_nand2_1
Xring/coarse/stage_14_impl/dwn_impl ring/coarse/RCHAIN_14_
+ ring/coarse/stage_14_impl/PATH_0 ring/coarse/RCHAIN_15_ VDD
+ VSS sg13g2_nand2_1
Xring/coarse/stage_14_impl/mid_impl ring/coarse/stage_14_impl/PATH_0
+ COARSE_MUX[14] ring/coarse/FCHAIN_14_ VDD VSS sg13g2_nand2b_1
Xring/coarse/stage_14_impl/upp_impl ring/coarse/FCHAIN_15_
+ COARSE_MUX[14] ring/coarse/FCHAIN_14_ VDD VSS sg13g2_nand2_1
Xring/coarse/stage_1_impl/dwn_impl ring/coarse/RCHAIN_1_ ring/coarse/stage_1_impl/PATH_0
+ ring/coarse/RCHAIN_2_ VDD VSS sg13g2_nand2_1
Xring/coarse/stage_1_impl/mid_impl ring/coarse/stage_1_impl/PATH_0
+ COARSE_MUX[1] ring/coarse/FCHAIN_1_ VDD VSS sg13g2_nand2b_1
Xring/coarse/stage_1_impl/upp_impl ring/coarse/FCHAIN_2_ COARSE_MUX[1]
+ ring/coarse/FCHAIN_1_ VDD VSS sg13g2_nand2_1
Xring/coarse/stage_2_impl/dwn_impl ring/coarse/RCHAIN_2_ ring/coarse/stage_2_impl/PATH_0
+ ring/coarse/RCHAIN_3_ VDD VSS sg13g2_nand2_1
Xring/coarse/stage_2_impl/mid_impl ring/coarse/stage_2_impl/PATH_0
+ COARSE_MUX[2] ring/coarse/FCHAIN_2_ VDD VSS sg13g2_nand2b_1
Xring/coarse/stage_2_impl/upp_impl ring/coarse/FCHAIN_3_ COARSE_MUX[2]
+ ring/coarse/FCHAIN_2_ VDD VSS sg13g2_nand2_1
Xring/coarse/stage_3_impl/dwn_impl ring/coarse/RCHAIN_3_ ring/coarse/stage_3_impl/PATH_0
+ ring/coarse/RCHAIN_4_ VDD VSS sg13g2_nand2_1
Xring/coarse/stage_3_impl/mid_impl ring/coarse/stage_3_impl/PATH_0
+ COARSE_MUX[3] ring/coarse/FCHAIN_3_ VDD VSS sg13g2_nand2b_1
Xring/coarse/stage_3_impl/upp_impl ring/coarse/FCHAIN_4_ COARSE_MUX[3]
+ ring/coarse/FCHAIN_3_ VDD VSS sg13g2_nand2_1
Xring/coarse/stage_4_impl/dwn_impl ring/coarse/RCHAIN_4_ ring/coarse/stage_4_impl/PATH_0
+ ring/coarse/RCHAIN_5_ VDD VSS sg13g2_nand2_1
Xring/coarse/stage_4_impl/mid_impl ring/coarse/stage_4_impl/PATH_0
+ COARSE_MUX[4] ring/coarse/FCHAIN_4_ VDD VSS sg13g2_nand2b_1
Xring/coarse/stage_4_impl/upp_impl ring/coarse/FCHAIN_5_ COARSE_MUX[4]
+ ring/coarse/FCHAIN_4_ VDD VSS sg13g2_nand2_1
Xring/coarse/stage_5_impl/dwn_impl ring/coarse/RCHAIN_5_ ring/coarse/stage_5_impl/PATH_0
+ ring/coarse/RCHAIN_6_ VDD VSS sg13g2_nand2_1
Xring/coarse/stage_5_impl/mid_impl ring/coarse/stage_5_impl/PATH_0
+ COARSE_MUX[5] ring/coarse/FCHAIN_5_ VDD VSS sg13g2_nand2b_1
Xring/coarse/stage_5_impl/upp_impl ring/coarse/FCHAIN_6_ COARSE_MUX[5]
+ ring/coarse/FCHAIN_5_ VDD VSS sg13g2_nand2_1
Xring/coarse/stage_6_impl/dwn_impl ring/coarse/RCHAIN_6_ ring/coarse/stage_6_impl/PATH_0
+ ring/coarse/RCHAIN_7_ VDD VSS sg13g2_nand2_1
Xring/coarse/stage_6_impl/mid_impl ring/coarse/stage_6_impl/PATH_0
+ COARSE_MUX[6] ring/coarse/FCHAIN_6_ VDD VSS sg13g2_nand2b_1
Xring/coarse/stage_6_impl/upp_impl ring/coarse/FCHAIN_7_ COARSE_MUX[6]
+ ring/coarse/FCHAIN_6_ VDD VSS sg13g2_nand2_1
Xring/coarse/stage_7_impl/dwn_impl ring/coarse/RCHAIN_7_ ring/coarse/stage_7_impl/PATH_0
+ ring/coarse/RCHAIN_8_ VDD VSS sg13g2_nand2_1
Xring/coarse/stage_7_impl/mid_impl ring/coarse/stage_7_impl/PATH_0
+ COARSE_MUX[7] ring/coarse/FCHAIN_7_ VDD VSS sg13g2_nand2b_1
Xring/coarse/stage_7_impl/upp_impl ring/coarse/FCHAIN_8_ COARSE_MUX[7]
+ ring/coarse/FCHAIN_7_ VDD VSS sg13g2_nand2_1
Xring/coarse/stage_8_impl/dwn_impl ring/coarse/RCHAIN_8_ ring/coarse/stage_8_impl/PATH_0
+ ring/coarse/RCHAIN_9_ VDD VSS sg13g2_nand2_1
Xring/coarse/stage_8_impl/mid_impl ring/coarse/stage_8_impl/PATH_0
+ COARSE_MUX[8] ring/coarse/FCHAIN_8_ VDD VSS sg13g2_nand2b_1
Xring/coarse/stage_8_impl/upp_impl ring/coarse/FCHAIN_9_ COARSE_MUX[8]
+ ring/coarse/FCHAIN_8_ VDD VSS sg13g2_nand2_1
Xring/coarse/stage_9_impl/dwn_impl ring/coarse/RCHAIN_9_ ring/coarse/stage_9_impl/PATH_0
+ ring/coarse/RCHAIN_10_ VDD VSS sg13g2_nand2_1
Xring/coarse/stage_9_impl/mid_impl ring/coarse/stage_9_impl/PATH_0
+ COARSE_MUX[9] ring/coarse/FCHAIN_9_ VDD VSS sg13g2_nand2b_1
Xring/coarse/stage_9_impl/upp_impl ring/coarse/FCHAIN_10_
+ COARSE_MUX[9] ring/coarse/FCHAIN_9_ VDD VSS sg13g2_nand2_1
Xring/dff_x_impl SS_BBPD[1] _unconnected_0 ring/dff_x_CLK
+ ring/SS_BBPD_WIRE_1_ ring/dff_x_RESET_B VDD VSS sg13g2_dfrbp_1
Xring/dff_x_impl_inv ring/dff_x_CLK REF VDD VSS sg13g2_inv_1
Xring/dff_x_impl_tiehi ring/dff_x_RESET_B VDD VSS sg13g2_tiehi
Xring/dff_y_impl SS_BBPD[0] _unconnected_1 ring/dff_y_CLK
+ ring/SS_BBPD_WIRE_0_ ring/dff_y_RESET_B VDD VSS sg13g2_dfrbp_1
Xring/dff_y_impl_inv ring/dff_y_CLK REF VDD VSS sg13g2_inv_1
Xring/dff_y_impl_tiehi ring/dff_y_RESET_B VDD VSS sg13g2_tiehi
Xring/fine/inv_0_impl ring/fine/LOAD MID_OUT VDD VSS sg13g2_inv_4
Xring/fine/inv_1_impl ring/FINE_OUT ring/fine/net4 VDD VSS
+ sg13g2_inv_4
Xring/fine/stage_0_dyn_impl ring/fine/UNCONNECTED_0_ ring/fine/MUXB_0_
+ ring/fine/net3 FINE_MUX[0] VDD VSS sg13g2_nand3_1
Xring/fine/stage_0_inv_b_impl ring/fine/MUXB_0_ FINE_MUX[0]
+ VDD VSS sg13g2_inv_1
Xring/fine/stage_10_dyn_impl ring/fine/UNCONNECTED_10_ ring/fine/MUXB_10_
+ ring/fine/net2 FINE_MUX[10] VDD VSS sg13g2_nand3_1
Xring/fine/stage_10_inv_b_impl ring/fine/MUXB_10_ FINE_MUX[10]
+ VDD VSS sg13g2_inv_1
Xring/fine/stage_11_dyn_impl ring/fine/UNCONNECTED_11_ ring/fine/MUXB_11_
+ ring/fine/net3 FINE_MUX[11] VDD VSS sg13g2_nand3_1
Xring/fine/stage_11_inv_b_impl ring/fine/MUXB_11_ FINE_MUX[11]
+ VDD VSS sg13g2_inv_1
Xring/fine/stage_12_dyn_impl ring/fine/UNCONNECTED_12_ ring/fine/MUXB_12_
+ ring/fine/net4 FINE_MUX[12] VDD VSS sg13g2_nand3_1
Xring/fine/stage_12_inv_b_impl ring/fine/MUXB_12_ FINE_MUX[12]
+ VDD VSS sg13g2_inv_1
Xring/fine/stage_13_dyn_impl ring/fine/UNCONNECTED_13_ ring/fine/MUXB_13_
+ ring/fine/net2 FINE_MUX[13] VDD VSS sg13g2_nand3_1
Xring/fine/stage_13_inv_b_impl ring/fine/MUXB_13_ FINE_MUX[13]
+ VDD VSS sg13g2_inv_1
Xring/fine/stage_14_dyn_impl ring/fine/UNCONNECTED_14_ ring/fine/MUXB_14_
+ ring/fine/net1 FINE_MUX[14] VDD VSS sg13g2_nand3_1
Xring/fine/stage_14_inv_b_impl ring/fine/MUXB_14_ FINE_MUX[14]
+ VDD VSS sg13g2_inv_1
Xring/fine/stage_15_dyn_impl ring/fine/UNCONNECTED_15_ ring/fine/MUXB_15_
+ ring/fine/net1 FINE_MUX[15] VDD VSS sg13g2_nand3_1
Xring/fine/stage_15_inv_b_impl ring/fine/MUXB_15_ FINE_MUX[15]
+ VDD VSS sg13g2_inv_1
Xring/fine/stage_16_dyn_impl ring/fine/UNCONNECTED_16_ ring/fine/MUXB_16_
+ ring/fine/net4 FINE_MUX[16] VDD VSS sg13g2_nand3_1
Xring/fine/stage_16_inv_b_impl ring/fine/MUXB_16_ FINE_MUX[16]
+ VDD VSS sg13g2_inv_1
Xring/fine/stage_17_dyn_impl ring/fine/UNCONNECTED_17_ ring/fine/MUXB_17_
+ ring/fine/net3 FINE_MUX[17] VDD VSS sg13g2_nand3_1
Xring/fine/stage_17_inv_b_impl ring/fine/MUXB_17_ FINE_MUX[17]
+ VDD VSS sg13g2_inv_1
Xring/fine/stage_18_dyn_impl ring/fine/UNCONNECTED_18_ ring/fine/MUXB_18_
+ ring/fine/net4 FINE_MUX[18] VDD VSS sg13g2_nand3_1
Xring/fine/stage_18_inv_b_impl ring/fine/MUXB_18_ FINE_MUX[18]
+ VDD VSS sg13g2_inv_1
Xring/fine/stage_19_dyn_impl ring/fine/UNCONNECTED_19_ ring/fine/MUXB_19_
+ ring/fine/net2 FINE_MUX[19] VDD VSS sg13g2_nand3_1
Xring/fine/stage_19_inv_b_impl ring/fine/MUXB_19_ FINE_MUX[19]
+ VDD VSS sg13g2_inv_1
Xring/fine/stage_1_dyn_impl ring/fine/UNCONNECTED_1_ ring/fine/MUXB_1_
+ ring/fine/net3 FINE_MUX[1] VDD VSS sg13g2_nand3_1
Xring/fine/stage_1_inv_b_impl ring/fine/MUXB_1_ FINE_MUX[1]
+ VDD VSS sg13g2_inv_1
Xring/fine/stage_20_dyn_impl ring/fine/UNCONNECTED_20_ ring/fine/MUXB_20_
+ ring/fine/net4 FINE_MUX[20] VDD VSS sg13g2_nand3_1
Xring/fine/stage_20_inv_b_impl ring/fine/MUXB_20_ FINE_MUX[20]
+ VDD VSS sg13g2_inv_1
Xring/fine/stage_21_dyn_impl ring/fine/UNCONNECTED_21_ ring/fine/MUXB_21_
+ ring/fine/net2 FINE_MUX[21] VDD VSS sg13g2_nand3_1
Xring/fine/stage_21_inv_b_impl ring/fine/MUXB_21_ FINE_MUX[21]
+ VDD VSS sg13g2_inv_1
Xring/fine/stage_22_dyn_impl ring/fine/UNCONNECTED_22_ ring/fine/MUXB_22_
+ ring/fine/net1 FINE_MUX[22] VDD VSS sg13g2_nand3_1
Xring/fine/stage_22_inv_b_impl ring/fine/MUXB_22_ FINE_MUX[22]
+ VDD VSS sg13g2_inv_1
Xring/fine/stage_23_dyn_impl ring/fine/UNCONNECTED_23_ ring/fine/MUXB_23_
+ ring/fine/net4 FINE_MUX[23] VDD VSS sg13g2_nand3_1
Xring/fine/stage_23_inv_b_impl ring/fine/MUXB_23_ FINE_MUX[23]
+ VDD VSS sg13g2_inv_1
Xring/fine/stage_24_dyn_impl ring/fine/UNCONNECTED_24_ ring/fine/MUXB_24_
+ ring/fine/net2 FINE_MUX[24] VDD VSS sg13g2_nand3_1
Xring/fine/stage_24_inv_b_impl ring/fine/MUXB_24_ FINE_MUX[24]
+ VDD VSS sg13g2_inv_1
Xring/fine/stage_25_dyn_impl ring/fine/UNCONNECTED_25_ ring/fine/MUXB_25_
+ ring/fine/net1 FINE_MUX[25] VDD VSS sg13g2_nand3_1
Xring/fine/stage_25_inv_b_impl ring/fine/MUXB_25_ FINE_MUX[25]
+ VDD VSS sg13g2_inv_1
Xring/fine/stage_26_dyn_impl ring/fine/UNCONNECTED_26_ ring/fine/MUXB_26_
+ ring/fine/net4 FINE_MUX[26] VDD VSS sg13g2_nand3_1
Xring/fine/stage_26_inv_b_impl ring/fine/MUXB_26_ FINE_MUX[26]
+ VDD VSS sg13g2_inv_1
Xring/fine/stage_27_dyn_impl ring/fine/UNCONNECTED_27_ ring/fine/MUXB_27_
+ ring/fine/net4 FINE_MUX[27] VDD VSS sg13g2_nand3_1
Xring/fine/stage_27_inv_b_impl ring/fine/MUXB_27_ FINE_MUX[27]
+ VDD VSS sg13g2_inv_1
Xring/fine/stage_28_dyn_impl ring/fine/UNCONNECTED_28_ ring/fine/MUXB_28_
+ ring/fine/net3 FINE_MUX[28] VDD VSS sg13g2_nand3_1
Xring/fine/stage_28_inv_b_impl ring/fine/MUXB_28_ FINE_MUX[28]
+ VDD VSS sg13g2_inv_1
Xring/fine/stage_29_dyn_impl ring/fine/UNCONNECTED_29_ ring/fine/MUXB_29_
+ ring/fine/net1 FINE_MUX[29] VDD VSS sg13g2_nand3_1
Xring/fine/stage_29_inv_b_impl ring/fine/MUXB_29_ FINE_MUX[29]
+ VDD VSS sg13g2_inv_1
Xring/fine/stage_2_dyn_impl ring/fine/UNCONNECTED_2_ ring/fine/MUXB_2_
+ ring/fine/net2 FINE_MUX[2] VDD VSS sg13g2_nand3_1
Xring/fine/stage_2_inv_b_impl ring/fine/MUXB_2_ FINE_MUX[2]
+ VDD VSS sg13g2_inv_1
Xring/fine/stage_30_dyn_impl ring/fine/UNCONNECTED_30_ ring/fine/MUXB_30_
+ ring/fine/net3 FINE_MUX[30] VDD VSS sg13g2_nand3_1
Xring/fine/stage_30_inv_b_impl ring/fine/MUXB_30_ FINE_MUX[30]
+ VDD VSS sg13g2_inv_1
Xring/fine/stage_3_dyn_impl ring/fine/UNCONNECTED_3_ ring/fine/MUXB_3_
+ ring/fine/net2 FINE_MUX[3] VDD VSS sg13g2_nand3_1
Xring/fine/stage_3_inv_b_impl ring/fine/MUXB_3_ FINE_MUX[3]
+ VDD VSS sg13g2_inv_1
Xring/fine/stage_4_dyn_impl ring/fine/UNCONNECTED_4_ ring/fine/MUXB_4_
+ ring/fine/net1 FINE_MUX[4] VDD VSS sg13g2_nand3_1
Xring/fine/stage_4_inv_b_impl ring/fine/MUXB_4_ FINE_MUX[4]
+ VDD VSS sg13g2_inv_1
Xring/fine/stage_5_dyn_impl ring/fine/UNCONNECTED_5_ ring/fine/MUXB_5_
+ ring/fine/net3 FINE_MUX[5] VDD VSS sg13g2_nand3_1
Xring/fine/stage_5_inv_b_impl ring/fine/MUXB_5_ FINE_MUX[5]
+ VDD VSS sg13g2_inv_1
Xring/fine/stage_6_dyn_impl ring/fine/UNCONNECTED_6_ ring/fine/MUXB_6_
+ ring/fine/net5 FINE_MUX[6] VDD VSS sg13g2_nand3_1
Xring/fine/stage_6_inv_b_impl ring/fine/MUXB_6_ FINE_MUX[6]
+ VDD VSS sg13g2_inv_1
Xring/fine/stage_7_dyn_impl ring/fine/UNCONNECTED_7_ ring/fine/MUXB_7_
+ ring/fine/net1 FINE_MUX[7] VDD VSS sg13g2_nand3_1
Xring/fine/stage_7_inv_b_impl ring/fine/MUXB_7_ FINE_MUX[7]
+ VDD VSS sg13g2_inv_1
Xring/fine/stage_8_dyn_impl ring/fine/UNCONNECTED_8_ ring/fine/MUXB_8_
+ ring/fine/net1 FINE_MUX[8] VDD VSS sg13g2_nand3_1
Xring/fine/stage_8_inv_b_impl ring/fine/MUXB_8_ FINE_MUX[8]
+ VDD VSS sg13g2_inv_1
Xring/fine/stage_9_dyn_impl ring/fine/UNCONNECTED_9_ ring/fine/MUXB_9_
+ ring/fine/net3 FINE_MUX[9] VDD VSS sg13g2_nand3_1
Xring/fine/stage_9_inv_b_impl ring/fine/MUXB_9_ FINE_MUX[9]
+ VDD VSS sg13g2_inv_1
Xring/mid/inv_0_impl ring/mid/LOAD ring/COARSE_OUT VDD VSS
+ sg13g2_inv_2
Xring/mid/inv_1_impl MID_OUT ring/mid/net25 VDD VSS sg13g2_inv_2
Xring/mid/stage_0_dyn_impl_0 ring/mid/UNCONNECTED_0_ ring/mid/MUXB_0_
+ ring/mid/net23 MID_MUX[0] VDD VSS sg13g2_nand3_1
Xring/mid/stage_0_dyn_impl_1 ring/mid/UNCONNECTED_0_ ring/mid/MUXB_0_
+ ring/mid/net23 MID_MUX[0] VDD VSS sg13g2_nand3_1
Xring/mid/stage_0_dyn_impl_2 ring/mid/UNCONNECTED_0_ ring/mid/MUXB_0_
+ ring/mid/net23 MID_MUX[0] VDD VSS sg13g2_nand3_1
Xring/mid/stage_0_dyn_impl_3 ring/mid/UNCONNECTED_0_ ring/mid/MUXB_0_
+ ring/mid/net26 MID_MUX[0] VDD VSS sg13g2_nand3_1
Xring/mid/stage_0_dyn_impl_4 ring/mid/UNCONNECTED_0_ ring/mid/MUXB_0_
+ ring/mid/net23 MID_MUX[0] VDD VSS sg13g2_nand3_1
Xring/mid/stage_0_dyn_impl_5 ring/mid/UNCONNECTED_0_ ring/mid/MUXB_0_
+ ring/mid/net23 MID_MUX[0] VDD VSS sg13g2_nand3_1
Xring/mid/stage_0_dyn_impl_6 ring/mid/UNCONNECTED_0_ ring/mid/MUXB_0_
+ ring/mid/net24 MID_MUX[0] VDD VSS sg13g2_nand3_1
Xring/mid/stage_0_dyn_impl_7 ring/mid/UNCONNECTED_0_ ring/mid/MUXB_0_
+ ring/mid/net26 MID_MUX[0] VDD VSS sg13g2_nand3_1
Xring/mid/stage_0_inv_b_impl ring/mid/MUXB_0_ MID_MUX[0] VDD
+ VSS sg13g2_inv_1
Xring/mid/stage_10_dyn_impl_0 ring/mid/UNCONNECTED_10_ ring/mid/MUXB_10_
+ ring/mid/net20 MID_MUX[10] VDD VSS sg13g2_nand3_1
Xring/mid/stage_10_dyn_impl_1 ring/mid/UNCONNECTED_10_ ring/mid/MUXB_10_
+ ring/mid/net25 MID_MUX[10] VDD VSS sg13g2_nand3_1
Xring/mid/stage_10_dyn_impl_2 ring/mid/UNCONNECTED_10_ ring/mid/MUXB_10_
+ ring/mid/net25 MID_MUX[10] VDD VSS sg13g2_nand3_1
Xring/mid/stage_10_dyn_impl_3 ring/mid/UNCONNECTED_10_ ring/mid/MUXB_10_
+ ring/mid/net20 MID_MUX[10] VDD VSS sg13g2_nand3_1
Xring/mid/stage_10_dyn_impl_4 ring/mid/UNCONNECTED_10_ ring/mid/MUXB_10_
+ ring/mid/net25 MID_MUX[10] VDD VSS sg13g2_nand3_1
Xring/mid/stage_10_dyn_impl_5 ring/mid/UNCONNECTED_10_ ring/mid/MUXB_10_
+ ring/mid/net25 MID_MUX[10] VDD VSS sg13g2_nand3_1
Xring/mid/stage_10_dyn_impl_6 ring/mid/UNCONNECTED_10_ ring/mid/MUXB_10_
+ ring/mid/net20 MID_MUX[10] VDD VSS sg13g2_nand3_1
Xring/mid/stage_10_dyn_impl_7 ring/mid/UNCONNECTED_10_ ring/mid/MUXB_10_
+ ring/mid/net26 MID_MUX[10] VDD VSS sg13g2_nand3_1
Xring/mid/stage_10_inv_b_impl ring/mid/MUXB_10_ MID_MUX[10]
+ VDD VSS sg13g2_inv_1
Xring/mid/stage_11_dyn_impl_0 ring/mid/UNCONNECTED_11_ ring/mid/MUXB_11_
+ ring/mid/net10 MID_MUX[11] VDD VSS sg13g2_nand3_1
Xring/mid/stage_11_dyn_impl_1 ring/mid/UNCONNECTED_11_ ring/mid/MUXB_11_
+ ring/mid/net8 MID_MUX[11] VDD VSS sg13g2_nand3_1
Xring/mid/stage_11_dyn_impl_2 ring/mid/UNCONNECTED_11_ ring/mid/MUXB_11_
+ ring/mid/net8 MID_MUX[11] VDD VSS sg13g2_nand3_1
Xring/mid/stage_11_dyn_impl_3 ring/mid/UNCONNECTED_11_ ring/mid/MUXB_11_
+ ring/mid/net10 MID_MUX[11] VDD VSS sg13g2_nand3_1
Xring/mid/stage_11_dyn_impl_4 ring/mid/UNCONNECTED_11_ ring/mid/MUXB_11_
+ ring/mid/net8 MID_MUX[11] VDD VSS sg13g2_nand3_1
Xring/mid/stage_11_dyn_impl_5 ring/mid/UNCONNECTED_11_ ring/mid/MUXB_11_
+ ring/mid/net10 MID_MUX[11] VDD VSS sg13g2_nand3_1
Xring/mid/stage_11_dyn_impl_6 ring/mid/UNCONNECTED_11_ ring/mid/MUXB_11_
+ ring/mid/net7 MID_MUX[11] VDD VSS sg13g2_nand3_1
Xring/mid/stage_11_dyn_impl_7 ring/mid/UNCONNECTED_11_ ring/mid/MUXB_11_
+ ring/mid/net12 MID_MUX[11] VDD VSS sg13g2_nand3_1
Xring/mid/stage_11_inv_b_impl ring/mid/MUXB_11_ MID_MUX[11]
+ VDD VSS sg13g2_inv_1
Xring/mid/stage_12_dyn_impl_0 ring/mid/UNCONNECTED_12_ ring/mid/MUXB_12_
+ ring/mid/net6 MID_MUX[12] VDD VSS sg13g2_nand3_1
Xring/mid/stage_12_dyn_impl_1 ring/mid/UNCONNECTED_12_ ring/mid/MUXB_12_
+ ring/mid/net6 MID_MUX[12] VDD VSS sg13g2_nand3_1
Xring/mid/stage_12_dyn_impl_2 ring/mid/UNCONNECTED_12_ ring/mid/MUXB_12_
+ ring/mid/net6 MID_MUX[12] VDD VSS sg13g2_nand3_1
Xring/mid/stage_12_dyn_impl_3 ring/mid/UNCONNECTED_12_ ring/mid/MUXB_12_
+ ring/mid/net6 MID_MUX[12] VDD VSS sg13g2_nand3_1
Xring/mid/stage_12_dyn_impl_4 ring/mid/UNCONNECTED_12_ ring/mid/MUXB_12_
+ ring/mid/net6 MID_MUX[12] VDD VSS sg13g2_nand3_1
Xring/mid/stage_12_dyn_impl_5 ring/mid/UNCONNECTED_12_ ring/mid/MUXB_12_
+ ring/mid/net6 MID_MUX[12] VDD VSS sg13g2_nand3_1
Xring/mid/stage_12_dyn_impl_6 ring/mid/UNCONNECTED_12_ ring/mid/MUXB_12_
+ ring/mid/net6 MID_MUX[12] VDD VSS sg13g2_nand3_1
Xring/mid/stage_12_dyn_impl_7 ring/mid/UNCONNECTED_12_ ring/mid/MUXB_12_
+ ring/mid/net6 MID_MUX[12] VDD VSS sg13g2_nand3_1
Xring/mid/stage_12_inv_b_impl ring/mid/MUXB_12_ MID_MUX[12]
+ VDD VSS sg13g2_inv_1
Xring/mid/stage_13_dyn_impl_0 ring/mid/UNCONNECTED_13_ ring/mid/MUXB_13_
+ ring/mid/net22 MID_MUX[13] VDD VSS sg13g2_nand3_1
Xring/mid/stage_13_dyn_impl_1 ring/mid/UNCONNECTED_13_ ring/mid/MUXB_13_
+ ring/mid/net22 MID_MUX[13] VDD VSS sg13g2_nand3_1
Xring/mid/stage_13_dyn_impl_2 ring/mid/UNCONNECTED_13_ ring/mid/MUXB_13_
+ ring/mid/net22 MID_MUX[13] VDD VSS sg13g2_nand3_1
Xring/mid/stage_13_dyn_impl_3 ring/mid/UNCONNECTED_13_ ring/mid/MUXB_13_
+ ring/mid/net22 MID_MUX[13] VDD VSS sg13g2_nand3_1
Xring/mid/stage_13_dyn_impl_4 ring/mid/UNCONNECTED_13_ ring/mid/MUXB_13_
+ ring/mid/net22 MID_MUX[13] VDD VSS sg13g2_nand3_1
Xring/mid/stage_13_dyn_impl_5 ring/mid/UNCONNECTED_13_ ring/mid/MUXB_13_
+ ring/mid/net16 MID_MUX[13] VDD VSS sg13g2_nand3_1
Xring/mid/stage_13_dyn_impl_6 ring/mid/UNCONNECTED_13_ ring/mid/MUXB_13_
+ ring/mid/net22 MID_MUX[13] VDD VSS sg13g2_nand3_1
Xring/mid/stage_13_dyn_impl_7 ring/mid/UNCONNECTED_13_ ring/mid/MUXB_13_
+ ring/mid/net22 MID_MUX[13] VDD VSS sg13g2_nand3_1
Xring/mid/stage_13_inv_b_impl ring/mid/MUXB_13_ MID_MUX[13]
+ VDD VSS sg13g2_inv_1
Xring/mid/stage_14_dyn_impl_0 ring/mid/UNCONNECTED_14_ ring/mid/MUXB_14_
+ ring/mid/net25 MID_MUX[14] VDD VSS sg13g2_nand3_1
Xring/mid/stage_14_dyn_impl_1 ring/mid/UNCONNECTED_14_ ring/mid/MUXB_14_
+ ring/mid/net22 MID_MUX[14] VDD VSS sg13g2_nand3_1
Xring/mid/stage_14_dyn_impl_2 ring/mid/UNCONNECTED_14_ ring/mid/MUXB_14_
+ ring/mid/net25 MID_MUX[14] VDD VSS sg13g2_nand3_1
Xring/mid/stage_14_dyn_impl_3 ring/mid/UNCONNECTED_14_ ring/mid/MUXB_14_
+ ring/mid/net24 MID_MUX[14] VDD VSS sg13g2_nand3_1
Xring/mid/stage_14_dyn_impl_4 ring/mid/UNCONNECTED_14_ ring/mid/MUXB_14_
+ ring/mid/net24 MID_MUX[14] VDD VSS sg13g2_nand3_1
Xring/mid/stage_14_dyn_impl_5 ring/mid/UNCONNECTED_14_ ring/mid/MUXB_14_
+ ring/mid/net25 MID_MUX[14] VDD VSS sg13g2_nand3_1
Xring/mid/stage_14_dyn_impl_6 ring/mid/UNCONNECTED_14_ ring/mid/MUXB_14_
+ ring/mid/net24 MID_MUX[14] VDD VSS sg13g2_nand3_1
Xring/mid/stage_14_dyn_impl_7 ring/mid/UNCONNECTED_14_ ring/mid/MUXB_14_
+ ring/mid/net26 MID_MUX[14] VDD VSS sg13g2_nand3_1
Xring/mid/stage_14_inv_b_impl ring/mid/MUXB_14_ MID_MUX[14]
+ VDD VSS sg13g2_inv_1
Xring/mid/stage_1_dyn_impl_0 ring/mid/UNCONNECTED_1_ ring/mid/MUXB_1_
+ ring/mid/net20 MID_MUX[1] VDD VSS sg13g2_nand3_1
Xring/mid/stage_1_dyn_impl_1 ring/mid/UNCONNECTED_1_ ring/mid/MUXB_1_
+ ring/mid/net20 MID_MUX[1] VDD VSS sg13g2_nand3_1
Xring/mid/stage_1_dyn_impl_2 ring/mid/UNCONNECTED_1_ ring/mid/MUXB_1_
+ ring/mid/net21 MID_MUX[1] VDD VSS sg13g2_nand3_1
Xring/mid/stage_1_dyn_impl_3 ring/mid/UNCONNECTED_1_ ring/mid/MUXB_1_
+ ring/mid/net20 MID_MUX[1] VDD VSS sg13g2_nand3_1
Xring/mid/stage_1_dyn_impl_4 ring/mid/UNCONNECTED_1_ ring/mid/MUXB_1_
+ ring/mid/net20 MID_MUX[1] VDD VSS sg13g2_nand3_1
Xring/mid/stage_1_dyn_impl_5 ring/mid/UNCONNECTED_1_ ring/mid/MUXB_1_
+ ring/mid/net21 MID_MUX[1] VDD VSS sg13g2_nand3_1
Xring/mid/stage_1_dyn_impl_6 ring/mid/UNCONNECTED_1_ ring/mid/MUXB_1_
+ ring/mid/net21 MID_MUX[1] VDD VSS sg13g2_nand3_1
Xring/mid/stage_1_dyn_impl_7 ring/mid/UNCONNECTED_1_ ring/mid/MUXB_1_
+ ring/mid/net20 MID_MUX[1] VDD VSS sg13g2_nand3_1
Xring/mid/stage_1_inv_b_impl ring/mid/MUXB_1_ MID_MUX[1] VDD
+ VSS sg13g2_inv_1
Xring/mid/stage_2_dyn_impl_0 ring/mid/UNCONNECTED_2_ ring/mid/MUXB_2_
+ ring/mid/net17 MID_MUX[2] VDD VSS sg13g2_nand3_1
Xring/mid/stage_2_dyn_impl_1 ring/mid/UNCONNECTED_2_ ring/mid/MUXB_2_
+ ring/mid/net17 MID_MUX[2] VDD VSS sg13g2_nand3_1
Xring/mid/stage_2_dyn_impl_2 ring/mid/UNCONNECTED_2_ ring/mid/MUXB_2_
+ ring/mid/net19 MID_MUX[2] VDD VSS sg13g2_nand3_1
Xring/mid/stage_2_dyn_impl_3 ring/mid/UNCONNECTED_2_ ring/mid/MUXB_2_
+ ring/mid/net19 MID_MUX[2] VDD VSS sg13g2_nand3_1
Xring/mid/stage_2_dyn_impl_4 ring/mid/UNCONNECTED_2_ ring/mid/MUXB_2_
+ ring/mid/net17 MID_MUX[2] VDD VSS sg13g2_nand3_1
Xring/mid/stage_2_dyn_impl_5 ring/mid/UNCONNECTED_2_ ring/mid/MUXB_2_
+ ring/mid/net19 MID_MUX[2] VDD VSS sg13g2_nand3_1
Xring/mid/stage_2_dyn_impl_6 ring/mid/UNCONNECTED_2_ ring/mid/MUXB_2_
+ ring/mid/net19 MID_MUX[2] VDD VSS sg13g2_nand3_1
Xring/mid/stage_2_dyn_impl_7 ring/mid/UNCONNECTED_2_ ring/mid/MUXB_2_
+ ring/mid/net17 MID_MUX[2] VDD VSS sg13g2_nand3_1
Xring/mid/stage_2_inv_b_impl ring/mid/MUXB_2_ MID_MUX[2] VDD
+ VSS sg13g2_inv_1
Xring/mid/stage_3_dyn_impl_0 ring/mid/UNCONNECTED_3_ ring/mid/MUXB_3_
+ ring/mid/net13 MID_MUX[3] VDD VSS sg13g2_nand3_1
Xring/mid/stage_3_dyn_impl_1 ring/mid/UNCONNECTED_3_ ring/mid/MUXB_3_
+ ring/mid/net13 MID_MUX[3] VDD VSS sg13g2_nand3_1
Xring/mid/stage_3_dyn_impl_2 ring/mid/UNCONNECTED_3_ ring/mid/MUXB_3_
+ ring/mid/net13 MID_MUX[3] VDD VSS sg13g2_nand3_1
Xring/mid/stage_3_dyn_impl_3 ring/mid/UNCONNECTED_3_ ring/mid/MUXB_3_
+ ring/mid/net13 MID_MUX[3] VDD VSS sg13g2_nand3_1
Xring/mid/stage_3_dyn_impl_4 ring/mid/UNCONNECTED_3_ ring/mid/MUXB_3_
+ ring/mid/net13 MID_MUX[3] VDD VSS sg13g2_nand3_1
Xring/mid/stage_3_dyn_impl_5 ring/mid/UNCONNECTED_3_ ring/mid/MUXB_3_
+ ring/mid/net13 MID_MUX[3] VDD VSS sg13g2_nand3_1
Xring/mid/stage_3_dyn_impl_6 ring/mid/UNCONNECTED_3_ ring/mid/MUXB_3_
+ ring/mid/net13 MID_MUX[3] VDD VSS sg13g2_nand3_1
Xring/mid/stage_3_dyn_impl_7 ring/mid/UNCONNECTED_3_ ring/mid/MUXB_3_
+ ring/mid/net13 MID_MUX[3] VDD VSS sg13g2_nand3_1
Xring/mid/stage_3_inv_b_impl ring/mid/MUXB_3_ MID_MUX[3] VDD
+ VSS sg13g2_inv_1
Xring/mid/stage_4_dyn_impl_0 ring/mid/UNCONNECTED_4_ ring/mid/MUXB_4_
+ ring/mid/net15 MID_MUX[4] VDD VSS sg13g2_nand3_1
Xring/mid/stage_4_dyn_impl_1 ring/mid/UNCONNECTED_4_ ring/mid/MUXB_4_
+ ring/mid/net15 MID_MUX[4] VDD VSS sg13g2_nand3_1
Xring/mid/stage_4_dyn_impl_2 ring/mid/UNCONNECTED_4_ ring/mid/MUXB_4_
+ ring/mid/net15 MID_MUX[4] VDD VSS sg13g2_nand3_1
Xring/mid/stage_4_dyn_impl_3 ring/mid/UNCONNECTED_4_ ring/mid/MUXB_4_
+ ring/mid/net14 MID_MUX[4] VDD VSS sg13g2_nand3_1
Xring/mid/stage_4_dyn_impl_4 ring/mid/UNCONNECTED_4_ ring/mid/MUXB_4_
+ ring/mid/net14 MID_MUX[4] VDD VSS sg13g2_nand3_1
Xring/mid/stage_4_dyn_impl_5 ring/mid/UNCONNECTED_4_ ring/mid/MUXB_4_
+ ring/mid/net15 MID_MUX[4] VDD VSS sg13g2_nand3_1
Xring/mid/stage_4_dyn_impl_6 ring/mid/UNCONNECTED_4_ ring/mid/MUXB_4_
+ ring/mid/net14 MID_MUX[4] VDD VSS sg13g2_nand3_1
Xring/mid/stage_4_dyn_impl_7 ring/mid/UNCONNECTED_4_ ring/mid/MUXB_4_
+ ring/mid/net15 MID_MUX[4] VDD VSS sg13g2_nand3_1
Xring/mid/stage_4_inv_b_impl ring/mid/MUXB_4_ MID_MUX[4] VDD
+ VSS sg13g2_inv_1
Xring/mid/stage_5_dyn_impl_0 ring/mid/UNCONNECTED_5_ ring/mid/MUXB_5_
+ ring/mid/net10 MID_MUX[5] VDD VSS sg13g2_nand3_1
Xring/mid/stage_5_dyn_impl_1 ring/mid/UNCONNECTED_5_ ring/mid/MUXB_5_
+ ring/mid/net10 MID_MUX[5] VDD VSS sg13g2_nand3_1
Xring/mid/stage_5_dyn_impl_2 ring/mid/UNCONNECTED_5_ ring/mid/MUXB_5_
+ ring/mid/net11 MID_MUX[5] VDD VSS sg13g2_nand3_1
Xring/mid/stage_5_dyn_impl_3 ring/mid/UNCONNECTED_5_ ring/mid/MUXB_5_
+ ring/mid/net10 MID_MUX[5] VDD VSS sg13g2_nand3_1
Xring/mid/stage_5_dyn_impl_4 ring/mid/UNCONNECTED_5_ ring/mid/MUXB_5_
+ ring/mid/net10 MID_MUX[5] VDD VSS sg13g2_nand3_1
Xring/mid/stage_5_dyn_impl_5 ring/mid/UNCONNECTED_5_ ring/mid/MUXB_5_
+ ring/mid/net11 MID_MUX[5] VDD VSS sg13g2_nand3_1
Xring/mid/stage_5_dyn_impl_6 ring/mid/UNCONNECTED_5_ ring/mid/MUXB_5_
+ ring/mid/net10 MID_MUX[5] VDD VSS sg13g2_nand3_1
Xring/mid/stage_5_dyn_impl_7 ring/mid/UNCONNECTED_5_ ring/mid/MUXB_5_
+ ring/mid/net11 MID_MUX[5] VDD VSS sg13g2_nand3_1
Xring/mid/stage_5_inv_b_impl ring/mid/MUXB_5_ MID_MUX[5] VDD
+ VSS sg13g2_inv_1
Xring/mid/stage_6_dyn_impl_0 ring/mid/UNCONNECTED_6_ ring/mid/MUXB_6_
+ ring/mid/net7 MID_MUX[6] VDD VSS sg13g2_nand3_1
Xring/mid/stage_6_dyn_impl_1 ring/mid/UNCONNECTED_6_ ring/mid/MUXB_6_
+ ring/mid/net8 MID_MUX[6] VDD VSS sg13g2_nand3_1
Xring/mid/stage_6_dyn_impl_2 ring/mid/UNCONNECTED_6_ ring/mid/MUXB_6_
+ ring/mid/net7 MID_MUX[6] VDD VSS sg13g2_nand3_1
Xring/mid/stage_6_dyn_impl_3 ring/mid/UNCONNECTED_6_ ring/mid/MUXB_6_
+ ring/mid/net8 MID_MUX[6] VDD VSS sg13g2_nand3_1
Xring/mid/stage_6_dyn_impl_4 ring/mid/UNCONNECTED_6_ ring/mid/MUXB_6_
+ ring/mid/net7 MID_MUX[6] VDD VSS sg13g2_nand3_1
Xring/mid/stage_6_dyn_impl_5 ring/mid/UNCONNECTED_6_ ring/mid/MUXB_6_
+ ring/mid/net8 MID_MUX[6] VDD VSS sg13g2_nand3_1
Xring/mid/stage_6_dyn_impl_6 ring/mid/UNCONNECTED_6_ ring/mid/MUXB_6_
+ ring/mid/net8 MID_MUX[6] VDD VSS sg13g2_nand3_1
Xring/mid/stage_6_dyn_impl_7 ring/mid/UNCONNECTED_6_ ring/mid/MUXB_6_
+ ring/mid/net7 MID_MUX[6] VDD VSS sg13g2_nand3_1
Xring/mid/stage_6_inv_b_impl ring/mid/MUXB_6_ MID_MUX[6] VDD
+ VSS sg13g2_inv_1
Xring/mid/stage_7_dyn_impl_0 ring/mid/UNCONNECTED_7_ ring/mid/MUXB_7_
+ ring/mid/net17 MID_MUX[7] VDD VSS sg13g2_nand3_1
Xring/mid/stage_7_dyn_impl_1 ring/mid/UNCONNECTED_7_ ring/mid/MUXB_7_
+ ring/mid/net17 MID_MUX[7] VDD VSS sg13g2_nand3_1
Xring/mid/stage_7_dyn_impl_2 ring/mid/UNCONNECTED_7_ ring/mid/MUXB_7_
+ ring/mid/net18 MID_MUX[7] VDD VSS sg13g2_nand3_1
Xring/mid/stage_7_dyn_impl_3 ring/mid/UNCONNECTED_7_ ring/mid/MUXB_7_
+ ring/mid/net18 MID_MUX[7] VDD VSS sg13g2_nand3_1
Xring/mid/stage_7_dyn_impl_4 ring/mid/UNCONNECTED_7_ ring/mid/MUXB_7_
+ ring/mid/net18 MID_MUX[7] VDD VSS sg13g2_nand3_1
Xring/mid/stage_7_dyn_impl_5 ring/mid/UNCONNECTED_7_ ring/mid/MUXB_7_
+ ring/mid/net17 MID_MUX[7] VDD VSS sg13g2_nand3_1
Xring/mid/stage_7_dyn_impl_6 ring/mid/UNCONNECTED_7_ ring/mid/MUXB_7_
+ ring/mid/net18 MID_MUX[7] VDD VSS sg13g2_nand3_1
Xring/mid/stage_7_dyn_impl_7 ring/mid/UNCONNECTED_7_ ring/mid/MUXB_7_
+ ring/mid/net17 MID_MUX[7] VDD VSS sg13g2_nand3_1
Xring/mid/stage_7_inv_b_impl ring/mid/MUXB_7_ MID_MUX[7] VDD
+ VSS sg13g2_inv_1
Xring/mid/stage_8_dyn_impl_0 ring/mid/UNCONNECTED_8_ ring/mid/MUXB_8_
+ ring/mid/net15 MID_MUX[8] VDD VSS sg13g2_nand3_1
Xring/mid/stage_8_dyn_impl_1 ring/mid/UNCONNECTED_8_ ring/mid/MUXB_8_
+ ring/mid/net15 MID_MUX[8] VDD VSS sg13g2_nand3_1
Xring/mid/stage_8_dyn_impl_2 ring/mid/UNCONNECTED_8_ ring/mid/MUXB_8_
+ ring/mid/net15 MID_MUX[8] VDD VSS sg13g2_nand3_1
Xring/mid/stage_8_dyn_impl_3 ring/mid/UNCONNECTED_8_ ring/mid/MUXB_8_
+ ring/mid/net23 MID_MUX[8] VDD VSS sg13g2_nand3_1
Xring/mid/stage_8_dyn_impl_4 ring/mid/UNCONNECTED_8_ ring/mid/MUXB_8_
+ ring/mid/net16 MID_MUX[8] VDD VSS sg13g2_nand3_1
Xring/mid/stage_8_dyn_impl_5 ring/mid/UNCONNECTED_8_ ring/mid/MUXB_8_
+ ring/mid/net16 MID_MUX[8] VDD VSS sg13g2_nand3_1
Xring/mid/stage_8_dyn_impl_6 ring/mid/UNCONNECTED_8_ ring/mid/MUXB_8_
+ ring/mid/net23 MID_MUX[8] VDD VSS sg13g2_nand3_1
Xring/mid/stage_8_dyn_impl_7 ring/mid/UNCONNECTED_8_ ring/mid/MUXB_8_
+ ring/mid/net23 MID_MUX[8] VDD VSS sg13g2_nand3_1
Xring/mid/stage_8_inv_b_impl ring/mid/MUXB_8_ MID_MUX[8] VDD
+ VSS sg13g2_inv_1
Xring/mid/stage_9_dyn_impl_0 ring/mid/UNCONNECTED_9_ ring/mid/MUXB_9_
+ ring/mid/net9 MID_MUX[9] VDD VSS sg13g2_nand3_1
Xring/mid/stage_9_dyn_impl_1 ring/mid/UNCONNECTED_9_ ring/mid/MUXB_9_
+ ring/mid/net19 MID_MUX[9] VDD VSS sg13g2_nand3_1
Xring/mid/stage_9_dyn_impl_2 ring/mid/UNCONNECTED_9_ ring/mid/MUXB_9_
+ ring/mid/net19 MID_MUX[9] VDD VSS sg13g2_nand3_1
Xring/mid/stage_9_dyn_impl_3 ring/mid/UNCONNECTED_9_ ring/mid/MUXB_9_
+ ring/mid/net9 MID_MUX[9] VDD VSS sg13g2_nand3_1
Xring/mid/stage_9_dyn_impl_4 ring/mid/UNCONNECTED_9_ ring/mid/MUXB_9_
+ ring/mid/net9 MID_MUX[9] VDD VSS sg13g2_nand3_1
Xring/mid/stage_9_dyn_impl_5 ring/mid/UNCONNECTED_9_ ring/mid/MUXB_9_
+ ring/mid/net9 MID_MUX[9] VDD VSS sg13g2_nand3_1
Xring/mid/stage_9_dyn_impl_6 ring/mid/UNCONNECTED_9_ ring/mid/MUXB_9_
+ ring/mid/net8 MID_MUX[9] VDD VSS sg13g2_nand3_1
Xring/mid/stage_9_dyn_impl_7 ring/mid/UNCONNECTED_9_ ring/mid/MUXB_9_
+ ring/mid/net19 MID_MUX[9] VDD VSS sg13g2_nand3_1
Xring/mid/stage_9_inv_b_impl ring/mid/MUXB_9_ MID_MUX[9] VDD
+ VSS sg13g2_inv_1
Xring/sym/inj_dummy_inv_impl ring/sym/INJ_DUMMY ring/sym/INJ_EDGE_BALANCED
+ VDD VSS sg13g2_inv_1
Xring/sym/inj_slope_balancer_impl ring/sym/INJ_EDGE_BALANCED
+ REF VDD VSS sg13g2_inv_1
Xring/sym/osc_dummy_inv_impl ring/sym/OSC_DUMMY ring/sym/OSC_BALANCED
+ VDD VSS sg13g2_inv_1
Xring/sym/osc_slope_balancer_impl ring/sym/OSC_BALANCED ring/FINE_OUT
+ VDD VSS sg13g2_inv_1
Xring/sym/ssbbpd_impl/buf_nand_x_impl ring/SS_BBPD_WIRE_1_
+ ring/sym/ssbbpd_impl/OUT_NANDX VDD VSS sg13g2_buf_1
Xring/sym/ssbbpd_impl/buf_nand_y_impl ring/SS_BBPD_WIRE_0_
+ ring/sym/ssbbpd_impl/OUT_NANDY VDD VSS sg13g2_buf_1
Xring/sym/ssbbpd_impl/nand_x_impl ring/sym/ssbbpd_impl/OUT_NANDX
+ ring/sym/OSC_BALANCED ring/sym/ssbbpd_impl/OUT_NANDY VDD VSS
+ sg13g2_nand2_1
Xring/sym/ssbbpd_impl/nand_y_impl ring/sym/ssbbpd_impl/OUT_NANDY
+ ring/sym/INJ_EDGE_BALANCED ring/sym/ssbbpd_impl/OUT_NANDX
+ VDD VSS sg13g2_nand2_1
Xring/sym/sym_mux/nand_inj_impl ring/sym/sym_mux/OSC_INJ ring/sym/OSC_BALANCED
+ ring/sym/sym_mux/DCO_EN_INJ_WIN VDD VSS sg13g2_nand2_1
Xring/sym/sym_mux/nand_pll_impl OUT ring/sym/sym_mux/REF_INJ
+ ring/sym/sym_mux/OSC_INJ VDD VSS sg13g2_nand2_1
Xring/sym/sym_mux/nand_ref_impl ring/sym/sym_mux/REF_INJ ring/sym/INJ_EDGE_BALANCED
+ zero_ VDD VSS sg13g2_nand2b_1
Xring/sym/sym_mux/norb_en_inj_impl ring/sym/sym_mux/DCO_EN_INJ_WIN
+ zero_ DCO_EN VDD VSS sg13g2_nor2b_1
XTIE_ZERO_zero_ zero_ VDD VSS sg13g2_tielo
Xring/fine/fanout1 ring/fine/net1 ring/fine/net2 VDD VSS sg13g2_buf_1
Xring/fine/fanout2 ring/fine/net2 ring/fine/net5 VDD VSS sg13g2_buf_1
Xring/fine/fanout3 ring/fine/net3 ring/fine/net5 VDD VSS sg13g2_buf_1
Xring/fine/fanout4 ring/fine/net4 ring/fine/net5 VDD VSS sg13g2_buf_1
Xring/fine/fanout5 ring/fine/net5 ring/fine/LOAD VDD VSS sg13g2_buf_1
Xring/mid/fanout6 ring/mid/net6 ring/mid/net12 VDD VSS sg13g2_buf_1
Xring/mid/fanout7 ring/mid/net7 ring/mid/net12 VDD VSS sg13g2_buf_1
Xring/mid/fanout8 ring/mid/net8 ring/mid/net11 VDD VSS sg13g2_buf_1
Xring/mid/fanout9 ring/mid/net9 ring/mid/net11 VDD VSS sg13g2_buf_1
Xring/mid/fanout10 ring/mid/net10 ring/mid/net11 VDD VSS sg13g2_buf_1
Xring/mid/fanout11 ring/mid/net11 ring/mid/net12 VDD VSS sg13g2_buf_1
Xring/mid/fanout12 ring/mid/net12 ring/mid/net28 VDD VSS sg13g2_buf_1
Xring/mid/fanout13 ring/mid/net13 ring/mid/net14 VDD VSS sg13g2_buf_1
Xring/mid/fanout14 ring/mid/net14 ring/mid/net28 VDD VSS sg13g2_buf_1
Xring/mid/fanout15 ring/mid/net15 ring/mid/net16 VDD VSS sg13g2_buf_1
Xring/mid/fanout16 ring/mid/net16 ring/mid/net28 VDD VSS sg13g2_buf_1
Xring/mid/fanout17 ring/mid/net17 ring/mid/net27 VDD VSS sg13g2_buf_1
Xring/mid/fanout18 ring/mid/net18 ring/mid/net19 VDD VSS sg13g2_buf_1
Xring/mid/fanout19 ring/mid/net19 ring/mid/net27 VDD VSS sg13g2_buf_1
Xring/mid/fanout20 ring/mid/net20 ring/mid/net21 VDD VSS sg13g2_buf_1
Xring/mid/fanout21 ring/mid/net21 ring/mid/net27 VDD VSS sg13g2_buf_1
Xring/mid/fanout22 ring/mid/net22 ring/mid/net24 VDD VSS sg13g2_buf_1
Xring/mid/fanout23 ring/mid/net23 ring/mid/net24 VDD VSS sg13g2_buf_1
Xring/mid/fanout24 ring/mid/net24 ring/mid/net27 VDD VSS sg13g2_buf_1
Xring/mid/fanout25 ring/mid/net25 ring/mid/net26 VDD VSS sg13g2_buf_1
Xring/mid/fanout26 ring/mid/net26 ring/mid/net27 VDD VSS sg13g2_buf_1
Xring/mid/fanout27 ring/mid/net27 ring/mid/net28 VDD VSS sg13g2_buf_1
Xring/mid/fanout28 ring/mid/net28 ring/mid/LOAD VDD VSS sg13g2_buf_1
XFILLER_0_0 VDD VSS sg13g2_decap_4
XFILLER_0_9 VDD VSS sg13g2_decap_8
XFILLER_0_16 VDD VSS sg13g2_decap_8
XFILLER_0_23 VDD VSS sg13g2_decap_8
XFILLER_0_30 VDD VSS sg13g2_decap_8
XFILLER_0_37 VDD VSS sg13g2_decap_8
XFILLER_0_44 VDD VSS sg13g2_decap_8
XFILLER_0_51 VDD VSS sg13g2_decap_8
XFILLER_0_58 VDD VSS sg13g2_decap_8
XFILLER_0_65 VDD VSS sg13g2_decap_8
XFILLER_0_72 VDD VSS sg13g2_decap_8
XFILLER_0_79 VDD VSS sg13g2_decap_8
XFILLER_0_94 VDD VSS sg13g2_fill_1
XFILLER_0_99 VDD VSS sg13g2_decap_8
XFILLER_0_110 VDD VSS sg13g2_decap_8
XFILLER_0_117 VDD VSS sg13g2_decap_8
XFILLER_0_124 VDD VSS sg13g2_fill_2
XFILLER_0_130 VDD VSS sg13g2_decap_8
XFILLER_0_137 VDD VSS sg13g2_decap_8
XFILLER_0_144 VDD VSS sg13g2_fill_2
XFILLER_0_150 VDD VSS sg13g2_decap_8
XFILLER_0_157 VDD VSS sg13g2_decap_8
XFILLER_0_164 VDD VSS sg13g2_decap_8
XFILLER_0_171 VDD VSS sg13g2_decap_8
XFILLER_0_178 VDD VSS sg13g2_decap_8
XFILLER_0_185 VDD VSS sg13g2_decap_4
XFILLER_0_189 VDD VSS sg13g2_fill_1
XFILLER_0_194 VDD VSS sg13g2_decap_4
XFILLER_0_206 VDD VSS sg13g2_decap_8
XFILLER_0_213 VDD VSS sg13g2_decap_8
XFILLER_0_220 VDD VSS sg13g2_decap_8
XFILLER_0_227 VDD VSS sg13g2_decap_4
XFILLER_0_231 VDD VSS sg13g2_fill_2
XFILLER_0_241 VDD VSS sg13g2_decap_8
XFILLER_0_248 VDD VSS sg13g2_decap_8
XFILLER_0_255 VDD VSS sg13g2_decap_4
XFILLER_0_259 VDD VSS sg13g2_fill_2
XFILLER_0_265 VDD VSS sg13g2_decap_8
XFILLER_0_272 VDD VSS sg13g2_decap_8
XFILLER_0_279 VDD VSS sg13g2_decap_8
XFILLER_0_286 VDD VSS sg13g2_decap_8
XFILLER_0_293 VDD VSS sg13g2_decap_4
XFILLER_1_0 VDD VSS sg13g2_fill_1
XFILLER_1_19 VDD VSS sg13g2_decap_4
XFILLER_1_33 VDD VSS sg13g2_fill_2
XFILLER_1_60 VDD VSS sg13g2_fill_1
XFILLER_1_64 VDD VSS sg13g2_fill_1
XFILLER_1_80 VDD VSS sg13g2_fill_2
XFILLER_1_82 VDD VSS sg13g2_fill_1
XFILLER_1_91 VDD VSS sg13g2_decap_8
XFILLER_1_190 VDD VSS sg13g2_decap_8
XFILLER_1_197 VDD VSS sg13g2_fill_1
XFILLER_1_206 VDD VSS sg13g2_decap_8
XFILLER_1_213 VDD VSS sg13g2_decap_8
XFILLER_1_220 VDD VSS sg13g2_decap_8
XFILLER_1_227 VDD VSS sg13g2_fill_1
XFILLER_1_236 VDD VSS sg13g2_decap_8
XFILLER_1_243 VDD VSS sg13g2_fill_1
XFILLER_1_264 VDD VSS sg13g2_fill_2
XFILLER_1_266 VDD VSS sg13g2_fill_1
XFILLER_1_275 VDD VSS sg13g2_decap_8
XFILLER_1_282 VDD VSS sg13g2_decap_8
XFILLER_1_289 VDD VSS sg13g2_decap_8
XFILLER_1_296 VDD VSS sg13g2_fill_1
XFILLER_2_0 VDD VSS sg13g2_decap_4
XFILLER_2_9 VDD VSS sg13g2_decap_8
XFILLER_2_16 VDD VSS sg13g2_decap_8
XFILLER_2_23 VDD VSS sg13g2_decap_4
XFILLER_2_27 VDD VSS sg13g2_fill_1
XFILLER_2_33 VDD VSS sg13g2_decap_8
XFILLER_2_40 VDD VSS sg13g2_decap_8
XFILLER_2_47 VDD VSS sg13g2_decap_8
XFILLER_2_54 VDD VSS sg13g2_fill_2
XFILLER_2_75 VDD VSS sg13g2_decap_8
XFILLER_2_82 VDD VSS sg13g2_decap_4
XFILLER_2_94 VDD VSS sg13g2_decap_8
XFILLER_2_101 VDD VSS sg13g2_decap_8
XFILLER_2_108 VDD VSS sg13g2_fill_2
XFILLER_2_110 VDD VSS sg13g2_fill_1
XFILLER_2_115 VDD VSS sg13g2_decap_8
XFILLER_2_122 VDD VSS sg13g2_fill_1
XFILLER_2_127 VDD VSS sg13g2_decap_8
XFILLER_2_134 VDD VSS sg13g2_decap_8
XFILLER_2_141 VDD VSS sg13g2_decap_8
XFILLER_2_148 VDD VSS sg13g2_decap_8
XFILLER_2_155 VDD VSS sg13g2_decap_8
XFILLER_2_162 VDD VSS sg13g2_decap_8
XFILLER_2_169 VDD VSS sg13g2_decap_8
XFILLER_2_176 VDD VSS sg13g2_decap_8
XFILLER_2_183 VDD VSS sg13g2_decap_8
XFILLER_2_190 VDD VSS sg13g2_decap_8
XFILLER_2_197 VDD VSS sg13g2_fill_2
XFILLER_2_207 VDD VSS sg13g2_decap_8
XFILLER_2_214 VDD VSS sg13g2_decap_8
XFILLER_2_221 VDD VSS sg13g2_decap_8
XFILLER_2_236 VDD VSS sg13g2_decap_8
XFILLER_2_243 VDD VSS sg13g2_decap_8
XFILLER_2_250 VDD VSS sg13g2_decap_8
XFILLER_2_257 VDD VSS sg13g2_decap_8
XFILLER_2_272 VDD VSS sg13g2_decap_8
XFILLER_2_279 VDD VSS sg13g2_decap_8
XFILLER_2_286 VDD VSS sg13g2_decap_8
XFILLER_2_293 VDD VSS sg13g2_decap_4
XFILLER_3_0 VDD VSS sg13g2_fill_2
XFILLER_3_2 VDD VSS sg13g2_fill_1
XFILLER_3_18 VDD VSS sg13g2_decap_8
XFILLER_3_25 VDD VSS sg13g2_fill_2
XFILLER_3_32 VDD VSS sg13g2_decap_4
XFILLER_3_36 VDD VSS sg13g2_fill_2
XFILLER_3_46 VDD VSS sg13g2_decap_8
XFILLER_3_53 VDD VSS sg13g2_decap_8
XFILLER_3_60 VDD VSS sg13g2_decap_8
XFILLER_3_67 VDD VSS sg13g2_decap_8
XFILLER_3_74 VDD VSS sg13g2_decap_8
XFILLER_3_81 VDD VSS sg13g2_decap_8
XFILLER_3_88 VDD VSS sg13g2_fill_2
XFILLER_3_150 VDD VSS sg13g2_decap_4
XFILLER_3_186 VDD VSS sg13g2_fill_1
XFILLER_3_203 VDD VSS sg13g2_decap_8
XFILLER_3_210 VDD VSS sg13g2_decap_8
XFILLER_3_217 VDD VSS sg13g2_decap_4
XFILLER_3_221 VDD VSS sg13g2_fill_1
XFILLER_3_226 VDD VSS sg13g2_fill_2
XFILLER_3_236 VDD VSS sg13g2_decap_4
XFILLER_3_240 VDD VSS sg13g2_fill_2
XFILLER_3_274 VDD VSS sg13g2_decap_8
XFILLER_3_281 VDD VSS sg13g2_decap_8
XFILLER_3_288 VDD VSS sg13g2_decap_8
XFILLER_3_295 VDD VSS sg13g2_fill_2
XFILLER_4_0 VDD VSS sg13g2_decap_8
XFILLER_4_7 VDD VSS sg13g2_decap_8
XFILLER_4_14 VDD VSS sg13g2_fill_1
XFILLER_4_19 VDD VSS sg13g2_decap_8
XFILLER_4_26 VDD VSS sg13g2_fill_1
XFILLER_4_41 VDD VSS sg13g2_decap_8
XFILLER_4_48 VDD VSS sg13g2_fill_2
XFILLER_4_50 VDD VSS sg13g2_fill_1
XFILLER_4_68 VDD VSS sg13g2_fill_2
XFILLER_4_80 VDD VSS sg13g2_decap_4
XFILLER_4_84 VDD VSS sg13g2_fill_1
XFILLER_4_95 VDD VSS sg13g2_decap_8
XFILLER_4_102 VDD VSS sg13g2_decap_8
XFILLER_4_109 VDD VSS sg13g2_decap_8
XFILLER_4_116 VDD VSS sg13g2_decap_8
XFILLER_4_123 VDD VSS sg13g2_decap_8
XFILLER_4_130 VDD VSS sg13g2_decap_8
XFILLER_4_137 VDD VSS sg13g2_decap_8
XFILLER_4_144 VDD VSS sg13g2_fill_1
XFILLER_4_149 VDD VSS sg13g2_decap_8
XFILLER_4_156 VDD VSS sg13g2_fill_1
XFILLER_4_161 VDD VSS sg13g2_decap_8
XFILLER_4_168 VDD VSS sg13g2_decap_8
XFILLER_4_175 VDD VSS sg13g2_decap_8
XFILLER_4_182 VDD VSS sg13g2_decap_8
XFILLER_4_189 VDD VSS sg13g2_decap_8
XFILLER_4_196 VDD VSS sg13g2_decap_8
XFILLER_4_203 VDD VSS sg13g2_decap_8
XFILLER_4_210 VDD VSS sg13g2_fill_2
XFILLER_4_212 VDD VSS sg13g2_fill_1
XFILLER_4_225 VDD VSS sg13g2_decap_8
XFILLER_4_232 VDD VSS sg13g2_decap_4
XFILLER_4_236 VDD VSS sg13g2_fill_1
XFILLER_4_249 VDD VSS sg13g2_decap_8
XFILLER_4_256 VDD VSS sg13g2_decap_8
XFILLER_4_263 VDD VSS sg13g2_decap_4
XFILLER_4_267 VDD VSS sg13g2_fill_2
XFILLER_4_274 VDD VSS sg13g2_decap_4
XFILLER_4_286 VDD VSS sg13g2_fill_2
XFILLER_4_296 VDD VSS sg13g2_fill_1
XFILLER_5_0 VDD VSS sg13g2_decap_4
XFILLER_5_4 VDD VSS sg13g2_fill_1
XFILLER_5_22 VDD VSS sg13g2_decap_8
XFILLER_5_29 VDD VSS sg13g2_fill_2
XFILLER_5_41 VDD VSS sg13g2_decap_8
XFILLER_5_48 VDD VSS sg13g2_decap_8
XFILLER_5_65 VDD VSS sg13g2_decap_8
XFILLER_5_72 VDD VSS sg13g2_fill_2
XFILLER_5_74 VDD VSS sg13g2_fill_1
XFILLER_5_78 VDD VSS sg13g2_decap_8
XFILLER_5_95 VDD VSS sg13g2_decap_8
XFILLER_5_102 VDD VSS sg13g2_fill_2
XFILLER_5_114 VDD VSS sg13g2_decap_4
XFILLER_5_118 VDD VSS sg13g2_fill_2
XFILLER_5_133 VDD VSS sg13g2_decap_8
XFILLER_5_148 VDD VSS sg13g2_fill_2
XFILLER_5_150 VDD VSS sg13g2_fill_1
XFILLER_5_179 VDD VSS sg13g2_decap_4
XFILLER_5_195 VDD VSS sg13g2_decap_8
XFILLER_5_202 VDD VSS sg13g2_decap_4
XFILLER_5_218 VDD VSS sg13g2_decap_8
XFILLER_5_225 VDD VSS sg13g2_decap_4
XFILLER_5_229 VDD VSS sg13g2_fill_1
XFILLER_5_242 VDD VSS sg13g2_decap_8
XFILLER_5_249 VDD VSS sg13g2_decap_8
XFILLER_5_256 VDD VSS sg13g2_fill_2
XFILLER_5_258 VDD VSS sg13g2_fill_1
XFILLER_5_267 VDD VSS sg13g2_decap_4
XFILLER_5_274 VDD VSS sg13g2_decap_8
XFILLER_5_281 VDD VSS sg13g2_fill_2
XFILLER_5_291 VDD VSS sg13g2_decap_4
XFILLER_5_295 VDD VSS sg13g2_fill_2
XFILLER_6_0 VDD VSS sg13g2_fill_2
XFILLER_6_11 VDD VSS sg13g2_decap_8
XFILLER_6_18 VDD VSS sg13g2_fill_2
XFILLER_6_20 VDD VSS sg13g2_fill_1
XFILLER_6_25 VDD VSS sg13g2_decap_8
XFILLER_6_32 VDD VSS sg13g2_decap_8
XFILLER_6_39 VDD VSS sg13g2_decap_8
XFILLER_6_46 VDD VSS sg13g2_decap_8
XFILLER_6_53 VDD VSS sg13g2_decap_8
XFILLER_6_60 VDD VSS sg13g2_decap_8
XFILLER_6_67 VDD VSS sg13g2_fill_2
XFILLER_6_79 VDD VSS sg13g2_decap_8
XFILLER_6_86 VDD VSS sg13g2_decap_8
XFILLER_6_93 VDD VSS sg13g2_decap_8
XFILLER_6_100 VDD VSS sg13g2_decap_8
XFILLER_6_107 VDD VSS sg13g2_fill_2
XFILLER_6_114 VDD VSS sg13g2_decap_8
XFILLER_6_121 VDD VSS sg13g2_decap_8
XFILLER_6_128 VDD VSS sg13g2_decap_8
XFILLER_6_135 VDD VSS sg13g2_decap_4
XFILLER_6_139 VDD VSS sg13g2_fill_2
XFILLER_6_149 VDD VSS sg13g2_decap_8
XFILLER_6_156 VDD VSS sg13g2_decap_4
XFILLER_6_160 VDD VSS sg13g2_fill_1
XFILLER_6_165 VDD VSS sg13g2_decap_8
XFILLER_6_172 VDD VSS sg13g2_decap_8
XFILLER_6_179 VDD VSS sg13g2_decap_8
XFILLER_6_186 VDD VSS sg13g2_decap_4
XFILLER_6_198 VDD VSS sg13g2_decap_8
XFILLER_6_205 VDD VSS sg13g2_fill_2
XFILLER_6_215 VDD VSS sg13g2_decap_8
XFILLER_6_222 VDD VSS sg13g2_decap_4
XFILLER_6_226 VDD VSS sg13g2_fill_1
XFILLER_6_239 VDD VSS sg13g2_decap_8
XFILLER_6_246 VDD VSS sg13g2_decap_4
XFILLER_6_258 VDD VSS sg13g2_decap_8
XFILLER_6_265 VDD VSS sg13g2_fill_2
XFILLER_6_267 VDD VSS sg13g2_fill_1
XFILLER_6_280 VDD VSS sg13g2_decap_4
XFILLER_6_284 VDD VSS sg13g2_fill_1
XFILLER_6_293 VDD VSS sg13g2_decap_4
XFILLER_7_0 VDD VSS sg13g2_fill_2
XFILLER_7_2 VDD VSS sg13g2_fill_1
XFILLER_7_16 VDD VSS sg13g2_fill_2
XFILLER_7_18 VDD VSS sg13g2_fill_1
XFILLER_7_32 VDD VSS sg13g2_decap_4
XFILLER_7_36 VDD VSS sg13g2_fill_2
XFILLER_7_51 VDD VSS sg13g2_fill_2
XFILLER_7_63 VDD VSS sg13g2_decap_8
XFILLER_7_70 VDD VSS sg13g2_decap_8
XFILLER_7_77 VDD VSS sg13g2_decap_8
XFILLER_7_97 VDD VSS sg13g2_decap_8
XFILLER_7_104 VDD VSS sg13g2_decap_4
XFILLER_7_108 VDD VSS sg13g2_fill_1
XFILLER_7_114 VDD VSS sg13g2_decap_4
XFILLER_7_118 VDD VSS sg13g2_fill_2
XFILLER_7_130 VDD VSS sg13g2_decap_8
XFILLER_7_137 VDD VSS sg13g2_decap_4
XFILLER_7_141 VDD VSS sg13g2_fill_2
XFILLER_7_151 VDD VSS sg13g2_decap_4
XFILLER_7_155 VDD VSS sg13g2_fill_2
XFILLER_7_175 VDD VSS sg13g2_decap_8
XFILLER_7_182 VDD VSS sg13g2_fill_2
XFILLER_7_196 VDD VSS sg13g2_decap_4
XFILLER_7_200 VDD VSS sg13g2_fill_1
XFILLER_7_213 VDD VSS sg13g2_decap_8
XFILLER_7_220 VDD VSS sg13g2_decap_4
XFILLER_7_240 VDD VSS sg13g2_decap_8
XFILLER_7_247 VDD VSS sg13g2_fill_1
XFILLER_7_256 VDD VSS sg13g2_decap_8
XFILLER_7_263 VDD VSS sg13g2_fill_2
XFILLER_7_265 VDD VSS sg13g2_fill_1
XFILLER_7_274 VDD VSS sg13g2_decap_8
XFILLER_7_289 VDD VSS sg13g2_decap_8
XFILLER_7_296 VDD VSS sg13g2_fill_1
XFILLER_8_0 VDD VSS sg13g2_decap_8
XFILLER_8_7 VDD VSS sg13g2_decap_8
XFILLER_8_14 VDD VSS sg13g2_decap_8
XFILLER_8_30 VDD VSS sg13g2_decap_8
XFILLER_8_37 VDD VSS sg13g2_fill_1
XFILLER_8_48 VDD VSS sg13g2_decap_4
XFILLER_8_52 VDD VSS sg13g2_fill_1
XFILLER_8_63 VDD VSS sg13g2_fill_2
XFILLER_8_65 VDD VSS sg13g2_fill_1
XFILLER_8_85 VDD VSS sg13g2_fill_2
XFILLER_8_87 VDD VSS sg13g2_fill_1
XFILLER_8_103 VDD VSS sg13g2_decap_8
XFILLER_8_110 VDD VSS sg13g2_fill_1
XFILLER_8_123 VDD VSS sg13g2_fill_1
XFILLER_8_134 VDD VSS sg13g2_decap_8
XFILLER_8_141 VDD VSS sg13g2_decap_4
XFILLER_8_145 VDD VSS sg13g2_fill_2
XFILLER_8_155 VDD VSS sg13g2_decap_8
XFILLER_8_162 VDD VSS sg13g2_decap_8
XFILLER_8_169 VDD VSS sg13g2_fill_2
XFILLER_8_171 VDD VSS sg13g2_fill_1
XFILLER_8_175 VDD VSS sg13g2_decap_8
XFILLER_8_190 VDD VSS sg13g2_decap_4
XFILLER_8_202 VDD VSS sg13g2_decap_8
XFILLER_8_209 VDD VSS sg13g2_fill_1
XFILLER_8_218 VDD VSS sg13g2_decap_8
XFILLER_8_225 VDD VSS sg13g2_decap_8
XFILLER_8_232 VDD VSS sg13g2_decap_8
XFILLER_8_239 VDD VSS sg13g2_decap_4
XFILLER_8_255 VDD VSS sg13g2_fill_2
XFILLER_8_265 VDD VSS sg13g2_decap_8
XFILLER_8_280 VDD VSS sg13g2_decap_4
XFILLER_8_284 VDD VSS sg13g2_fill_1
XFILLER_8_293 VDD VSS sg13g2_decap_4
XFILLER_9_0 VDD VSS sg13g2_fill_1
XFILLER_9_10 VDD VSS sg13g2_decap_4
XFILLER_9_14 VDD VSS sg13g2_fill_1
XFILLER_9_19 VDD VSS sg13g2_fill_1
XFILLER_9_24 VDD VSS sg13g2_fill_2
XFILLER_9_30 VDD VSS sg13g2_decap_8
XFILLER_9_37 VDD VSS sg13g2_decap_8
XFILLER_9_44 VDD VSS sg13g2_decap_8
XFILLER_9_51 VDD VSS sg13g2_decap_4
XFILLER_9_55 VDD VSS sg13g2_fill_2
XFILLER_9_65 VDD VSS sg13g2_decap_8
XFILLER_9_72 VDD VSS sg13g2_decap_8
XFILLER_9_79 VDD VSS sg13g2_decap_8
XFILLER_9_86 VDD VSS sg13g2_fill_1
XFILLER_9_95 VDD VSS sg13g2_decap_8
XFILLER_9_102 VDD VSS sg13g2_decap_4
XFILLER_9_120 VDD VSS sg13g2_decap_8
XFILLER_9_127 VDD VSS sg13g2_decap_8
XFILLER_9_134 VDD VSS sg13g2_decap_8
XFILLER_9_141 VDD VSS sg13g2_fill_2
XFILLER_9_151 VDD VSS sg13g2_fill_1
XFILLER_9_156 VDD VSS sg13g2_decap_8
XFILLER_9_163 VDD VSS sg13g2_decap_8
XFILLER_9_170 VDD VSS sg13g2_decap_8
XFILLER_9_177 VDD VSS sg13g2_decap_8
XFILLER_9_184 VDD VSS sg13g2_decap_8
XFILLER_9_191 VDD VSS sg13g2_decap_4
XFILLER_9_195 VDD VSS sg13g2_fill_1
XFILLER_9_204 VDD VSS sg13g2_decap_8
XFILLER_9_211 VDD VSS sg13g2_fill_2
XFILLER_9_213 VDD VSS sg13g2_fill_1
XFILLER_9_222 VDD VSS sg13g2_decap_8
XFILLER_9_229 VDD VSS sg13g2_fill_2
XFILLER_9_240 VDD VSS sg13g2_decap_8
XFILLER_9_247 VDD VSS sg13g2_fill_2
XFILLER_9_257 VDD VSS sg13g2_decap_8
XFILLER_9_264 VDD VSS sg13g2_decap_8
XFILLER_9_271 VDD VSS sg13g2_decap_8
XFILLER_9_278 VDD VSS sg13g2_decap_8
XFILLER_9_285 VDD VSS sg13g2_decap_8
XFILLER_9_292 VDD VSS sg13g2_decap_4
XFILLER_9_296 VDD VSS sg13g2_fill_1
XFILLER_10_0 VDD VSS sg13g2_decap_4
XFILLER_10_4 VDD VSS sg13g2_fill_2
XFILLER_10_10 VDD VSS sg13g2_decap_4
XFILLER_10_14 VDD VSS sg13g2_fill_2
XFILLER_10_21 VDD VSS sg13g2_decap_8
XFILLER_10_28 VDD VSS sg13g2_fill_2
XFILLER_10_34 VDD VSS sg13g2_fill_1
XFILLER_10_44 VDD VSS sg13g2_fill_2
XFILLER_10_46 VDD VSS sg13g2_fill_1
XFILLER_10_56 VDD VSS sg13g2_decap_4
XFILLER_10_60 VDD VSS sg13g2_fill_1
XFILLER_10_78 VDD VSS sg13g2_fill_1
XFILLER_10_89 VDD VSS sg13g2_decap_8
XFILLER_10_96 VDD VSS sg13g2_decap_8
XFILLER_10_103 VDD VSS sg13g2_decap_8
XFILLER_10_110 VDD VSS sg13g2_decap_8
XFILLER_10_117 VDD VSS sg13g2_decap_8
XFILLER_10_139 VDD VSS sg13g2_decap_8
XFILLER_10_146 VDD VSS sg13g2_decap_4
XFILLER_10_150 VDD VSS sg13g2_fill_1
XFILLER_10_191 VDD VSS sg13g2_decap_8
XFILLER_10_198 VDD VSS sg13g2_fill_1
XFILLER_10_207 VDD VSS sg13g2_decap_8
XFILLER_10_214 VDD VSS sg13g2_fill_2
XFILLER_10_228 VDD VSS sg13g2_decap_8
XFILLER_10_235 VDD VSS sg13g2_decap_4
XFILLER_10_239 VDD VSS sg13g2_fill_1
XFILLER_10_248 VDD VSS sg13g2_decap_8
XFILLER_10_255 VDD VSS sg13g2_decap_4
XFILLER_10_259 VDD VSS sg13g2_fill_1
XFILLER_10_268 VDD VSS sg13g2_decap_8
XFILLER_10_283 VDD VSS sg13g2_fill_2
XFILLER_10_293 VDD VSS sg13g2_decap_4
XFILLER_11_0 VDD VSS sg13g2_fill_2
XFILLER_11_15 VDD VSS sg13g2_decap_8
XFILLER_11_22 VDD VSS sg13g2_fill_2
XFILLER_11_28 VDD VSS sg13g2_decap_8
XFILLER_11_35 VDD VSS sg13g2_decap_8
XFILLER_11_42 VDD VSS sg13g2_decap_4
XFILLER_11_46 VDD VSS sg13g2_fill_2
XFILLER_11_52 VDD VSS sg13g2_fill_2
XFILLER_11_63 VDD VSS sg13g2_decap_8
XFILLER_11_70 VDD VSS sg13g2_decap_8
XFILLER_11_77 VDD VSS sg13g2_decap_8
XFILLER_11_84 VDD VSS sg13g2_decap_8
XFILLER_11_91 VDD VSS sg13g2_decap_4
XFILLER_11_105 VDD VSS sg13g2_decap_8
XFILLER_11_112 VDD VSS sg13g2_fill_1
XFILLER_11_121 VDD VSS sg13g2_decap_8
XFILLER_11_128 VDD VSS sg13g2_decap_8
XFILLER_11_135 VDD VSS sg13g2_fill_2
XFILLER_11_145 VDD VSS sg13g2_fill_2
XFILLER_11_150 VDD VSS sg13g2_fill_2
XFILLER_11_155 VDD VSS sg13g2_decap_8
XFILLER_11_162 VDD VSS sg13g2_decap_8
XFILLER_11_169 VDD VSS sg13g2_decap_8
XFILLER_11_176 VDD VSS sg13g2_decap_8
XFILLER_11_183 VDD VSS sg13g2_fill_2
XFILLER_11_185 VDD VSS sg13g2_fill_1
XFILLER_11_194 VDD VSS sg13g2_decap_8
XFILLER_11_213 VDD VSS sg13g2_decap_8
XFILLER_11_220 VDD VSS sg13g2_decap_4
XFILLER_11_232 VDD VSS sg13g2_decap_8
XFILLER_11_239 VDD VSS sg13g2_decap_8
XFILLER_11_246 VDD VSS sg13g2_fill_2
XFILLER_11_256 VDD VSS sg13g2_decap_4
XFILLER_11_260 VDD VSS sg13g2_fill_1
XFILLER_11_269 VDD VSS sg13g2_decap_4
XFILLER_11_273 VDD VSS sg13g2_fill_2
XFILLER_11_283 VDD VSS sg13g2_decap_4
XFILLER_11_295 VDD VSS sg13g2_fill_2
XFILLER_12_0 VDD VSS sg13g2_decap_8
XFILLER_12_7 VDD VSS sg13g2_decap_8
XFILLER_12_14 VDD VSS sg13g2_fill_2
XFILLER_12_16 VDD VSS sg13g2_fill_1
XFILLER_12_21 VDD VSS sg13g2_fill_1
XFILLER_12_27 VDD VSS sg13g2_fill_2
XFILLER_12_38 VDD VSS sg13g2_fill_1
XFILLER_12_43 VDD VSS sg13g2_decap_8
XFILLER_12_50 VDD VSS sg13g2_decap_8
XFILLER_12_61 VDD VSS sg13g2_decap_4
XFILLER_12_89 VDD VSS sg13g2_decap_4
XFILLER_12_93 VDD VSS sg13g2_fill_1
XFILLER_12_104 VDD VSS sg13g2_fill_2
XFILLER_12_106 VDD VSS sg13g2_fill_1
XFILLER_12_126 VDD VSS sg13g2_decap_8
XFILLER_12_133 VDD VSS sg13g2_fill_2
XFILLER_12_135 VDD VSS sg13g2_fill_1
XFILLER_12_144 VDD VSS sg13g2_fill_2
XFILLER_12_178 VDD VSS sg13g2_decap_8
XFILLER_12_185 VDD VSS sg13g2_decap_4
XFILLER_12_197 VDD VSS sg13g2_decap_8
XFILLER_12_204 VDD VSS sg13g2_decap_4
XFILLER_12_216 VDD VSS sg13g2_decap_8
XFILLER_12_223 VDD VSS sg13g2_decap_4
XFILLER_12_239 VDD VSS sg13g2_decap_4
XFILLER_12_249 VDD VSS sg13g2_fill_1
XFILLER_12_254 VDD VSS sg13g2_decap_8
XFILLER_12_261 VDD VSS sg13g2_fill_1
XFILLER_12_270 VDD VSS sg13g2_decap_8
XFILLER_12_281 VDD VSS sg13g2_decap_4
XFILLER_12_293 VDD VSS sg13g2_decap_4
XFILLER_13_0 VDD VSS sg13g2_fill_2
XFILLER_13_15 VDD VSS sg13g2_decap_4
XFILLER_13_19 VDD VSS sg13g2_fill_2
XFILLER_13_29 VDD VSS sg13g2_decap_8
XFILLER_13_36 VDD VSS sg13g2_fill_2
XFILLER_13_41 VDD VSS sg13g2_decap_8
XFILLER_13_48 VDD VSS sg13g2_fill_2
XFILLER_13_50 VDD VSS sg13g2_fill_1
XFILLER_13_64 VDD VSS sg13g2_decap_4
XFILLER_13_68 VDD VSS sg13g2_fill_1
XFILLER_13_77 VDD VSS sg13g2_decap_8
XFILLER_13_84 VDD VSS sg13g2_decap_8
XFILLER_13_91 VDD VSS sg13g2_decap_8
XFILLER_13_98 VDD VSS sg13g2_fill_2
XFILLER_13_103 VDD VSS sg13g2_fill_2
XFILLER_13_109 VDD VSS sg13g2_decap_8
XFILLER_13_116 VDD VSS sg13g2_decap_8
XFILLER_13_123 VDD VSS sg13g2_decap_8
XFILLER_13_130 VDD VSS sg13g2_fill_2
XFILLER_13_140 VDD VSS sg13g2_decap_8
XFILLER_13_147 VDD VSS sg13g2_decap_8
XFILLER_13_157 VDD VSS sg13g2_decap_8
XFILLER_13_164 VDD VSS sg13g2_decap_8
XFILLER_13_171 VDD VSS sg13g2_fill_2
XFILLER_13_181 VDD VSS sg13g2_decap_8
XFILLER_13_188 VDD VSS sg13g2_fill_2
XFILLER_13_198 VDD VSS sg13g2_decap_8
XFILLER_13_205 VDD VSS sg13g2_decap_4
XFILLER_13_209 VDD VSS sg13g2_fill_2
XFILLER_13_223 VDD VSS sg13g2_decap_8
XFILLER_13_230 VDD VSS sg13g2_decap_8
XFILLER_13_237 VDD VSS sg13g2_fill_2
XFILLER_13_239 VDD VSS sg13g2_fill_1
XFILLER_13_244 VDD VSS sg13g2_decap_8
XFILLER_13_255 VDD VSS sg13g2_decap_4
XFILLER_13_267 VDD VSS sg13g2_decap_8
XFILLER_13_274 VDD VSS sg13g2_fill_1
XFILLER_13_283 VDD VSS sg13g2_decap_4
XFILLER_13_287 VDD VSS sg13g2_fill_2
XFILLER_13_292 VDD VSS sg13g2_decap_4
XFILLER_13_296 VDD VSS sg13g2_fill_1
XFILLER_14_0 VDD VSS sg13g2_decap_4
XFILLER_14_4 VDD VSS sg13g2_fill_1
XFILLER_14_13 VDD VSS sg13g2_fill_1
XFILLER_14_24 VDD VSS sg13g2_fill_2
XFILLER_14_26 VDD VSS sg13g2_fill_1
XFILLER_14_46 VDD VSS sg13g2_decap_8
XFILLER_14_53 VDD VSS sg13g2_fill_1
XFILLER_14_77 VDD VSS sg13g2_fill_1
XFILLER_14_82 VDD VSS sg13g2_fill_1
XFILLER_14_91 VDD VSS sg13g2_fill_1
XFILLER_14_97 VDD VSS sg13g2_fill_1
XFILLER_14_108 VDD VSS sg13g2_fill_2
XFILLER_14_110 VDD VSS sg13g2_fill_1
XFILLER_14_119 VDD VSS sg13g2_fill_2
XFILLER_14_121 VDD VSS sg13g2_fill_1
XFILLER_14_134 VDD VSS sg13g2_decap_4
XFILLER_14_171 VDD VSS sg13g2_fill_2
XFILLER_14_173 VDD VSS sg13g2_fill_1
XFILLER_14_186 VDD VSS sg13g2_decap_4
XFILLER_14_214 VDD VSS sg13g2_decap_8
XFILLER_14_221 VDD VSS sg13g2_fill_2
XFILLER_14_223 VDD VSS sg13g2_fill_1
XFILLER_14_236 VDD VSS sg13g2_decap_8
XFILLER_14_255 VDD VSS sg13g2_decap_8
XFILLER_14_262 VDD VSS sg13g2_decap_8
XFILLER_14_269 VDD VSS sg13g2_fill_2
XFILLER_14_271 VDD VSS sg13g2_fill_1
XFILLER_14_280 VDD VSS sg13g2_fill_2
XFILLER_14_282 VDD VSS sg13g2_fill_1
XFILLER_14_296 VDD VSS sg13g2_fill_1
XFILLER_15_0 VDD VSS sg13g2_decap_4
XFILLER_15_4 VDD VSS sg13g2_fill_2
XFILLER_15_11 VDD VSS sg13g2_decap_8
XFILLER_15_18 VDD VSS sg13g2_decap_8
XFILLER_15_25 VDD VSS sg13g2_decap_8
XFILLER_15_32 VDD VSS sg13g2_decap_8
XFILLER_15_39 VDD VSS sg13g2_decap_8
XFILLER_15_46 VDD VSS sg13g2_decap_8
XFILLER_15_53 VDD VSS sg13g2_decap_8
XFILLER_15_60 VDD VSS sg13g2_fill_2
XFILLER_15_66 VDD VSS sg13g2_fill_2
XFILLER_15_68 VDD VSS sg13g2_fill_1
XFILLER_15_72 VDD VSS sg13g2_decap_8
XFILLER_15_79 VDD VSS sg13g2_decap_8
XFILLER_15_86 VDD VSS sg13g2_decap_8
XFILLER_15_93 VDD VSS sg13g2_fill_1
XFILLER_15_99 VDD VSS sg13g2_decap_8
XFILLER_15_106 VDD VSS sg13g2_decap_8
XFILLER_15_113 VDD VSS sg13g2_decap_4
XFILLER_15_117 VDD VSS sg13g2_fill_2
XFILLER_15_127 VDD VSS sg13g2_decap_8
XFILLER_15_134 VDD VSS sg13g2_decap_8
XFILLER_15_141 VDD VSS sg13g2_decap_8
XFILLER_15_148 VDD VSS sg13g2_decap_8
XFILLER_15_155 VDD VSS sg13g2_decap_8
XFILLER_15_162 VDD VSS sg13g2_decap_8
XFILLER_15_169 VDD VSS sg13g2_fill_1
XFILLER_15_178 VDD VSS sg13g2_decap_8
XFILLER_15_185 VDD VSS sg13g2_decap_8
XFILLER_15_192 VDD VSS sg13g2_decap_8
XFILLER_15_199 VDD VSS sg13g2_decap_8
XFILLER_15_206 VDD VSS sg13g2_decap_4
XFILLER_15_210 VDD VSS sg13g2_fill_2
XFILLER_15_220 VDD VSS sg13g2_decap_8
XFILLER_15_227 VDD VSS sg13g2_fill_2
XFILLER_15_229 VDD VSS sg13g2_fill_1
XFILLER_15_242 VDD VSS sg13g2_decap_4
XFILLER_15_246 VDD VSS sg13g2_fill_1
XFILLER_15_251 VDD VSS sg13g2_decap_8
XFILLER_15_258 VDD VSS sg13g2_decap_8
XFILLER_15_265 VDD VSS sg13g2_decap_8
XFILLER_15_272 VDD VSS sg13g2_decap_8
XFILLER_15_279 VDD VSS sg13g2_decap_8
XFILLER_15_286 VDD VSS sg13g2_decap_8
XFILLER_15_293 VDD VSS sg13g2_decap_4
XFILLER_16_0 VDD VSS sg13g2_fill_1
XFILLER_16_11 VDD VSS sg13g2_fill_2
XFILLER_16_13 VDD VSS sg13g2_fill_1
XFILLER_16_24 VDD VSS sg13g2_fill_2
XFILLER_16_36 VDD VSS sg13g2_fill_2
XFILLER_16_53 VDD VSS sg13g2_fill_1
XFILLER_16_64 VDD VSS sg13g2_fill_2
XFILLER_16_66 VDD VSS sg13g2_fill_1
XFILLER_16_82 VDD VSS sg13g2_decap_4
XFILLER_16_86 VDD VSS sg13g2_fill_2
XFILLER_16_98 VDD VSS sg13g2_fill_2
XFILLER_16_100 VDD VSS sg13g2_fill_1
XFILLER_16_111 VDD VSS sg13g2_decap_8
XFILLER_16_118 VDD VSS sg13g2_decap_8
XFILLER_16_125 VDD VSS sg13g2_decap_4
XFILLER_16_129 VDD VSS sg13g2_fill_1
XFILLER_16_138 VDD VSS sg13g2_decap_8
XFILLER_16_145 VDD VSS sg13g2_fill_2
XFILLER_16_147 VDD VSS sg13g2_fill_1
XFILLER_16_151 VDD VSS sg13g2_decap_8
XFILLER_16_158 VDD VSS sg13g2_decap_8
XFILLER_16_173 VDD VSS sg13g2_decap_4
XFILLER_16_177 VDD VSS sg13g2_fill_2
XFILLER_16_195 VDD VSS sg13g2_decap_4
XFILLER_16_211 VDD VSS sg13g2_decap_8
XFILLER_16_226 VDD VSS sg13g2_decap_8
XFILLER_16_233 VDD VSS sg13g2_decap_8
XFILLER_16_240 VDD VSS sg13g2_decap_8
XFILLER_16_247 VDD VSS sg13g2_decap_8
XFILLER_16_254 VDD VSS sg13g2_decap_8
XFILLER_16_261 VDD VSS sg13g2_decap_8
XFILLER_16_268 VDD VSS sg13g2_decap_8
XFILLER_16_275 VDD VSS sg13g2_decap_8
XFILLER_16_282 VDD VSS sg13g2_decap_8
XFILLER_16_289 VDD VSS sg13g2_decap_8
XFILLER_16_296 VDD VSS sg13g2_fill_1
XFILLER_17_0 VDD VSS sg13g2_decap_8
XFILLER_17_7 VDD VSS sg13g2_decap_8
XFILLER_17_14 VDD VSS sg13g2_decap_8
XFILLER_17_21 VDD VSS sg13g2_decap_8
XFILLER_17_28 VDD VSS sg13g2_decap_8
XFILLER_17_35 VDD VSS sg13g2_decap_8
XFILLER_17_42 VDD VSS sg13g2_decap_8
XFILLER_17_49 VDD VSS sg13g2_decap_8
XFILLER_17_56 VDD VSS sg13g2_decap_8
XFILLER_17_67 VDD VSS sg13g2_decap_8
XFILLER_17_74 VDD VSS sg13g2_decap_8
XFILLER_17_81 VDD VSS sg13g2_decap_8
XFILLER_17_88 VDD VSS sg13g2_decap_8
XFILLER_17_95 VDD VSS sg13g2_decap_8
XFILLER_17_102 VDD VSS sg13g2_decap_8
XFILLER_17_109 VDD VSS sg13g2_decap_8
XFILLER_17_116 VDD VSS sg13g2_decap_8
XFILLER_17_123 VDD VSS sg13g2_decap_8
XFILLER_17_130 VDD VSS sg13g2_decap_4
XFILLER_17_163 VDD VSS sg13g2_fill_2
XFILLER_17_173 VDD VSS sg13g2_decap_8
XFILLER_17_180 VDD VSS sg13g2_fill_2
XFILLER_17_186 VDD VSS sg13g2_decap_8
XFILLER_17_193 VDD VSS sg13g2_decap_8
XFILLER_17_200 VDD VSS sg13g2_decap_4
XFILLER_17_212 VDD VSS sg13g2_decap_4
XFILLER_17_216 VDD VSS sg13g2_fill_1
XFILLER_17_225 VDD VSS sg13g2_decap_8
XFILLER_17_232 VDD VSS sg13g2_decap_8
XFILLER_17_239 VDD VSS sg13g2_decap_8
XFILLER_17_246 VDD VSS sg13g2_decap_8
XFILLER_17_253 VDD VSS sg13g2_decap_8
XFILLER_17_260 VDD VSS sg13g2_decap_8
XFILLER_17_267 VDD VSS sg13g2_decap_8
XFILLER_17_274 VDD VSS sg13g2_decap_8
XFILLER_17_281 VDD VSS sg13g2_decap_8
XFILLER_17_288 VDD VSS sg13g2_decap_8
XFILLER_17_295 VDD VSS sg13g2_fill_2
.ENDS PLL_RING_DCO_PHYS
